* NGSPICE file created from TopModule.ext - technology: sky130A

* Black-box entry subcircuit for sky130_fd_sc_hd__fill_2 abstract view
.subckt sky130_fd_sc_hd__fill_2 VGND VNB VPB VPWR
.ends

* Black-box entry subcircuit for sky130_fd_sc_hd__inv_2 abstract view
.subckt sky130_fd_sc_hd__inv_2 A VGND VNB VPB VPWR Y
.ends

* Black-box entry subcircuit for sky130_fd_sc_hd__tapvpwrvgnd_1 abstract view
.subckt sky130_fd_sc_hd__tapvpwrvgnd_1 VGND VPWR
.ends

* Black-box entry subcircuit for sky130_ef_sc_hd__decap_12 abstract view
.subckt sky130_ef_sc_hd__decap_12 VPWR VGND VPB VNB
.ends

* Black-box entry subcircuit for sky130_fd_sc_hd__dfrtp_1 abstract view
.subckt sky130_fd_sc_hd__dfrtp_1 CLK D RESET_B VGND VNB VPB VPWR Q
.ends

* Black-box entry subcircuit for sky130_fd_sc_hd__a2bb2o_1 abstract view
.subckt sky130_fd_sc_hd__a2bb2o_1 A1_N A2_N B1 B2 VGND VNB VPB VPWR X
.ends

* Black-box entry subcircuit for sky130_fd_sc_hd__a21oi_1 abstract view
.subckt sky130_fd_sc_hd__a21oi_1 A1 A2 B1 VGND VNB VPB VPWR Y
.ends

* Black-box entry subcircuit for sky130_fd_sc_hd__fill_1 abstract view
.subckt sky130_fd_sc_hd__fill_1 VGND VNB VPB VPWR
.ends

* Black-box entry subcircuit for sky130_fd_sc_hd__dfrtp_2 abstract view
.subckt sky130_fd_sc_hd__dfrtp_2 CLK D RESET_B VGND VNB VPB VPWR Q
.ends

* Black-box entry subcircuit for sky130_fd_sc_hd__decap_8 abstract view
.subckt sky130_fd_sc_hd__decap_8 VGND VNB VPB VPWR
.ends

* Black-box entry subcircuit for sky130_fd_sc_hd__decap_4 abstract view
.subckt sky130_fd_sc_hd__decap_4 VGND VNB VPB VPWR
.ends

* Black-box entry subcircuit for sky130_fd_sc_hd__decap_3 abstract view
.subckt sky130_fd_sc_hd__decap_3 VGND VNB VPB VPWR
.ends

* Black-box entry subcircuit for sky130_fd_sc_hd__buf_1 abstract view
.subckt sky130_fd_sc_hd__buf_1 A VGND VNB VPB VPWR X
.ends

* Black-box entry subcircuit for sky130_fd_sc_hd__clkbuf_1 abstract view
.subckt sky130_fd_sc_hd__clkbuf_1 A VGND VNB VPB VPWR X
.ends

* Black-box entry subcircuit for sky130_fd_sc_hd__and3_1 abstract view
.subckt sky130_fd_sc_hd__and3_1 A B C VGND VNB VPB VPWR X
.ends

* Black-box entry subcircuit for sky130_fd_sc_hd__decap_6 abstract view
.subckt sky130_fd_sc_hd__decap_6 VGND VNB VPB VPWR
.ends

* Black-box entry subcircuit for sky130_fd_sc_hd__nand2_1 abstract view
.subckt sky130_fd_sc_hd__nand2_1 A B VGND VNB VPB VPWR Y
.ends

* Black-box entry subcircuit for sky130_fd_sc_hd__a21o_1 abstract view
.subckt sky130_fd_sc_hd__a21o_1 A1 A2 B1 VGND VNB VPB VPWR X
.ends

* Black-box entry subcircuit for sky130_fd_sc_hd__or3_1 abstract view
.subckt sky130_fd_sc_hd__or3_1 A B C VGND VNB VPB VPWR X
.ends

* Black-box entry subcircuit for sky130_fd_sc_hd__or2_1 abstract view
.subckt sky130_fd_sc_hd__or2_1 A B VGND VNB VPB VPWR X
.ends

* Black-box entry subcircuit for sky130_fd_sc_hd__nand3_1 abstract view
.subckt sky130_fd_sc_hd__nand3_1 A B C VGND VNB VPB VPWR Y
.ends

* Black-box entry subcircuit for sky130_fd_sc_hd__buf_4 abstract view
.subckt sky130_fd_sc_hd__buf_4 A VGND VNB VPB VPWR X
.ends

* Black-box entry subcircuit for sky130_fd_sc_hd__a31o_1 abstract view
.subckt sky130_fd_sc_hd__a31o_1 A1 A2 A3 B1 VGND VNB VPB VPWR X
.ends

* Black-box entry subcircuit for sky130_fd_sc_hd__bufinv_16 abstract view
.subckt sky130_fd_sc_hd__bufinv_16 A VGND VNB VPB VPWR Y
.ends

* Black-box entry subcircuit for sky130_fd_sc_hd__and4_1 abstract view
.subckt sky130_fd_sc_hd__and4_1 A B C D VGND VNB VPB VPWR X
.ends

* Black-box entry subcircuit for sky130_fd_sc_hd__dfrtp_4 abstract view
.subckt sky130_fd_sc_hd__dfrtp_4 CLK D RESET_B VGND VNB VPB VPWR Q
.ends

* Black-box entry subcircuit for sky130_fd_sc_hd__nor2_1 abstract view
.subckt sky130_fd_sc_hd__nor2_1 A B VGND VNB VPB VPWR Y
.ends

* Black-box entry subcircuit for sky130_fd_sc_hd__clkinv_2 abstract view
.subckt sky130_fd_sc_hd__clkinv_2 A VGND VNB VPB VPWR Y
.ends

* Black-box entry subcircuit for sky130_fd_sc_hd__xnor2_1 abstract view
.subckt sky130_fd_sc_hd__xnor2_1 A B VGND VNB VPB VPWR Y
.ends

* Black-box entry subcircuit for sky130_fd_sc_hd__clkbuf_4 abstract view
.subckt sky130_fd_sc_hd__clkbuf_4 A VGND VNB VPB VPWR X
.ends

* Black-box entry subcircuit for sky130_fd_sc_hd__o21a_1 abstract view
.subckt sky130_fd_sc_hd__o21a_1 A1 A2 B1 VGND VNB VPB VPWR X
.ends

* Black-box entry subcircuit for sky130_fd_sc_hd__and2_2 abstract view
.subckt sky130_fd_sc_hd__and2_2 A B VGND VNB VPB VPWR X
.ends

* Black-box entry subcircuit for sky130_fd_sc_hd__clkbuf_16 abstract view
.subckt sky130_fd_sc_hd__clkbuf_16 A VGND VNB VPB VPWR X
.ends

* Black-box entry subcircuit for sky130_fd_sc_hd__a41o_1 abstract view
.subckt sky130_fd_sc_hd__a41o_1 A1 A2 A3 A4 B1 VGND VNB VPB VPWR X
.ends

* Black-box entry subcircuit for sky130_fd_sc_hd__clkinv_4 abstract view
.subckt sky130_fd_sc_hd__clkinv_4 A VGND VNB VPB VPWR Y
.ends

* Black-box entry subcircuit for sky130_fd_sc_hd__o221a_1 abstract view
.subckt sky130_fd_sc_hd__o221a_1 A1 A2 B1 B2 C1 VGND VNB VPB VPWR X
.ends

* Black-box entry subcircuit for sky130_fd_sc_hd__a21bo_4 abstract view
.subckt sky130_fd_sc_hd__a21bo_4 A1 A2 B1_N VGND VNB VPB VPWR X
.ends

* Black-box entry subcircuit for sky130_fd_sc_hd__a211oi_1 abstract view
.subckt sky130_fd_sc_hd__a211oi_1 A1 A2 B1 C1 VGND VNB VPB VPWR Y
.ends

* Black-box entry subcircuit for sky130_fd_sc_hd__o211ai_4 abstract view
.subckt sky130_fd_sc_hd__o211ai_4 A1 A2 B1 C1 VGND VNB VPB VPWR Y
.ends

* Black-box entry subcircuit for sky130_fd_sc_hd__and2_1 abstract view
.subckt sky130_fd_sc_hd__and2_1 A B VGND VNB VPB VPWR X
.ends

* Black-box entry subcircuit for sky130_fd_sc_hd__buf_2 abstract view
.subckt sky130_fd_sc_hd__buf_2 A VGND VNB VPB VPWR X
.ends

* Black-box entry subcircuit for sky130_fd_sc_hd__and4_2 abstract view
.subckt sky130_fd_sc_hd__and4_2 A B C D VGND VNB VPB VPWR X
.ends

* Black-box entry subcircuit for sky130_fd_sc_hd__nor3_2 abstract view
.subckt sky130_fd_sc_hd__nor3_2 A B C VGND VNB VPB VPWR Y
.ends

* Black-box entry subcircuit for sky130_fd_sc_hd__xor2_1 abstract view
.subckt sky130_fd_sc_hd__xor2_1 A B VGND VNB VPB VPWR X
.ends

* Black-box entry subcircuit for sky130_fd_sc_hd__conb_1 abstract view
.subckt sky130_fd_sc_hd__conb_1 VGND VNB VPB VPWR HI LO
.ends

* Black-box entry subcircuit for sky130_fd_sc_hd__o211a_1 abstract view
.subckt sky130_fd_sc_hd__o211a_1 A1 A2 B1 C1 VGND VNB VPB VPWR X
.ends

* Black-box entry subcircuit for sky130_fd_sc_hd__nand2_2 abstract view
.subckt sky130_fd_sc_hd__nand2_2 A B VGND VNB VPB VPWR Y
.ends

* Black-box entry subcircuit for sky130_fd_sc_hd__a21boi_1 abstract view
.subckt sky130_fd_sc_hd__a21boi_1 A1 A2 B1_N VGND VNB VPB VPWR Y
.ends

* Black-box entry subcircuit for sky130_fd_sc_hd__nor3_1 abstract view
.subckt sky130_fd_sc_hd__nor3_1 A B C VGND VNB VPB VPWR Y
.ends

* Black-box entry subcircuit for sky130_fd_sc_hd__o31a_1 abstract view
.subckt sky130_fd_sc_hd__o31a_1 A1 A2 A3 B1 VGND VNB VPB VPWR X
.ends

* Black-box entry subcircuit for sky130_fd_sc_hd__and4b_1 abstract view
.subckt sky130_fd_sc_hd__and4b_1 A_N B C D VGND VNB VPB VPWR X
.ends

* Black-box entry subcircuit for sky130_fd_sc_hd__and3b_1 abstract view
.subckt sky130_fd_sc_hd__and3b_1 A_N B C VGND VNB VPB VPWR X
.ends

* Black-box entry subcircuit for sky130_fd_sc_hd__or4_1 abstract view
.subckt sky130_fd_sc_hd__or4_1 A B C D VGND VNB VPB VPWR X
.ends

* Black-box entry subcircuit for sky130_fd_sc_hd__and4_4 abstract view
.subckt sky130_fd_sc_hd__and4_4 A B C D VGND VNB VPB VPWR X
.ends

* Black-box entry subcircuit for sky130_fd_sc_hd__and3_2 abstract view
.subckt sky130_fd_sc_hd__and3_2 A B C VGND VNB VPB VPWR X
.ends

* Black-box entry subcircuit for sky130_fd_sc_hd__clkbuf_8 abstract view
.subckt sky130_fd_sc_hd__clkbuf_8 A VGND VNB VPB VPWR X
.ends

* Black-box entry subcircuit for sky130_fd_sc_hd__diode_2 abstract view
.subckt sky130_fd_sc_hd__diode_2 DIODE VGND VNB VPB VPWR
.ends

* Black-box entry subcircuit for sky130_fd_sc_hd__nor2_2 abstract view
.subckt sky130_fd_sc_hd__nor2_2 A B VGND VNB VPB VPWR Y
.ends

.subckt TopModule VGND VPWR an[0] an[1] an[2] an[3] an[4] an[5] an[6] an[7] clk rst
+ seg[0] seg[1] seg[2] seg[3] seg[4] seg[5] seg[6]
XFILLER_0_27_82 VGND VGND VPWR VPWR sky130_fd_sc_hd__fill_2
X_294_ _155_ VGND VGND VPWR VPWR _034_ sky130_fd_sc_hd__inv_2
XTAP_TAPCELL_ROW_15_106 VGND VPWR sky130_fd_sc_hd__tapvpwrvgnd_1
XFILLER_0_3_39 VPWR VGND VPWR VGND sky130_ef_sc_hd__decap_12
X_346_ clknet_2_1__leaf_clk _016_ _052_ VGND VGND VPWR VPWR counter.one_second_counter\[23\]
+ sky130_fd_sc_hd__dfrtp_1
XTAP_TAPCELL_ROW_20_120 VGND VPWR sky130_fd_sc_hd__tapvpwrvgnd_1
XFILLER_0_18_29 VPWR VGND VPWR VGND sky130_ef_sc_hd__decap_12
X_277_ _147_ _146_ _082_ _071_ VGND VGND VPWR VPWR _152_ sky130_fd_sc_hd__a2bb2o_1
X_200_ counter.one_second_counter\[4\] _073_ counter.one_second_counter\[5\] VGND
+ VGND VPWR VPWR _096_ sky130_fd_sc_hd__a21oi_1
XFILLER_0_4_71 VGND VGND VPWR VPWR sky130_fd_sc_hd__fill_1
X_329_ clknet_2_3__leaf_clk _024_ _035_ VGND VGND VPWR VPWR counter.one_second_counter\[6\]
+ sky130_fd_sc_hd__dfrtp_2
XFILLER_0_0_29 VGND VGND VPWR VPWR sky130_fd_sc_hd__decap_8
XFILLER_0_9_27 VGND VGND VPWR VPWR sky130_fd_sc_hd__fill_2
XFILLER_0_10_41 VGND VGND VPWR VPWR sky130_fd_sc_hd__decap_4
XFILLER_0_10_85 VPWR VGND VPWR VGND sky130_ef_sc_hd__decap_12
XFILLER_0_19_169 VPWR VGND VPWR VGND sky130_ef_sc_hd__decap_12
XPHY_EDGE_ROW_8_Left_36 VGND VGND VPWR VPWR sky130_fd_sc_hd__decap_3
XFILLER_0_24_161 VGND VGND VPWR VPWR sky130_fd_sc_hd__fill_2
XFILLER_0_21_73 VPWR VGND VPWR VGND sky130_ef_sc_hd__decap_12
XFILLER_0_26_29 VPWR VGND VPWR VGND sky130_ef_sc_hd__decap_12
XFILLER_0_8_136 VGND VGND VPWR VPWR sky130_fd_sc_hd__decap_4
XFILLER_0_8_147 VPWR VGND VPWR VGND sky130_ef_sc_hd__decap_12
XFILLER_0_12_153 VPWR VGND VPWR VGND sky130_ef_sc_hd__decap_12
XTAP_TAPCELL_ROW_18_115 VGND VPWR sky130_fd_sc_hd__tapvpwrvgnd_1
Xoutput7 net7 VGND VGND VPWR VPWR seg[5] sky130_fd_sc_hd__buf_1
XPHY_EDGE_ROW_21_Left_49 VGND VGND VPWR VPWR sky130_fd_sc_hd__decap_3
XFILLER_0_2_109 VGND VGND VPWR VPWR sky130_fd_sc_hd__decap_4
X_293_ _155_ VGND VGND VPWR VPWR _033_ sky130_fd_sc_hd__inv_2
X_362_ net5 VGND VGND VPWR VPWR net2 sky130_fd_sc_hd__clkbuf_1
XTAP_TAPCELL_ROW_20_121 VGND VPWR sky130_fd_sc_hd__tapvpwrvgnd_1
XFILLER_0_18_19 VGND VGND VPWR VPWR sky130_fd_sc_hd__fill_2
X_345_ clknet_2_1__leaf_clk _015_ _051_ VGND VGND VPWR VPWR counter.one_second_counter\[22\]
+ sky130_fd_sc_hd__dfrtp_2
X_276_ _151_ VGND VGND VPWR VPWR _018_ sky130_fd_sc_hd__buf_1
XPHY_EDGE_ROW_21_Right_21 VGND VGND VPWR VPWR sky130_fd_sc_hd__decap_3
XPHY_EDGE_ROW_12_Right_12 VGND VGND VPWR VPWR sky130_fd_sc_hd__decap_3
X_259_ _083_ _138_ _139_ VGND VGND VPWR VPWR _140_ sky130_fd_sc_hd__and3_1
X_328_ clknet_2_2__leaf_clk _023_ _034_ VGND VGND VPWR VPWR counter.one_second_counter\[5\]
+ sky130_fd_sc_hd__dfrtp_1
XFILLER_0_27_181 VGND VGND VPWR VPWR sky130_fd_sc_hd__decap_6
XPHY_EDGE_ROW_24_Left_52 VGND VGND VPWR VPWR sky130_fd_sc_hd__decap_3
XFILLER_0_10_97 VGND VGND VPWR VPWR sky130_fd_sc_hd__decap_8
XFILLER_0_25_107 VGND VGND VPWR VPWR sky130_fd_sc_hd__decap_4
XFILLER_0_18_181 VGND VGND VPWR VPWR sky130_fd_sc_hd__decap_6
XFILLER_0_21_85 VGND VGND VPWR VPWR sky130_fd_sc_hd__fill_1
XFILLER_0_27_3 VPWR VGND VPWR VGND sky130_ef_sc_hd__decap_12
XFILLER_0_1_84 VGND VGND VPWR VPWR sky130_fd_sc_hd__decap_8
XFILLER_0_16_85 VPWR VGND VPWR VGND sky130_ef_sc_hd__decap_12
XFILLER_0_16_41 VPWR VGND VPWR VGND sky130_ef_sc_hd__decap_12
XFILLER_0_6_29 VPWR VGND VPWR VGND sky130_ef_sc_hd__decap_12
XFILLER_0_12_165 VPWR VGND VPWR VGND sky130_ef_sc_hd__decap_12
XPHY_EDGE_ROW_6_Right_6 VGND VGND VPWR VPWR sky130_fd_sc_hd__decap_3
XFILLER_0_8_159 VPWR VGND VPWR VGND sky130_ef_sc_hd__decap_12
Xoutput8 net8 VGND VGND VPWR VPWR seg[6] sky130_fd_sc_hd__buf_1
XFILLER_0_7_181 VGND VGND VPWR VPWR sky130_fd_sc_hd__decap_8
XTAP_TAPCELL_ROW_23_130 VGND VPWR sky130_fd_sc_hd__tapvpwrvgnd_1
X_292_ _155_ VGND VGND VPWR VPWR _032_ sky130_fd_sc_hd__inv_2
XFILLER_0_4_184 VGND VGND VPWR VPWR sky130_fd_sc_hd__decap_3
XFILLER_0_7_61 VGND VGND VPWR VPWR sky130_fd_sc_hd__fill_1
XFILLER_0_7_83 VGND VGND VPWR VPWR sky130_fd_sc_hd__decap_4
XFILLER_0_13_75 VGND VGND VPWR VPWR sky130_fd_sc_hd__decap_4
XFILLER_0_13_53 VGND VGND VPWR VPWR sky130_fd_sc_hd__decap_3
XFILLER_0_1_121 VGND VGND VPWR VPWR sky130_fd_sc_hd__decap_8
XFILLER_0_1_110 VGND VGND VPWR VPWR sky130_fd_sc_hd__fill_2
X_344_ clknet_2_1__leaf_clk _014_ _050_ VGND VGND VPWR VPWR counter.one_second_counter\[21\]
+ sky130_fd_sc_hd__dfrtp_2
X_275_ _083_ _149_ _150_ VGND VGND VPWR VPWR _151_ sky130_fd_sc_hd__and3_1
XFILLER_0_19_85 VGND VGND VPWR VPWR sky130_fd_sc_hd__fill_1
X_258_ counter.one_second_counter\[20\] _135_ VGND VGND VPWR VPWR _139_ sky130_fd_sc_hd__nand2_1
X_189_ counter.one_second_counter\[1\] counter.one_second_counter\[0\] counter.one_second_counter\[2\]
+ VGND VGND VPWR VPWR _088_ sky130_fd_sc_hd__a21o_1
X_327_ clknet_2_2__leaf_clk _022_ _033_ VGND VGND VPWR VPWR counter.one_second_counter\[4\]
+ sky130_fd_sc_hd__dfrtp_2
XFILLER_0_24_141 VPWR VGND VPWR VGND sky130_ef_sc_hd__decap_12
XFILLER_0_21_42 VGND VGND VPWR VPWR sky130_fd_sc_hd__decap_3
XFILLER_0_16_97 VPWR VGND VPWR VGND sky130_ef_sc_hd__decap_12
XFILLER_0_16_53 VGND VGND VPWR VPWR sky130_fd_sc_hd__decap_8
XFILLER_0_12_188 VGND VGND VPWR VPWR sky130_fd_sc_hd__fill_2
XFILLER_0_12_177 VGND VGND VPWR VPWR sky130_fd_sc_hd__fill_1
XFILLER_0_9_3 VPWR VGND VPWR VGND sky130_ef_sc_hd__decap_12
XFILLER_0_27_85 VGND VGND VPWR VPWR sky130_fd_sc_hd__decap_6
XFILLER_0_27_41 VPWR VGND VPWR VGND sky130_ef_sc_hd__decap_12
X_291_ _155_ VGND VGND VPWR VPWR _031_ sky130_fd_sc_hd__inv_2
XFILLER_0_4_152 VPWR VGND VPWR VGND sky130_ef_sc_hd__decap_12
XFILLER_0_13_21 VPWR VGND VPWR VGND sky130_ef_sc_hd__decap_12
XFILLER_0_1_155 VGND VGND VPWR VPWR sky130_fd_sc_hd__decap_3
X_343_ clknet_2_0__leaf_clk _013_ _049_ VGND VGND VPWR VPWR counter.one_second_counter\[20\]
+ sky130_fd_sc_hd__dfrtp_2
X_274_ _147_ _071_ _146_ VGND VGND VPWR VPWR _150_ sky130_fd_sc_hd__or3_1
XFILLER_0_4_85 VPWR VGND VPWR VGND sky130_ef_sc_hd__decap_12
X_257_ counter.one_second_counter\[20\] _135_ VGND VGND VPWR VPWR _138_ sky130_fd_sc_hd__or2_1
X_188_ counter.one_second_counter\[2\] counter.one_second_counter\[1\] counter.one_second_counter\[0\]
+ VGND VGND VPWR VPWR _087_ sky130_fd_sc_hd__nand3_1
X_326_ clknet_2_2__leaf_clk _021_ _032_ VGND VGND VPWR VPWR counter.one_second_counter\[3\]
+ sky130_fd_sc_hd__dfrtp_1
XFILLER_0_16_109 VGND VGND VPWR VPWR sky130_fd_sc_hd__fill_1
X_309_ net1 VGND VGND VPWR VPWR _157_ sky130_fd_sc_hd__buf_4
XFILLER_0_24_153 VGND VGND VPWR VPWR sky130_fd_sc_hd__decap_8
XFILLER_0_21_189 VGND VGND VPWR VPWR sky130_fd_sc_hd__fill_1
XFILLER_0_21_167 VGND VGND VPWR VPWR sky130_fd_sc_hd__fill_1
XTAP_TAPCELL_ROW_10_90 VGND VPWR sky130_fd_sc_hd__tapvpwrvgnd_1
XFILLER_0_8_117 VGND VGND VPWR VPWR sky130_fd_sc_hd__fill_1
XFILLER_0_4_164 VPWR VGND VPWR VGND sky130_ef_sc_hd__decap_12
XFILLER_0_13_33 VPWR VGND VPWR VGND sky130_ef_sc_hd__decap_12
X_290_ _155_ VGND VGND VPWR VPWR _030_ sky130_fd_sc_hd__inv_2
XTAP_TAPCELL_ROW_3_70 VGND VPWR sky130_fd_sc_hd__tapvpwrvgnd_1
X_273_ counter.one_second_counter\[24\] _126_ _145_ counter.one_second_counter\[25\]
+ VGND VGND VPWR VPWR _149_ sky130_fd_sc_hd__a31o_1
X_342_ clknet_2_0__leaf_clk _011_ _048_ VGND VGND VPWR VPWR counter.one_second_counter\[19\]
+ sky130_fd_sc_hd__dfrtp_2
XFILLER_0_4_42 VPWR VGND VPWR VGND sky130_ef_sc_hd__decap_12
XFILLER_0_4_97 VGND VGND VPWR VPWR sky130_fd_sc_hd__fill_2
XTAP_TAPCELL_ROW_0_60 VGND VPWR sky130_fd_sc_hd__tapvpwrvgnd_1
X_187_ _086_ VGND VGND VPWR VPWR _012_ sky130_fd_sc_hd__clkbuf_1
X_256_ _137_ VGND VGND VPWR VPWR _011_ sky130_fd_sc_hd__clkbuf_1
XFILLER_0_10_45 VGND VGND VPWR VPWR sky130_fd_sc_hd__fill_1
X_325_ clknet_2_2__leaf_clk _020_ _031_ VGND VGND VPWR VPWR counter.one_second_counter\[2\]
+ sky130_fd_sc_hd__dfrtp_2
Xclkload0 clknet_2_0__leaf_clk VGND VGND VPWR VPWR clkload0/Y sky130_fd_sc_hd__bufinv_16
XFILLER_0_24_132 VGND VGND VPWR VPWR sky130_fd_sc_hd__decap_8
X_239_ counter.one_second_counter\[10\] counter.one_second_counter\[11\] _076_ _106_
+ VGND VGND VPWR VPWR _125_ sky130_fd_sc_hd__and4_1
X_308_ _156_ VGND VGND VPWR VPWR _047_ sky130_fd_sc_hd__inv_2
XFILLER_0_1_98 VPWR VGND VPWR VGND sky130_ef_sc_hd__decap_12
XFILLER_0_1_21 VGND VGND VPWR VPWR sky130_fd_sc_hd__fill_2
XFILLER_0_15_176 VPWR VGND VPWR VGND sky130_ef_sc_hd__decap_12
XFILLER_0_15_121 VGND VGND VPWR VPWR sky130_fd_sc_hd__fill_2
XTAP_TAPCELL_ROW_10_91 VGND VPWR sky130_fd_sc_hd__tapvpwrvgnd_1
XFILLER_0_21_113 VPWR VGND VPWR VGND sky130_ef_sc_hd__decap_12
XFILLER_0_12_113 VGND VGND VPWR VPWR sky130_fd_sc_hd__decap_3
XPHY_EDGE_ROW_19_Right_19 VGND VGND VPWR VPWR sky130_fd_sc_hd__decap_3
XPHY_EDGE_ROW_15_Left_43 VGND VGND VPWR VPWR sky130_fd_sc_hd__decap_3
XFILLER_0_4_176 VGND VGND VPWR VPWR sky130_fd_sc_hd__decap_8
XFILLER_0_11_9 VGND VGND VPWR VPWR sky130_fd_sc_hd__fill_1
XFILLER_0_13_45 VGND VGND VPWR VPWR sky130_fd_sc_hd__decap_8
XFILLER_0_1_135 VPWR VGND VPWR VGND sky130_ef_sc_hd__decap_12
X_341_ clknet_2_3__leaf_clk _010_ _047_ VGND VGND VPWR VPWR counter.one_second_counter\[18\]
+ sky130_fd_sc_hd__dfrtp_4
X_272_ _000_ _148_ VGND VGND VPWR VPWR _017_ sky130_fd_sc_hd__nor2_1
XPHY_EDGE_ROW_0_Left_28 VGND VGND VPWR VPWR sky130_fd_sc_hd__decap_3
XFILLER_0_4_54 VGND VGND VPWR VPWR sky130_fd_sc_hd__decap_8
X_324_ clknet_2_1__leaf_clk _012_ _030_ VGND VGND VPWR VPWR counter.one_second_counter\[1\]
+ sky130_fd_sc_hd__dfrtp_4
X_255_ _083_ _133_ _136_ VGND VGND VPWR VPWR _137_ sky130_fd_sc_hd__and3_1
X_186_ _084_ _083_ _085_ VGND VGND VPWR VPWR _086_ sky130_fd_sc_hd__and3_1
XFILLER_0_27_141 VGND VGND VPWR VPWR sky130_fd_sc_hd__decap_4
XTAP_TAPCELL_ROW_0_61 VGND VPWR sky130_fd_sc_hd__tapvpwrvgnd_1
Xclkload1 clknet_2_1__leaf_clk VGND VGND VPWR VPWR clkload1/Y sky130_fd_sc_hd__clkinv_2
XFILLER_0_18_141 VPWR VGND VPWR VGND sky130_ef_sc_hd__decap_12
XFILLER_0_18_130 VGND VGND VPWR VPWR sky130_fd_sc_hd__decap_8
XPHY_EDGE_ROW_3_Left_31 VGND VGND VPWR VPWR sky130_fd_sc_hd__decap_3
X_307_ _156_ VGND VGND VPWR VPWR _046_ sky130_fd_sc_hd__inv_2
XFILLER_0_24_188 VGND VGND VPWR VPWR sky130_fd_sc_hd__fill_2
XFILLER_0_21_34 VGND VGND VPWR VPWR sky130_fd_sc_hd__decap_8
X_238_ counter.one_second_counter\[15\] VGND VGND VPWR VPWR _124_ sky130_fd_sc_hd__inv_2
XFILLER_0_1_44 VPWR VGND VPWR VGND sky130_ef_sc_hd__decap_12
X_169_ counter.one_second_counter\[25\] VGND VGND VPWR VPWR _071_ sky130_fd_sc_hd__inv_2
XFILLER_0_15_188 VGND VGND VPWR VPWR sky130_fd_sc_hd__fill_2
XFILLER_0_15_166 VGND VGND VPWR VPWR sky130_fd_sc_hd__fill_2
XFILLER_0_15_111 VGND VGND VPWR VPWR sky130_fd_sc_hd__fill_1
XFILLER_0_21_169 VPWR VGND VPWR VGND sky130_ef_sc_hd__decap_12
XFILLER_0_21_125 VPWR VGND VPWR VGND sky130_ef_sc_hd__decap_12
XFILLER_0_18_3 VGND VGND VPWR VPWR sky130_fd_sc_hd__decap_8
XFILLER_0_4_122 VPWR VGND VPWR VGND sky130_ef_sc_hd__decap_12
XFILLER_0_7_54 VGND VGND VPWR VPWR sky130_fd_sc_hd__fill_2
XFILLER_0_7_3 VPWR VGND VPWR VGND sky130_ef_sc_hd__decap_12
XFILLER_0_13_79 VGND VGND VPWR VPWR sky130_fd_sc_hd__fill_1
XFILLER_0_13_57 VPWR VGND VPWR VGND sky130_ef_sc_hd__decap_12
XTAP_TAPCELL_ROW_14_101 VGND VPWR sky130_fd_sc_hd__tapvpwrvgnd_1
XFILLER_0_1_147 VGND VGND VPWR VPWR sky130_fd_sc_hd__decap_8
X_340_ clknet_2_3__leaf_clk _009_ _046_ VGND VGND VPWR VPWR counter.one_second_counter\[17\]
+ sky130_fd_sc_hd__dfrtp_4
X_271_ _147_ _146_ VGND VGND VPWR VPWR _148_ sky130_fd_sc_hd__xnor2_1
X_323_ clknet_2_3__leaf_clk _001_ _029_ VGND VGND VPWR VPWR counter.one_second_counter\[0\]
+ sky130_fd_sc_hd__dfrtp_4
X_185_ counter.one_second_counter\[1\] counter.one_second_counter\[0\] VGND VGND VPWR
+ VPWR _085_ sky130_fd_sc_hd__or2_1
X_254_ _135_ VGND VGND VPWR VPWR _136_ sky130_fd_sc_hd__inv_2
XFILLER_0_10_69 VPWR VGND VPWR VGND sky130_ef_sc_hd__decap_12
XFILLER_0_18_153 VGND VGND VPWR VPWR sky130_fd_sc_hd__fill_1
XFILLER_0_18_120 VGND VGND VPWR VPWR sky130_fd_sc_hd__decap_6
Xclkload2 clknet_2_2__leaf_clk VGND VGND VPWR VPWR clkload2/X sky130_fd_sc_hd__clkbuf_4
XFILLER_0_24_178 VGND VGND VPWR VPWR sky130_fd_sc_hd__decap_4
XFILLER_0_21_57 VGND VGND VPWR VPWR sky130_fd_sc_hd__fill_1
X_168_ counter.one_second_enable counter.count\[0\] _070_ VGND VGND VPWR VPWR _060_
+ sky130_fd_sc_hd__o21a_1
X_237_ _123_ VGND VGND VPWR VPWR _006_ sky130_fd_sc_hd__buf_1
X_306_ _156_ VGND VGND VPWR VPWR _045_ sky130_fd_sc_hd__inv_2
XFILLER_0_21_137 VPWR VGND VPWR VGND sky130_ef_sc_hd__decap_12
XPHY_EDGE_ROW_1_Right_1 VGND VGND VPWR VPWR sky130_fd_sc_hd__decap_3
XFILLER_0_7_142 VPWR VGND VPWR VGND sky130_ef_sc_hd__decap_12
XFILLER_0_27_78 VGND VGND VPWR VPWR sky130_fd_sc_hd__fill_1
XTAP_TAPCELL_ROW_17_110 VGND VPWR sky130_fd_sc_hd__tapvpwrvgnd_1
XFILLER_0_4_134 VGND VGND VPWR VPWR sky130_fd_sc_hd__decap_6
XTAP_TAPCELL_ROW_14_102 VGND VPWR sky130_fd_sc_hd__tapvpwrvgnd_1
XFILLER_0_13_69 VGND VGND VPWR VPWR sky130_fd_sc_hd__decap_3
XFILLER_0_0_181 VGND VGND VPWR VPWR sky130_fd_sc_hd__decap_6
X_270_ counter.one_second_counter\[24\] VGND VGND VPWR VPWR _147_ sky130_fd_sc_hd__inv_2
XFILLER_0_24_35 VPWR VGND VPWR VGND sky130_ef_sc_hd__decap_12
XFILLER_0_4_67 VGND VGND VPWR VPWR sky130_fd_sc_hd__decap_4
X_322_ clknet_2_0__leaf_clk _000_ _028_ VGND VGND VPWR VPWR counter.one_second_enable
+ sky130_fd_sc_hd__dfrtp_4
XFILLER_0_27_154 VPWR VGND VPWR VGND sky130_ef_sc_hd__decap_12
XFILLER_0_19_24 VPWR VGND VPWR VGND sky130_ef_sc_hd__decap_12
X_253_ _126_ _134_ VGND VGND VPWR VPWR _135_ sky130_fd_sc_hd__and2_2
X_184_ counter.one_second_counter\[1\] counter.one_second_counter\[0\] VGND VGND VPWR
+ VPWR _084_ sky130_fd_sc_hd__nand2_1
XFILLER_0_10_15 VPWR VGND VPWR VGND sky130_ef_sc_hd__decap_12
X_167_ counter.one_second_enable counter.count\[0\] _067_ VGND VGND VPWR VPWR _070_
+ sky130_fd_sc_hd__a21oi_1
X_236_ _092_ _121_ _122_ VGND VGND VPWR VPWR _123_ sky130_fd_sc_hd__and3_1
X_305_ _156_ VGND VGND VPWR VPWR _044_ sky130_fd_sc_hd__inv_2
XFILLER_0_15_146 VPWR VGND VPWR VGND sky130_ef_sc_hd__decap_12
XFILLER_0_15_113 VGND VGND VPWR VPWR sky130_fd_sc_hd__decap_8
XFILLER_0_1_13 VGND VGND VPWR VPWR sky130_fd_sc_hd__decap_8
XFILLER_0_21_149 VPWR VGND VPWR VGND sky130_ef_sc_hd__decap_12
XFILLER_0_12_105 VGND VGND VPWR VPWR sky130_fd_sc_hd__decap_8
X_219_ counter.one_second_counter\[10\] _106_ VGND VGND VPWR VPWR _110_ sky130_fd_sc_hd__nand2_1
XFILLER_0_22_90 VGND VGND VPWR VPWR sky130_fd_sc_hd__decap_4
XFILLER_0_7_110 VGND VGND VPWR VPWR sky130_fd_sc_hd__fill_2
XFILLER_0_7_154 VPWR VGND VPWR VGND sky130_ef_sc_hd__decap_12
XTAP_TAPCELL_ROW_17_111 VGND VPWR sky130_fd_sc_hd__tapvpwrvgnd_1
Xclkbuf_0_clk clk VGND VGND VPWR VPWR clknet_0_clk sky130_fd_sc_hd__clkbuf_16
XPHY_EDGE_ROW_24_Right_24 VGND VGND VPWR VPWR sky130_fd_sc_hd__decap_3
XFILLER_0_23_3 VGND VGND VPWR VPWR sky130_fd_sc_hd__decap_8
XPHY_EDGE_ROW_15_Right_15 VGND VGND VPWR VPWR sky130_fd_sc_hd__decap_3
XTAP_TAPCELL_ROW_14_103 VGND VPWR sky130_fd_sc_hd__tapvpwrvgnd_1
XPHY_EDGE_ROW_19_Left_47 VGND VGND VPWR VPWR sky130_fd_sc_hd__decap_3
XFILLER_0_24_47 VGND VGND VPWR VPWR sky130_fd_sc_hd__decap_6
X_252_ counter.one_second_counter\[19\] counter.one_second_counter\[18\] counter.one_second_counter\[17\]
+ counter.one_second_counter\[16\] VGND VGND VPWR VPWR _134_ sky130_fd_sc_hd__and4_1
XFILLER_0_19_36 VPWR VGND VPWR VGND sky130_ef_sc_hd__decap_12
X_321_ net1 VGND VGND VPWR VPWR _059_ sky130_fd_sc_hd__inv_2
X_183_ counter.one_second_counter\[0\] _000_ VGND VGND VPWR VPWR _001_ sky130_fd_sc_hd__nor2_1
XFILLER_0_10_27 VGND VGND VPWR VPWR sky130_fd_sc_hd__fill_1
XFILLER_0_27_166 VGND VGND VPWR VPWR sky130_fd_sc_hd__fill_2
X_235_ counter.one_second_counter\[14\] counter.one_second_counter\[13\] _117_ VGND
+ VGND VPWR VPWR _122_ sky130_fd_sc_hd__nand3_1
XFILLER_0_21_48 VGND VGND VPWR VPWR sky130_fd_sc_hd__decap_8
X_304_ _156_ VGND VGND VPWR VPWR _043_ sky130_fd_sc_hd__inv_2
XFILLER_0_15_169 VGND VGND VPWR VPWR sky130_fd_sc_hd__fill_1
XFILLER_0_15_158 VGND VGND VPWR VPWR sky130_fd_sc_hd__fill_2
X_166_ _064_ _069_ VGND VGND VPWR VPWR _061_ sky130_fd_sc_hd__nor2_1
XPHY_EDGE_ROW_7_Left_35 VGND VGND VPWR VPWR sky130_fd_sc_hd__decap_3
XFILLER_0_16_15 VPWR VGND VPWR VGND sky130_ef_sc_hd__decap_12
XFILLER_0_12_139 VGND VGND VPWR VPWR sky130_fd_sc_hd__fill_1
X_218_ counter.one_second_counter\[10\] _106_ VGND VGND VPWR VPWR _109_ sky130_fd_sc_hd__or2_1
XFILLER_0_22_80 VGND VGND VPWR VPWR sky130_fd_sc_hd__decap_4
XFILLER_0_7_166 VGND VGND VPWR VPWR sky130_fd_sc_hd__fill_2
XTAP_TAPCELL_ROW_17_112 VGND VPWR sky130_fd_sc_hd__tapvpwrvgnd_1
XFILLER_0_17_91 VPWR VGND VPWR VGND sky130_ef_sc_hd__decap_12
XFILLER_0_16_3 VPWR VGND VPWR VGND sky130_ef_sc_hd__decap_12
XFILLER_0_7_57 VGND VGND VPWR VPWR sky130_fd_sc_hd__decap_4
XPHY_EDGE_ROW_20_Left_48 VGND VGND VPWR VPWR sky130_fd_sc_hd__decap_3
Xclkbuf_2_0__f_clk clknet_0_clk VGND VGND VPWR VPWR clknet_2_0__leaf_clk sky130_fd_sc_hd__clkbuf_16
XFILLER_0_5_3 VPWR VGND VPWR VGND sky130_ef_sc_hd__decap_12
XFILLER_0_19_48 VGND VGND VPWR VPWR sky130_fd_sc_hd__decap_4
XFILLER_0_19_15 VGND VGND VPWR VPWR sky130_fd_sc_hd__decap_6
X_251_ counter.one_second_counter\[18\] counter.one_second_counter\[17\] counter.one_second_counter\[16\]
+ _126_ counter.one_second_counter\[19\] VGND VGND VPWR VPWR _133_ sky130_fd_sc_hd__a41o_1
X_320_ net1 VGND VGND VPWR VPWR _058_ sky130_fd_sc_hd__inv_2
X_182_ _083_ VGND VGND VPWR VPWR _000_ sky130_fd_sc_hd__clkinv_4
XFILLER_0_24_104 VPWR VGND VPWR VGND sky130_ef_sc_hd__decap_12
XPHY_EDGE_ROW_23_Left_51 VGND VGND VPWR VPWR sky130_fd_sc_hd__decap_3
XFILLER_0_1_26 VPWR VGND VPWR VGND sky130_ef_sc_hd__decap_12
X_234_ counter.one_second_counter\[12\] counter.one_second_counter\[13\] _113_ counter.one_second_counter\[14\]
+ VGND VGND VPWR VPWR _121_ sky130_fd_sc_hd__a31o_1
X_303_ _156_ VGND VGND VPWR VPWR _042_ sky130_fd_sc_hd__inv_2
X_165_ counter.one_second_enable counter.count\[0\] counter.count\[1\] VGND VGND VPWR
+ VPWR _069_ sky130_fd_sc_hd__a21oi_1
XFILLER_0_23_181 VGND VGND VPWR VPWR sky130_fd_sc_hd__decap_3
X_217_ _108_ VGND VGND VPWR VPWR _027_ sky130_fd_sc_hd__buf_1
XFILLER_0_16_27 VGND VGND VPWR VPWR sky130_fd_sc_hd__fill_1
XFILLER_0_7_189 VGND VGND VPWR VPWR sky130_fd_sc_hd__fill_1
XFILLER_0_11_162 VGND VGND VPWR VPWR sky130_fd_sc_hd__decap_6
XFILLER_0_27_15 VPWR VGND VPWR VGND sky130_ef_sc_hd__decap_12
XFILLER_0_3_181 VGND VGND VPWR VPWR sky130_fd_sc_hd__decap_8
XPHY_EDGE_ROW_5_Right_5 VGND VGND VPWR VPWR sky130_fd_sc_hd__decap_3
XFILLER_0_1_129 VGND VGND VPWR VPWR sky130_fd_sc_hd__fill_1
XTAP_TAPCELL_ROW_20_119 VGND VPWR sky130_fd_sc_hd__tapvpwrvgnd_1
XFILLER_0_24_27 VGND VGND VPWR VPWR sky130_fd_sc_hd__fill_1
XFILLER_0_4_15 VPWR VGND VPWR VGND sky130_ef_sc_hd__decap_12
XFILLER_0_4_37 VGND VGND VPWR VPWR sky130_fd_sc_hd__fill_2
X_250_ _131_ _128_ _132_ counter.one_second_counter\[18\] _092_ VGND VGND VPWR VPWR
+ _010_ sky130_fd_sc_hd__o221a_1
X_181_ _071_ _082_ counter.one_second_counter\[26\] VGND VGND VPWR VPWR _083_ sky130_fd_sc_hd__a21bo_4
XFILLER_0_10_29 VPWR VGND VPWR VGND sky130_ef_sc_hd__decap_12
XFILLER_0_27_113 VPWR VGND VPWR VGND sky130_ef_sc_hd__decap_12
XTAP_TAPCELL_ROW_9_86 VGND VPWR sky130_fd_sc_hd__tapvpwrvgnd_1
XFILLER_0_25_70 VGND VGND VPWR VPWR sky130_fd_sc_hd__fill_1
XFILLER_0_18_157 VPWR VGND VPWR VGND sky130_ef_sc_hd__decap_12
X_164_ counter.one_second_enable _067_ _068_ _065_ VGND VGND VPWR VPWR _062_ sky130_fd_sc_hd__a211oi_1
XFILLER_0_24_116 VGND VGND VPWR VPWR sky130_fd_sc_hd__decap_6
X_302_ _156_ VGND VGND VPWR VPWR _041_ sky130_fd_sc_hd__inv_2
X_233_ _120_ VGND VGND VPWR VPWR _005_ sky130_fd_sc_hd__clkbuf_1
XFILLER_0_1_38 VGND VGND VPWR VPWR sky130_fd_sc_hd__fill_1
XFILLER_0_20_185 VGND VGND VPWR VPWR sky130_fd_sc_hd__fill_2
XFILLER_0_20_141 VGND VGND VPWR VPWR sky130_fd_sc_hd__fill_1
XFILLER_0_7_102 VGND VGND VPWR VPWR sky130_fd_sc_hd__decap_8
XFILLER_0_7_113 VPWR VGND VPWR VGND sky130_ef_sc_hd__decap_12
X_216_ _092_ _105_ _107_ VGND VGND VPWR VPWR _108_ sky130_fd_sc_hd__and3_1
XFILLER_0_11_130 VPWR VGND VPWR VGND sky130_ef_sc_hd__decap_12
XFILLER_0_27_27 VGND VGND VPWR VPWR sky130_fd_sc_hd__fill_1
XFILLER_0_7_15 VPWR VGND VPWR VGND sky130_ef_sc_hd__decap_12
XTAP_TAPCELL_ROW_23_128 VGND VPWR sky130_fd_sc_hd__tapvpwrvgnd_1
XPHY_EDGE_ROW_20_Right_20 VGND VGND VPWR VPWR sky130_fd_sc_hd__decap_3
XPHY_EDGE_ROW_11_Right_11 VGND VGND VPWR VPWR sky130_fd_sc_hd__decap_3
XFILLER_0_0_141 VPWR VGND VPWR VGND sky130_ef_sc_hd__decap_12
XFILLER_0_14_83 VGND VGND VPWR VPWR sky130_fd_sc_hd__fill_1
XFILLER_0_4_27 VGND VGND VPWR VPWR sky130_fd_sc_hd__fill_1
X_180_ _072_ _080_ _081_ counter.one_second_counter\[24\] VGND VGND VPWR VPWR _082_
+ sky130_fd_sc_hd__o211ai_4
XFILLER_0_27_169 VPWR VGND VPWR VGND sky130_ef_sc_hd__decap_12
XFILLER_0_27_125 VPWR VGND VPWR VGND sky130_ef_sc_hd__decap_12
XTAP_TAPCELL_ROW_0_56 VGND VPWR sky130_fd_sc_hd__tapvpwrvgnd_1
XTAP_TAPCELL_ROW_9_87 VGND VPWR sky130_fd_sc_hd__tapvpwrvgnd_1
XFILLER_0_18_169 VPWR VGND VPWR VGND sky130_ef_sc_hd__decap_12
X_163_ counter.count\[2\] _064_ VGND VGND VPWR VPWR _068_ sky130_fd_sc_hd__nor2_1
X_301_ _156_ VGND VGND VPWR VPWR _040_ sky130_fd_sc_hd__inv_2
X_232_ _092_ _118_ _119_ VGND VGND VPWR VPWR _120_ sky130_fd_sc_hd__and3_1
XFILLER_0_11_84 VGND VGND VPWR VPWR sky130_fd_sc_hd__fill_2
XFILLER_0_21_109 VGND VGND VPWR VPWR sky130_fd_sc_hd__decap_3
XFILLER_0_16_29 VPWR VGND VPWR VGND sky130_ef_sc_hd__decap_12
XFILLER_0_14_183 VGND VGND VPWR VPWR sky130_fd_sc_hd__fill_1
X_215_ _106_ VGND VGND VPWR VPWR _107_ sky130_fd_sc_hd__inv_2
XTAP_TAPCELL_ROW_6_77 VGND VPWR sky130_fd_sc_hd__tapvpwrvgnd_1
XTAP_TAPCELL_ROW_26_137 VGND VPWR sky130_fd_sc_hd__tapvpwrvgnd_1
XFILLER_0_22_94 VGND VGND VPWR VPWR sky130_fd_sc_hd__fill_1
XFILLER_0_2_60 VGND VGND VPWR VPWR sky130_fd_sc_hd__decap_3
XFILLER_0_7_125 VGND VGND VPWR VPWR sky130_fd_sc_hd__decap_6
XFILLER_0_7_169 VPWR VGND VPWR VGND sky130_ef_sc_hd__decap_12
XFILLER_0_11_142 VGND VGND VPWR VPWR sky130_fd_sc_hd__decap_4
XFILLER_0_11_153 VGND VGND VPWR VPWR sky130_fd_sc_hd__decap_6
XFILLER_0_7_27 VGND VGND VPWR VPWR sky130_fd_sc_hd__decap_6
XTAP_TAPCELL_ROW_23_129 VGND VPWR sky130_fd_sc_hd__tapvpwrvgnd_1
XFILLER_0_0_153 VPWR VGND VPWR VGND sky130_ef_sc_hd__decap_12
XFILLER_0_14_3 VPWR VGND VPWR VGND sky130_ef_sc_hd__decap_12
XFILLER_0_24_29 VGND VGND VPWR VPWR sky130_fd_sc_hd__decap_3
XFILLER_0_14_73 VGND VGND VPWR VPWR sky130_fd_sc_hd__fill_1
XTAP_TAPCELL_ROW_13_98 VGND VPWR sky130_fd_sc_hd__tapvpwrvgnd_1
XFILLER_0_27_137 VGND VGND VPWR VPWR sky130_fd_sc_hd__decap_3
XTAP_TAPCELL_ROW_0_57 VGND VPWR sky130_fd_sc_hd__tapvpwrvgnd_1
XFILLER_0_3_3 VGND VGND VPWR VPWR sky130_fd_sc_hd__decap_6
XTAP_TAPCELL_ROW_9_88 VGND VPWR sky130_fd_sc_hd__tapvpwrvgnd_1
XFILLER_0_25_61 VGND VGND VPWR VPWR sky130_fd_sc_hd__fill_1
XFILLER_0_18_126 VGND VGND VPWR VPWR sky130_fd_sc_hd__fill_1
X_162_ counter.count\[2\] _066_ VGND VGND VPWR VPWR _067_ sky130_fd_sc_hd__and2_1
X_231_ counter.one_second_counter\[13\] _117_ VGND VGND VPWR VPWR _119_ sky130_fd_sc_hd__nand2_1
XFILLER_0_17_181 VGND VGND VPWR VPWR sky130_fd_sc_hd__decap_8
X_300_ _156_ VGND VGND VPWR VPWR _039_ sky130_fd_sc_hd__inv_2
XFILLER_0_15_107 VGND VGND VPWR VPWR sky130_fd_sc_hd__decap_4
Xinput1 rst VGND VGND VPWR VPWR net1 sky130_fd_sc_hd__buf_2
XPHY_EDGE_ROW_27_Left_55 VGND VGND VPWR VPWR sky130_fd_sc_hd__decap_3
XFILLER_0_20_165 VPWR VGND VPWR VGND sky130_ef_sc_hd__decap_12
X_214_ counter.one_second_counter\[9\] counter.one_second_counter\[8\] _073_ _074_
+ VGND VGND VPWR VPWR _106_ sky130_fd_sc_hd__and4_2
XTAP_TAPCELL_ROW_6_78 VGND VPWR sky130_fd_sc_hd__tapvpwrvgnd_1
XPHY_EDGE_ROW_11_Left_39 VGND VGND VPWR VPWR sky130_fd_sc_hd__decap_3
XTAP_TAPCELL_ROW_26_138 VGND VPWR sky130_fd_sc_hd__tapvpwrvgnd_1
XFILLER_0_27_29 VPWR VGND VPWR VGND sky130_ef_sc_hd__decap_12
XFILLER_0_17_40 VPWR VGND VPWR VGND sky130_ef_sc_hd__decap_12
XTAP_TAPCELL_ROW_3_68 VGND VPWR sky130_fd_sc_hd__tapvpwrvgnd_1
XFILLER_0_0_110 VGND VGND VPWR VPWR sky130_fd_sc_hd__fill_2
XPHY_EDGE_ROW_9_Right_9 VGND VGND VPWR VPWR sky130_fd_sc_hd__decap_3
XPHY_EDGE_ROW_14_Left_42 VGND VGND VPWR VPWR sky130_fd_sc_hd__decap_3
XFILLER_0_0_165 VGND VGND VPWR VPWR sky130_fd_sc_hd__decap_3
XFILLER_0_8_82 VGND VGND VPWR VPWR sky130_fd_sc_hd__fill_2
XFILLER_0_24_19 VGND VGND VPWR VPWR sky130_fd_sc_hd__decap_8
XFILLER_0_4_29 VGND VGND VPWR VPWR sky130_fd_sc_hd__decap_8
XTAP_TAPCELL_ROW_13_99 VGND VPWR sky130_fd_sc_hd__tapvpwrvgnd_1
XFILLER_0_14_85 VPWR VGND VPWR VGND sky130_ef_sc_hd__decap_12
XFILLER_0_14_41 VGND VGND VPWR VPWR sky130_fd_sc_hd__decap_8
XTAP_TAPCELL_ROW_0_58 VGND VPWR sky130_fd_sc_hd__tapvpwrvgnd_1
XFILLER_0_25_51 VGND VGND VPWR VPWR sky130_fd_sc_hd__decap_4
XFILLER_0_18_138 VGND VGND VPWR VPWR sky130_fd_sc_hd__fill_2
X_161_ counter.count\[3\] counter.count\[1\] counter.count\[0\] VGND VGND VPWR VPWR
+ _066_ sky130_fd_sc_hd__nor3_2
X_230_ counter.one_second_counter\[13\] _117_ VGND VGND VPWR VPWR _118_ sky130_fd_sc_hd__or2_1
XFILLER_0_5_94 VGND VGND VPWR VPWR sky130_fd_sc_hd__fill_1
XFILLER_0_14_141 VPWR VGND VPWR VGND sky130_ef_sc_hd__decap_12
XTAP_TAPCELL_ROW_10_89 VGND VPWR sky130_fd_sc_hd__tapvpwrvgnd_1
XFILLER_0_20_177 VGND VGND VPWR VPWR sky130_fd_sc_hd__decap_8
X_213_ counter.one_second_counter\[8\] _073_ _074_ counter.one_second_counter\[9\]
+ VGND VGND VPWR VPWR _105_ sky130_fd_sc_hd__a31o_1
XPHY_EDGE_ROW_2_Left_30 VGND VGND VPWR VPWR sky130_fd_sc_hd__decap_3
XTAP_TAPCELL_ROW_6_79 VGND VPWR sky130_fd_sc_hd__tapvpwrvgnd_1
XFILLER_0_22_41 VGND VGND VPWR VPWR sky130_fd_sc_hd__decap_4
XFILLER_0_11_111 VGND VGND VPWR VPWR sky130_fd_sc_hd__fill_1
XTAP_TAPCELL_ROW_26_139 VGND VPWR sky130_fd_sc_hd__tapvpwrvgnd_1
XFILLER_0_2_40 VPWR VGND VPWR VGND sky130_ef_sc_hd__decap_12
XFILLER_0_17_63 VGND VGND VPWR VPWR sky130_fd_sc_hd__fill_1
XFILLER_0_17_52 VGND VGND VPWR VPWR sky130_fd_sc_hd__decap_4
XTAP_TAPCELL_ROW_3_69 VGND VPWR sky130_fd_sc_hd__tapvpwrvgnd_1
XFILLER_0_8_61 VGND VGND VPWR VPWR sky130_fd_sc_hd__decap_8
XFILLER_0_14_97 VGND VGND VPWR VPWR sky130_fd_sc_hd__decap_8
XTAP_TAPCELL_ROW_0_59 VGND VPWR sky130_fd_sc_hd__tapvpwrvgnd_1
XFILLER_0_26_150 VGND VGND VPWR VPWR sky130_fd_sc_hd__decap_3
XFILLER_0_5_40 VPWR VGND VPWR VGND sky130_ef_sc_hd__decap_12
X_160_ counter.count\[3\] _065_ VGND VGND VPWR VPWR _063_ sky130_fd_sc_hd__xor2_1
XTopModule_9 VGND VGND VPWR VPWR TopModule_9/HI an[0] sky130_fd_sc_hd__conb_1
XPHY_EDGE_ROW_27_Right_27 VGND VGND VPWR VPWR sky130_fd_sc_hd__decap_3
XFILLER_0_23_153 VPWR VGND VPWR VGND sky130_ef_sc_hd__decap_12
XPHY_EDGE_ROW_18_Right_18 VGND VGND VPWR VPWR sky130_fd_sc_hd__decap_3
X_289_ _155_ VGND VGND VPWR VPWR _029_ sky130_fd_sc_hd__inv_2
XFILLER_0_11_54 VGND VGND VPWR VPWR sky130_fd_sc_hd__fill_2
X_212_ _104_ VGND VGND VPWR VPWR _026_ sky130_fd_sc_hd__clkbuf_1
XFILLER_0_14_153 VPWR VGND VPWR VGND sky130_ef_sc_hd__decap_12
XFILLER_0_11_178 VPWR VGND VPWR VGND sky130_ef_sc_hd__decap_12
XFILLER_0_2_85 VPWR VGND VPWR VGND sky130_ef_sc_hd__decap_12
XFILLER_0_2_52 VGND VGND VPWR VPWR sky130_fd_sc_hd__decap_8
XFILLER_0_6_161 VGND VGND VPWR VPWR sky130_fd_sc_hd__fill_1
XFILLER_0_17_20 VGND VGND VPWR VPWR sky130_fd_sc_hd__fill_1
XPHY_EDGE_ROW_0_Right_0 VGND VGND VPWR VPWR sky130_fd_sc_hd__decap_3
XFILLER_0_21_7 VGND VGND VPWR VPWR sky130_fd_sc_hd__decap_4
XFILLER_0_12_3 VPWR VGND VPWR VGND sky130_ef_sc_hd__decap_12
XFILLER_0_5_52 VGND VGND VPWR VPWR sky130_fd_sc_hd__decap_4
XFILLER_0_5_74 VPWR VGND VPWR VGND sky130_ef_sc_hd__decap_12
XFILLER_0_1_3 VGND VGND VPWR VPWR sky130_fd_sc_hd__decap_4
X_288_ _155_ VGND VGND VPWR VPWR _028_ sky130_fd_sc_hd__inv_2
XFILLER_0_23_187 VGND VGND VPWR VPWR sky130_fd_sc_hd__decap_3
XFILLER_0_23_165 VGND VGND VPWR VPWR sky130_fd_sc_hd__decap_3
Xclkbuf_2_1__f_clk clknet_0_clk VGND VGND VPWR VPWR clknet_2_1__leaf_clk sky130_fd_sc_hd__clkbuf_16
X_211_ _102_ _083_ _103_ VGND VGND VPWR VPWR _104_ sky130_fd_sc_hd__and3_1
XFILLER_0_14_165 VPWR VGND VPWR VGND sky130_ef_sc_hd__decap_12
XFILLER_0_2_97 VPWR VGND VPWR VGND sky130_ef_sc_hd__decap_12
XFILLER_0_6_173 VGND VGND VPWR VPWR sky130_fd_sc_hd__fill_1
XFILLER_0_11_113 VGND VGND VPWR VPWR sky130_fd_sc_hd__decap_6
XFILLER_0_11_146 VGND VGND VPWR VPWR sky130_fd_sc_hd__fill_1
XFILLER_0_3_110 VGND VGND VPWR VPWR sky130_fd_sc_hd__fill_2
XFILLER_0_3_165 VGND VGND VPWR VPWR sky130_fd_sc_hd__decap_3
XTAP_TAPCELL_ROW_7_80 VGND VPWR sky130_fd_sc_hd__tapvpwrvgnd_1
XTAP_TAPCELL_ROW_13_100 VGND VPWR sky130_fd_sc_hd__tapvpwrvgnd_1
XFILLER_0_0_113 VPWR VGND VPWR VGND sky130_ef_sc_hd__decap_12
XFILLER_0_8_74 VGND VGND VPWR VPWR sky130_fd_sc_hd__decap_8
XFILLER_0_8_85 VGND VGND VPWR VPWR sky130_fd_sc_hd__decap_6
XFILLER_0_14_77 VGND VGND VPWR VPWR sky130_fd_sc_hd__decap_6
XPHY_EDGE_ROW_18_Left_46 VGND VGND VPWR VPWR sky130_fd_sc_hd__decap_3
XFILLER_0_26_141 VGND VGND VPWR VPWR sky130_fd_sc_hd__decap_4
XFILLER_0_25_76 VPWR VGND VPWR VGND sky130_ef_sc_hd__decap_12
XFILLER_0_17_163 VGND VGND VPWR VPWR sky130_fd_sc_hd__decap_4
XFILLER_0_17_130 VPWR VGND VPWR VGND sky130_ef_sc_hd__decap_12
XFILLER_0_5_86 VGND VGND VPWR VPWR sky130_fd_sc_hd__decap_8
XFILLER_0_23_111 VGND VGND VPWR VPWR sky130_fd_sc_hd__fill_1
X_287_ net1 VGND VGND VPWR VPWR _155_ sky130_fd_sc_hd__buf_4
XFILLER_0_14_177 VGND VGND VPWR VPWR sky130_fd_sc_hd__decap_6
X_210_ counter.one_second_counter\[8\] _075_ VGND VGND VPWR VPWR _103_ sky130_fd_sc_hd__nand2_1
X_339_ clknet_2_3__leaf_clk _008_ _045_ VGND VGND VPWR VPWR counter.one_second_counter\[16\]
+ sky130_fd_sc_hd__dfrtp_4
XFILLER_0_6_141 VPWR VGND VPWR VGND sky130_ef_sc_hd__decap_12
XFILLER_0_11_169 VGND VGND VPWR VPWR sky130_fd_sc_hd__fill_2
XPHY_EDGE_ROW_6_Left_34 VGND VGND VPWR VPWR sky130_fd_sc_hd__decap_3
XFILLER_0_6_185 VGND VGND VPWR VPWR sky130_fd_sc_hd__fill_2
XTAP_TAPCELL_ROW_7_81 VGND VPWR sky130_fd_sc_hd__tapvpwrvgnd_1
XFILLER_0_0_169 VPWR VGND VPWR VGND sky130_ef_sc_hd__decap_12
XFILLER_0_0_125 VPWR VGND VPWR VGND sky130_ef_sc_hd__decap_12
XTAP_TAPCELL_ROW_4_71 VGND VPWR sky130_fd_sc_hd__tapvpwrvgnd_1
XFILLER_0_25_88 VGND VGND VPWR VPWR sky130_fd_sc_hd__decap_6
XFILLER_0_25_55 VGND VGND VPWR VPWR sky130_fd_sc_hd__fill_1
XFILLER_0_18_109 VGND VGND VPWR VPWR sky130_fd_sc_hd__decap_4
XFILLER_0_17_142 VPWR VGND VPWR VGND sky130_ef_sc_hd__decap_12
X_286_ counter.count\[1\] _153_ _067_ VGND VGND VPWR VPWR net8 sky130_fd_sc_hd__a21oi_1
XFILLER_0_14_112 VGND VGND VPWR VPWR sky130_fd_sc_hd__decap_8
XPHY_EDGE_ROW_23_Right_23 VGND VGND VPWR VPWR sky130_fd_sc_hd__decap_3
XFILLER_0_20_104 VPWR VGND VPWR VGND sky130_ef_sc_hd__decap_12
XPHY_EDGE_ROW_14_Right_14 VGND VGND VPWR VPWR sky130_fd_sc_hd__decap_3
XPHY_EDGE_ROW_22_Left_50 VGND VGND VPWR VPWR sky130_fd_sc_hd__decap_3
X_338_ clknet_2_2__leaf_clk _007_ _044_ VGND VGND VPWR VPWR counter.one_second_counter\[15\]
+ sky130_fd_sc_hd__dfrtp_1
X_269_ counter.one_second_counter\[23\] _144_ _146_ _092_ VGND VGND VPWR VPWR _016_
+ sky130_fd_sc_hd__o211a_1
XFILLER_0_6_153 VGND VGND VPWR VPWR sky130_fd_sc_hd__decap_8
XTAP_TAPCELL_ROW_11_92 VGND VPWR sky130_fd_sc_hd__tapvpwrvgnd_1
XFILLER_0_17_67 VPWR VGND VPWR VGND sky130_ef_sc_hd__decap_12
XFILLER_0_17_12 VGND VGND VPWR VPWR sky130_fd_sc_hd__decap_8
XTAP_TAPCELL_ROW_7_82 VGND VPWR sky130_fd_sc_hd__tapvpwrvgnd_1
XFILLER_0_3_134 VPWR VGND VPWR VGND sky130_ef_sc_hd__decap_12
XFILLER_0_3_189 VGND VGND VPWR VPWR sky130_fd_sc_hd__fill_1
XFILLER_0_0_137 VGND VGND VPWR VPWR sky130_fd_sc_hd__decap_3
XPHY_EDGE_ROW_4_Right_4 VGND VGND VPWR VPWR sky130_fd_sc_hd__decap_3
XFILLER_0_14_57 VPWR VGND VPWR VGND sky130_ef_sc_hd__decap_12
XTAP_TAPCELL_ROW_4_72 VGND VPWR sky130_fd_sc_hd__tapvpwrvgnd_1
XFILLER_0_3_9 VGND VGND VPWR VPWR sky130_fd_sc_hd__fill_1
XFILLER_0_17_154 VGND VGND VPWR VPWR sky130_fd_sc_hd__decap_4
XFILLER_0_10_3 VPWR VGND VPWR VGND sky130_ef_sc_hd__decap_12
XFILLER_0_23_113 VPWR VGND VPWR VGND sky130_ef_sc_hd__decap_12
X_285_ _066_ VGND VGND VPWR VPWR net7 sky130_fd_sc_hd__inv_2
XTAP_TAPCELL_ROW_1_62 VGND VPWR sky130_fd_sc_hd__tapvpwrvgnd_1
XFILLER_0_20_116 VPWR VGND VPWR VGND sky130_ef_sc_hd__decap_12
XFILLER_0_22_68 VPWR VGND VPWR VGND sky130_ef_sc_hd__decap_12
X_199_ _095_ VGND VGND VPWR VPWR _022_ sky130_fd_sc_hd__clkbuf_1
X_268_ _126_ _145_ VGND VGND VPWR VPWR _146_ sky130_fd_sc_hd__nand2_2
X_337_ clknet_2_2__leaf_clk _006_ _043_ VGND VGND VPWR VPWR counter.one_second_counter\[14\]
+ sky130_fd_sc_hd__dfrtp_2
XFILLER_0_12_90 VGND VGND VPWR VPWR sky130_fd_sc_hd__decap_8
XFILLER_0_6_110 VPWR VGND VPWR VGND sky130_ef_sc_hd__decap_12
XFILLER_0_6_165 VGND VGND VPWR VPWR sky130_fd_sc_hd__decap_8
XTAP_TAPCELL_ROW_11_93 VGND VPWR sky130_fd_sc_hd__tapvpwrvgnd_1
XFILLER_0_17_79 VPWR VGND VPWR VGND sky130_ef_sc_hd__decap_12
XFILLER_0_17_57 VGND VGND VPWR VPWR sky130_fd_sc_hd__decap_6
XTAP_TAPCELL_ROW_22_125 VGND VPWR sky130_fd_sc_hd__tapvpwrvgnd_1
XFILLER_0_3_102 VGND VGND VPWR VPWR sky130_fd_sc_hd__decap_8
XFILLER_0_14_69 VGND VGND VPWR VPWR sky130_fd_sc_hd__decap_4
XTAP_TAPCELL_ROW_4_73 VGND VPWR sky130_fd_sc_hd__tapvpwrvgnd_1
XFILLER_0_25_57 VGND VGND VPWR VPWR sky130_fd_sc_hd__decap_4
XFILLER_0_26_188 VGND VGND VPWR VPWR sky130_fd_sc_hd__fill_2
X_353_ clknet_2_3__leaf_clk _063_ _059_ VGND VGND VPWR VPWR counter.count\[3\] sky130_fd_sc_hd__dfrtp_4
XFILLER_0_17_111 VGND VGND VPWR VPWR sky130_fd_sc_hd__fill_1
X_284_ counter.count\[0\] _153_ _066_ VGND VGND VPWR VPWR net4 sky130_fd_sc_hd__a21oi_1
XFILLER_0_11_15 VPWR VGND VPWR VGND sky130_ef_sc_hd__decap_12
XFILLER_0_23_169 VPWR VGND VPWR VGND sky130_ef_sc_hd__decap_12
XFILLER_0_23_125 VPWR VGND VPWR VGND sky130_ef_sc_hd__decap_12
XFILLER_0_14_136 VGND VGND VPWR VPWR sky130_fd_sc_hd__decap_4
XFILLER_0_14_125 VGND VGND VPWR VPWR sky130_fd_sc_hd__decap_8
XTAP_TAPCELL_ROW_1_63 VGND VPWR sky130_fd_sc_hd__tapvpwrvgnd_1
XFILLER_0_20_128 VPWR VGND VPWR VGND sky130_ef_sc_hd__decap_12
X_198_ _092_ _093_ _094_ VGND VGND VPWR VPWR _095_ sky130_fd_sc_hd__and3_1
X_267_ _081_ _134_ VGND VGND VPWR VPWR _145_ sky130_fd_sc_hd__and2_1
X_336_ clknet_2_3__leaf_clk _005_ _042_ VGND VGND VPWR VPWR counter.one_second_counter\[13\]
+ sky130_fd_sc_hd__dfrtp_4
XFILLER_0_6_122 VPWR VGND VPWR VGND sky130_ef_sc_hd__decap_12
XFILLER_0_6_177 VGND VGND VPWR VPWR sky130_fd_sc_hd__decap_8
XTAP_TAPCELL_ROW_25_134 VGND VPWR sky130_fd_sc_hd__tapvpwrvgnd_1
XTAP_TAPCELL_ROW_11_94 VGND VPWR sky130_fd_sc_hd__tapvpwrvgnd_1
X_319_ _157_ VGND VGND VPWR VPWR _057_ sky130_fd_sc_hd__inv_2
XFILLER_0_3_169 VPWR VGND VPWR VGND sky130_ef_sc_hd__decap_12
XTAP_TAPCELL_ROW_22_126 VGND VPWR sky130_fd_sc_hd__tapvpwrvgnd_1
XFILLER_0_8_23 VGND VGND VPWR VPWR sky130_fd_sc_hd__decap_4
XFILLER_0_14_15 VPWR VGND VPWR VGND sky130_ef_sc_hd__decap_12
XFILLER_0_26_156 VGND VGND VPWR VPWR sky130_fd_sc_hd__fill_2
XFILLER_0_26_145 VGND VGND VPWR VPWR sky130_fd_sc_hd__fill_1
XFILLER_0_5_57 VPWR VGND VPWR VGND sky130_ef_sc_hd__decap_12
XFILLER_0_17_189 VGND VGND VPWR VPWR sky130_fd_sc_hd__fill_1
XFILLER_0_17_167 VGND VGND VPWR VPWR sky130_fd_sc_hd__fill_1
X_352_ clknet_2_3__leaf_clk _062_ _058_ VGND VGND VPWR VPWR counter.count\[2\] sky130_fd_sc_hd__dfrtp_4
XFILLER_0_23_137 VPWR VGND VPWR VGND sky130_ef_sc_hd__decap_12
XTAP_TAPCELL_ROW_1_64 VGND VPWR sky130_fd_sc_hd__tapvpwrvgnd_1
X_283_ counter.count\[1\] _153_ net6 VGND VGND VPWR VPWR net5 sky130_fd_sc_hd__a21boi_1
XFILLER_0_11_27 VPWR VGND VPWR VGND sky130_ef_sc_hd__decap_12
XFILLER_0_9_142 VGND VGND VPWR VPWR sky130_fd_sc_hd__decap_8
XFILLER_0_9_153 VPWR VGND VPWR VGND sky130_ef_sc_hd__decap_12
X_335_ clknet_2_2__leaf_clk _004_ _041_ VGND VGND VPWR VPWR counter.one_second_counter\[12\]
+ sky130_fd_sc_hd__dfrtp_1
X_266_ _000_ _143_ _144_ VGND VGND VPWR VPWR _015_ sky130_fd_sc_hd__nor3_1
X_197_ counter.one_second_counter\[4\] _073_ VGND VGND VPWR VPWR _094_ sky130_fd_sc_hd__or2_1
XFILLER_0_6_134 VGND VGND VPWR VPWR sky130_fd_sc_hd__decap_6
XPHY_EDGE_ROW_10_Right_10 VGND VGND VPWR VPWR sky130_fd_sc_hd__decap_3
XFILLER_0_11_107 VGND VGND VPWR VPWR sky130_fd_sc_hd__decap_4
XTAP_TAPCELL_ROW_25_135 VGND VPWR sky130_fd_sc_hd__tapvpwrvgnd_1
XPHY_EDGE_ROW_26_Left_54 VGND VGND VPWR VPWR sky130_fd_sc_hd__decap_3
XFILLER_0_3_126 VGND VGND VPWR VPWR sky130_fd_sc_hd__fill_1
X_249_ counter.one_second_counter\[17\] counter.one_second_counter\[16\] _126_ VGND
+ VGND VPWR VPWR _132_ sky130_fd_sc_hd__and3_1
X_318_ _157_ VGND VGND VPWR VPWR _056_ sky130_fd_sc_hd__inv_2
XPHY_EDGE_ROW_10_Left_38 VGND VGND VPWR VPWR sky130_fd_sc_hd__decap_3
XTAP_TAPCELL_ROW_22_127 VGND VPWR sky130_fd_sc_hd__tapvpwrvgnd_1
XFILLER_0_3_90 VPWR VGND VPWR VGND sky130_ef_sc_hd__decap_12
XFILLER_0_26_3 VPWR VGND VPWR VGND sky130_ef_sc_hd__decap_12
XFILLER_0_8_13 VGND VGND VPWR VPWR sky130_fd_sc_hd__fill_2
XFILLER_0_14_49 VGND VGND VPWR VPWR sky130_fd_sc_hd__fill_1
XFILLER_0_14_27 VGND VGND VPWR VPWR sky130_fd_sc_hd__fill_1
XPHY_EDGE_ROW_8_Right_8 VGND VGND VPWR VPWR sky130_fd_sc_hd__decap_3
XFILLER_0_20_92 VPWR VGND VPWR VGND sky130_ef_sc_hd__decap_12
XPHY_EDGE_ROW_13_Left_41 VGND VGND VPWR VPWR sky130_fd_sc_hd__decap_3
XFILLER_0_25_26 VGND VGND VPWR VPWR sky130_fd_sc_hd__fill_2
XFILLER_0_5_36 VGND VGND VPWR VPWR sky130_fd_sc_hd__fill_1
XFILLER_0_23_149 VGND VGND VPWR VPWR sky130_fd_sc_hd__fill_1
XFILLER_0_23_105 VGND VGND VPWR VPWR sky130_fd_sc_hd__decap_6
X_351_ clknet_2_0__leaf_clk _061_ _057_ VGND VGND VPWR VPWR counter.count\[1\] sky130_fd_sc_hd__dfrtp_4
X_282_ _154_ VGND VGND VPWR VPWR net6 sky130_fd_sc_hd__buf_1
XFILLER_0_11_39 VPWR VGND VPWR VGND sky130_ef_sc_hd__decap_12
X_334_ clknet_2_3__leaf_clk _003_ _040_ VGND VGND VPWR VPWR counter.one_second_counter\[11\]
+ sky130_fd_sc_hd__dfrtp_2
XFILLER_0_9_121 VGND VGND VPWR VPWR sky130_fd_sc_hd__fill_1
XFILLER_0_9_165 VGND VGND VPWR VPWR sky130_fd_sc_hd__decap_3
XFILLER_0_9_187 VGND VGND VPWR VPWR sky130_fd_sc_hd__decap_3
X_196_ counter.one_second_counter\[4\] _073_ VGND VGND VPWR VPWR _093_ sky130_fd_sc_hd__nand2_1
XFILLER_0_2_15 VPWR VGND VPWR VGND sky130_ef_sc_hd__decap_12
X_265_ counter.one_second_counter\[22\] _142_ VGND VGND VPWR VPWR _144_ sky130_fd_sc_hd__and2_1
XTAP_TAPCELL_ROW_25_136 VGND VPWR sky130_fd_sc_hd__tapvpwrvgnd_1
XFILLER_0_10_141 VPWR VGND VPWR VGND sky130_ef_sc_hd__decap_12
XFILLER_0_10_185 VGND VGND VPWR VPWR sky130_fd_sc_hd__fill_2
X_179_ counter.one_second_counter\[23\] counter.one_second_counter\[22\] counter.one_second_counter\[21\]
+ counter.one_second_counter\[20\] VGND VGND VPWR VPWR _081_ sky130_fd_sc_hd__and4_2
X_248_ counter.one_second_counter\[18\] counter.one_second_counter\[17\] VGND VGND
+ VPWR VPWR _131_ sky130_fd_sc_hd__nand2_1
XFILLER_0_3_149 VPWR VGND VPWR VGND sky130_ef_sc_hd__decap_12
X_317_ _157_ VGND VGND VPWR VPWR _055_ sky130_fd_sc_hd__inv_2
Xclkbuf_2_2__f_clk clknet_0_clk VGND VGND VPWR VPWR clknet_2_2__leaf_clk sky130_fd_sc_hd__clkbuf_16
XFILLER_0_19_3 VPWR VGND VPWR VGND sky130_ef_sc_hd__decap_12
XFILLER_0_8_3 VGND VGND VPWR VPWR sky130_fd_sc_hd__decap_8
XFILLER_0_25_180 VGND VGND VPWR VPWR sky130_fd_sc_hd__fill_2
XFILLER_0_17_169 VPWR VGND VPWR VGND sky130_ef_sc_hd__decap_12
XFILLER_0_17_103 VGND VGND VPWR VPWR sky130_fd_sc_hd__decap_8
XFILLER_0_5_15 VPWR VGND VPWR VGND sky130_ef_sc_hd__decap_12
X_350_ clknet_2_1__leaf_clk _060_ _056_ VGND VGND VPWR VPWR counter.count\[0\] sky130_fd_sc_hd__dfrtp_4
X_281_ counter.count\[3\] counter.count\[2\] counter.count\[0\] VGND VGND VPWR VPWR
+ _154_ sky130_fd_sc_hd__or3_1
XFILLER_0_22_183 VGND VGND VPWR VPWR sky130_fd_sc_hd__decap_4
XFILLER_0_9_111 VGND VGND VPWR VPWR sky130_fd_sc_hd__fill_1
XFILLER_0_9_177 VGND VGND VPWR VPWR sky130_fd_sc_hd__fill_2
X_333_ clknet_2_1__leaf_clk _002_ _039_ VGND VGND VPWR VPWR counter.one_second_counter\[10\]
+ sky130_fd_sc_hd__dfrtp_4
XFILLER_0_2_27 VGND VGND VPWR VPWR sky130_fd_sc_hd__fill_1
X_264_ counter.one_second_counter\[22\] _142_ VGND VGND VPWR VPWR _143_ sky130_fd_sc_hd__nor2_1
X_195_ _083_ VGND VGND VPWR VPWR _092_ sky130_fd_sc_hd__buf_2
XFILLER_0_12_83 VGND VGND VPWR VPWR sky130_fd_sc_hd__fill_1
XFILLER_0_10_153 VPWR VGND VPWR VGND sky130_ef_sc_hd__decap_12
X_247_ _000_ _130_ VGND VGND VPWR VPWR _009_ sky130_fd_sc_hd__nor2_1
XFILLER_0_17_28 VPWR VGND VPWR VGND sky130_ef_sc_hd__decap_12
X_316_ _157_ VGND VGND VPWR VPWR _054_ sky130_fd_sc_hd__inv_2
X_178_ counter.one_second_counter\[8\] _075_ _077_ _079_ VGND VGND VPWR VPWR _080_
+ sky130_fd_sc_hd__o31a_1
XFILLER_0_3_70 VGND VGND VPWR VPWR sky130_fd_sc_hd__fill_2
XFILLER_0_18_60 VPWR VGND VPWR VGND sky130_ef_sc_hd__decap_12
XFILLER_0_14_29 VPWR VGND VPWR VGND sky130_ef_sc_hd__decap_12
XFILLER_0_20_83 VGND VGND VPWR VPWR sky130_fd_sc_hd__fill_1
XFILLER_0_26_115 VGND VGND VPWR VPWR sky130_fd_sc_hd__decap_6
XFILLER_0_5_27 VGND VGND VPWR VPWR sky130_fd_sc_hd__decap_6
X_280_ _066_ _153_ VGND VGND VPWR VPWR net3 sky130_fd_sc_hd__nor2_1
XFILLER_0_6_81 VGND VGND VPWR VPWR sky130_fd_sc_hd__decap_3
X_332_ clknet_2_3__leaf_clk _027_ _038_ VGND VGND VPWR VPWR counter.one_second_counter\[9\]
+ sky130_fd_sc_hd__dfrtp_2
X_263_ _141_ _139_ _142_ _000_ VGND VGND VPWR VPWR _014_ sky130_fd_sc_hd__a211oi_1
X_194_ _091_ VGND VGND VPWR VPWR _021_ sky130_fd_sc_hd__buf_1
XFILLER_0_22_29 VPWR VGND VPWR VGND sky130_ef_sc_hd__decap_12
XFILLER_0_10_110 VGND VGND VPWR VPWR sky130_fd_sc_hd__decap_8
XFILLER_0_10_165 VPWR VGND VPWR VGND sky130_ef_sc_hd__decap_12
XFILLER_0_5_181 VGND VGND VPWR VPWR sky130_fd_sc_hd__decap_8
X_246_ counter.one_second_counter\[17\] _128_ VGND VGND VPWR VPWR _130_ sky130_fd_sc_hd__xor2_1
XFILLER_0_23_61 VGND VGND VPWR VPWR sky130_fd_sc_hd__fill_1
X_315_ _157_ VGND VGND VPWR VPWR _053_ sky130_fd_sc_hd__inv_2
X_177_ counter.one_second_counter\[17\] counter.one_second_counter\[16\] _078_ counter.one_second_counter\[18\]
+ VGND VGND VPWR VPWR _079_ sky130_fd_sc_hd__and4b_1
X_229_ _000_ _116_ _117_ VGND VGND VPWR VPWR _004_ sky130_fd_sc_hd__nor3_1
XFILLER_0_8_27 VGND VGND VPWR VPWR sky130_fd_sc_hd__fill_1
XFILLER_0_8_49 VPWR VGND VPWR VGND sky130_ef_sc_hd__decap_12
XFILLER_0_18_72 VPWR VGND VPWR VGND sky130_ef_sc_hd__decap_12
XPHY_EDGE_ROW_26_Right_26 VGND VGND VPWR VPWR sky130_fd_sc_hd__decap_3
XPHY_EDGE_ROW_17_Right_17 VGND VGND VPWR VPWR sky130_fd_sc_hd__decap_3
XFILLER_0_0_83 VGND VGND VPWR VPWR sky130_fd_sc_hd__fill_1
XFILLER_0_9_81 VGND VGND VPWR VPWR sky130_fd_sc_hd__fill_1
XFILLER_0_26_127 VPWR VGND VPWR VGND sky130_ef_sc_hd__decap_12
XFILLER_0_15_62 VPWR VGND VPWR VGND sky130_ef_sc_hd__decap_12
XFILLER_0_25_160 VGND VGND VPWR VPWR sky130_fd_sc_hd__decap_8
XPHY_EDGE_ROW_17_Left_45 VGND VGND VPWR VPWR sky130_fd_sc_hd__decap_3
XFILLER_0_26_83 VGND VGND VPWR VPWR sky130_fd_sc_hd__fill_1
XFILLER_0_13_141 VGND VGND VPWR VPWR sky130_fd_sc_hd__fill_2
XFILLER_0_9_113 VGND VGND VPWR VPWR sky130_fd_sc_hd__decap_8
XFILLER_0_9_135 VGND VGND VPWR VPWR sky130_fd_sc_hd__fill_2
X_262_ counter.one_second_counter\[21\] counter.one_second_counter\[20\] _126_ _134_
+ VGND VGND VPWR VPWR _142_ sky130_fd_sc_hd__and4_1
X_193_ _073_ _083_ _090_ VGND VGND VPWR VPWR _091_ sky130_fd_sc_hd__and3b_1
X_331_ clknet_2_0__leaf_clk _026_ _037_ VGND VGND VPWR VPWR counter.one_second_counter\[8\]
+ sky130_fd_sc_hd__dfrtp_2
XFILLER_0_12_41 VPWR VGND VPWR VGND sky130_ef_sc_hd__decap_12
XFILLER_0_10_177 VGND VGND VPWR VPWR sky130_fd_sc_hd__decap_8
X_314_ _157_ VGND VGND VPWR VPWR _052_ sky130_fd_sc_hd__inv_2
X_176_ counter.one_second_counter\[19\] counter.one_second_counter\[13\] counter.one_second_counter\[14\]
+ counter.one_second_counter\[15\] VGND VGND VPWR VPWR _078_ sky130_fd_sc_hd__and4b_1
X_245_ _129_ VGND VGND VPWR VPWR _008_ sky130_fd_sc_hd__clkbuf_1
XFILLER_0_2_174 VPWR VGND VPWR VGND sky130_ef_sc_hd__decap_12
XPHY_EDGE_ROW_5_Left_33 VGND VGND VPWR VPWR sky130_fd_sc_hd__decap_3
X_159_ counter.count\[2\] _064_ VGND VGND VPWR VPWR _065_ sky130_fd_sc_hd__and2_1
X_228_ counter.one_second_counter\[12\] _113_ VGND VGND VPWR VPWR _117_ sky130_fd_sc_hd__and2_1
XFILLER_0_20_85 VGND VGND VPWR VPWR sky130_fd_sc_hd__fill_1
XFILLER_0_20_41 VPWR VGND VPWR VGND sky130_ef_sc_hd__decap_12
XFILLER_0_17_3 VGND VGND VPWR VPWR sky130_fd_sc_hd__decap_4
XFILLER_0_26_139 VGND VGND VPWR VPWR sky130_fd_sc_hd__fill_1
XFILLER_0_25_172 VGND VGND VPWR VPWR sky130_fd_sc_hd__decap_8
XFILLER_0_15_74 VGND VGND VPWR VPWR sky130_fd_sc_hd__decap_8
XFILLER_0_16_183 VGND VGND VPWR VPWR sky130_fd_sc_hd__fill_1
XFILLER_0_9_103 VGND VGND VPWR VPWR sky130_fd_sc_hd__decap_8
X_330_ clknet_2_1__leaf_clk _025_ _036_ VGND VGND VPWR VPWR counter.one_second_counter\[7\]
+ sky130_fd_sc_hd__dfrtp_1
X_261_ counter.one_second_counter\[21\] VGND VGND VPWR VPWR _141_ sky130_fd_sc_hd__inv_2
X_192_ counter.one_second_counter\[2\] counter.one_second_counter\[1\] counter.one_second_counter\[0\]
+ counter.one_second_counter\[3\] VGND VGND VPWR VPWR _090_ sky130_fd_sc_hd__a31o_1
XFILLER_0_12_53 VGND VGND VPWR VPWR sky130_fd_sc_hd__decap_4
X_313_ _157_ VGND VGND VPWR VPWR _051_ sky130_fd_sc_hd__inv_2
XTAP_TAPCELL_ROW_16_107 VGND VPWR sky130_fd_sc_hd__tapvpwrvgnd_1
X_175_ counter.one_second_counter\[10\] counter.one_second_counter\[11\] counter.one_second_counter\[9\]
+ _076_ VGND VGND VPWR VPWR _077_ sky130_fd_sc_hd__or4_1
X_244_ _083_ _127_ _128_ VGND VGND VPWR VPWR _129_ sky130_fd_sc_hd__and3_1
XFILLER_0_2_186 VGND VGND VPWR VPWR sky130_fd_sc_hd__fill_1
XFILLER_0_3_51 VGND VGND VPWR VPWR sky130_fd_sc_hd__decap_4
XFILLER_0_18_85 VPWR VGND VPWR VGND sky130_ef_sc_hd__decap_12
X_158_ counter.one_second_enable counter.count\[1\] counter.count\[0\] VGND VGND VPWR
+ VPWR _064_ sky130_fd_sc_hd__and3_1
XFILLER_0_8_29 VPWR VGND VPWR VGND sky130_ef_sc_hd__decap_12
X_227_ counter.one_second_counter\[12\] _113_ VGND VGND VPWR VPWR _116_ sky130_fd_sc_hd__nor2_1
XFILLER_0_20_53 VPWR VGND VPWR VGND sky130_ef_sc_hd__decap_12
XFILLER_0_0_85 VGND VGND VPWR VPWR sky130_fd_sc_hd__decap_8
XPHY_EDGE_ROW_3_Right_3 VGND VGND VPWR VPWR sky130_fd_sc_hd__decap_3
XFILLER_0_19_181 VGND VGND VPWR VPWR sky130_fd_sc_hd__decap_8
XFILLER_0_17_118 VPWR VGND VPWR VGND sky130_ef_sc_hd__decap_12
XFILLER_0_26_85 VGND VGND VPWR VPWR sky130_fd_sc_hd__decap_8
XFILLER_0_26_74 VGND VGND VPWR VPWR sky130_fd_sc_hd__decap_3
XFILLER_0_26_41 VPWR VGND VPWR VGND sky130_ef_sc_hd__decap_12
XFILLER_0_13_154 VPWR VGND VPWR VGND sky130_ef_sc_hd__decap_12
X_260_ _140_ VGND VGND VPWR VPWR _013_ sky130_fd_sc_hd__clkbuf_1
XFILLER_0_9_126 VGND VGND VPWR VPWR sky130_fd_sc_hd__decap_4
XTAP_TAPCELL_ROW_19_116 VGND VPWR sky130_fd_sc_hd__tapvpwrvgnd_1
X_191_ _089_ VGND VGND VPWR VPWR _020_ sky130_fd_sc_hd__clkbuf_1
XTopModule_10 VGND VGND VPWR VPWR an[1] TopModule_10/LO sky130_fd_sc_hd__conb_1
XFILLER_0_12_98 VGND VGND VPWR VPWR sky130_fd_sc_hd__fill_2
XFILLER_0_5_162 VGND VGND VPWR VPWR sky130_fd_sc_hd__fill_1
XTAP_TAPCELL_ROW_16_108 VGND VPWR sky130_fd_sc_hd__tapvpwrvgnd_1
X_174_ counter.one_second_counter\[15\] counter.one_second_counter\[14\] counter.one_second_counter\[12\]
+ counter.one_second_counter\[13\] VGND VGND VPWR VPWR _076_ sky130_fd_sc_hd__and4_1
X_312_ _157_ VGND VGND VPWR VPWR _050_ sky130_fd_sc_hd__inv_2
X_243_ counter.one_second_counter\[16\] _126_ VGND VGND VPWR VPWR _128_ sky130_fd_sc_hd__nand2_2
XTAP_TAPCELL_ROW_21_122 VGND VPWR sky130_fd_sc_hd__tapvpwrvgnd_1
XFILLER_0_18_97 VPWR VGND VPWR VGND sky130_ef_sc_hd__decap_12
X_226_ _115_ VGND VGND VPWR VPWR _003_ sky130_fd_sc_hd__buf_1
XFILLER_0_20_65 VPWR VGND VPWR VGND sky130_ef_sc_hd__decap_12
X_209_ counter.one_second_counter\[8\] _075_ VGND VGND VPWR VPWR _102_ sky130_fd_sc_hd__or2_1
XFILLER_0_0_53 VGND VGND VPWR VPWR sky130_fd_sc_hd__decap_3
XPHY_EDGE_ROW_22_Right_22 VGND VGND VPWR VPWR sky130_fd_sc_hd__decap_3
XFILLER_0_15_54 VGND VGND VPWR VPWR sky130_fd_sc_hd__fill_2
XFILLER_0_15_10 VPWR VGND VPWR VGND sky130_ef_sc_hd__decap_12
XPHY_EDGE_ROW_13_Right_13 VGND VGND VPWR VPWR sky130_fd_sc_hd__decap_3
XFILLER_0_22_3 VGND VGND VPWR VPWR sky130_fd_sc_hd__decap_8
XFILLER_0_16_141 VPWR VGND VPWR VGND sky130_ef_sc_hd__decap_12
XFILLER_0_26_53 VGND VGND VPWR VPWR sky130_fd_sc_hd__decap_3
XFILLER_0_13_166 VGND VGND VPWR VPWR sky130_fd_sc_hd__fill_2
XFILLER_0_13_133 VGND VGND VPWR VPWR sky130_fd_sc_hd__decap_8
XFILLER_0_13_111 VGND VGND VPWR VPWR sky130_fd_sc_hd__fill_1
XFILLER_0_6_41 VGND VGND VPWR VPWR sky130_fd_sc_hd__fill_1
XFILLER_0_6_85 VGND VGND VPWR VPWR sky130_fd_sc_hd__decap_6
XTAP_TAPCELL_ROW_19_117 VGND VPWR sky130_fd_sc_hd__tapvpwrvgnd_1
X_190_ _087_ _083_ _088_ VGND VGND VPWR VPWR _089_ sky130_fd_sc_hd__and3_1
XFILLER_0_8_171 VPWR VGND VPWR VGND sky130_ef_sc_hd__decap_12
XTopModule_11 VGND VGND VPWR VPWR an[2] TopModule_11/LO sky130_fd_sc_hd__conb_1
XFILLER_0_12_77 VGND VGND VPWR VPWR sky130_fd_sc_hd__decap_6
XTAP_TAPCELL_ROW_24_131 VGND VPWR sky130_fd_sc_hd__tapvpwrvgnd_1
X_311_ _157_ VGND VGND VPWR VPWR _049_ sky130_fd_sc_hd__inv_2
XTAP_TAPCELL_ROW_16_109 VGND VPWR sky130_fd_sc_hd__tapvpwrvgnd_1
X_173_ _073_ _074_ VGND VGND VPWR VPWR _075_ sky130_fd_sc_hd__and2_1
X_242_ counter.one_second_counter\[16\] _126_ VGND VGND VPWR VPWR _127_ sky130_fd_sc_hd__or2_1
XFILLER_0_2_144 VPWR VGND VPWR VGND sky130_ef_sc_hd__decap_12
XTAP_TAPCELL_ROW_21_123 VGND VPWR sky130_fd_sc_hd__tapvpwrvgnd_1
X_225_ _092_ _112_ _114_ VGND VGND VPWR VPWR _115_ sky130_fd_sc_hd__and3_1
XPHY_EDGE_ROW_9_Left_37 VGND VGND VPWR VPWR sky130_fd_sc_hd__decap_3
XFILLER_0_24_7 VPWR VGND VPWR VGND sky130_ef_sc_hd__decap_12
XFILLER_0_20_77 VGND VGND VPWR VPWR sky130_fd_sc_hd__decap_6
X_208_ _101_ _099_ _000_ _075_ VGND VGND VPWR VPWR _025_ sky130_fd_sc_hd__a211oi_1
XFILLER_0_0_98 VPWR VGND VPWR VGND sky130_ef_sc_hd__decap_12
Xclkbuf_2_3__f_clk clknet_0_clk VGND VGND VPWR VPWR clknet_2_3__leaf_clk sky130_fd_sc_hd__clkbuf_16
XFILLER_0_15_22 VPWR VGND VPWR VGND sky130_ef_sc_hd__decap_12
XFILLER_0_25_186 VGND VGND VPWR VPWR sky130_fd_sc_hd__fill_1
XFILLER_0_16_153 VPWR VGND VPWR VGND sky130_ef_sc_hd__decap_12
XFILLER_0_15_3 VGND VGND VPWR VPWR sky130_fd_sc_hd__decap_4
XFILLER_0_6_20 VGND VGND VPWR VPWR sky130_fd_sc_hd__fill_1
XTAP_TAPCELL_ROW_19_118 VGND VPWR sky130_fd_sc_hd__tapvpwrvgnd_1
XFILLER_0_4_3 VPWR VGND VPWR VGND sky130_ef_sc_hd__decap_12
XFILLER_0_8_183 VGND VGND VPWR VPWR sky130_fd_sc_hd__decap_4
XTAP_TAPCELL_ROW_27_140 VGND VPWR sky130_fd_sc_hd__tapvpwrvgnd_1
XTopModule_12 VGND VGND VPWR VPWR an[3] TopModule_12/LO sky130_fd_sc_hd__conb_1
XTAP_TAPCELL_ROW_24_132 VGND VPWR sky130_fd_sc_hd__tapvpwrvgnd_1
X_310_ _157_ VGND VGND VPWR VPWR _048_ sky130_fd_sc_hd__inv_2
XFILLER_0_23_11 VGND VGND VPWR VPWR sky130_fd_sc_hd__fill_2
X_241_ _124_ _122_ _126_ _000_ VGND VGND VPWR VPWR _007_ sky130_fd_sc_hd__a211oi_1
X_172_ counter.one_second_counter\[7\] counter.one_second_counter\[6\] counter.one_second_counter\[5\]
+ counter.one_second_counter\[4\] VGND VGND VPWR VPWR _074_ sky130_fd_sc_hd__and4_1
XTAP_TAPCELL_ROW_21_124 VGND VPWR sky130_fd_sc_hd__tapvpwrvgnd_1
XFILLER_0_2_156 VPWR VGND VPWR VGND sky130_ef_sc_hd__decap_12
XFILLER_0_3_65 VGND VGND VPWR VPWR sky130_fd_sc_hd__fill_2
X_224_ _113_ VGND VGND VPWR VPWR _114_ sky130_fd_sc_hd__inv_2
XPHY_EDGE_ROW_25_Left_53 VGND VGND VPWR VPWR sky130_fd_sc_hd__decap_3
X_207_ counter.one_second_counter\[7\] VGND VGND VPWR VPWR _101_ sky130_fd_sc_hd__inv_2
XFILLER_0_19_162 VGND VGND VPWR VPWR sky130_fd_sc_hd__decap_6
XFILLER_0_15_34 VPWR VGND VPWR VGND sky130_ef_sc_hd__decap_12
XPHY_EDGE_ROW_12_Left_40 VGND VGND VPWR VPWR sky130_fd_sc_hd__decap_3
XPHY_EDGE_ROW_7_Right_7 VGND VGND VPWR VPWR sky130_fd_sc_hd__decap_3
XFILLER_0_22_124 VPWR VGND VPWR VGND sky130_ef_sc_hd__decap_12
XFILLER_0_16_165 VPWR VGND VPWR VGND sky130_ef_sc_hd__decap_12
XFILLER_0_26_99 VGND VGND VPWR VPWR sky130_fd_sc_hd__decap_8
XFILLER_0_26_66 VGND VGND VPWR VPWR sky130_fd_sc_hd__decap_8
XFILLER_0_26_22 VGND VGND VPWR VPWR sky130_fd_sc_hd__decap_6
XFILLER_0_22_146 VPWR VGND VPWR VGND sky130_ef_sc_hd__decap_12
XFILLER_0_6_98 VPWR VGND VPWR VGND sky130_ef_sc_hd__decap_12
XTAP_TAPCELL_ROW_27_141 VGND VPWR sky130_fd_sc_hd__tapvpwrvgnd_1
XFILLER_0_10_105 VGND VGND VPWR VPWR sky130_fd_sc_hd__fill_2
XTopModule_13 VGND VGND VPWR VPWR an[4] TopModule_13/LO sky130_fd_sc_hd__conb_1
XFILLER_0_5_110 VGND VGND VPWR VPWR sky130_fd_sc_hd__fill_2
X_171_ counter.one_second_counter\[3\] counter.one_second_counter\[2\] counter.one_second_counter\[1\]
+ counter.one_second_counter\[0\] VGND VGND VPWR VPWR _073_ sky130_fd_sc_hd__and4_4
XTAP_TAPCELL_ROW_24_133 VGND VPWR sky130_fd_sc_hd__tapvpwrvgnd_1
X_240_ _125_ VGND VGND VPWR VPWR _126_ sky130_fd_sc_hd__clkbuf_4
XFILLER_0_2_168 VGND VGND VPWR VPWR sky130_fd_sc_hd__decap_3
XFILLER_0_3_55 VGND VGND VPWR VPWR sky130_fd_sc_hd__fill_1
X_223_ counter.one_second_counter\[10\] counter.one_second_counter\[11\] _106_ VGND
+ VGND VPWR VPWR _113_ sky130_fd_sc_hd__and3_2
X_206_ _100_ VGND VGND VPWR VPWR _024_ sky130_fd_sc_hd__clkbuf_1
XFILLER_0_0_67 VPWR VGND VPWR VGND sky130_ef_sc_hd__decap_12
XFILLER_0_0_45 VGND VGND VPWR VPWR sky130_fd_sc_hd__decap_8
XFILLER_0_9_32 VPWR VGND VPWR VGND sky130_ef_sc_hd__decap_12
XFILLER_0_25_111 VGND VGND VPWR VPWR sky130_fd_sc_hd__fill_1
XFILLER_0_15_57 VGND VGND VPWR VPWR sky130_fd_sc_hd__fill_2
XFILLER_0_15_46 VGND VGND VPWR VPWR sky130_fd_sc_hd__decap_8
XFILLER_0_16_177 VGND VGND VPWR VPWR sky130_fd_sc_hd__decap_6
XFILLER_0_22_158 VGND VGND VPWR VPWR sky130_fd_sc_hd__fill_1
XFILLER_0_22_136 VGND VGND VPWR VPWR sky130_fd_sc_hd__decap_4
XFILLER_0_20_3 VPWR VGND VPWR VGND sky130_ef_sc_hd__decap_12
XFILLER_0_13_169 VGND VGND VPWR VPWR sky130_fd_sc_hd__fill_1
XFILLER_0_6_11 VGND VGND VPWR VPWR sky130_fd_sc_hd__fill_2
XFILLER_0_8_141 VGND VGND VPWR VPWR sky130_fd_sc_hd__fill_1
XTAP_TAPCELL_ROW_27_142 VGND VPWR sky130_fd_sc_hd__tapvpwrvgnd_1
XTopModule_14 VGND VGND VPWR VPWR an[5] TopModule_14/LO sky130_fd_sc_hd__conb_1
XFILLER_0_5_122 VPWR VGND VPWR VGND sky130_ef_sc_hd__decap_12
XFILLER_0_5_166 VGND VGND VPWR VPWR sky130_fd_sc_hd__fill_2
X_170_ counter.one_second_counter\[18\] counter.one_second_counter\[17\] counter.one_second_counter\[19\]
+ VGND VGND VPWR VPWR _072_ sky130_fd_sc_hd__a21o_1
X_299_ _156_ VGND VGND VPWR VPWR _038_ sky130_fd_sc_hd__inv_2
XFILLER_0_23_57 VGND VGND VPWR VPWR sky130_fd_sc_hd__decap_4
XFILLER_0_3_78 VPWR VGND VPWR VGND sky130_ef_sc_hd__decap_12
X_222_ counter.one_second_counter\[10\] _106_ counter.one_second_counter\[11\] VGND
+ VGND VPWR VPWR _112_ sky130_fd_sc_hd__a21o_1
XTAP_TAPCELL_ROW_8_83 VGND VPWR sky130_fd_sc_hd__tapvpwrvgnd_1
X_205_ _092_ _098_ _099_ VGND VGND VPWR VPWR _100_ sky130_fd_sc_hd__and3_1
XFILLER_0_0_79 VGND VGND VPWR VPWR sky130_fd_sc_hd__decap_4
XFILLER_0_0_57 VGND VGND VPWR VPWR sky130_fd_sc_hd__decap_4
XFILLER_0_9_44 VPWR VGND VPWR VGND sky130_ef_sc_hd__decap_12
XFILLER_0_21_181 VGND VGND VPWR VPWR sky130_fd_sc_hd__decap_8
XFILLER_0_13_148 VGND VGND VPWR VPWR sky130_fd_sc_hd__decap_3
XFILLER_0_13_3 VPWR VGND VPWR VGND sky130_ef_sc_hd__decap_12
XFILLER_0_6_45 VPWR VGND VPWR VGND sky130_ef_sc_hd__decap_12
XTAP_TAPCELL_ROW_27_143 VGND VPWR sky130_fd_sc_hd__tapvpwrvgnd_1
XFILLER_0_12_181 VGND VGND VPWR VPWR sky130_fd_sc_hd__fill_1
XFILLER_0_12_26 VGND VGND VPWR VPWR sky130_fd_sc_hd__fill_2
XFILLER_0_12_15 VGND VGND VPWR VPWR sky130_fd_sc_hd__decap_8
XTopModule_15 VGND VGND VPWR VPWR an[6] TopModule_15/LO sky130_fd_sc_hd__conb_1
Xoutput2 net2 VGND VGND VPWR VPWR seg[0] sky130_fd_sc_hd__buf_1
XFILLER_0_5_134 VPWR VGND VPWR VGND sky130_ef_sc_hd__decap_12
XFILLER_0_5_189 VGND VGND VPWR VPWR sky130_fd_sc_hd__fill_1
XFILLER_0_10_118 VGND VGND VPWR VPWR sky130_fd_sc_hd__fill_1
XFILLER_0_2_3 VPWR VGND VPWR VGND sky130_ef_sc_hd__decap_12
XFILLER_0_23_47 VGND VGND VPWR VPWR sky130_fd_sc_hd__fill_1
X_298_ net1 VGND VGND VPWR VPWR _156_ sky130_fd_sc_hd__clkbuf_8
XFILLER_0_3_13 VGND VGND VPWR VPWR sky130_fd_sc_hd__decap_3
XFILLER_0_3_57 VGND VGND VPWR VPWR sky130_fd_sc_hd__decap_8
X_221_ _111_ VGND VGND VPWR VPWR _002_ sky130_fd_sc_hd__buf_1
XTAP_TAPCELL_ROW_8_84 VGND VPWR sky130_fd_sc_hd__tapvpwrvgnd_1
X_204_ counter.one_second_counter\[6\] _097_ VGND VGND VPWR VPWR _099_ sky130_fd_sc_hd__nand2_1
XFILLER_0_20_15 VPWR VGND VPWR VGND sky130_ef_sc_hd__decap_12
XFILLER_0_19_110 VGND VGND VPWR VPWR sky130_fd_sc_hd__fill_2
XFILLER_0_19_90 VPWR VGND VPWR VGND sky130_ef_sc_hd__decap_12
XFILLER_0_10_81 VGND VGND VPWR VPWR sky130_fd_sc_hd__decap_3
XTAP_TAPCELL_ROW_5_74 VGND VPWR sky130_fd_sc_hd__tapvpwrvgnd_1
XFILLER_0_16_113 VPWR VGND VPWR VGND sky130_ef_sc_hd__decap_12
XPHY_EDGE_ROW_16_Left_44 VGND VGND VPWR VPWR sky130_fd_sc_hd__decap_3
XFILLER_0_6_24 VGND VGND VPWR VPWR sky130_fd_sc_hd__decap_4
XFILLER_0_6_57 VPWR VGND VPWR VGND sky130_ef_sc_hd__decap_12
XANTENNA_1 _082_ VGND VGND VPWR VPWR sky130_fd_sc_hd__diode_2
XTAP_TAPCELL_ROW_27_144 VGND VPWR sky130_fd_sc_hd__tapvpwrvgnd_1
XTopModule_16 VGND VGND VPWR VPWR an[7] TopModule_16/LO sky130_fd_sc_hd__conb_1
XFILLER_0_5_102 VGND VGND VPWR VPWR sky130_fd_sc_hd__decap_8
Xoutput3 net3 VGND VGND VPWR VPWR seg[1] sky130_fd_sc_hd__buf_1
XPHY_EDGE_ROW_1_Left_29 VGND VGND VPWR VPWR sky130_fd_sc_hd__decap_3
XFILLER_0_5_113 VGND VGND VPWR VPWR sky130_fd_sc_hd__fill_1
XFILLER_0_5_146 VPWR VGND VPWR VGND sky130_ef_sc_hd__decap_12
X_297_ _155_ VGND VGND VPWR VPWR _037_ sky130_fd_sc_hd__inv_2
X_220_ _092_ _109_ _110_ VGND VGND VPWR VPWR _111_ sky130_fd_sc_hd__and3_1
XFILLER_0_18_48 VPWR VGND VPWR VGND sky130_ef_sc_hd__decap_12
XTAP_TAPCELL_ROW_12_95 VGND VPWR sky130_fd_sc_hd__tapvpwrvgnd_1
X_349_ clknet_2_2__leaf_clk _019_ _055_ VGND VGND VPWR VPWR counter.one_second_counter\[26\]
+ sky130_fd_sc_hd__dfrtp_1
XTAP_TAPCELL_ROW_8_85 VGND VPWR sky130_fd_sc_hd__tapvpwrvgnd_1
X_203_ counter.one_second_counter\[6\] _097_ VGND VGND VPWR VPWR _098_ sky130_fd_sc_hd__or2_1
XFILLER_0_20_27 VGND VGND VPWR VPWR sky130_fd_sc_hd__fill_1
XFILLER_0_0_15 VPWR VGND VPWR VGND sky130_ef_sc_hd__decap_12
XPHY_EDGE_ROW_4_Left_32 VGND VGND VPWR VPWR sky130_fd_sc_hd__decap_3
XFILLER_0_9_57 VPWR VGND VPWR VGND sky130_ef_sc_hd__decap_12
XFILLER_0_25_136 VPWR VGND VPWR VGND sky130_ef_sc_hd__decap_12
XTAP_TAPCELL_ROW_5_75 VGND VPWR sky130_fd_sc_hd__tapvpwrvgnd_1
XFILLER_0_16_125 VPWR VGND VPWR VGND sky130_ef_sc_hd__decap_12
XFILLER_0_26_15 VGND VGND VPWR VPWR sky130_fd_sc_hd__decap_4
XFILLER_0_21_161 VGND VGND VPWR VPWR sky130_fd_sc_hd__decap_3
XFILLER_0_6_69 VPWR VGND VPWR VGND sky130_ef_sc_hd__decap_12
XANTENNA_2 _146_ VGND VGND VPWR VPWR sky130_fd_sc_hd__diode_2
XFILLER_0_8_111 VGND VGND VPWR VPWR sky130_fd_sc_hd__decap_6
XTAP_TAPCELL_ROW_27_145 VGND VPWR sky130_fd_sc_hd__tapvpwrvgnd_1
XTAP_TAPCELL_ROW_2_65 VGND VPWR sky130_fd_sc_hd__tapvpwrvgnd_1
Xoutput4 net4 VGND VGND VPWR VPWR seg[2] sky130_fd_sc_hd__buf_1
XFILLER_0_5_158 VGND VGND VPWR VPWR sky130_fd_sc_hd__decap_4
XFILLER_0_5_169 VPWR VGND VPWR VGND sky130_ef_sc_hd__decap_12
XFILLER_0_23_16 VPWR VGND VPWR VGND sky130_ef_sc_hd__decap_12
XTAP_TAPCELL_ROW_15_104 VGND VPWR sky130_fd_sc_hd__tapvpwrvgnd_1
X_296_ _155_ VGND VGND VPWR VPWR _036_ sky130_fd_sc_hd__inv_2
XFILLER_0_7_90 VPWR VGND VPWR VGND sky130_ef_sc_hd__decap_12
XFILLER_0_2_139 VGND VGND VPWR VPWR sky130_fd_sc_hd__fill_1
XTAP_TAPCELL_ROW_12_96 VGND VPWR sky130_fd_sc_hd__tapvpwrvgnd_1
XPHY_EDGE_ROW_25_Right_25 VGND VGND VPWR VPWR sky130_fd_sc_hd__decap_3
XFILLER_0_18_27 VGND VGND VPWR VPWR sky130_fd_sc_hd__fill_1
XPHY_EDGE_ROW_16_Right_16 VGND VGND VPWR VPWR sky130_fd_sc_hd__decap_3
X_348_ clknet_2_0__leaf_clk _018_ _054_ VGND VGND VPWR VPWR counter.one_second_counter\[25\]
+ sky130_fd_sc_hd__dfrtp_2
X_279_ counter.count\[3\] counter.count\[2\] VGND VGND VPWR VPWR _153_ sky130_fd_sc_hd__nor2_2
XFILLER_0_24_92 VPWR VGND VPWR VGND sky130_ef_sc_hd__decap_12
X_202_ _000_ _096_ _097_ VGND VGND VPWR VPWR _023_ sky130_fd_sc_hd__nor3_1
XFILLER_0_19_81 VGND VGND VPWR VPWR sky130_fd_sc_hd__decap_4
XFILLER_0_0_27 VGND VGND VPWR VPWR sky130_fd_sc_hd__fill_1
XFILLER_0_9_69 VPWR VGND VPWR VGND sky130_ef_sc_hd__decap_12
XFILLER_0_19_189 VGND VGND VPWR VPWR sky130_fd_sc_hd__fill_1
XFILLER_0_25_148 VPWR VGND VPWR VGND sky130_ef_sc_hd__decap_12
XFILLER_0_16_137 VGND VGND VPWR VPWR sky130_fd_sc_hd__decap_3
XTAP_TAPCELL_ROW_5_76 VGND VPWR sky130_fd_sc_hd__tapvpwrvgnd_1
XPHY_EDGE_ROW_2_Right_2 VGND VGND VPWR VPWR sky130_fd_sc_hd__decap_3
XFILLER_0_1_92 VGND VGND VPWR VPWR sky130_fd_sc_hd__fill_1
XANTENNA_3 _060_ VGND VGND VPWR VPWR sky130_fd_sc_hd__diode_2
XFILLER_0_13_107 VGND VGND VPWR VPWR sky130_fd_sc_hd__decap_4
XFILLER_0_12_29 VPWR VGND VPWR VGND sky130_ef_sc_hd__decap_12
XTAP_TAPCELL_ROW_2_66 VGND VPWR sky130_fd_sc_hd__tapvpwrvgnd_1
Xoutput5 net5 VGND VGND VPWR VPWR seg[3] sky130_fd_sc_hd__buf_1
XTAP_TAPCELL_ROW_18_113 VGND VPWR sky130_fd_sc_hd__tapvpwrvgnd_1
XFILLER_0_23_28 VGND VGND VPWR VPWR sky130_fd_sc_hd__decap_3
XTAP_TAPCELL_ROW_15_105 VGND VPWR sky130_fd_sc_hd__tapvpwrvgnd_1
XFILLER_0_11_3 VGND VGND VPWR VPWR sky130_fd_sc_hd__decap_6
XFILLER_0_23_39 VGND VGND VPWR VPWR sky130_fd_sc_hd__decap_8
XFILLER_0_2_118 VGND VGND VPWR VPWR sky130_fd_sc_hd__fill_1
X_295_ _155_ VGND VGND VPWR VPWR _035_ sky130_fd_sc_hd__inv_2
XFILLER_0_13_83 VGND VGND VPWR VPWR sky130_fd_sc_hd__decap_4
XTAP_TAPCELL_ROW_12_97 VGND VPWR sky130_fd_sc_hd__tapvpwrvgnd_1
XFILLER_0_0_3 VPWR VGND VPWR VGND sky130_ef_sc_hd__decap_12
X_347_ clknet_2_2__leaf_clk _017_ _053_ VGND VGND VPWR VPWR counter.one_second_counter\[24\]
+ sky130_fd_sc_hd__dfrtp_4
X_278_ counter.one_second_counter\[26\] counter.one_second_counter\[25\] _092_ _152_
+ VGND VGND VPWR VPWR _019_ sky130_fd_sc_hd__o211a_1
XFILLER_0_20_29 VPWR VGND VPWR VGND sky130_ef_sc_hd__decap_12
XFILLER_0_4_81 VGND VGND VPWR VPWR sky130_fd_sc_hd__decap_3
X_201_ counter.one_second_counter\[5\] counter.one_second_counter\[4\] _073_ VGND
+ VGND VPWR VPWR _097_ sky130_fd_sc_hd__and3_1
XFILLER_0_9_15 VPWR VGND VPWR VGND sky130_ef_sc_hd__decap_12
XFILLER_0_19_113 VGND VGND VPWR VPWR sky130_fd_sc_hd__decap_6
XFILLER_0_19_102 VGND VGND VPWR VPWR sky130_fd_sc_hd__decap_8
XFILLER_0_21_61 VPWR VGND VPWR VGND sky130_ef_sc_hd__decap_12
XFILLER_0_16_61 VGND VGND VPWR VPWR sky130_fd_sc_hd__decap_3
XFILLER_0_6_16 VGND VGND VPWR VPWR sky130_fd_sc_hd__decap_4
XFILLER_0_8_124 VPWR VGND VPWR VGND sky130_ef_sc_hd__decap_12
XFILLER_0_12_141 VPWR VGND VPWR VGND sky130_ef_sc_hd__decap_12
XTAP_TAPCELL_ROW_2_67 VGND VPWR sky130_fd_sc_hd__tapvpwrvgnd_1
Xoutput6 net6 VGND VGND VPWR VPWR seg[4] sky130_fd_sc_hd__buf_1
XTAP_TAPCELL_ROW_18_114 VGND VPWR sky130_fd_sc_hd__tapvpwrvgnd_1
.ends
