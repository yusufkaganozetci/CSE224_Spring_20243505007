* NGSPICE file created from CPU_TOP.ext - technology: sky130A

* Black-box entry subcircuit for sky130_fd_sc_hd__decap_6 abstract view
.subckt sky130_fd_sc_hd__decap_6 VGND VNB VPB VPWR
.ends

* Black-box entry subcircuit for sky130_fd_sc_hd__tapvpwrvgnd_1 abstract view
.subckt sky130_fd_sc_hd__tapvpwrvgnd_1 VGND VPWR
.ends

* Black-box entry subcircuit for sky130_fd_sc_hd__o211a_1 abstract view
.subckt sky130_fd_sc_hd__o211a_1 A1 A2 B1 C1 VGND VNB VPB VPWR X
.ends

* Black-box entry subcircuit for sky130_fd_sc_hd__inv_2 abstract view
.subckt sky130_fd_sc_hd__inv_2 A VGND VNB VPB VPWR Y
.ends

* Black-box entry subcircuit for sky130_ef_sc_hd__decap_12 abstract view
.subckt sky130_ef_sc_hd__decap_12 VPWR VGND VPB VNB
.ends

* Black-box entry subcircuit for sky130_fd_sc_hd__fill_1 abstract view
.subckt sky130_fd_sc_hd__fill_1 VGND VNB VPB VPWR
.ends

* Black-box entry subcircuit for sky130_fd_sc_hd__fill_2 abstract view
.subckt sky130_fd_sc_hd__fill_2 VGND VNB VPB VPWR
.ends

* Black-box entry subcircuit for sky130_fd_sc_hd__or3_1 abstract view
.subckt sky130_fd_sc_hd__or3_1 A B C VGND VNB VPB VPWR X
.ends

* Black-box entry subcircuit for sky130_fd_sc_hd__mux2_1 abstract view
.subckt sky130_fd_sc_hd__mux2_1 A0 A1 S VGND VNB VPB VPWR X
.ends

* Black-box entry subcircuit for sky130_fd_sc_hd__decap_3 abstract view
.subckt sky130_fd_sc_hd__decap_3 VGND VNB VPB VPWR
.ends

* Black-box entry subcircuit for sky130_fd_sc_hd__clkbuf_1 abstract view
.subckt sky130_fd_sc_hd__clkbuf_1 A VGND VNB VPB VPWR X
.ends

* Black-box entry subcircuit for sky130_fd_sc_hd__dlygate4sd1_1 abstract view
.subckt sky130_fd_sc_hd__dlygate4sd1_1 A VGND VNB VPB VPWR X
.ends

* Black-box entry subcircuit for sky130_fd_sc_hd__decap_4 abstract view
.subckt sky130_fd_sc_hd__decap_4 VGND VNB VPB VPWR
.ends

* Black-box entry subcircuit for sky130_fd_sc_hd__o221a_1 abstract view
.subckt sky130_fd_sc_hd__o221a_1 A1 A2 B1 B2 C1 VGND VNB VPB VPWR X
.ends

* Black-box entry subcircuit for sky130_fd_sc_hd__o21a_1 abstract view
.subckt sky130_fd_sc_hd__o21a_1 A1 A2 B1 VGND VNB VPB VPWR X
.ends

* Black-box entry subcircuit for sky130_fd_sc_hd__dfxtp_1 abstract view
.subckt sky130_fd_sc_hd__dfxtp_1 CLK D VGND VNB VPB VPWR Q
.ends

* Black-box entry subcircuit for sky130_fd_sc_hd__buf_8 abstract view
.subckt sky130_fd_sc_hd__buf_8 A VGND VNB VPB VPWR X
.ends

* Black-box entry subcircuit for sky130_fd_sc_hd__nand3b_2 abstract view
.subckt sky130_fd_sc_hd__nand3b_2 A_N B C VGND VNB VPB VPWR Y
.ends

* Black-box entry subcircuit for sky130_fd_sc_hd__buf_2 abstract view
.subckt sky130_fd_sc_hd__buf_2 A VGND VNB VPB VPWR X
.ends

* Black-box entry subcircuit for sky130_fd_sc_hd__and2_1 abstract view
.subckt sky130_fd_sc_hd__and2_1 A B VGND VNB VPB VPWR X
.ends

* Black-box entry subcircuit for sky130_fd_sc_hd__or2_1 abstract view
.subckt sky130_fd_sc_hd__or2_1 A B VGND VNB VPB VPWR X
.ends

* Black-box entry subcircuit for sky130_fd_sc_hd__decap_8 abstract view
.subckt sky130_fd_sc_hd__decap_8 VGND VNB VPB VPWR
.ends

* Black-box entry subcircuit for sky130_fd_sc_hd__dfrtp_1 abstract view
.subckt sky130_fd_sc_hd__dfrtp_1 CLK D RESET_B VGND VNB VPB VPWR Q
.ends

* Black-box entry subcircuit for sky130_fd_sc_hd__buf_6 abstract view
.subckt sky130_fd_sc_hd__buf_6 A VGND VNB VPB VPWR X
.ends

* Black-box entry subcircuit for sky130_fd_sc_hd__or3_2 abstract view
.subckt sky130_fd_sc_hd__or3_2 A B C VGND VNB VPB VPWR X
.ends

* Black-box entry subcircuit for sky130_fd_sc_hd__o211ai_2 abstract view
.subckt sky130_fd_sc_hd__o211ai_2 A1 A2 B1 C1 VGND VNB VPB VPWR Y
.ends

* Black-box entry subcircuit for sky130_fd_sc_hd__o21ai_1 abstract view
.subckt sky130_fd_sc_hd__o21ai_1 A1 A2 B1 VGND VNB VPB VPWR Y
.ends

* Black-box entry subcircuit for sky130_fd_sc_hd__o22a_1 abstract view
.subckt sky130_fd_sc_hd__o22a_1 A1 A2 B1 B2 VGND VNB VPB VPWR X
.ends

* Black-box entry subcircuit for sky130_fd_sc_hd__a21oi_1 abstract view
.subckt sky130_fd_sc_hd__a21oi_1 A1 A2 B1 VGND VNB VPB VPWR Y
.ends

* Black-box entry subcircuit for sky130_fd_sc_hd__nor2_1 abstract view
.subckt sky130_fd_sc_hd__nor2_1 A B VGND VNB VPB VPWR Y
.ends

* Black-box entry subcircuit for sky130_fd_sc_hd__and4_1 abstract view
.subckt sky130_fd_sc_hd__and4_1 A B C D VGND VNB VPB VPWR X
.ends

* Black-box entry subcircuit for sky130_fd_sc_hd__and3_1 abstract view
.subckt sky130_fd_sc_hd__and3_1 A B C VGND VNB VPB VPWR X
.ends

* Black-box entry subcircuit for sky130_fd_sc_hd__or2_4 abstract view
.subckt sky130_fd_sc_hd__or2_4 A B VGND VNB VPB VPWR X
.ends

* Black-box entry subcircuit for sky130_fd_sc_hd__a21o_1 abstract view
.subckt sky130_fd_sc_hd__a21o_1 A1 A2 B1 VGND VNB VPB VPWR X
.ends

* Black-box entry subcircuit for sky130_fd_sc_hd__dlymetal6s2s_1 abstract view
.subckt sky130_fd_sc_hd__dlymetal6s2s_1 A VGND VNB VPB VPWR X
.ends

* Black-box entry subcircuit for sky130_fd_sc_hd__a21boi_2 abstract view
.subckt sky130_fd_sc_hd__a21boi_2 A1 A2 B1_N VGND VNB VPB VPWR Y
.ends

* Black-box entry subcircuit for sky130_fd_sc_hd__buf_1 abstract view
.subckt sky130_fd_sc_hd__buf_1 A VGND VNB VPB VPWR X
.ends

* Black-box entry subcircuit for sky130_fd_sc_hd__clkbuf_4 abstract view
.subckt sky130_fd_sc_hd__clkbuf_4 A VGND VNB VPB VPWR X
.ends

* Black-box entry subcircuit for sky130_fd_sc_hd__nor2_4 abstract view
.subckt sky130_fd_sc_hd__nor2_4 A B VGND VNB VPB VPWR Y
.ends

* Black-box entry subcircuit for sky130_fd_sc_hd__buf_4 abstract view
.subckt sky130_fd_sc_hd__buf_4 A VGND VNB VPB VPWR X
.ends

* Black-box entry subcircuit for sky130_fd_sc_hd__nand2_1 abstract view
.subckt sky130_fd_sc_hd__nand2_1 A B VGND VNB VPB VPWR Y
.ends

* Black-box entry subcircuit for sky130_fd_sc_hd__nor2_2 abstract view
.subckt sky130_fd_sc_hd__nor2_2 A B VGND VNB VPB VPWR Y
.ends

* Black-box entry subcircuit for sky130_fd_sc_hd__a22oi_4 abstract view
.subckt sky130_fd_sc_hd__a22oi_4 A1 A2 B1 B2 VGND VNB VPB VPWR Y
.ends

* Black-box entry subcircuit for sky130_fd_sc_hd__or4_4 abstract view
.subckt sky130_fd_sc_hd__or4_4 A B C D VGND VNB VPB VPWR X
.ends

* Black-box entry subcircuit for sky130_fd_sc_hd__a2bb2o_2 abstract view
.subckt sky130_fd_sc_hd__a2bb2o_2 A1_N A2_N B1 B2 VGND VNB VPB VPWR X
.ends

* Black-box entry subcircuit for sky130_fd_sc_hd__or3_4 abstract view
.subckt sky130_fd_sc_hd__or3_4 A B C VGND VNB VPB VPWR X
.ends

* Black-box entry subcircuit for sky130_fd_sc_hd__or4_1 abstract view
.subckt sky130_fd_sc_hd__or4_1 A B C D VGND VNB VPB VPWR X
.ends

* Black-box entry subcircuit for sky130_fd_sc_hd__nand3_1 abstract view
.subckt sky130_fd_sc_hd__nand3_1 A B C VGND VNB VPB VPWR Y
.ends

* Black-box entry subcircuit for sky130_fd_sc_hd__and4bb_1 abstract view
.subckt sky130_fd_sc_hd__and4bb_1 A_N B_N C D VGND VNB VPB VPWR X
.ends

* Black-box entry subcircuit for sky130_fd_sc_hd__a21oi_2 abstract view
.subckt sky130_fd_sc_hd__a21oi_2 A1 A2 B1 VGND VNB VPB VPWR Y
.ends

* Black-box entry subcircuit for sky130_fd_sc_hd__xor2_1 abstract view
.subckt sky130_fd_sc_hd__xor2_1 A B VGND VNB VPB VPWR X
.ends

* Black-box entry subcircuit for sky130_fd_sc_hd__and4b_1 abstract view
.subckt sky130_fd_sc_hd__and4b_1 A_N B C D VGND VNB VPB VPWR X
.ends

* Black-box entry subcircuit for sky130_fd_sc_hd__a21bo_1 abstract view
.subckt sky130_fd_sc_hd__a21bo_1 A1 A2 B1_N VGND VNB VPB VPWR X
.ends

* Black-box entry subcircuit for sky130_fd_sc_hd__o22ai_1 abstract view
.subckt sky130_fd_sc_hd__o22ai_1 A1 A2 B1 B2 VGND VNB VPB VPWR Y
.ends

* Black-box entry subcircuit for sky130_fd_sc_hd__o21a_2 abstract view
.subckt sky130_fd_sc_hd__o21a_2 A1 A2 B1 VGND VNB VPB VPWR X
.ends

* Black-box entry subcircuit for sky130_fd_sc_hd__o2111a_1 abstract view
.subckt sky130_fd_sc_hd__o2111a_1 A1 A2 B1 C1 D1 VGND VNB VPB VPWR X
.ends

* Black-box entry subcircuit for sky130_fd_sc_hd__or4b_1 abstract view
.subckt sky130_fd_sc_hd__or4b_1 A B C D_N VGND VNB VPB VPWR X
.ends

* Black-box entry subcircuit for sky130_fd_sc_hd__a2bb2o_1 abstract view
.subckt sky130_fd_sc_hd__a2bb2o_1 A1_N A2_N B1 B2 VGND VNB VPB VPWR X
.ends

* Black-box entry subcircuit for sky130_fd_sc_hd__dfrtp_2 abstract view
.subckt sky130_fd_sc_hd__dfrtp_2 CLK D RESET_B VGND VNB VPB VPWR Q
.ends

* Black-box entry subcircuit for sky130_fd_sc_hd__a41o_1 abstract view
.subckt sky130_fd_sc_hd__a41o_1 A1 A2 A3 A4 B1 VGND VNB VPB VPWR X
.ends

* Black-box entry subcircuit for sky130_fd_sc_hd__a21boi_1 abstract view
.subckt sky130_fd_sc_hd__a21boi_1 A1 A2 B1_N VGND VNB VPB VPWR Y
.ends

* Black-box entry subcircuit for sky130_fd_sc_hd__xnor2_1 abstract view
.subckt sky130_fd_sc_hd__xnor2_1 A B VGND VNB VPB VPWR Y
.ends

* Black-box entry subcircuit for sky130_fd_sc_hd__a21oi_4 abstract view
.subckt sky130_fd_sc_hd__a21oi_4 A1 A2 B1 VGND VNB VPB VPWR Y
.ends

* Black-box entry subcircuit for sky130_fd_sc_hd__a221o_1 abstract view
.subckt sky130_fd_sc_hd__a221o_1 A1 A2 B1 B2 C1 VGND VNB VPB VPWR X
.ends

* Black-box entry subcircuit for sky130_fd_sc_hd__o21bai_2 abstract view
.subckt sky130_fd_sc_hd__o21bai_2 A1 A2 B1_N VGND VNB VPB VPWR Y
.ends

* Black-box entry subcircuit for sky130_fd_sc_hd__nand3_4 abstract view
.subckt sky130_fd_sc_hd__nand3_4 A B C VGND VNB VPB VPWR Y
.ends

* Black-box entry subcircuit for sky130_fd_sc_hd__dfrtp_4 abstract view
.subckt sky130_fd_sc_hd__dfrtp_4 CLK D RESET_B VGND VNB VPB VPWR Q
.ends

* Black-box entry subcircuit for sky130_fd_sc_hd__nor3_1 abstract view
.subckt sky130_fd_sc_hd__nor3_1 A B C VGND VNB VPB VPWR Y
.ends

* Black-box entry subcircuit for sky130_fd_sc_hd__a31o_1 abstract view
.subckt sky130_fd_sc_hd__a31o_1 A1 A2 A3 B1 VGND VNB VPB VPWR X
.ends

* Black-box entry subcircuit for sky130_fd_sc_hd__o22a_2 abstract view
.subckt sky130_fd_sc_hd__o22a_2 A1 A2 B1 B2 VGND VNB VPB VPWR X
.ends

* Black-box entry subcircuit for sky130_fd_sc_hd__xnor2_2 abstract view
.subckt sky130_fd_sc_hd__xnor2_2 A B VGND VNB VPB VPWR Y
.ends

* Black-box entry subcircuit for sky130_fd_sc_hd__nand2_2 abstract view
.subckt sky130_fd_sc_hd__nand2_2 A B VGND VNB VPB VPWR Y
.ends

* Black-box entry subcircuit for sky130_fd_sc_hd__clkbuf_8 abstract view
.subckt sky130_fd_sc_hd__clkbuf_8 A VGND VNB VPB VPWR X
.ends

* Black-box entry subcircuit for sky130_fd_sc_hd__o221ai_4 abstract view
.subckt sky130_fd_sc_hd__o221ai_4 A1 A2 B1 B2 C1 VGND VNB VPB VPWR Y
.ends

* Black-box entry subcircuit for sky130_fd_sc_hd__o21ai_2 abstract view
.subckt sky130_fd_sc_hd__o21ai_2 A1 A2 B1 VGND VNB VPB VPWR Y
.ends

* Black-box entry subcircuit for sky130_fd_sc_hd__clkinv_8 abstract view
.subckt sky130_fd_sc_hd__clkinv_8 A VGND VNB VPB VPWR Y
.ends

* Black-box entry subcircuit for sky130_fd_sc_hd__and3b_1 abstract view
.subckt sky130_fd_sc_hd__and3b_1 A_N B C VGND VNB VPB VPWR X
.ends

* Black-box entry subcircuit for sky130_fd_sc_hd__o31a_1 abstract view
.subckt sky130_fd_sc_hd__o31a_1 A1 A2 A3 B1 VGND VNB VPB VPWR X
.ends

* Black-box entry subcircuit for sky130_fd_sc_hd__and2b_1 abstract view
.subckt sky130_fd_sc_hd__and2b_1 A_N B VGND VNB VPB VPWR X
.ends

* Black-box entry subcircuit for sky130_fd_sc_hd__a211o_1 abstract view
.subckt sky130_fd_sc_hd__a211o_1 A1 A2 B1 C1 VGND VNB VPB VPWR X
.ends

* Black-box entry subcircuit for sky130_fd_sc_hd__mux2_2 abstract view
.subckt sky130_fd_sc_hd__mux2_2 A0 A1 S VGND VNB VPB VPWR X
.ends

* Black-box entry subcircuit for sky130_fd_sc_hd__and4b_2 abstract view
.subckt sky130_fd_sc_hd__and4b_2 A_N B C D VGND VNB VPB VPWR X
.ends

* Black-box entry subcircuit for sky130_fd_sc_hd__a22oi_2 abstract view
.subckt sky130_fd_sc_hd__a22oi_2 A1 A2 B1 B2 VGND VNB VPB VPWR Y
.ends

* Black-box entry subcircuit for sky130_fd_sc_hd__o221a_4 abstract view
.subckt sky130_fd_sc_hd__o221a_4 A1 A2 B1 B2 C1 VGND VNB VPB VPWR X
.ends

* Black-box entry subcircuit for sky130_fd_sc_hd__or2b_1 abstract view
.subckt sky130_fd_sc_hd__or2b_1 A B_N VGND VNB VPB VPWR X
.ends

* Black-box entry subcircuit for sky130_fd_sc_hd__nand2_4 abstract view
.subckt sky130_fd_sc_hd__nand2_4 A B VGND VNB VPB VPWR Y
.ends

* Black-box entry subcircuit for sky130_fd_sc_hd__o211ai_1 abstract view
.subckt sky130_fd_sc_hd__o211ai_1 A1 A2 B1 C1 VGND VNB VPB VPWR Y
.ends

* Black-box entry subcircuit for sky130_fd_sc_hd__inv_6 abstract view
.subckt sky130_fd_sc_hd__inv_6 A VGND VNB VPB VPWR Y
.ends

* Black-box entry subcircuit for sky130_fd_sc_hd__o311a_1 abstract view
.subckt sky130_fd_sc_hd__o311a_1 A1 A2 A3 B1 C1 VGND VNB VPB VPWR X
.ends

* Black-box entry subcircuit for sky130_fd_sc_hd__a32o_2 abstract view
.subckt sky130_fd_sc_hd__a32o_2 A1 A2 A3 B1 B2 VGND VNB VPB VPWR X
.ends

* Black-box entry subcircuit for sky130_fd_sc_hd__o2bb2a_1 abstract view
.subckt sky130_fd_sc_hd__o2bb2a_1 A1_N A2_N B1 B2 VGND VNB VPB VPWR X
.ends

* Black-box entry subcircuit for sky130_fd_sc_hd__a211o_2 abstract view
.subckt sky130_fd_sc_hd__a211o_2 A1 A2 B1 C1 VGND VNB VPB VPWR X
.ends

* Black-box entry subcircuit for sky130_fd_sc_hd__inv_12 abstract view
.subckt sky130_fd_sc_hd__inv_12 A VGND VNB VPB VPWR Y
.ends

* Black-box entry subcircuit for sky130_fd_sc_hd__or4bb_4 abstract view
.subckt sky130_fd_sc_hd__or4bb_4 A B C_N D_N VGND VNB VPB VPWR X
.ends

* Black-box entry subcircuit for sky130_fd_sc_hd__a311o_1 abstract view
.subckt sky130_fd_sc_hd__a311o_1 A1 A2 A3 B1 C1 VGND VNB VPB VPWR X
.ends

* Black-box entry subcircuit for sky130_fd_sc_hd__or3b_1 abstract view
.subckt sky130_fd_sc_hd__or3b_1 A B C_N VGND VNB VPB VPWR X
.ends

* Black-box entry subcircuit for sky130_fd_sc_hd__a211oi_1 abstract view
.subckt sky130_fd_sc_hd__a211oi_1 A1 A2 B1 C1 VGND VNB VPB VPWR Y
.ends

* Black-box entry subcircuit for sky130_fd_sc_hd__clkinv_4 abstract view
.subckt sky130_fd_sc_hd__clkinv_4 A VGND VNB VPB VPWR Y
.ends

* Black-box entry subcircuit for sky130_fd_sc_hd__a2111o_1 abstract view
.subckt sky130_fd_sc_hd__a2111o_1 A1 A2 B1 C1 D1 VGND VNB VPB VPWR X
.ends

* Black-box entry subcircuit for sky130_fd_sc_hd__clkbuf_2 abstract view
.subckt sky130_fd_sc_hd__clkbuf_2 A VGND VNB VPB VPWR X
.ends

* Black-box entry subcircuit for sky130_fd_sc_hd__clkbuf_16 abstract view
.subckt sky130_fd_sc_hd__clkbuf_16 A VGND VNB VPB VPWR X
.ends

* Black-box entry subcircuit for sky130_fd_sc_hd__nor3_2 abstract view
.subckt sky130_fd_sc_hd__nor3_2 A B C VGND VNB VPB VPWR Y
.ends

* Black-box entry subcircuit for sky130_fd_sc_hd__or3b_2 abstract view
.subckt sky130_fd_sc_hd__or3b_2 A B C_N VGND VNB VPB VPWR X
.ends

* Black-box entry subcircuit for sky130_fd_sc_hd__inv_8 abstract view
.subckt sky130_fd_sc_hd__inv_8 A VGND VNB VPB VPWR Y
.ends

* Black-box entry subcircuit for sky130_fd_sc_hd__nor4_4 abstract view
.subckt sky130_fd_sc_hd__nor4_4 A B C D VGND VNB VPB VPWR Y
.ends

* Black-box entry subcircuit for sky130_fd_sc_hd__o2111ai_4 abstract view
.subckt sky130_fd_sc_hd__o2111ai_4 A1 A2 B1 C1 D1 VGND VNB VPB VPWR Y
.ends

* Black-box entry subcircuit for sky130_fd_sc_hd__nor3b_1 abstract view
.subckt sky130_fd_sc_hd__nor3b_1 A B C_N VGND VNB VPB VPWR Y
.ends

* Black-box entry subcircuit for sky130_fd_sc_hd__clkinvlp_4 abstract view
.subckt sky130_fd_sc_hd__clkinvlp_4 A VGND VNB VPB VPWR Y
.ends

* Black-box entry subcircuit for sky130_fd_sc_hd__clkinv_1 abstract view
.subckt sky130_fd_sc_hd__clkinv_1 A VGND VNB VPB VPWR Y
.ends

* Black-box entry subcircuit for sky130_fd_sc_hd__o21bai_1 abstract view
.subckt sky130_fd_sc_hd__o21bai_1 A1 A2 B1_N VGND VNB VPB VPWR Y
.ends

* Black-box entry subcircuit for sky130_fd_sc_hd__a22o_1 abstract view
.subckt sky130_fd_sc_hd__a22o_1 A1 A2 B1 B2 VGND VNB VPB VPWR X
.ends

* Black-box entry subcircuit for sky130_fd_sc_hd__o21ai_4 abstract view
.subckt sky130_fd_sc_hd__o21ai_4 A1 A2 B1 VGND VNB VPB VPWR Y
.ends

* Black-box entry subcircuit for sky130_fd_sc_hd__mux2_4 abstract view
.subckt sky130_fd_sc_hd__mux2_4 A0 A1 S VGND VNB VPB VPWR X
.ends

* Black-box entry subcircuit for sky130_fd_sc_hd__bufinv_16 abstract view
.subckt sky130_fd_sc_hd__bufinv_16 A VGND VNB VPB VPWR Y
.ends

* Black-box entry subcircuit for sky130_fd_sc_hd__o31ai_1 abstract view
.subckt sky130_fd_sc_hd__o31ai_1 A1 A2 A3 B1 VGND VNB VPB VPWR Y
.ends

* Black-box entry subcircuit for sky130_fd_sc_hd__nor4_2 abstract view
.subckt sky130_fd_sc_hd__nor4_2 A B C D VGND VNB VPB VPWR Y
.ends

* Black-box entry subcircuit for sky130_fd_sc_hd__clkinvlp_2 abstract view
.subckt sky130_fd_sc_hd__clkinvlp_2 A VGND VNB VPB VPWR Y
.ends

* Black-box entry subcircuit for sky130_fd_sc_hd__xor2_2 abstract view
.subckt sky130_fd_sc_hd__xor2_2 A B VGND VNB VPB VPWR X
.ends

* Black-box entry subcircuit for sky130_fd_sc_hd__or2b_4 abstract view
.subckt sky130_fd_sc_hd__or2b_4 A B_N VGND VNB VPB VPWR X
.ends

* Black-box entry subcircuit for sky130_fd_sc_hd__inv_16 abstract view
.subckt sky130_fd_sc_hd__inv_16 A VGND VNB VPB VPWR Y
.ends

* Black-box entry subcircuit for sky130_fd_sc_hd__o2111ai_2 abstract view
.subckt sky130_fd_sc_hd__o2111ai_2 A1 A2 B1 C1 D1 VGND VNB VPB VPWR Y
.ends

* Black-box entry subcircuit for sky130_fd_sc_hd__buf_12 abstract view
.subckt sky130_fd_sc_hd__buf_12 A VGND VNB VPB VPWR X
.ends

* Black-box entry subcircuit for sky130_fd_sc_hd__a211o_4 abstract view
.subckt sky130_fd_sc_hd__a211o_4 A1 A2 B1 C1 VGND VNB VPB VPWR X
.ends

* Black-box entry subcircuit for sky130_fd_sc_hd__a31o_4 abstract view
.subckt sky130_fd_sc_hd__a31o_4 A1 A2 A3 B1 VGND VNB VPB VPWR X
.ends

* Black-box entry subcircuit for sky130_fd_sc_hd__and3_2 abstract view
.subckt sky130_fd_sc_hd__and3_2 A B C VGND VNB VPB VPWR X
.ends

* Black-box entry subcircuit for sky130_fd_sc_hd__a21o_2 abstract view
.subckt sky130_fd_sc_hd__a21o_2 A1 A2 B1 VGND VNB VPB VPWR X
.ends

* Black-box entry subcircuit for sky130_fd_sc_hd__or2_2 abstract view
.subckt sky130_fd_sc_hd__or2_2 A B VGND VNB VPB VPWR X
.ends

* Black-box entry subcircuit for sky130_fd_sc_hd__o31a_2 abstract view
.subckt sky130_fd_sc_hd__o31a_2 A1 A2 A3 B1 VGND VNB VPB VPWR X
.ends

* Black-box entry subcircuit for sky130_fd_sc_hd__o31ai_4 abstract view
.subckt sky130_fd_sc_hd__o31ai_4 A1 A2 A3 B1 VGND VNB VPB VPWR Y
.ends

* Black-box entry subcircuit for sky130_fd_sc_hd__nor2b_2 abstract view
.subckt sky130_fd_sc_hd__nor2b_2 A B_N VGND VNB VPB VPWR Y
.ends

* Black-box entry subcircuit for sky130_fd_sc_hd__a31oi_4 abstract view
.subckt sky130_fd_sc_hd__a31oi_4 A1 A2 A3 B1 VGND VNB VPB VPWR Y
.ends

* Black-box entry subcircuit for sky130_fd_sc_hd__o311a_4 abstract view
.subckt sky130_fd_sc_hd__o311a_4 A1 A2 A3 B1 C1 VGND VNB VPB VPWR X
.ends

* Black-box entry subcircuit for sky130_fd_sc_hd__or4bb_1 abstract view
.subckt sky130_fd_sc_hd__or4bb_1 A B C_N D_N VGND VNB VPB VPWR X
.ends

* Black-box entry subcircuit for sky130_fd_sc_hd__nand2b_4 abstract view
.subckt sky130_fd_sc_hd__nand2b_4 A_N B VGND VNB VPB VPWR Y
.ends

* Black-box entry subcircuit for sky130_fd_sc_hd__a22o_2 abstract view
.subckt sky130_fd_sc_hd__a22o_2 A1 A2 B1 B2 VGND VNB VPB VPWR X
.ends

* Black-box entry subcircuit for sky130_fd_sc_hd__and3_4 abstract view
.subckt sky130_fd_sc_hd__and3_4 A B C VGND VNB VPB VPWR X
.ends

* Black-box entry subcircuit for sky130_fd_sc_hd__a31oi_2 abstract view
.subckt sky130_fd_sc_hd__a31oi_2 A1 A2 A3 B1 VGND VNB VPB VPWR Y
.ends

* Black-box entry subcircuit for sky130_fd_sc_hd__a32o_1 abstract view
.subckt sky130_fd_sc_hd__a32o_1 A1 A2 A3 B1 B2 VGND VNB VPB VPWR X
.ends

* Black-box entry subcircuit for sky130_fd_sc_hd__o32ai_4 abstract view
.subckt sky130_fd_sc_hd__o32ai_4 A1 A2 A3 B1 B2 VGND VNB VPB VPWR Y
.ends

* Black-box entry subcircuit for sky130_fd_sc_hd__and4_4 abstract view
.subckt sky130_fd_sc_hd__and4_4 A B C D VGND VNB VPB VPWR X
.ends

* Black-box entry subcircuit for sky130_fd_sc_hd__nand4_2 abstract view
.subckt sky130_fd_sc_hd__nand4_2 A B C D VGND VNB VPB VPWR Y
.ends

* Black-box entry subcircuit for sky130_fd_sc_hd__or4b_2 abstract view
.subckt sky130_fd_sc_hd__or4b_2 A B C D_N VGND VNB VPB VPWR X
.ends

* Black-box entry subcircuit for sky130_fd_sc_hd__o32a_1 abstract view
.subckt sky130_fd_sc_hd__o32a_1 A1 A2 A3 B1 B2 VGND VNB VPB VPWR X
.ends

* Black-box entry subcircuit for sky130_fd_sc_hd__a221oi_2 abstract view
.subckt sky130_fd_sc_hd__a221oi_2 A1 A2 B1 B2 C1 VGND VNB VPB VPWR Y
.ends

* Black-box entry subcircuit for sky130_fd_sc_hd__or4bb_2 abstract view
.subckt sky130_fd_sc_hd__or4bb_2 A B C_N D_N VGND VNB VPB VPWR X
.ends

* Black-box entry subcircuit for sky130_fd_sc_hd__nor2_8 abstract view
.subckt sky130_fd_sc_hd__nor2_8 A B VGND VNB VPB VPWR Y
.ends

* Black-box entry subcircuit for sky130_fd_sc_hd__or4b_4 abstract view
.subckt sky130_fd_sc_hd__or4b_4 A B C D_N VGND VNB VPB VPWR X
.ends

* Black-box entry subcircuit for sky130_fd_sc_hd__dlymetal6s4s_1 abstract view
.subckt sky130_fd_sc_hd__dlymetal6s4s_1 A VGND VNB VPB VPWR X
.ends

* Black-box entry subcircuit for sky130_fd_sc_hd__o211ai_4 abstract view
.subckt sky130_fd_sc_hd__o211ai_4 A1 A2 B1 C1 VGND VNB VPB VPWR Y
.ends

* Black-box entry subcircuit for sky130_fd_sc_hd__o2111ai_1 abstract view
.subckt sky130_fd_sc_hd__o2111ai_1 A1 A2 B1 C1 D1 VGND VNB VPB VPWR Y
.ends

* Black-box entry subcircuit for sky130_fd_sc_hd__and2_2 abstract view
.subckt sky130_fd_sc_hd__and2_2 A B VGND VNB VPB VPWR X
.ends

* Black-box entry subcircuit for sky130_fd_sc_hd__nand3b_1 abstract view
.subckt sky130_fd_sc_hd__nand3b_1 A_N B C VGND VNB VPB VPWR Y
.ends

.subckt CPU_TOP VGND VPWR an[0] an[1] an[2] an[3] clk control res seg[0] seg[1] seg[2]
+ seg[3] seg[4] seg[5] seg[6]
XFILLER_0_94_77 VGND VGND VPWR VPWR sky130_fd_sc_hd__decap_6
XTAP_TAPCELL_ROW_87_1605 VGND VPWR sky130_fd_sc_hd__tapvpwrvgnd_1
X_3155_ _0701_ _1118_ _1119_ net24 VGND VGND VPWR VPWR _1120_ sky130_fd_sc_hd__o211a_1
X_3086_ _1050_ VGND VGND VPWR VPWR _1051_ sky130_fd_sc_hd__inv_2
XFILLER_0_27_93 VPWR VGND VPWR VGND sky130_ef_sc_hd__decap_12
XFILLER_0_77_623 VGND VGND VPWR VPWR sky130_fd_sc_hd__fill_1
XFILLER_0_77_656 VGND VGND VPWR VPWR sky130_fd_sc_hd__fill_2
XFILLER_0_76_133 VGND VGND VPWR VPWR sky130_fd_sc_hd__decap_6
XFILLER_0_134_83 VGND VGND VPWR VPWR sky130_fd_sc_hd__fill_1
XFILLER_0_76_177 VPWR VGND VPWR VGND sky130_ef_sc_hd__decap_12
XFILLER_0_18_701 VPWR VGND VPWR VGND sky130_ef_sc_hd__decap_12
XFILLER_0_43_81 VPWR VGND VPWR VGND sky130_ef_sc_hd__decap_12
XTAP_TAPCELL_ROW_46_990 VGND VPWR sky130_fd_sc_hd__tapvpwrvgnd_1
XFILLER_0_91_125 VPWR VGND VPWR VGND sky130_ef_sc_hd__decap_12
X_3988_ _1739_ _1910_ _1911_ VGND VGND VPWR VPWR _1912_ sky130_fd_sc_hd__or3_1
XFILLER_0_119_279 VGND VGND VPWR VPWR sky130_fd_sc_hd__fill_1
XFILLER_0_91_169 VPWR VGND VPWR VGND sky130_ef_sc_hd__decap_12
X_2939_ cpu_inst.regfile_inst.registers\[5\]\[3\] cpu_inst.regfile_inst.registers\[4\]\[3\]
+ _0675_ VGND VGND VPWR VPWR _0904_ sky130_fd_sc_hd__mux2_1
XFILLER_0_115_441 VGND VGND VPWR VPWR sky130_fd_sc_hd__decap_6
XFILLER_0_115_485 VPWR VGND VPWR VGND sky130_ef_sc_hd__decap_12
XFILLER_0_103_614 VGND VGND VPWR VPWR sky130_fd_sc_hd__fill_2
XTAP_TAPCELL_ROW_98_1767 VGND VPWR sky130_fd_sc_hd__tapvpwrvgnd_1
XFILLER_0_130_433 VPWR VGND VPWR VGND sky130_ef_sc_hd__decap_12
XPHY_EDGE_ROW_107_Left_246 VGND VGND VPWR VPWR sky130_fd_sc_hd__decap_3
X_4609_ _2253_ VGND VGND VPWR VPWR _0310_ sky130_fd_sc_hd__clkbuf_1
XFILLER_0_13_461 VPWR VGND VPWR VGND sky130_ef_sc_hd__decap_12
XFILLER_0_130_477 VPWR VGND VPWR VGND sky130_ef_sc_hd__decap_12
XFILLER_0_7_81 VPWR VGND VPWR VGND sky130_ef_sc_hd__decap_12
XTAP_TAPCELL_ROW_129_2233 VGND VPWR sky130_fd_sc_hd__tapvpwrvgnd_1
XFILLER_0_99_225 VPWR VGND VPWR VGND sky130_ef_sc_hd__decap_12
XTAP_TAPCELL_ROW_5_376 VGND VPWR sky130_fd_sc_hd__tapvpwrvgnd_1
XTAP_TAPCELL_ROW_51_1063 VGND VPWR sky130_fd_sc_hd__tapvpwrvgnd_1
XPHY_EDGE_ROW_116_Left_255 VGND VGND VPWR VPWR sky130_fd_sc_hd__decap_3
XFILLER_0_67_111 VGND VGND VPWR VPWR sky130_fd_sc_hd__fill_1
XFILLER_0_138_533 VPWR VGND VPWR VGND sky130_ef_sc_hd__decap_12
XFILLER_0_95_475 VGND VGND VPWR VPWR sky130_fd_sc_hd__fill_1
XTAP_TAPCELL_ROW_24_662 VGND VPWR sky130_fd_sc_hd__tapvpwrvgnd_1
XFILLER_0_125_205 VPWR VGND VPWR VGND sky130_ef_sc_hd__decap_12
XFILLER_0_125_249 VPWR VGND VPWR VGND sky130_ef_sc_hd__decap_12
XFILLER_0_3_609 VGND VGND VPWR VPWR sky130_fd_sc_hd__decap_6
XFILLER_0_24_737 VPWR VGND VPWR VGND sky130_ef_sc_hd__decap_12
XFILLER_0_36_597 VGND VGND VPWR VPWR sky130_fd_sc_hd__fill_1
XPHY_EDGE_ROW_125_Left_264 VGND VGND VPWR VPWR sky130_fd_sc_hd__decap_3
XFILLER_0_23_225 VPWR VGND VPWR VGND sky130_ef_sc_hd__decap_12
Xrebuffer7 net33 VGND VGND VPWR VPWR net20 sky130_fd_sc_hd__dlygate4sd1_1
XFILLER_0_133_293 VPWR VGND VPWR VGND sky130_ef_sc_hd__decap_12
XFILLER_0_32_781 VPWR VGND VPWR VGND sky130_ef_sc_hd__decap_12
XFILLER_0_48_15 VPWR VGND VPWR VGND sky130_ef_sc_hd__decap_12
XPHY_EDGE_ROW_134_Left_273 VGND VGND VPWR VPWR sky130_fd_sc_hd__decap_3
XFILLER_0_3_39 VPWR VGND VPWR VGND sky130_ef_sc_hd__decap_12
XTAP_TAPCELL_ROW_69_1335 VGND VPWR sky130_fd_sc_hd__tapvpwrvgnd_1
XFILLER_0_99_781 VGND VGND VPWR VPWR sky130_fd_sc_hd__decap_3
XTAP_TAPCELL_ROW_82_1524 VGND VPWR sky130_fd_sc_hd__tapvpwrvgnd_1
X_4960_ _2467_ VGND VGND VPWR VPWR _0447_ sky130_fd_sc_hd__clkbuf_1
XFILLER_0_59_645 VGND VGND VPWR VPWR sky130_fd_sc_hd__decap_4
XFILLER_0_58_133 VGND VGND VPWR VPWR sky130_fd_sc_hd__decap_6
X_3911_ _1835_ _1836_ _1313_ VGND VGND VPWR VPWR _1837_ sky130_fd_sc_hd__mux2_1
XTAP_TAPCELL_ROW_82_1535 VGND VPWR sky130_fd_sc_hd__tapvpwrvgnd_1
X_4891_ _2430_ VGND VGND VPWR VPWR _0415_ sky130_fd_sc_hd__clkbuf_1
XFILLER_0_104_53 VPWR VGND VPWR VGND sky130_ef_sc_hd__decap_12
X_3842_ cpu_inst.regfile_inst.registers\[0\]\[27\] _1667_ _1668_ cpu_inst.regfile_inst.registers\[4\]\[27\]
+ _1560_ VGND VGND VPWR VPWR _1770_ sky130_fd_sc_hd__o221a_1
XFILLER_0_86_497 VGND VGND VPWR VPWR sky130_fd_sc_hd__decap_6
XFILLER_0_73_125 VPWR VGND VPWR VGND sky130_ef_sc_hd__decap_12
XFILLER_0_58_177 VPWR VGND VPWR VGND sky130_ef_sc_hd__decap_12
XFILLER_0_13_51 VGND VGND VPWR VPWR sky130_fd_sc_hd__decap_4
XFILLER_0_104_97 VPWR VGND VPWR VGND sky130_ef_sc_hd__decap_12
XFILLER_0_73_169 VPWR VGND VPWR VGND sky130_ef_sc_hd__decap_12
XFILLER_0_61_309 VGND VGND VPWR VPWR sky130_fd_sc_hd__fill_1
XFILLER_0_39_391 VGND VGND VPWR VPWR sky130_fd_sc_hd__fill_1
X_3773_ _1176_ _1701_ _1702_ VGND VGND VPWR VPWR _1703_ sky130_fd_sc_hd__o21a_1
X_5512_ clknet_leaf_22_clk _0432_ VGND VGND VPWR VPWR cpu_inst.regfile_inst.registers\[8\]\[16\]
+ sky130_fd_sc_hd__dfxtp_1
XFILLER_0_6_469 VGND VGND VPWR VPWR sky130_fd_sc_hd__decap_6
XFILLER_0_125_783 VGND VGND VPWR VPWR sky130_fd_sc_hd__fill_1
XFILLER_0_120_41 VPWR VGND VPWR VGND sky130_ef_sc_hd__decap_12
XTAP_TAPCELL_ROW_113_2001 VGND VPWR sky130_fd_sc_hd__tapvpwrvgnd_1
XFILLER_0_89_55 VGND VGND VPWR VPWR sky130_fd_sc_hd__fill_1
X_2724_ cpu_inst.display_inst.digit_select\[0\] VGND VGND VPWR VPWR _0689_ sky130_fd_sc_hd__inv_2
XFILLER_0_42_545 VGND VGND VPWR VPWR sky130_fd_sc_hd__fill_1
XFILLER_0_112_433 VPWR VGND VPWR VGND sky130_ef_sc_hd__decap_12
X_2655_ _0595_ VGND VGND VPWR VPWR _0620_ sky130_fd_sc_hd__buf_8
X_5443_ clknet_leaf_28_clk _0363_ VGND VGND VPWR VPWR cpu_inst.regfile_inst.registers\[0\]\[11\]
+ sky130_fd_sc_hd__dfxtp_1
XFILLER_0_120_85 VPWR VGND VPWR VGND sky130_ef_sc_hd__decap_12
XFILLER_0_112_477 VPWR VGND VPWR VGND sky130_ef_sc_hd__decap_12
X_5374_ clknet_leaf_34_clk _0294_ VGND VGND VPWR VPWR cpu_inst.regfile_inst.registers\[10\]\[6\]
+ sky130_fd_sc_hd__dfxtp_1
X_4325_ _2107_ VGND VGND VPWR VPWR _0172_ sky130_fd_sc_hd__clkbuf_1
X_2586_ cpu_inst.decoder_inst.current_pc\[1\] cpu_inst.decoder_inst.current_pc\[2\]
+ _0521_ VGND VGND VPWR VPWR _0551_ sky130_fd_sc_hd__nand3b_2
XTAP_TAPCELL_ROW_93_1697 VGND VPWR sky130_fd_sc_hd__tapvpwrvgnd_1
XFILLER_0_10_475 VGND VGND VPWR VPWR sky130_fd_sc_hd__fill_1
X_4256_ _2070_ VGND VGND VPWR VPWR _0140_ sky130_fd_sc_hd__clkbuf_1
X_4187_ _2023_ VGND VGND VPWR VPWR _2035_ sky130_fd_sc_hd__buf_2
X_3207_ _1171_ VGND VGND VPWR VPWR _1172_ sky130_fd_sc_hd__inv_2
X_3138_ _1057_ _0679_ VGND VGND VPWR VPWR _1103_ sky130_fd_sc_hd__and2_1
XTAP_TAPCELL_ROW_2_324 VGND VPWR sky130_fd_sc_hd__tapvpwrvgnd_1
XTAP_TAPCELL_ROW_2_335 VGND VPWR sky130_fd_sc_hd__tapvpwrvgnd_1
XTAP_TAPCELL_ROW_124_2163 VGND VPWR sky130_fd_sc_hd__tapvpwrvgnd_1
X_3069_ cpu_inst.regfile_inst.registers\[8\]\[13\] _0642_ VGND VGND VPWR VPWR _1034_
+ sky130_fd_sc_hd__or2_1
XFILLER_0_49_111 VGND VGND VPWR VPWR sky130_fd_sc_hd__fill_1
XFILLER_0_135_503 VGND VGND VPWR VPWR sky130_fd_sc_hd__fill_1
XFILLER_0_37_317 VPWR VGND VPWR VGND sky130_ef_sc_hd__decap_12
XTAP_TAPCELL_ROW_41_908 VGND VPWR sky130_fd_sc_hd__tapvpwrvgnd_1
XTAP_TAPCELL_ROW_41_919 VGND VPWR sky130_fd_sc_hd__tapvpwrvgnd_1
XFILLER_0_107_205 VPWR VGND VPWR VGND sky130_ef_sc_hd__decap_12
XFILLER_0_92_456 VGND VGND VPWR VPWR sky130_fd_sc_hd__decap_4
XFILLER_0_52_309 VPWR VGND VPWR VGND sky130_ef_sc_hd__decap_12
XFILLER_0_18_531 VGND VGND VPWR VPWR sky130_fd_sc_hd__fill_1
XTAP_TAPCELL_ROW_21_610 VGND VPWR sky130_fd_sc_hd__tapvpwrvgnd_1
XTAP_TAPCELL_ROW_21_621 VGND VPWR sky130_fd_sc_hd__tapvpwrvgnd_1
XFILLER_0_123_709 VPWR VGND VPWR VGND sky130_ef_sc_hd__decap_12
XFILLER_0_107_249 VPWR VGND VPWR VGND sky130_ef_sc_hd__decap_12
XFILLER_0_45_361 VPWR VGND VPWR VGND sky130_ef_sc_hd__decap_12
XFILLER_0_33_534 VGND VGND VPWR VPWR sky130_fd_sc_hd__decap_6
XFILLER_0_115_293 VPWR VGND VPWR VGND sky130_ef_sc_hd__decap_12
XFILLER_0_21_729 VPWR VGND VPWR VGND sky130_ef_sc_hd__decap_12
XFILLER_0_131_753 VPWR VGND VPWR VGND sky130_ef_sc_hd__decap_12
XFILLER_0_14_781 VPWR VGND VPWR VGND sky130_ef_sc_hd__decap_12
XFILLER_0_131_797 VPWR VGND VPWR VGND sky130_ef_sc_hd__decap_12
XFILLER_0_18_29 VPWR VGND VPWR VGND sky130_ef_sc_hd__decap_12
XTAP_TAPCELL_ROW_109_1936 VGND VPWR sky130_fd_sc_hd__tapvpwrvgnd_1
XFILLER_0_87_217 VGND VGND VPWR VPWR sky130_fd_sc_hd__decap_6
XTAP_TAPCELL_ROW_29_732 VGND VPWR sky130_fd_sc_hd__tapvpwrvgnd_1
XFILLER_0_95_261 VPWR VGND VPWR VGND sky130_ef_sc_hd__decap_12
XFILLER_0_83_423 VGND VGND VPWR VPWR sky130_fd_sc_hd__fill_2
XTAP_TAPCELL_ROW_64_1265 VGND VPWR sky130_fd_sc_hd__tapvpwrvgnd_1
XTAP_TAPCELL_ROW_64_1254 VGND VPWR sky130_fd_sc_hd__tapvpwrvgnd_1
XFILLER_0_55_125 VPWR VGND VPWR VGND sky130_ef_sc_hd__decap_12
XFILLER_0_126_525 VGND VGND VPWR VPWR sky130_fd_sc_hd__decap_6
XFILLER_0_50_27 VGND VGND VPWR VPWR sky130_fd_sc_hd__fill_1
XFILLER_0_126_569 VPWR VGND VPWR VGND sky130_ef_sc_hd__decap_12
XFILLER_0_71_629 VGND VGND VPWR VPWR sky130_fd_sc_hd__decap_8
XFILLER_0_55_169 VPWR VGND VPWR VGND sky130_ef_sc_hd__decap_12
XFILLER_0_24_501 VPWR VGND VPWR VGND sky130_ef_sc_hd__decap_12
XFILLER_0_107_783 VGND VGND VPWR VPWR sky130_fd_sc_hd__fill_1
XFILLER_0_70_139 VGND VGND VPWR VPWR sky130_fd_sc_hd__fill_1
XFILLER_0_3_417 VPWR VGND VPWR VGND sky130_ef_sc_hd__decap_12
XFILLER_0_24_545 VGND VGND VPWR VPWR sky130_fd_sc_hd__decap_6
XFILLER_0_24_589 VPWR VGND VPWR VGND sky130_ef_sc_hd__decap_12
XFILLER_0_11_217 VGND VGND VPWR VPWR sky130_fd_sc_hd__decap_6
XFILLER_0_59_69 VPWR VGND VPWR VGND sky130_ef_sc_hd__decap_12
X_4110_ _1223_ cpu_inst.regfile_inst.registers\[25\]\[7\] _1982_ VGND VGND VPWR VPWR
+ _1994_ sky130_fd_sc_hd__mux2_1
X_5090_ clknet_leaf_32_clk _0010_ VGND VGND VPWR VPWR cpu_inst.regfile_inst.registers\[6\]\[10\]
+ sky130_fd_sc_hd__dfxtp_1
XFILLER_0_75_57 VPWR VGND VPWR VGND sky130_ef_sc_hd__decap_12
X_4041_ _1956_ VGND VGND VPWR VPWR _0039_ sky130_fd_sc_hd__clkbuf_1
X_4943_ _1943_ cpu_inst.regfile_inst.registers\[8\]\[23\] _2436_ VGND VGND VPWR VPWR
+ _2459_ sky130_fd_sc_hd__mux2_1
XFILLER_0_47_615 VGND VGND VPWR VPWR sky130_fd_sc_hd__fill_1
XFILLER_0_59_475 VPWR VGND VPWR VGND sky130_ef_sc_hd__decap_12
XFILLER_0_19_317 VPWR VGND VPWR VGND sky130_ef_sc_hd__decap_12
XFILLER_0_24_83 VGND VGND VPWR VPWR sky130_fd_sc_hd__fill_1
XFILLER_0_129_385 VGND VGND VPWR VPWR sky130_fd_sc_hd__decap_6
XFILLER_0_117_503 VGND VGND VPWR VPWR sky130_fd_sc_hd__fill_1
X_4874_ cpu_inst.regfile_inst.registers\[9\]\[23\] VGND VGND VPWR VPWR _2422_ sky130_fd_sc_hd__clkbuf_1
XFILLER_0_62_607 VGND VGND VPWR VPWR sky130_fd_sc_hd__fill_1
XFILLER_0_131_51 VGND VGND VPWR VPWR sky130_fd_sc_hd__decap_4
X_3825_ cpu_inst.regfile_inst.registers\[25\]\[26\] _1285_ _1449_ _1734_ VGND VGND
+ VPWR VPWR _1754_ sky130_fd_sc_hd__o211a_1
XFILLER_0_6_233 VPWR VGND VPWR VGND sky130_ef_sc_hd__decap_12
XFILLER_0_27_361 VPWR VGND VPWR VGND sky130_ef_sc_hd__decap_12
XFILLER_0_34_309 VPWR VGND VPWR VGND sky130_ef_sc_hd__decap_12
X_3756_ _1638_ _1686_ _1451_ VGND VGND VPWR VPWR _1687_ sky130_fd_sc_hd__mux2_1
XFILLER_0_6_277 VPWR VGND VPWR VGND sky130_ef_sc_hd__decap_12
XTAP_TAPCELL_ROW_95_1726 VGND VPWR sky130_fd_sc_hd__tapvpwrvgnd_1
X_2707_ _0670_ _0671_ _0652_ VGND VGND VPWR VPWR _0672_ sky130_fd_sc_hd__mux2_1
XFILLER_0_113_753 VPWR VGND VPWR VGND sky130_ef_sc_hd__decap_12
X_3687_ _1598_ VGND VGND VPWR VPWR _1619_ sky130_fd_sc_hd__inv_2
XFILLER_0_71_3 VPWR VGND VPWR VGND sky130_ef_sc_hd__decap_12
XFILLER_0_70_684 VGND VGND VPWR VPWR sky130_fd_sc_hd__decap_6
X_5426_ clknet_leaf_42_clk _0346_ net2 VGND VGND VPWR VPWR cpu_inst.decoder_inst.current_pc\[26\]
+ sky130_fd_sc_hd__dfrtp_1
XFILLER_0_113_797 VPWR VGND VPWR VGND sky130_ef_sc_hd__decap_12
XTAP_TAPCELL_ROW_7_405 VGND VPWR sky130_fd_sc_hd__tapvpwrvgnd_1
X_2638_ _0602_ VGND VGND VPWR VPWR _0603_ sky130_fd_sc_hd__buf_6
X_5357_ clknet_leaf_18_clk _0277_ VGND VGND VPWR VPWR cpu_inst.regfile_inst.registers\[11\]\[21\]
+ sky130_fd_sc_hd__dfxtp_1
X_2569_ _0510_ _0533_ VGND VGND VPWR VPWR _0534_ sky130_fd_sc_hd__or2_1
X_5288_ clknet_leaf_20_clk _0208_ VGND VGND VPWR VPWR cpu_inst.regfile_inst.registers\[1\]\[16\]
+ sky130_fd_sc_hd__dfxtp_1
X_4308_ _1290_ _1331_ _1330_ VGND VGND VPWR VPWR _2098_ sky130_fd_sc_hd__or3_2
X_4239_ cpu_inst.regfile_inst.registers\[24\]\[4\] VGND VGND VPWR VPWR _2062_ sky130_fd_sc_hd__clkbuf_1
XFILLER_0_69_217 VGND VGND VPWR VPWR sky130_fd_sc_hd__decap_6
XFILLER_0_84_209 VPWR VGND VPWR VGND sky130_ef_sc_hd__decap_12
XFILLER_0_38_604 VGND VGND VPWR VPWR sky130_fd_sc_hd__decap_4
XTAP_TAPCELL_ROW_104_1866 VGND VPWR sky130_fd_sc_hd__tapvpwrvgnd_1
XTAP_TAPCELL_ROW_104_1855 VGND VPWR sky130_fd_sc_hd__tapvpwrvgnd_1
XFILLER_0_77_261 VPWR VGND VPWR VGND sky130_ef_sc_hd__decap_12
XFILLER_0_108_525 VGND VGND VPWR VPWR sky130_fd_sc_hd__decap_6
XFILLER_0_65_434 VGND VGND VPWR VPWR sky130_fd_sc_hd__decap_3
XFILLER_0_37_125 VPWR VGND VPWR VGND sky130_ef_sc_hd__decap_12
XFILLER_0_92_253 VPWR VGND VPWR VGND sky130_ef_sc_hd__decap_12
XFILLER_0_34_810 VGND VGND VPWR VPWR sky130_fd_sc_hd__fill_2
XFILLER_0_37_169 VPWR VGND VPWR VGND sky130_ef_sc_hd__decap_12
XPHY_EDGE_ROW_137_Right_137 VGND VGND VPWR VPWR sky130_fd_sc_hd__decap_3
XTAP_TAPCELL_ROW_137_2354 VGND VPWR sky130_fd_sc_hd__tapvpwrvgnd_1
XFILLER_0_123_517 VPWR VGND VPWR VGND sky130_ef_sc_hd__decap_12
XFILLER_0_52_139 VGND VGND VPWR VPWR sky130_fd_sc_hd__fill_1
XFILLER_0_61_673 VGND VGND VPWR VPWR sky130_fd_sc_hd__decap_3
XFILLER_0_131_561 VPWR VGND VPWR VGND sky130_ef_sc_hd__decap_12
XFILLER_0_21_559 VGND VGND VPWR VPWR sky130_fd_sc_hd__fill_1
XFILLER_0_29_39 VPWR VGND VPWR VGND sky130_ef_sc_hd__decap_12
XFILLER_0_136_29 VPWR VGND VPWR VGND sky130_ef_sc_hd__decap_12
XFILLER_0_45_27 VPWR VGND VPWR VGND sky130_ef_sc_hd__decap_12
XFILLER_0_61_15 VPWR VGND VPWR VGND sky130_ef_sc_hd__decap_12
XFILLER_0_0_29 VPWR VGND VPWR VGND sky130_ef_sc_hd__decap_12
XFILLER_0_56_401 VGND VGND VPWR VPWR sky130_fd_sc_hd__decap_8
XFILLER_0_29_648 VGND VGND VPWR VPWR sky130_fd_sc_hd__decap_3
XFILLER_0_44_607 VGND VGND VPWR VPWR sky130_fd_sc_hd__fill_2
XFILLER_0_138_193 VGND VGND VPWR VPWR sky130_fd_sc_hd__decap_3
XFILLER_0_126_333 VPWR VGND VPWR VGND sky130_ef_sc_hd__decap_12
XFILLER_0_16_309 VPWR VGND VPWR VGND sky130_ef_sc_hd__decap_12
XFILLER_0_126_377 VPWR VGND VPWR VGND sky130_ef_sc_hd__decap_12
XPHY_EDGE_ROW_104_Right_104 VGND VGND VPWR VPWR sky130_fd_sc_hd__decap_3
X_3610_ cpu_inst.regfile_inst.registers\[25\]\[21\] _1252_ _1069_ _1543_ VGND VGND
+ VPWR VPWR _1544_ sky130_fd_sc_hd__o211ai_2
X_4590_ _2243_ VGND VGND VPWR VPWR _0301_ sky130_fd_sc_hd__clkbuf_1
XFILLER_0_9_27 VPWR VGND VPWR VGND sky130_ef_sc_hd__decap_12
XFILLER_0_25_821 VPWR VGND VPWR VGND sky130_ef_sc_hd__decap_12
X_3541_ _0735_ _1475_ _1476_ _0721_ VGND VGND VPWR VPWR _1477_ sky130_fd_sc_hd__o211a_1
XTAP_TAPCELL_ROW_12_484 VGND VPWR sky130_fd_sc_hd__tapvpwrvgnd_1
XTAP_TAPCELL_ROW_12_473 VGND VPWR sky130_fd_sc_hd__tapvpwrvgnd_1
XFILLER_0_4_737 VPWR VGND VPWR VGND sky130_ef_sc_hd__decap_12
XFILLER_0_3_225 VPWR VGND VPWR VGND sky130_ef_sc_hd__decap_12
XTAP_TAPCELL_ROW_77_1456 VGND VPWR sky130_fd_sc_hd__tapvpwrvgnd_1
XFILLER_0_10_41 VPWR VGND VPWR VGND sky130_ef_sc_hd__decap_12
XFILLER_0_51_161 VGND VGND VPWR VPWR sky130_fd_sc_hd__decap_6
XFILLER_0_110_701 VPWR VGND VPWR VGND sky130_ef_sc_hd__decap_12
X_3472_ cpu_inst.regfile_inst.registers\[25\]\[16\] _1310_ _1311_ _1355_ VGND VGND
+ VPWR VPWR _1410_ sky130_fd_sc_hd__o211a_1
XFILLER_0_10_85 VPWR VGND VPWR VGND sky130_ef_sc_hd__decap_12
X_5211_ clknet_leaf_37_clk _0131_ VGND VGND VPWR VPWR cpu_inst.regfile_inst.registers\[24\]\[3\]
+ sky130_fd_sc_hd__dfxtp_1
XTAP_TAPCELL_ROW_90_1656 VGND VPWR sky130_fd_sc_hd__tapvpwrvgnd_1
XTAP_TAPCELL_ROW_90_1645 VGND VPWR sky130_fd_sc_hd__tapvpwrvgnd_1
X_5142_ clknet_leaf_4_clk _0062_ VGND VGND VPWR VPWR cpu_inst.regfile_inst.registers\[2\]\[30\]
+ sky130_fd_sc_hd__dfxtp_1
XFILLER_0_20_581 VGND VGND VPWR VPWR sky130_fd_sc_hd__decap_6
X_5073_ cpu_inst.display_inst.counter\[16\] _2528_ _2531_ _2270_ VGND VGND VPWR VPWR
+ _0496_ sky130_fd_sc_hd__o211a_1
X_4024_ _0687_ _1827_ _1832_ VGND VGND VPWR VPWR _1947_ sky130_fd_sc_hd__o21ai_1
XTAP_TAPCELL_ROW_121_2111 VGND VPWR sky130_fd_sc_hd__tapvpwrvgnd_1
XFILLER_0_79_559 VGND VGND VPWR VPWR sky130_fd_sc_hd__fill_1
XTAP_TAPCELL_ROW_121_2122 VGND VPWR sky130_fd_sc_hd__tapvpwrvgnd_1
XFILLER_0_66_209 VPWR VGND VPWR VGND sky130_ef_sc_hd__decap_12
XFILLER_0_35_93 VPWR VGND VPWR VGND sky130_ef_sc_hd__decap_12
XFILLER_0_137_609 VGND VGND VPWR VPWR sky130_fd_sc_hd__decap_6
XFILLER_0_59_261 VPWR VGND VPWR VGND sky130_ef_sc_hd__decap_12
XFILLER_0_75_765 VPWR VGND VPWR VGND sky130_ef_sc_hd__decap_12
X_4926_ _2450_ VGND VGND VPWR VPWR _0430_ sky130_fd_sc_hd__clkbuf_1
XFILLER_0_19_125 VPWR VGND VPWR VGND sky130_ef_sc_hd__decap_12
XFILLER_0_129_193 VPWR VGND VPWR VGND sky130_ef_sc_hd__decap_12
XFILLER_0_74_253 VPWR VGND VPWR VGND sky130_ef_sc_hd__decap_12
X_4857_ _2413_ VGND VGND VPWR VPWR _0398_ sky130_fd_sc_hd__clkbuf_1
XFILLER_0_19_169 VPWR VGND VPWR VGND sky130_ef_sc_hd__decap_12
XFILLER_0_28_670 VPWR VGND VPWR VGND sky130_ef_sc_hd__decap_12
XFILLER_0_51_81 VPWR VGND VPWR VGND sky130_ef_sc_hd__decap_12
XFILLER_0_105_517 VGND VGND VPWR VPWR sky130_fd_sc_hd__decap_6
XFILLER_0_90_757 VGND VGND VPWR VPWR sky130_fd_sc_hd__fill_2
X_3808_ _1295_ _1736_ _1663_ VGND VGND VPWR VPWR _1737_ sky130_fd_sc_hd__o21a_1
XFILLER_0_7_553 VGND VGND VPWR VPWR sky130_fd_sc_hd__decap_6
XTAP_TAPCELL_ROW_31_760 VGND VPWR sky130_fd_sc_hd__tapvpwrvgnd_1
XTAP_TAPCELL_ROW_31_771 VGND VPWR sky130_fd_sc_hd__tapvpwrvgnd_1
XFILLER_0_34_139 VGND VGND VPWR VPWR sky130_fd_sc_hd__fill_1
XTAP_TAPCELL_ROW_119_2084 VGND VPWR sky130_fd_sc_hd__tapvpwrvgnd_1
XFILLER_0_105_539 VGND VGND VPWR VPWR sky130_fd_sc_hd__decap_6
X_4788_ cpu_inst.regfile_inst.registers\[0\]\[12\] VGND VGND VPWR VPWR _2379_ sky130_fd_sc_hd__clkbuf_1
XFILLER_0_7_597 VPWR VGND VPWR VGND sky130_ef_sc_hd__decap_12
X_3739_ cpu_inst.regfile_inst.registers\[1\]\[24\] _1469_ _1470_ cpu_inst.regfile_inst.registers\[5\]\[24\]
+ VGND VGND VPWR VPWR _1670_ sky130_fd_sc_hd__o22a_1
XFILLER_0_30_301 VGND VGND VPWR VPWR sky130_fd_sc_hd__decap_6
XTAP_TAPCELL_ROW_132_2273 VGND VPWR sky130_fd_sc_hd__tapvpwrvgnd_1
XFILLER_0_113_561 VPWR VGND VPWR VGND sky130_ef_sc_hd__decap_12
XFILLER_0_30_345 VPWR VGND VPWR VGND sky130_ef_sc_hd__decap_12
XTAP_TAPCELL_ROW_132_2284 VGND VPWR sky130_fd_sc_hd__tapvpwrvgnd_1
XFILLER_0_100_233 VPWR VGND VPWR VGND sky130_ef_sc_hd__decap_12
X_5409_ clknet_leaf_4_clk _0329_ net2 VGND VGND VPWR VPWR cpu_inst.decoder_inst.current_pc\[9\]
+ sky130_fd_sc_hd__dfrtp_1
XFILLER_0_30_389 VPWR VGND VPWR VGND sky130_ef_sc_hd__decap_12
XFILLER_0_100_277 VPWR VGND VPWR VGND sky130_ef_sc_hd__decap_12
XFILLER_0_98_813 VPWR VGND VPWR VGND sky130_ef_sc_hd__decap_12
XTAP_TAPCELL_ROW_48_1013 VGND VPWR sky130_fd_sc_hd__tapvpwrvgnd_1
XTAP_TAPCELL_ROW_39_882 VGND VPWR sky130_fd_sc_hd__tapvpwrvgnd_1
XTAP_TAPCELL_ROW_48_1024 VGND VPWR sky130_fd_sc_hd__tapvpwrvgnd_1
XFILLER_0_38_401 VPWR VGND VPWR VGND sky130_ef_sc_hd__decap_12
XFILLER_0_66_754 VGND VGND VPWR VPWR sky130_fd_sc_hd__fill_2
XTAP_TAPCELL_ROW_61_1213 VGND VPWR sky130_fd_sc_hd__tapvpwrvgnd_1
XFILLER_0_108_333 VPWR VGND VPWR VGND sky130_ef_sc_hd__decap_12
XFILLER_0_108_377 VPWR VGND VPWR VGND sky130_ef_sc_hd__decap_12
XFILLER_0_124_837 VGND VGND VPWR VPWR sky130_fd_sc_hd__decap_4
XFILLER_0_81_779 VGND VGND VPWR VPWR sky130_fd_sc_hd__decap_4
XFILLER_0_80_245 VGND VGND VPWR VPWR sky130_fd_sc_hd__decap_6
XFILLER_0_80_289 VPWR VGND VPWR VGND sky130_ef_sc_hd__decap_12
XFILLER_0_61_470 VGND VGND VPWR VPWR sky130_fd_sc_hd__decap_6
XFILLER_0_22_813 VPWR VGND VPWR VGND sky130_ef_sc_hd__decap_12
XFILLER_0_33_161 VGND VGND VPWR VPWR sky130_fd_sc_hd__decap_6
XFILLER_0_40_109 VPWR VGND VPWR VGND sky130_ef_sc_hd__decap_12
XFILLER_0_1_729 VPWR VGND VPWR VGND sky130_ef_sc_hd__decap_12
XFILLER_0_131_391 VGND VGND VPWR VPWR sky130_fd_sc_hd__fill_1
XTAP_TAPCELL_ROW_59_1186 VGND VPWR sky130_fd_sc_hd__tapvpwrvgnd_1
XTAP_TAPCELL_ROW_72_1386 VGND VPWR sky130_fd_sc_hd__tapvpwrvgnd_1
XTAP_TAPCELL_ROW_72_1375 VGND VPWR sky130_fd_sc_hd__tapvpwrvgnd_1
XFILLER_0_56_15 VPWR VGND VPWR VGND sky130_ef_sc_hd__decap_12
XFILLER_0_89_813 VPWR VGND VPWR VGND sky130_ef_sc_hd__decap_12
XFILLER_0_88_301 VGND VGND VPWR VPWR sky130_fd_sc_hd__decap_6
XFILLER_0_88_345 VPWR VGND VPWR VGND sky130_ef_sc_hd__decap_12
XFILLER_0_48_209 VPWR VGND VPWR VGND sky130_ef_sc_hd__decap_12
XFILLER_0_119_609 VGND VGND VPWR VPWR sky130_fd_sc_hd__decap_6
XFILLER_0_88_389 VGND VGND VPWR VPWR sky130_fd_sc_hd__decap_8
XTAP_TAPCELL_ROW_17_554 VGND VPWR sky130_fd_sc_hd__tapvpwrvgnd_1
XFILLER_0_57_732 VGND VGND VPWR VPWR sky130_fd_sc_hd__decap_4
X_2972_ _0548_ _0805_ _0932_ VGND VGND VPWR VPWR _0937_ sky130_fd_sc_hd__a21oi_1
XFILLER_0_84_584 VGND VGND VPWR VPWR sky130_fd_sc_hd__fill_1
X_4711_ _2328_ _2329_ VGND VGND VPWR VPWR _2330_ sky130_fd_sc_hd__nor2_1
XFILLER_0_56_253 VPWR VGND VPWR VGND sky130_ef_sc_hd__decap_12
XFILLER_0_17_629 VPWR VGND VPWR VGND sky130_ef_sc_hd__decap_12
XFILLER_0_127_653 VPWR VGND VPWR VGND sky130_ef_sc_hd__decap_12
XFILLER_0_126_141 VPWR VGND VPWR VGND sky130_ef_sc_hd__decap_12
XFILLER_0_112_53 VPWR VGND VPWR VGND sky130_ef_sc_hd__decap_12
XFILLER_0_71_223 VGND VGND VPWR VPWR sky130_fd_sc_hd__fill_1
X_4642_ _1089_ _1167_ _1195_ _2274_ VGND VGND VPWR VPWR _2275_ sky130_fd_sc_hd__and4_1
XFILLER_0_4_501 VPWR VGND VPWR VGND sky130_ef_sc_hd__decap_12
XFILLER_0_16_139 VGND VGND VPWR VPWR sky130_fd_sc_hd__fill_1
XFILLER_0_127_697 VPWR VGND VPWR VGND sky130_ef_sc_hd__decap_12
XFILLER_0_21_51 VGND VGND VPWR VPWR sky130_fd_sc_hd__decap_4
XFILLER_0_112_97 VPWR VGND VPWR VGND sky130_ef_sc_hd__decap_12
XFILLER_0_12_301 VGND VGND VPWR VPWR sky130_fd_sc_hd__decap_6
XFILLER_0_4_545 VPWR VGND VPWR VGND sky130_ef_sc_hd__decap_12
XFILLER_0_25_673 VPWR VGND VPWR VGND sky130_ef_sc_hd__decap_12
X_4573_ _2234_ VGND VGND VPWR VPWR _0293_ sky130_fd_sc_hd__clkbuf_1
X_3524_ cpu_inst.regfile_inst.registers\[7\]\[19\] cpu_inst.regfile_inst.registers\[6\]\[19\]
+ _0867_ VGND VGND VPWR VPWR _1460_ sky130_fd_sc_hd__mux2_1
XFILLER_0_97_55 VGND VGND VPWR VPWR sky130_fd_sc_hd__fill_1
XFILLER_0_12_345 VPWR VGND VPWR VGND sky130_ef_sc_hd__decap_12
XFILLER_0_4_589 VPWR VGND VPWR VGND sky130_ef_sc_hd__decap_12
XFILLER_0_110_531 VGND VGND VPWR VPWR sky130_fd_sc_hd__fill_1
X_3455_ cpu_inst.regfile_inst.registers\[25\]\[17\] _0693_ _0695_ _1392_ VGND VGND
+ VPWR VPWR _1393_ sky130_fd_sc_hd__o211ai_2
XFILLER_0_12_389 VPWR VGND VPWR VGND sky130_ef_sc_hd__decap_12
X_3386_ _1334_ VGND VGND VPWR VPWR _0006_ sky130_fd_sc_hd__clkbuf_1
X_5125_ clknet_leaf_22_clk _0045_ VGND VGND VPWR VPWR cpu_inst.regfile_inst.registers\[2\]\[13\]
+ sky130_fd_sc_hd__dfxtp_1
XFILLER_0_34_3 VPWR VGND VPWR VGND sky130_ef_sc_hd__decap_12
XFILLER_0_98_109 VPWR VGND VPWR VGND sky130_ef_sc_hd__decap_12
X_5056_ cpu_inst.display_inst.counter\[9\] cpu_inst.display_inst.counter\[10\] _2515_
+ VGND VGND VPWR VPWR _2520_ sky130_fd_sc_hd__and3_1
X_4007_ _0899_ _1309_ _1317_ VGND VGND VPWR VPWR _1930_ sky130_fd_sc_hd__mux2_1
XTAP_TAPCELL_ROW_36_841 VGND VPWR sky130_fd_sc_hd__tapvpwrvgnd_1
XFILLER_0_137_417 VPWR VGND VPWR VGND sky130_ef_sc_hd__decap_12
XTAP_TAPCELL_ROW_101_1814 VGND VPWR sky130_fd_sc_hd__tapvpwrvgnd_1
XFILLER_0_75_573 VGND VGND VPWR VPWR sky130_fd_sc_hd__fill_2
XFILLER_0_63_724 VGND VGND VPWR VPWR sky130_fd_sc_hd__decap_4
X_4909_ _2441_ VGND VGND VPWR VPWR _0422_ sky130_fd_sc_hd__clkbuf_1
XTAP_TAPCELL_ROW_134_2313 VGND VPWR sky130_fd_sc_hd__tapvpwrvgnd_1
XFILLER_0_106_837 VGND VGND VPWR VPWR sky130_fd_sc_hd__decap_4
XFILLER_0_62_245 VGND VGND VPWR VPWR sky130_fd_sc_hd__decap_6
XFILLER_0_7_361 VPWR VGND VPWR VGND sky130_ef_sc_hd__decap_12
XFILLER_0_132_133 VGND VGND VPWR VPWR sky130_fd_sc_hd__decap_6
XFILLER_0_90_598 VGND VGND VPWR VPWR sky130_fd_sc_hd__fill_1
XFILLER_0_62_289 VPWR VGND VPWR VGND sky130_ef_sc_hd__decap_12
XFILLER_0_15_161 VGND VGND VPWR VPWR sky130_fd_sc_hd__decap_6
XFILLER_0_22_109 VPWR VGND VPWR VGND sky130_ef_sc_hd__decap_12
XFILLER_0_132_177 VPWR VGND VPWR VGND sky130_ef_sc_hd__decap_12
XFILLER_0_113_391 VGND VGND VPWR VPWR sky130_fd_sc_hd__fill_1
XFILLER_0_30_153 VPWR VGND VPWR VGND sky130_ef_sc_hd__decap_12
XFILLER_0_30_197 VPWR VGND VPWR VGND sky130_ef_sc_hd__decap_12
XTAP_TAPCELL_ROW_112_1987 VGND VPWR sky130_fd_sc_hd__tapvpwrvgnd_1
XTAP_TAPCELL_ROW_112_1976 VGND VPWR sky130_fd_sc_hd__tapvpwrvgnd_1
XFILLER_0_26_29 VPWR VGND VPWR VGND sky130_ef_sc_hd__decap_12
XFILLER_0_98_654 VPWR VGND VPWR VGND sky130_ef_sc_hd__decap_12
XFILLER_0_85_337 VPWR VGND VPWR VGND sky130_ef_sc_hd__decap_12
XTAP_TAPCELL_ROW_14_513 VGND VPWR sky130_fd_sc_hd__tapvpwrvgnd_1
XFILLER_0_38_253 VPWR VGND VPWR VGND sky130_ef_sc_hd__decap_12
XFILLER_0_124_601 VPWR VGND VPWR VGND sky130_ef_sc_hd__decap_12
XFILLER_0_109_653 VPWR VGND VPWR VGND sky130_ef_sc_hd__decap_12
XFILLER_0_108_141 VPWR VGND VPWR VGND sky130_ef_sc_hd__decap_12
XFILLER_0_54_757 VGND VGND VPWR VPWR sky130_fd_sc_hd__fill_2
XFILLER_0_54_735 VGND VGND VPWR VPWR sky130_fd_sc_hd__decap_6
XFILLER_0_53_223 VGND VGND VPWR VPWR sky130_fd_sc_hd__fill_1
XFILLER_0_123_111 VGND VGND VPWR VPWR sky130_fd_sc_hd__fill_1
XFILLER_0_109_697 VPWR VGND VPWR VGND sky130_ef_sc_hd__decap_12
XFILLER_0_81_554 VGND VGND VPWR VPWR sky130_fd_sc_hd__decap_6
XFILLER_0_124_645 VPWR VGND VPWR VGND sky130_ef_sc_hd__decap_12
XFILLER_0_111_317 VPWR VGND VPWR VGND sky130_ef_sc_hd__decap_12
XTAP_TAPCELL_ROW_74_1404 VGND VPWR sky130_fd_sc_hd__tapvpwrvgnd_1
XFILLER_0_22_643 VGND VGND VPWR VPWR sky130_fd_sc_hd__fill_1
XTAP_TAPCELL_ROW_74_1415 VGND VPWR sky130_fd_sc_hd__tapvpwrvgnd_1
XFILLER_0_10_805 VGND VGND VPWR VPWR sky130_fd_sc_hd__decap_6
XFILLER_0_1_559 VGND VGND VPWR VPWR sky130_fd_sc_hd__fill_1
XFILLER_0_67_69 VPWR VGND VPWR VGND sky130_ef_sc_hd__decap_12
X_3240_ _0685_ _1204_ VGND VGND VPWR VPWR _1205_ sky130_fd_sc_hd__or2_4
X_3171_ _1049_ _1111_ _1135_ VGND VGND VPWR VPWR _1136_ sky130_fd_sc_hd__a21o_1
XFILLER_0_83_57 VPWR VGND VPWR VGND sky130_ef_sc_hd__decap_12
Xrebuffer17 net31 VGND VGND VPWR VPWR net30 sky130_fd_sc_hd__dlygate4sd1_1
XFILLER_0_77_805 VGND VGND VPWR VPWR sky130_fd_sc_hd__decap_8
Xrebuffer28 _0633_ VGND VGND VPWR VPWR net41 sky130_fd_sc_hd__dlymetal6s2s_1
XFILLER_0_88_153 VPWR VGND VPWR VGND sky130_ef_sc_hd__decap_12
XFILLER_0_119_417 VPWR VGND VPWR VGND sky130_ef_sc_hd__decap_12
XFILLER_0_88_197 VPWR VGND VPWR VGND sky130_ef_sc_hd__decap_12
XTAP_TAPCELL_ROW_85_1577 VGND VPWR sky130_fd_sc_hd__tapvpwrvgnd_1
XFILLER_0_9_615 VGND VGND VPWR VPWR sky130_fd_sc_hd__fill_1
XTAP_TAPCELL_ROW_33_800 VGND VPWR sky130_fd_sc_hd__tapvpwrvgnd_1
XFILLER_0_91_329 VGND VGND VPWR VPWR sky130_fd_sc_hd__decap_6
X_2955_ _0918_ _0889_ _0919_ VGND VGND VPWR VPWR _0920_ sky130_fd_sc_hd__a21boi_2
XFILLER_0_32_83 VGND VGND VPWR VPWR sky130_fd_sc_hd__fill_1
XFILLER_0_45_724 VGND VGND VPWR VPWR sky130_fd_sc_hd__fill_1
XFILLER_0_127_461 VPWR VGND VPWR VGND sky130_ef_sc_hd__decap_12
X_2886_ cpu_inst.regfile_inst.registers\[2\]\[12\] _0848_ _0849_ cpu_inst.regfile_inst.registers\[7\]\[12\]
+ _0850_ VGND VGND VPWR VPWR _0851_ sky130_fd_sc_hd__o221a_1
XFILLER_0_5_821 VPWR VGND VPWR VGND sky130_ef_sc_hd__decap_12
XFILLER_0_44_245 VGND VGND VPWR VPWR sky130_fd_sc_hd__decap_6
XTAP_TAPCELL_ROW_116_2043 VGND VPWR sky130_fd_sc_hd__tapvpwrvgnd_1
XFILLER_0_114_133 VGND VGND VPWR VPWR sky130_fd_sc_hd__decap_6
X_4625_ _2261_ VGND VGND VPWR VPWR _0318_ sky130_fd_sc_hd__clkbuf_1
XFILLER_0_44_289 VPWR VGND VPWR VGND sky130_ef_sc_hd__decap_12
XFILLER_0_114_177 VPWR VGND VPWR VGND sky130_ef_sc_hd__decap_12
X_4556_ cpu_inst.regfile_inst.registers\[11\]\[29\] VGND VGND VPWR VPWR _2226_ sky130_fd_sc_hd__clkbuf_1
XFILLER_0_130_637 VGND VGND VPWR VPWR sky130_fd_sc_hd__decap_6
X_3507_ _1428_ _1442_ VGND VGND VPWR VPWR _1444_ sky130_fd_sc_hd__or2_1
XFILLER_0_12_153 VPWR VGND VPWR VGND sky130_ef_sc_hd__decap_12
XFILLER_0_13_665 VGND VGND VPWR VPWR sky130_fd_sc_hd__decap_6
X_4487_ _2191_ VGND VGND VPWR VPWR _0250_ sky130_fd_sc_hd__clkbuf_1
XFILLER_0_12_197 VPWR VGND VPWR VGND sky130_ef_sc_hd__decap_12
X_3438_ _1346_ _1347_ _1375_ VGND VGND VPWR VPWR _1377_ sky130_fd_sc_hd__and3_1
X_3369_ cpu_inst.regfile_inst.registers\[25\]\[3\] _1310_ _1311_ _0909_ VGND VGND
+ VPWR VPWR _1319_ sky130_fd_sc_hd__o211a_1
XFILLER_0_99_418 VGND VGND VPWR VPWR sky130_fd_sc_hd__decap_4
X_5108_ clknet_leaf_7_clk _0028_ VGND VGND VPWR VPWR cpu_inst.regfile_inst.registers\[6\]\[28\]
+ sky130_fd_sc_hd__dfxtp_1
X_5039_ cpu_inst.display_inst.counter\[4\] cpu_inst.display_inst.counter\[5\] _2507_
+ VGND VGND VPWR VPWR _2509_ sky130_fd_sc_hd__and3_1
XFILLER_0_67_337 VGND VGND VPWR VPWR sky130_fd_sc_hd__decap_3
XTAP_TAPCELL_ROW_0_285 VGND VPWR sky130_fd_sc_hd__tapvpwrvgnd_1
XTAP_TAPCELL_ROW_0_296 VGND VPWR sky130_fd_sc_hd__tapvpwrvgnd_1
XFILLER_0_137_225 VPWR VGND VPWR VGND sky130_ef_sc_hd__decap_12
XFILLER_0_82_307 VGND VGND VPWR VPWR sky130_fd_sc_hd__fill_1
XFILLER_0_48_573 VPWR VGND VPWR VGND sky130_ef_sc_hd__decap_12
XFILLER_0_94_189 VGND VGND VPWR VPWR sky130_fd_sc_hd__decap_6
XFILLER_0_91_841 VGND VGND VPWR VPWR sky130_fd_sc_hd__fill_1
XFILLER_0_35_223 VGND VGND VPWR VPWR sky130_fd_sc_hd__fill_1
XFILLER_0_8_681 VPWR VGND VPWR VGND sky130_ef_sc_hd__decap_12
XFILLER_0_36_757 VPWR VGND VPWR VGND sky130_ef_sc_hd__decap_12
XFILLER_0_105_111 VGND VGND VPWR VPWR sky130_fd_sc_hd__fill_1
XFILLER_0_63_598 VGND VGND VPWR VPWR sky130_fd_sc_hd__fill_2
XFILLER_0_23_429 VPWR VGND VPWR VGND sky130_ef_sc_hd__decap_12
XFILLER_0_51_727 VGND VGND VPWR VPWR sky130_fd_sc_hd__fill_1
XFILLER_0_121_615 VGND VGND VPWR VPWR sky130_fd_sc_hd__fill_1
XFILLER_0_106_678 VGND VGND VPWR VPWR sky130_fd_sc_hd__decap_3
XFILLER_0_133_497 VGND VGND VPWR VPWR sky130_fd_sc_hd__decap_6
Xoutput7 net7 VGND VGND VPWR VPWR seg[0] sky130_fd_sc_hd__buf_1
XTAP_TAPCELL_ROW_56_1145 VGND VPWR sky130_fd_sc_hd__tapvpwrvgnd_1
XTAP_TAPCELL_ROW_56_1134 VGND VPWR sky130_fd_sc_hd__tapvpwrvgnd_1
XFILLER_0_31_473 VGND VGND VPWR VPWR sky130_fd_sc_hd__fill_2
XFILLER_0_101_361 VPWR VGND VPWR VGND sky130_ef_sc_hd__decap_12
XFILLER_0_37_39 VPWR VGND VPWR VGND sky130_ef_sc_hd__decap_12
XFILLER_0_53_27 VPWR VGND VPWR VGND sky130_ef_sc_hd__decap_12
XFILLER_0_85_167 VGND VGND VPWR VPWR sky130_fd_sc_hd__fill_1
XFILLER_0_94_690 VGND VGND VPWR VPWR sky130_fd_sc_hd__decap_3
XFILLER_0_39_595 VGND VGND VPWR VPWR sky130_fd_sc_hd__fill_1
XFILLER_0_109_461 VPWR VGND VPWR VGND sky130_ef_sc_hd__decap_12
XTAP_TAPCELL_ROW_80_1496 VGND VPWR sky130_fd_sc_hd__tapvpwrvgnd_1
XFILLER_0_54_554 VGND VGND VPWR VPWR sky130_fd_sc_hd__fill_2
XFILLER_0_26_245 VGND VGND VPWR VPWR sky130_fd_sc_hd__decap_6
X_2740_ _0600_ VGND VGND VPWR VPWR _0705_ sky130_fd_sc_hd__clkbuf_4
XFILLER_0_81_373 VGND VGND VPWR VPWR sky130_fd_sc_hd__decap_8
X_2671_ _0635_ _0616_ VGND VGND VPWR VPWR _0636_ sky130_fd_sc_hd__nor2_4
XFILLER_0_26_289 VPWR VGND VPWR VGND sky130_ef_sc_hd__decap_12
XFILLER_0_42_738 VGND VGND VPWR VPWR sky130_fd_sc_hd__decap_8
XFILLER_0_124_475 VGND VGND VPWR VPWR sky130_fd_sc_hd__fill_1
X_4410_ _2150_ VGND VGND VPWR VPWR _0214_ sky130_fd_sc_hd__clkbuf_1
XFILLER_0_2_813 VPWR VGND VPWR VGND sky130_ef_sc_hd__decap_12
XFILLER_0_41_237 VPWR VGND VPWR VGND sky130_ef_sc_hd__decap_12
XFILLER_0_112_637 VGND VGND VPWR VPWR sky130_fd_sc_hd__decap_6
XFILLER_0_111_125 VPWR VGND VPWR VGND sky130_ef_sc_hd__decap_12
X_5390_ clknet_leaf_14_clk _0310_ VGND VGND VPWR VPWR cpu_inst.regfile_inst.registers\[10\]\[22\]
+ sky130_fd_sc_hd__dfxtp_1
XFILLER_0_111_169 VPWR VGND VPWR VGND sky130_ef_sc_hd__decap_12
X_4341_ _2115_ VGND VGND VPWR VPWR _0180_ sky130_fd_sc_hd__clkbuf_1
XFILLER_0_10_613 VPWR VGND VPWR VGND sky130_ef_sc_hd__decap_12
XFILLER_0_120_681 VPWR VGND VPWR VGND sky130_ef_sc_hd__decap_12
X_4272_ _2078_ VGND VGND VPWR VPWR _0148_ sky130_fd_sc_hd__clkbuf_1
XFILLER_0_10_657 VPWR VGND VPWR VGND sky130_ef_sc_hd__decap_12
X_3223_ _1150_ _1145_ _1062_ VGND VGND VPWR VPWR _1188_ sky130_fd_sc_hd__mux2_1
XFILLER_0_118_41 VPWR VGND VPWR VGND sky130_ef_sc_hd__decap_12
XFILLER_0_118_85 VPWR VGND VPWR VGND sky130_ef_sc_hd__decap_12
XTAP_TAPCELL_ROW_87_1606 VGND VPWR sky130_fd_sc_hd__tapvpwrvgnd_1
X_3154_ cpu_inst.regfile_inst.registers\[8\]\[14\] _0613_ VGND VGND VPWR VPWR _1119_
+ sky130_fd_sc_hd__or2_1
X_3085_ _0862_ _1023_ VGND VGND VPWR VPWR _1050_ sky130_fd_sc_hd__and2_1
XFILLER_0_89_473 VGND VGND VPWR VPWR sky130_fd_sc_hd__decap_3
XFILLER_0_49_337 VPWR VGND VPWR VGND sky130_ef_sc_hd__decap_12
XFILLER_0_119_225 VPWR VGND VPWR VGND sky130_ef_sc_hd__decap_12
XFILLER_0_77_668 VGND VGND VPWR VPWR sky130_fd_sc_hd__decap_4
XFILLER_0_64_307 VGND VGND VPWR VPWR sky130_fd_sc_hd__fill_1
XTAP_TAPCELL_ROW_46_991 VGND VPWR sky130_fd_sc_hd__tapvpwrvgnd_1
X_3987_ cpu_inst.regfile_inst.registers\[1\]\[31\] _1804_ _1805_ cpu_inst.regfile_inst.registers\[5\]\[31\]
+ _0562_ VGND VGND VPWR VPWR _1911_ sky130_fd_sc_hd__o221a_1
XFILLER_0_76_189 VGND VGND VPWR VPWR sky130_fd_sc_hd__decap_6
XFILLER_0_57_381 VGND VGND VPWR VPWR sky130_fd_sc_hd__fill_1
XFILLER_0_18_713 VPWR VGND VPWR VGND sky130_ef_sc_hd__decap_12
XFILLER_0_43_93 VPWR VGND VPWR VGND sky130_ef_sc_hd__decap_12
XFILLER_0_135_729 VPWR VGND VPWR VGND sky130_ef_sc_hd__decap_12
XFILLER_0_128_781 VPWR VGND VPWR VGND sky130_ef_sc_hd__decap_12
XFILLER_0_91_137 VPWR VGND VPWR VGND sky130_ef_sc_hd__decap_12
XFILLER_0_73_841 VGND VGND VPWR VPWR sky130_fd_sc_hd__fill_1
X_2938_ _0557_ VGND VGND VPWR VPWR _0903_ sky130_fd_sc_hd__buf_4
XFILLER_0_17_223 VGND VGND VPWR VPWR sky130_fd_sc_hd__fill_1
XFILLER_0_18_757 VPWR VGND VPWR VGND sky130_ef_sc_hd__decap_12
XFILLER_0_33_727 VGND VGND VPWR VPWR sky130_fd_sc_hd__fill_1
XFILLER_0_130_401 VPWR VGND VPWR VGND sky130_ef_sc_hd__decap_12
XTAP_TAPCELL_ROW_98_1768 VGND VPWR sky130_fd_sc_hd__tapvpwrvgnd_1
XFILLER_0_5_673 VPWR VGND VPWR VGND sky130_ef_sc_hd__decap_12
X_2869_ cpu_inst.regfile_inst.registers\[8\]\[8\] _0598_ VGND VGND VPWR VPWR _0834_
+ sky130_fd_sc_hd__or2_1
XFILLER_0_115_497 VGND VGND VPWR VPWR sky130_fd_sc_hd__decap_6
X_4608_ cpu_inst.regfile_inst.registers\[10\]\[22\] _2252_ VGND VGND VPWR VPWR _2253_
+ sky130_fd_sc_hd__and2_1
XFILLER_0_130_445 VPWR VGND VPWR VGND sky130_ef_sc_hd__decap_12
X_4539_ _2217_ VGND VGND VPWR VPWR _0276_ sky130_fd_sc_hd__clkbuf_1
XFILLER_0_13_473 VPWR VGND VPWR VGND sky130_ef_sc_hd__decap_12
XFILLER_0_130_489 VPWR VGND VPWR VGND sky130_ef_sc_hd__decap_12
XFILLER_0_7_93 VPWR VGND VPWR VGND sky130_ef_sc_hd__decap_12
XTAP_TAPCELL_ROW_129_2234 VGND VPWR sky130_fd_sc_hd__tapvpwrvgnd_1
XTAP_TAPCELL_ROW_5_377 VGND VPWR sky130_fd_sc_hd__tapvpwrvgnd_1
XTAP_TAPCELL_ROW_51_1064 VGND VPWR sky130_fd_sc_hd__tapvpwrvgnd_1
XFILLER_0_99_237 VPWR VGND VPWR VGND sky130_ef_sc_hd__decap_12
XFILLER_0_138_501 VGND VGND VPWR VPWR sky130_fd_sc_hd__decap_3
XFILLER_0_67_167 VGND VGND VPWR VPWR sky130_fd_sc_hd__fill_1
XFILLER_0_56_808 VGND VGND VPWR VPWR sky130_fd_sc_hd__decap_4
XFILLER_0_138_545 VPWR VGND VPWR VGND sky130_ef_sc_hd__decap_12
XTAP_TAPCELL_ROW_24_663 VGND VPWR sky130_fd_sc_hd__tapvpwrvgnd_1
XFILLER_0_138_589 VPWR VGND VPWR VGND sky130_ef_sc_hd__decap_12
XFILLER_0_125_217 VGND VGND VPWR VPWR sky130_fd_sc_hd__decap_6
XFILLER_0_91_682 VGND VGND VPWR VPWR sky130_fd_sc_hd__fill_1
XFILLER_0_91_671 VGND VGND VPWR VPWR sky130_fd_sc_hd__fill_1
XFILLER_0_51_513 VPWR VGND VPWR VGND sky130_ef_sc_hd__decap_12
XFILLER_0_133_261 VPWR VGND VPWR VGND sky130_ef_sc_hd__decap_12
XFILLER_0_106_464 VGND VGND VPWR VPWR sky130_fd_sc_hd__decap_4
XFILLER_0_2_109 VPWR VGND VPWR VGND sky130_ef_sc_hd__decap_12
XFILLER_0_23_237 VPWR VGND VPWR VGND sky130_ef_sc_hd__decap_12
XFILLER_0_24_749 VGND VGND VPWR VPWR sky130_fd_sc_hd__decap_6
Xrebuffer8 _0607_ VGND VGND VPWR VPWR net21 sky130_fd_sc_hd__dlygate4sd1_1
XFILLER_0_32_793 VGND VGND VPWR VPWR sky130_fd_sc_hd__decap_8
XFILLER_0_102_681 VGND VGND VPWR VPWR sky130_fd_sc_hd__fill_2
XFILLER_0_31_281 VPWR VGND VPWR VGND sky130_ef_sc_hd__decap_12
XFILLER_0_48_27 VGND VGND VPWR VPWR sky130_fd_sc_hd__fill_1
XFILLER_0_64_15 VPWR VGND VPWR VGND sky130_ef_sc_hd__decap_12
XTAP_TAPCELL_ROW_69_1336 VGND VPWR sky130_fd_sc_hd__tapvpwrvgnd_1
X_3910_ cpu_inst.regfile_inst.registers\[7\]\[29\] cpu_inst.regfile_inst.registers\[6\]\[29\]
+ _1797_ VGND VGND VPWR VPWR _1836_ sky130_fd_sc_hd__mux2_1
XTAP_TAPCELL_ROW_82_1536 VGND VPWR sky130_fd_sc_hd__tapvpwrvgnd_1
XTAP_TAPCELL_ROW_82_1525 VGND VPWR sky130_fd_sc_hd__tapvpwrvgnd_1
X_4890_ cpu_inst.regfile_inst.registers\[9\]\[31\] VGND VGND VPWR VPWR _2430_ sky130_fd_sc_hd__clkbuf_1
XFILLER_0_46_307 VGND VGND VPWR VPWR sky130_fd_sc_hd__fill_1
X_3841_ _1295_ _1748_ _1737_ VGND VGND VPWR VPWR _1769_ sky130_fd_sc_hd__o21a_1
XFILLER_0_58_189 VGND VGND VPWR VPWR sky130_fd_sc_hd__decap_6
XFILLER_0_27_521 VGND VGND VPWR VPWR sky130_fd_sc_hd__decap_4
XTAP_TAPCELL_ROW_43_950 VGND VPWR sky130_fd_sc_hd__tapvpwrvgnd_1
XFILLER_0_117_729 VPWR VGND VPWR VGND sky130_ef_sc_hd__decap_12
XFILLER_0_104_65 VPWR VGND VPWR VGND sky130_ef_sc_hd__decap_12
X_3772_ _1176_ _1640_ VGND VGND VPWR VPWR _1702_ sky130_fd_sc_hd__nand2_1
XFILLER_0_73_137 VPWR VGND VPWR VGND sky130_ef_sc_hd__decap_12
XFILLER_0_55_841 VGND VGND VPWR VPWR sky130_fd_sc_hd__fill_1
XFILLER_0_70_811 VGND VGND VPWR VPWR sky130_fd_sc_hd__fill_1
X_5511_ clknet_leaf_26_clk _0431_ VGND VGND VPWR VPWR cpu_inst.regfile_inst.registers\[8\]\[15\]
+ sky130_fd_sc_hd__dfxtp_1
X_2723_ _0681_ _0687_ VGND VGND VPWR VPWR _0688_ sky130_fd_sc_hd__nor2_2
XFILLER_0_15_727 VGND VGND VPWR VPWR sky130_fd_sc_hd__fill_1
XFILLER_0_42_502 VGND VGND VPWR VPWR sky130_fd_sc_hd__decap_8
XFILLER_0_112_401 VPWR VGND VPWR VGND sky130_ef_sc_hd__decap_12
XFILLER_0_81_181 VPWR VGND VPWR VGND sky130_ef_sc_hd__decap_12
XFILLER_0_27_598 VPWR VGND VPWR VGND sky130_ef_sc_hd__decap_12
XFILLER_0_120_53 VPWR VGND VPWR VGND sky130_ef_sc_hd__decap_12
XTAP_TAPCELL_ROW_113_2002 VGND VPWR sky130_fd_sc_hd__tapvpwrvgnd_1
X_5442_ clknet_leaf_32_clk _0362_ VGND VGND VPWR VPWR cpu_inst.regfile_inst.registers\[0\]\[10\]
+ sky130_fd_sc_hd__dfxtp_1
X_2654_ _0546_ _0562_ net21 _0618_ VGND VGND VPWR VPWR _0619_ sky130_fd_sc_hd__a22oi_4
XFILLER_0_120_97 VPWR VGND VPWR VGND sky130_ef_sc_hd__decap_12
XFILLER_0_112_445 VPWR VGND VPWR VGND sky130_ef_sc_hd__decap_12
XFILLER_0_100_607 VGND VGND VPWR VPWR sky130_fd_sc_hd__fill_2
X_2585_ _0537_ _0538_ _0549_ _0531_ VGND VGND VPWR VPWR _0550_ sky130_fd_sc_hd__or4_4
XFILLER_0_2_643 VGND VGND VPWR VPWR sky130_fd_sc_hd__fill_1
X_5373_ clknet_leaf_35_clk _0293_ VGND VGND VPWR VPWR cpu_inst.regfile_inst.registers\[10\]\[5\]
+ sky130_fd_sc_hd__dfxtp_1
XFILLER_0_112_489 VPWR VGND VPWR VGND sky130_ef_sc_hd__decap_12
X_4324_ _1192_ cpu_inst.regfile_inst.registers\[5\]\[12\] _2105_ VGND VGND VPWR VPWR
+ _2107_ sky130_fd_sc_hd__mux2_1
XFILLER_0_10_421 VPWR VGND VPWR VGND sky130_ef_sc_hd__decap_12
XFILLER_0_129_51 VGND VGND VPWR VPWR sky130_fd_sc_hd__decap_4
XTAP_TAPCELL_ROW_93_1698 VGND VPWR sky130_fd_sc_hd__tapvpwrvgnd_1
X_4255_ cpu_inst.regfile_inst.registers\[24\]\[12\] VGND VGND VPWR VPWR _2070_ sky130_fd_sc_hd__clkbuf_1
X_3206_ net3 _1110_ _1170_ VGND VGND VPWR VPWR _1171_ sky130_fd_sc_hd__o21a_1
X_4186_ _2034_ VGND VGND VPWR VPWR _0106_ sky130_fd_sc_hd__clkbuf_1
X_3137_ net3 _0688_ _1091_ _1101_ VGND VGND VPWR VPWR _1102_ sky130_fd_sc_hd__a2bb2o_2
XTAP_TAPCELL_ROW_2_325 VGND VPWR sky130_fd_sc_hd__tapvpwrvgnd_1
XTAP_TAPCELL_ROW_2_336 VGND VPWR sky130_fd_sc_hd__tapvpwrvgnd_1
XTAP_TAPCELL_ROW_124_2153 VGND VPWR sky130_fd_sc_hd__tapvpwrvgnd_1
XTAP_TAPCELL_ROW_124_2164 VGND VPWR sky130_fd_sc_hd__tapvpwrvgnd_1
XPHY_EDGE_ROW_118_Right_118 VGND VGND VPWR VPWR sky130_fd_sc_hd__decap_3
XFILLER_0_89_281 VPWR VGND VPWR VGND sky130_ef_sc_hd__decap_12
X_3068_ cpu_inst.regfile_inst.registers\[11\]\[13\] cpu_inst.regfile_inst.registers\[10\]\[13\]
+ _0731_ VGND VGND VPWR VPWR _1033_ sky130_fd_sc_hd__mux2_1
XFILLER_0_77_487 VPWR VGND VPWR VGND sky130_ef_sc_hd__decap_12
XFILLER_0_65_638 VGND VGND VPWR VPWR sky130_fd_sc_hd__fill_1
XFILLER_0_37_329 VGND VGND VPWR VPWR sky130_fd_sc_hd__decap_6
XTAP_TAPCELL_ROW_41_909 VGND VPWR sky130_fd_sc_hd__tapvpwrvgnd_1
XFILLER_0_49_167 VGND VGND VPWR VPWR sky130_fd_sc_hd__fill_1
XFILLER_0_107_217 VGND VGND VPWR VPWR sky130_fd_sc_hd__decap_6
XTAP_TAPCELL_ROW_21_611 VGND VPWR sky130_fd_sc_hd__tapvpwrvgnd_1
XFILLER_0_46_841 VGND VGND VPWR VPWR sky130_fd_sc_hd__fill_1
XFILLER_0_135_559 VGND VGND VPWR VPWR sky130_fd_sc_hd__fill_1
XFILLER_0_73_671 VGND VGND VPWR VPWR sky130_fd_sc_hd__fill_1
XFILLER_0_18_587 VGND VGND VPWR VPWR sky130_fd_sc_hd__fill_1
XTAP_TAPCELL_ROW_21_622 VGND VPWR sky130_fd_sc_hd__tapvpwrvgnd_1
XFILLER_0_45_373 VPWR VGND VPWR VGND sky130_ef_sc_hd__decap_12
XFILLER_0_122_209 VPWR VGND VPWR VGND sky130_ef_sc_hd__decap_12
XFILLER_0_131_721 VGND VGND VPWR VPWR sky130_fd_sc_hd__decap_6
XFILLER_0_115_261 VPWR VGND VPWR VGND sky130_ef_sc_hd__decap_12
XFILLER_0_131_765 VPWR VGND VPWR VGND sky130_ef_sc_hd__decap_12
XFILLER_0_130_253 VPWR VGND VPWR VGND sky130_ef_sc_hd__decap_12
XFILLER_0_14_793 VPWR VGND VPWR VGND sky130_ef_sc_hd__decap_12
XFILLER_0_13_281 VPWR VGND VPWR VGND sky130_ef_sc_hd__decap_12
XTAP_TAPCELL_ROW_109_1937 VGND VPWR sky130_fd_sc_hd__tapvpwrvgnd_1
XTAP_TAPCELL_ROW_29_733 VGND VPWR sky130_fd_sc_hd__tapvpwrvgnd_1
XFILLER_0_68_421 VGND VGND VPWR VPWR sky130_fd_sc_hd__decap_6
XFILLER_0_34_29 VPWR VGND VPWR VGND sky130_ef_sc_hd__decap_12
XFILLER_0_96_774 VGND VGND VPWR VPWR sky130_fd_sc_hd__decap_8
XFILLER_0_96_752 VGND VGND VPWR VPWR sky130_fd_sc_hd__decap_4
XFILLER_0_95_273 VGND VGND VPWR VPWR sky130_fd_sc_hd__decap_6
XTAP_TAPCELL_ROW_64_1266 VGND VPWR sky130_fd_sc_hd__tapvpwrvgnd_1
XTAP_TAPCELL_ROW_64_1255 VGND VPWR sky130_fd_sc_hd__tapvpwrvgnd_1
XFILLER_0_28_307 VGND VGND VPWR VPWR sky130_fd_sc_hd__fill_1
XFILLER_0_55_137 VPWR VGND VPWR VGND sky130_ef_sc_hd__decap_12
XFILLER_0_37_841 VGND VGND VPWR VPWR sky130_fd_sc_hd__fill_1
XFILLER_0_52_800 VGND VGND VPWR VPWR sky130_fd_sc_hd__decap_8
XFILLER_0_24_513 VPWR VGND VPWR VGND sky130_ef_sc_hd__decap_12
XFILLER_0_63_181 VPWR VGND VPWR VGND sky130_ef_sc_hd__decap_12
XFILLER_0_134_581 VGND VGND VPWR VPWR sky130_fd_sc_hd__decap_6
XFILLER_0_59_15 VPWR VGND VPWR VGND sky130_ef_sc_hd__decap_12
XFILLER_0_3_429 VPWR VGND VPWR VGND sky130_ef_sc_hd__decap_12
XFILLER_0_75_69 VPWR VGND VPWR VGND sky130_ef_sc_hd__decap_12
X_4040_ cpu_inst.regfile_inst.registers\[2\]\[7\] VGND VGND VPWR VPWR _1956_ sky130_fd_sc_hd__clkbuf_1
XFILLER_0_91_57 VPWR VGND VPWR VGND sky130_ef_sc_hd__decap_12
X_4942_ _2458_ VGND VGND VPWR VPWR _0438_ sky130_fd_sc_hd__clkbuf_1
XFILLER_0_86_251 VGND VGND VPWR VPWR sky130_fd_sc_hd__fill_1
XFILLER_0_59_487 VPWR VGND VPWR VGND sky130_ef_sc_hd__decap_12
XFILLER_0_19_329 VGND VGND VPWR VPWR sky130_fd_sc_hd__decap_6
X_4873_ _2421_ VGND VGND VPWR VPWR _0406_ sky130_fd_sc_hd__clkbuf_1
XFILLER_0_28_841 VGND VGND VPWR VPWR sky130_fd_sc_hd__fill_1
XFILLER_0_117_559 VGND VGND VPWR VPWR sky130_fd_sc_hd__fill_1
X_3824_ _1751_ _1752_ VGND VGND VPWR VPWR _1753_ sky130_fd_sc_hd__or2_1
XFILLER_0_55_671 VGND VGND VPWR VPWR sky130_fd_sc_hd__fill_1
XFILLER_0_104_209 VPWR VGND VPWR VGND sky130_ef_sc_hd__decap_12
X_3755_ cpu_inst.regfile_inst.registers\[25\]\[24\] _1285_ _1449_ _1660_ VGND VGND
+ VPWR VPWR _1686_ sky130_fd_sc_hd__o211a_1
XFILLER_0_6_245 VGND VGND VPWR VPWR sky130_fd_sc_hd__decap_6
XFILLER_0_27_373 VPWR VGND VPWR VGND sky130_ef_sc_hd__decap_12
XFILLER_0_42_321 VPWR VGND VPWR VGND sky130_ef_sc_hd__decap_12
XFILLER_0_113_721 VGND VGND VPWR VPWR sky130_fd_sc_hd__decap_6
XTAP_TAPCELL_ROW_95_1727 VGND VPWR sky130_fd_sc_hd__tapvpwrvgnd_1
X_3686_ cpu_inst.regfile_inst.registers\[25\]\[23\] _0693_ _1311_ _1617_ VGND VGND
+ VPWR VPWR _1618_ sky130_fd_sc_hd__o211a_1
XFILLER_0_70_674 VGND VGND VPWR VPWR sky130_fd_sc_hd__decap_4
XFILLER_0_6_289 VPWR VGND VPWR VGND sky130_ef_sc_hd__decap_12
X_2706_ cpu_inst.regfile_inst.registers\[7\]\[0\] cpu_inst.regfile_inst.registers\[6\]\[0\]
+ _0648_ VGND VGND VPWR VPWR _0671_ sky130_fd_sc_hd__mux2_1
XFILLER_0_40_83 VGND VGND VPWR VPWR sky130_fd_sc_hd__fill_1
XFILLER_0_42_365 VPWR VGND VPWR VGND sky130_ef_sc_hd__decap_12
XFILLER_0_113_765 VPWR VGND VPWR VGND sky130_ef_sc_hd__decap_12
X_5425_ clknet_leaf_42_clk _0345_ net2 VGND VGND VPWR VPWR cpu_inst.decoder_inst.current_pc\[25\]
+ sky130_fd_sc_hd__dfrtp_1
XPHY_EDGE_ROW_12_Right_12 VGND VGND VPWR VPWR sky130_fd_sc_hd__decap_3
X_2637_ _0528_ _0588_ _0570_ VGND VGND VPWR VPWR _0602_ sky130_fd_sc_hd__or3_4
XFILLER_0_112_253 VPWR VGND VPWR VGND sky130_ef_sc_hd__decap_12
XFILLER_0_64_3 VPWR VGND VPWR VGND sky130_ef_sc_hd__decap_12
XFILLER_0_11_741 VPWR VGND VPWR VGND sky130_ef_sc_hd__decap_12
XTAP_TAPCELL_ROW_7_406 VGND VPWR sky130_fd_sc_hd__tapvpwrvgnd_1
X_5356_ clknet_leaf_17_clk _0276_ VGND VGND VPWR VPWR cpu_inst.regfile_inst.registers\[11\]\[20\]
+ sky130_fd_sc_hd__dfxtp_1
X_2568_ cpu_inst.decoder_inst.current_pc\[5\] cpu_inst.decoder_inst.current_pc\[4\]
+ cpu_inst.decoder_inst.current_pc\[7\] cpu_inst.decoder_inst.current_pc\[6\] VGND
+ VGND VPWR VPWR _0533_ sky130_fd_sc_hd__or4_1
XFILLER_0_11_785 VPWR VGND VPWR VGND sky130_ef_sc_hd__decap_12
XFILLER_0_10_251 VGND VGND VPWR VPWR sky130_fd_sc_hd__fill_1
XFILLER_0_49_81 VPWR VGND VPWR VGND sky130_ef_sc_hd__decap_12
X_5287_ clknet_leaf_21_clk _0207_ VGND VGND VPWR VPWR cpu_inst.regfile_inst.registers\[1\]\[15\]
+ sky130_fd_sc_hd__dfxtp_1
X_4307_ _2097_ VGND VGND VPWR VPWR _0164_ sky130_fd_sc_hd__clkbuf_1
X_4238_ _2061_ VGND VGND VPWR VPWR _0131_ sky130_fd_sc_hd__clkbuf_1
XFILLER_0_4_83 VGND VGND VPWR VPWR sky130_fd_sc_hd__fill_1
XFILLER_0_97_505 VPWR VGND VPWR VGND sky130_ef_sc_hd__decap_12
X_4169_ _2026_ VGND VGND VPWR VPWR _0097_ sky130_fd_sc_hd__clkbuf_1
XFILLER_0_97_549 VGND VGND VPWR VPWR sky130_fd_sc_hd__decap_3
XPHY_EDGE_ROW_21_Right_21 VGND VGND VPWR VPWR sky130_fd_sc_hd__decap_3
XTAP_TAPCELL_ROW_104_1867 VGND VPWR sky130_fd_sc_hd__tapvpwrvgnd_1
XTAP_TAPCELL_ROW_104_1856 VGND VPWR sky130_fd_sc_hd__tapvpwrvgnd_1
XFILLER_0_77_273 VGND VGND VPWR VPWR sky130_fd_sc_hd__decap_6
XFILLER_0_65_402 VPWR VGND VPWR VGND sky130_ef_sc_hd__decap_12
XFILLER_0_136_813 VPWR VGND VPWR VGND sky130_ef_sc_hd__decap_12
XFILLER_0_92_221 VPWR VGND VPWR VGND sky130_ef_sc_hd__decap_12
XFILLER_0_19_841 VGND VGND VPWR VPWR sky130_fd_sc_hd__fill_1
XFILLER_0_37_137 VPWR VGND VPWR VGND sky130_ef_sc_hd__decap_12
XFILLER_0_92_265 VPWR VGND VPWR VGND sky130_ef_sc_hd__decap_12
XTAP_TAPCELL_ROW_137_2355 VGND VPWR sky130_fd_sc_hd__tapvpwrvgnd_1
XFILLER_0_45_181 VPWR VGND VPWR VGND sky130_ef_sc_hd__decap_12
XFILLER_0_123_529 VPWR VGND VPWR VGND sky130_ef_sc_hd__decap_12
XFILLER_0_116_581 VGND VGND VPWR VPWR sky130_fd_sc_hd__decap_6
XFILLER_0_21_505 VPWR VGND VPWR VGND sky130_ef_sc_hd__decap_12
XPHY_EDGE_ROW_30_Right_30 VGND VGND VPWR VPWR sky130_fd_sc_hd__decap_3
XFILLER_0_131_573 VPWR VGND VPWR VGND sky130_ef_sc_hd__decap_12
XFILLER_0_60_195 VGND VGND VPWR VPWR sky130_fd_sc_hd__fill_1
XFILLER_0_45_39 VPWR VGND VPWR VGND sky130_ef_sc_hd__decap_12
XFILLER_0_68_251 VGND VGND VPWR VPWR sky130_fd_sc_hd__fill_1
XFILLER_0_61_27 VPWR VGND VPWR VGND sky130_ef_sc_hd__decap_12
XFILLER_0_56_424 VGND VGND VPWR VPWR sky130_fd_sc_hd__decap_4
XFILLER_0_126_301 VGND VGND VPWR VPWR sky130_fd_sc_hd__decap_6
XFILLER_0_56_435 VPWR VGND VPWR VGND sky130_ef_sc_hd__decap_12
XFILLER_0_126_345 VPWR VGND VPWR VGND sky130_ef_sc_hd__decap_12
XFILLER_0_71_449 VGND VGND VPWR VPWR sky130_fd_sc_hd__fill_2
XFILLER_0_9_39 VPWR VGND VPWR VGND sky130_ef_sc_hd__decap_12
XFILLER_0_24_321 VPWR VGND VPWR VGND sky130_ef_sc_hd__decap_12
XFILLER_0_25_833 VGND VGND VPWR VPWR sky130_fd_sc_hd__decap_6
XFILLER_0_126_389 VPWR VGND VPWR VGND sky130_ef_sc_hd__decap_12
X_3540_ cpu_inst.regfile_inst.registers\[8\]\[19\] _0725_ VGND VGND VPWR VPWR _1476_
+ sky130_fd_sc_hd__or2_1
XTAP_TAPCELL_ROW_12_485 VGND VPWR sky130_fd_sc_hd__tapvpwrvgnd_1
XTAP_TAPCELL_ROW_12_474 VGND VPWR sky130_fd_sc_hd__tapvpwrvgnd_1
XFILLER_0_4_749 VGND VGND VPWR VPWR sky130_fd_sc_hd__decap_6
XFILLER_0_101_55 VGND VGND VPWR VPWR sky130_fd_sc_hd__fill_1
XTAP_TAPCELL_ROW_77_1457 VGND VPWR sky130_fd_sc_hd__tapvpwrvgnd_1
XFILLER_0_10_53 VPWR VGND VPWR VGND sky130_ef_sc_hd__decap_12
XFILLER_0_3_237 VPWR VGND VPWR VGND sky130_ef_sc_hd__decap_12
XFILLER_0_24_365 VPWR VGND VPWR VGND sky130_ef_sc_hd__decap_12
XFILLER_0_110_713 VPWR VGND VPWR VGND sky130_ef_sc_hd__decap_12
X_3471_ _1374_ _1376_ _1407_ VGND VGND VPWR VPWR _1409_ sky130_fd_sc_hd__or3_1
X_5210_ clknet_leaf_36_clk _0130_ VGND VGND VPWR VPWR cpu_inst.regfile_inst.registers\[24\]\[2\]
+ sky130_fd_sc_hd__dfxtp_1
XFILLER_0_10_97 VPWR VGND VPWR VGND sky130_ef_sc_hd__decap_12
XFILLER_0_110_757 VPWR VGND VPWR VGND sky130_ef_sc_hd__decap_12
XTAP_TAPCELL_ROW_90_1657 VGND VPWR sky130_fd_sc_hd__tapvpwrvgnd_1
XTAP_TAPCELL_ROW_90_1646 VGND VPWR sky130_fd_sc_hd__tapvpwrvgnd_1
X_5141_ clknet_leaf_6_clk _0061_ VGND VGND VPWR VPWR cpu_inst.regfile_inst.registers\[2\]\[29\]
+ sky130_fd_sc_hd__dfxtp_1
XFILLER_0_19_51 VGND VGND VPWR VPWR sky130_fd_sc_hd__decap_4
X_5072_ cpu_inst.display_inst.counter\[15\] cpu_inst.display_inst.counter\[16\] _2526_
+ VGND VGND VPWR VPWR _2531_ sky130_fd_sc_hd__nand3_1
X_4023_ _0687_ _1785_ _1791_ VGND VGND VPWR VPWR _1946_ sky130_fd_sc_hd__o21ai_1
XFILLER_0_79_505 VGND VGND VPWR VPWR sky130_fd_sc_hd__decap_3
XFILLER_0_126_41 VPWR VGND VPWR VGND sky130_ef_sc_hd__decap_12
XFILLER_0_126_85 VPWR VGND VPWR VGND sky130_ef_sc_hd__decap_12
XTAP_TAPCELL_ROW_121_2112 VGND VPWR sky130_fd_sc_hd__tapvpwrvgnd_1
XFILLER_0_87_582 VGND VGND VPWR VPWR sky130_fd_sc_hd__decap_3
XFILLER_0_59_273 VGND VGND VPWR VPWR sky130_fd_sc_hd__decap_6
XFILLER_0_136_109 VPWR VGND VPWR VGND sky130_ef_sc_hd__decap_12
XFILLER_0_129_161 VGND VGND VPWR VPWR sky130_fd_sc_hd__decap_6
XFILLER_0_118_813 VPWR VGND VPWR VGND sky130_ef_sc_hd__decap_12
XFILLER_0_74_221 VPWR VGND VPWR VGND sky130_ef_sc_hd__decap_12
X_4925_ _1156_ cpu_inst.regfile_inst.registers\[8\]\[14\] _2449_ VGND VGND VPWR VPWR
+ _2450_ sky130_fd_sc_hd__mux2_1
XFILLER_0_19_137 VPWR VGND VPWR VGND sky130_ef_sc_hd__decap_12
XFILLER_0_75_777 VGND VGND VPWR VPWR sky130_fd_sc_hd__decap_6
XFILLER_0_74_265 VPWR VGND VPWR VGND sky130_ef_sc_hd__decap_12
X_4856_ cpu_inst.regfile_inst.registers\[9\]\[14\] VGND VGND VPWR VPWR _2413_ sky130_fd_sc_hd__clkbuf_1
XFILLER_0_16_811 VGND VGND VPWR VPWR sky130_fd_sc_hd__fill_1
X_3807_ _1675_ _1719_ VGND VGND VPWR VPWR _1736_ sky130_fd_sc_hd__nor2_1
XFILLER_0_28_682 VPWR VGND VPWR VGND sky130_ef_sc_hd__decap_12
XTAP_TAPCELL_ROW_31_761 VGND VPWR sky130_fd_sc_hd__tapvpwrvgnd_1
XFILLER_0_51_93 VPWR VGND VPWR VGND sky130_ef_sc_hd__decap_12
XTAP_TAPCELL_ROW_119_2085 VGND VPWR sky130_fd_sc_hd__tapvpwrvgnd_1
XFILLER_0_27_181 VPWR VGND VPWR VGND sky130_ef_sc_hd__decap_12
XTAP_TAPCELL_ROW_31_772 VGND VPWR sky130_fd_sc_hd__tapvpwrvgnd_1
X_4787_ _2378_ VGND VGND VPWR VPWR _0363_ sky130_fd_sc_hd__clkbuf_1
X_3738_ cpu_inst.regfile_inst.registers\[2\]\[24\] _1667_ _1668_ cpu_inst.regfile_inst.registers\[7\]\[24\]
+ _1557_ VGND VGND VPWR VPWR _1669_ sky130_fd_sc_hd__o221a_1
XFILLER_0_31_836 VGND VGND VPWR VPWR sky130_fd_sc_hd__fill_1
XTAP_TAPCELL_ROW_132_2274 VGND VPWR sky130_fd_sc_hd__tapvpwrvgnd_1
XFILLER_0_113_573 VPWR VGND VPWR VGND sky130_ef_sc_hd__decap_12
X_3669_ _1600_ _1576_ _1577_ VGND VGND VPWR VPWR _1602_ sky130_fd_sc_hd__nand3_1
XFILLER_0_42_195 VGND VGND VPWR VPWR sky130_fd_sc_hd__fill_1
XTAP_TAPCELL_ROW_132_2285 VGND VPWR sky130_fd_sc_hd__tapvpwrvgnd_1
X_5408_ clknet_leaf_4_clk _0328_ net2 VGND VGND VPWR VPWR cpu_inst.decoder_inst.current_pc\[8\]
+ sky130_fd_sc_hd__dfrtp_1
XFILLER_0_30_357 VGND VGND VPWR VPWR sky130_fd_sc_hd__decap_6
XFILLER_0_100_245 VGND VGND VPWR VPWR sky130_fd_sc_hd__decap_6
X_5339_ clknet_leaf_38_clk _0259_ VGND VGND VPWR VPWR cpu_inst.regfile_inst.registers\[11\]\[3\]
+ sky130_fd_sc_hd__dfxtp_1
XFILLER_0_100_289 VPWR VGND VPWR VGND sky130_ef_sc_hd__decap_12
XFILLER_0_98_825 VPWR VGND VPWR VGND sky130_ef_sc_hd__decap_12
XFILLER_0_97_335 VGND VGND VPWR VPWR sky130_fd_sc_hd__fill_1
XTAP_TAPCELL_ROW_39_883 VGND VPWR sky130_fd_sc_hd__tapvpwrvgnd_1
XTAP_TAPCELL_ROW_48_1014 VGND VPWR sky130_fd_sc_hd__tapvpwrvgnd_1
XTAP_TAPCELL_ROW_48_1025 VGND VPWR sky130_fd_sc_hd__tapvpwrvgnd_1
XFILLER_0_38_413 VGND VGND VPWR VPWR sky130_fd_sc_hd__decap_6
XFILLER_0_108_301 VGND VGND VPWR VPWR sky130_fd_sc_hd__decap_6
XTAP_TAPCELL_ROW_61_1214 VGND VPWR sky130_fd_sc_hd__tapvpwrvgnd_1
XFILLER_0_136_643 VGND VGND VPWR VPWR sky130_fd_sc_hd__fill_1
XFILLER_0_53_405 VPWR VGND VPWR VGND sky130_ef_sc_hd__decap_12
XFILLER_0_124_805 VGND VGND VPWR VPWR sky130_fd_sc_hd__decap_6
XFILLER_0_108_345 VPWR VGND VPWR VGND sky130_ef_sc_hd__decap_12
XFILLER_0_53_449 VPWR VGND VPWR VGND sky130_ef_sc_hd__decap_12
XFILLER_0_19_671 VGND VGND VPWR VPWR sky130_fd_sc_hd__fill_1
XFILLER_0_108_389 VPWR VGND VPWR VGND sky130_ef_sc_hd__decap_12
XFILLER_0_123_337 VPWR VGND VPWR VGND sky130_ef_sc_hd__decap_12
XFILLER_0_22_825 VPWR VGND VPWR VGND sky130_ef_sc_hd__decap_12
XFILLER_0_21_335 VGND VGND VPWR VPWR sky130_fd_sc_hd__fill_1
XTAP_TAPCELL_ROW_59_1187 VGND VPWR sky130_fd_sc_hd__tapvpwrvgnd_1
XTAP_TAPCELL_ROW_72_1387 VGND VPWR sky130_fd_sc_hd__tapvpwrvgnd_1
XTAP_TAPCELL_ROW_72_1376 VGND VPWR sky130_fd_sc_hd__tapvpwrvgnd_1
XFILLER_0_56_27 VGND VGND VPWR VPWR sky130_fd_sc_hd__fill_1
XFILLER_0_89_825 VPWR VGND VPWR VGND sky130_ef_sc_hd__decap_12
XFILLER_0_72_15 VPWR VGND VPWR VGND sky130_ef_sc_hd__decap_12
XFILLER_0_88_357 VGND VGND VPWR VPWR sky130_fd_sc_hd__decap_6
XTAP_TAPCELL_ROW_17_555 VGND VPWR sky130_fd_sc_hd__tapvpwrvgnd_1
XFILLER_0_118_109 VPWR VGND VPWR VGND sky130_ef_sc_hd__decap_12
X_2971_ _0933_ _0935_ VGND VGND VPWR VPWR _0936_ sky130_fd_sc_hd__nor2_1
XFILLER_0_57_744 VGND VGND VPWR VPWR sky130_fd_sc_hd__decap_8
XFILLER_0_56_221 VPWR VGND VPWR VGND sky130_ef_sc_hd__decap_12
XFILLER_0_8_307 VGND VGND VPWR VPWR sky130_fd_sc_hd__fill_1
XFILLER_0_72_714 VGND VGND VPWR VPWR sky130_fd_sc_hd__fill_1
X_4710_ cpu_inst.decoder_inst.current_pc\[15\] _2323_ cpu_inst.decoder_inst.current_pc\[16\]
+ VGND VGND VPWR VPWR _2329_ sky130_fd_sc_hd__a21oi_1
XFILLER_0_56_265 VPWR VGND VPWR VGND sky130_ef_sc_hd__decap_12
XFILLER_0_127_665 VGND VGND VPWR VPWR sky130_fd_sc_hd__decap_6
XFILLER_0_126_153 VPWR VGND VPWR VGND sky130_ef_sc_hd__decap_12
XFILLER_0_122_3 VPWR VGND VPWR VGND sky130_ef_sc_hd__decap_12
X_4641_ _0686_ _1110_ _1173_ _0681_ VGND VGND VPWR VPWR _2274_ sky130_fd_sc_hd__and4bb_1
XFILLER_0_112_65 VPWR VGND VPWR VGND sky130_ef_sc_hd__decap_12
XFILLER_0_4_513 VPWR VGND VPWR VGND sky130_ef_sc_hd__decap_12
XFILLER_0_126_197 VPWR VGND VPWR VGND sky130_ef_sc_hd__decap_12
XFILLER_0_71_279 VGND VGND VPWR VPWR sky130_fd_sc_hd__fill_1
XFILLER_0_4_557 VPWR VGND VPWR VGND sky130_ef_sc_hd__decap_12
XFILLER_0_25_685 VPWR VGND VPWR VGND sky130_ef_sc_hd__decap_12
X_4572_ cpu_inst.regfile_inst.registers\[10\]\[5\] _2230_ VGND VGND VPWR VPWR _2234_
+ sky130_fd_sc_hd__and2_1
X_3523_ cpu_inst.regfile_inst.registers\[5\]\[19\] cpu_inst.regfile_inst.registers\[4\]\[19\]
+ _1386_ VGND VGND VPWR VPWR _1459_ sky130_fd_sc_hd__mux2_1
XFILLER_0_24_195 VGND VGND VPWR VPWR sky130_fd_sc_hd__fill_1
X_3454_ _0864_ _1389_ _1391_ _0876_ VGND VGND VPWR VPWR _1392_ sky130_fd_sc_hd__o22a_1
XFILLER_0_12_357 VGND VGND VPWR VPWR sky130_fd_sc_hd__decap_6
XFILLER_0_0_741 VPWR VGND VPWR VGND sky130_ef_sc_hd__decap_12
XFILLER_0_110_587 VGND VGND VPWR VPWR sky130_fd_sc_hd__fill_1
XFILLER_0_0_785 VPWR VGND VPWR VGND sky130_ef_sc_hd__decap_12
X_3385_ _1168_ cpu_inst.regfile_inst.registers\[6\]\[6\] _1300_ VGND VGND VPWR VPWR
+ _1334_ sky130_fd_sc_hd__mux2_1
X_5124_ clknet_leaf_22_clk _0044_ VGND VGND VPWR VPWR cpu_inst.regfile_inst.registers\[2\]\[12\]
+ sky130_fd_sc_hd__dfxtp_1
XFILLER_0_137_51 VGND VGND VPWR VPWR sky130_fd_sc_hd__decap_4
X_5055_ cpu_inst.display_inst.counter\[10\] _2517_ _2519_ VGND VGND VPWR VPWR _0490_
+ sky130_fd_sc_hd__o21a_1
X_4006_ _1929_ VGND VGND VPWR VPWR _0031_ sky130_fd_sc_hd__clkbuf_1
XFILLER_0_27_3 VPWR VGND VPWR VGND sky130_ef_sc_hd__decap_12
XFILLER_0_79_335 VGND VGND VPWR VPWR sky130_fd_sc_hd__fill_1
XFILLER_0_67_519 VGND VGND VPWR VPWR sky130_fd_sc_hd__decap_6
XFILLER_0_1_51 VGND VGND VPWR VPWR sky130_fd_sc_hd__decap_4
XTAP_TAPCELL_ROW_36_842 VGND VPWR sky130_fd_sc_hd__tapvpwrvgnd_1
XTAP_TAPCELL_ROW_101_1815 VGND VPWR sky130_fd_sc_hd__tapvpwrvgnd_1
XFILLER_0_137_429 VPWR VGND VPWR VGND sky130_ef_sc_hd__decap_12
XFILLER_0_63_703 VGND VGND VPWR VPWR sky130_fd_sc_hd__decap_8
XFILLER_0_8_841 VGND VGND VPWR VPWR sky130_fd_sc_hd__fill_1
XFILLER_0_35_405 VPWR VGND VPWR VGND sky130_ef_sc_hd__decap_12
X_4908_ _1941_ cpu_inst.regfile_inst.registers\[8\]\[6\] _2436_ VGND VGND VPWR VPWR
+ _2441_ sky130_fd_sc_hd__mux2_1
XFILLER_0_48_788 VGND VGND VPWR VPWR sky130_fd_sc_hd__fill_2
XFILLER_0_118_643 VGND VGND VPWR VPWR sky130_fd_sc_hd__fill_1
XFILLER_0_106_805 VGND VGND VPWR VPWR sky130_fd_sc_hd__decap_6
XTAP_TAPCELL_ROW_134_2314 VGND VPWR sky130_fd_sc_hd__tapvpwrvgnd_1
XTAP_TAPCELL_ROW_134_2303 VGND VPWR sky130_fd_sc_hd__tapvpwrvgnd_1
XFILLER_0_7_373 VPWR VGND VPWR VGND sky130_ef_sc_hd__decap_12
X_4839_ _2404_ VGND VGND VPWR VPWR _0389_ sky130_fd_sc_hd__clkbuf_1
XFILLER_0_105_337 VPWR VGND VPWR VGND sky130_ef_sc_hd__decap_12
XFILLER_0_71_780 VGND VGND VPWR VPWR sky130_fd_sc_hd__decap_4
XFILLER_0_50_419 VGND VGND VPWR VPWR sky130_fd_sc_hd__fill_1
XFILLER_0_120_307 VGND VGND VPWR VPWR sky130_fd_sc_hd__fill_1
XFILLER_0_30_121 VPWR VGND VPWR VGND sky130_ef_sc_hd__decap_12
XFILLER_0_132_189 VGND VGND VPWR VPWR sky130_fd_sc_hd__decap_6
XFILLER_0_30_165 VPWR VGND VPWR VGND sky130_ef_sc_hd__decap_12
XFILLER_0_31_666 VGND VGND VPWR VPWR sky130_fd_sc_hd__decap_3
XTAP_TAPCELL_ROW_112_1977 VGND VPWR sky130_fd_sc_hd__tapvpwrvgnd_1
XFILLER_0_85_305 VPWR VGND VPWR VGND sky130_ef_sc_hd__decap_12
XFILLER_0_85_349 VPWR VGND VPWR VGND sky130_ef_sc_hd__decap_12
XTAP_TAPCELL_ROW_14_503 VGND VPWR sky130_fd_sc_hd__tapvpwrvgnd_1
XFILLER_0_38_221 VPWR VGND VPWR VGND sky130_ef_sc_hd__decap_12
XFILLER_0_39_744 VGND VGND VPWR VPWR sky130_fd_sc_hd__fill_1
XFILLER_0_42_29 VPWR VGND VPWR VGND sky130_ef_sc_hd__decap_12
XTAP_TAPCELL_ROW_14_514 VGND VPWR sky130_fd_sc_hd__tapvpwrvgnd_1
XFILLER_0_38_265 VPWR VGND VPWR VGND sky130_ef_sc_hd__decap_12
XFILLER_0_109_665 VGND VGND VPWR VPWR sky130_fd_sc_hd__decap_6
XFILLER_0_93_393 VGND VGND VPWR VPWR sky130_fd_sc_hd__decap_6
XFILLER_0_124_613 VPWR VGND VPWR VGND sky130_ef_sc_hd__decap_12
XFILLER_0_108_153 VPWR VGND VPWR VGND sky130_ef_sc_hd__decap_12
XFILLER_0_124_657 VPWR VGND VPWR VGND sky130_ef_sc_hd__decap_12
XFILLER_0_108_197 VPWR VGND VPWR VGND sky130_ef_sc_hd__decap_12
XFILLER_0_53_279 VGND VGND VPWR VPWR sky130_fd_sc_hd__fill_1
XFILLER_0_123_167 VGND VGND VPWR VPWR sky130_fd_sc_hd__fill_1
XFILLER_0_1_505 VPWR VGND VPWR VGND sky130_ef_sc_hd__decap_12
XFILLER_0_34_493 VGND VGND VPWR VPWR sky130_fd_sc_hd__fill_1
XFILLER_0_120_841 VGND VGND VPWR VPWR sky130_fd_sc_hd__fill_1
XFILLER_0_111_329 VGND VGND VPWR VPWR sky130_fd_sc_hd__decap_6
XTAP_TAPCELL_ROW_74_1416 VGND VPWR sky130_fd_sc_hd__tapvpwrvgnd_1
XTAP_TAPCELL_ROW_74_1405 VGND VPWR sky130_fd_sc_hd__tapvpwrvgnd_1
XFILLER_0_6_29 VPWR VGND VPWR VGND sky130_ef_sc_hd__decap_12
XFILLER_0_67_15 VPWR VGND VPWR VGND sky130_ef_sc_hd__decap_12
XFILLER_0_22_699 VGND VGND VPWR VPWR sky130_fd_sc_hd__fill_1
X_3170_ _1133_ _1134_ VGND VGND VPWR VPWR _1135_ sky130_fd_sc_hd__nand2_1
XFILLER_0_83_69 VPWR VGND VPWR VGND sky130_ef_sc_hd__decap_12
Xrebuffer18 net32 VGND VGND VPWR VPWR net31 sky130_fd_sc_hd__dlygate4sd1_1
XFILLER_0_88_121 VPWR VGND VPWR VGND sky130_ef_sc_hd__decap_12
XFILLER_0_16_41 VPWR VGND VPWR VGND sky130_ef_sc_hd__decap_12
XFILLER_0_88_165 VPWR VGND VPWR VGND sky130_ef_sc_hd__decap_12
XFILLER_0_77_839 VGND VGND VPWR VPWR sky130_fd_sc_hd__fill_1
XFILLER_0_16_85 VPWR VGND VPWR VGND sky130_ef_sc_hd__decap_12
XTAP_TAPCELL_ROW_85_1578 VGND VPWR sky130_fd_sc_hd__tapvpwrvgnd_1
XTAP_TAPCELL_ROW_33_801 VGND VPWR sky130_fd_sc_hd__tapvpwrvgnd_1
XFILLER_0_119_429 VPWR VGND VPWR VGND sky130_ef_sc_hd__decap_12
XFILLER_0_17_405 VPWR VGND VPWR VGND sky130_ef_sc_hd__decap_12
X_2954_ _0880_ _0888_ VGND VGND VPWR VPWR _0919_ sky130_fd_sc_hd__nand2_1
XFILLER_0_127_473 VPWR VGND VPWR VGND sky130_ef_sc_hd__decap_12
X_2885_ _0725_ VGND VGND VPWR VPWR _0850_ sky130_fd_sc_hd__clkbuf_4
XFILLER_0_84_393 VGND VGND VPWR VPWR sky130_fd_sc_hd__fill_2
XFILLER_0_5_833 VGND VGND VPWR VPWR sky130_fd_sc_hd__decap_6
XFILLER_0_17_449 VPWR VGND VPWR VGND sky130_ef_sc_hd__decap_12
XTAP_TAPCELL_ROW_116_2044 VGND VPWR sky130_fd_sc_hd__tapvpwrvgnd_1
XTAP_TAPCELL_ROW_116_2033 VGND VPWR sky130_fd_sc_hd__tapvpwrvgnd_1
X_4624_ cpu_inst.regfile_inst.registers\[10\]\[30\] _2252_ VGND VGND VPWR VPWR _2261_
+ sky130_fd_sc_hd__and2_1
XPHY_EDGE_ROW_6_Right_6 VGND VGND VPWR VPWR sky130_fd_sc_hd__decap_3
XFILLER_0_4_321 VPWR VGND VPWR VGND sky130_ef_sc_hd__decap_12
XFILLER_0_32_419 VGND VGND VPWR VPWR sky130_fd_sc_hd__fill_1
XFILLER_0_102_307 VGND VGND VPWR VPWR sky130_fd_sc_hd__fill_1
X_4555_ _2225_ VGND VGND VPWR VPWR _0284_ sky130_fd_sc_hd__clkbuf_1
XFILLER_0_12_121 VPWR VGND VPWR VGND sky130_ef_sc_hd__decap_12
XFILLER_0_4_365 VPWR VGND VPWR VGND sky130_ef_sc_hd__decap_12
XFILLER_0_114_189 VGND VGND VPWR VPWR sky130_fd_sc_hd__decap_6
X_3506_ _1428_ _1442_ VGND VGND VPWR VPWR _1443_ sky130_fd_sc_hd__nand2_1
XFILLER_0_40_452 VGND VGND VPWR VPWR sky130_fd_sc_hd__decap_8
XFILLER_0_111_841 VGND VGND VPWR VPWR sky130_fd_sc_hd__fill_1
X_4486_ _1760_ cpu_inst.regfile_inst.registers\[7\]\[26\] _2186_ VGND VGND VPWR VPWR
+ _2191_ sky130_fd_sc_hd__mux2_1
XFILLER_0_12_165 VPWR VGND VPWR VGND sky130_ef_sc_hd__decap_12
XFILLER_0_40_485 VGND VGND VPWR VPWR sky130_fd_sc_hd__decap_4
X_3437_ _1346_ _1347_ _1375_ VGND VGND VPWR VPWR _1376_ sky130_fd_sc_hd__a21oi_2
X_3368_ _1309_ _1316_ _1317_ VGND VGND VPWR VPWR _1318_ sky130_fd_sc_hd__mux2_1
X_5107_ clknet_leaf_8_clk _0027_ VGND VGND VPWR VPWR cpu_inst.regfile_inst.registers\[6\]\[27\]
+ sky130_fd_sc_hd__dfxtp_1
XFILLER_0_57_81 VPWR VGND VPWR VGND sky130_ef_sc_hd__decap_12
X_3299_ _1172_ _1199_ VGND VGND VPWR VPWR _1264_ sky130_fd_sc_hd__nand2_1
X_5038_ cpu_inst.display_inst.counter\[4\] _2507_ VGND VGND VPWR VPWR _0484_ sky130_fd_sc_hd__xor2_1
XFILLER_0_95_625 VGND VGND VPWR VPWR sky130_fd_sc_hd__decap_3
XFILLER_0_95_614 VGND VGND VPWR VPWR sky130_fd_sc_hd__fill_2
XTAP_TAPCELL_ROW_0_286 VGND VPWR sky130_fd_sc_hd__tapvpwrvgnd_1
XTAP_TAPCELL_ROW_0_297 VGND VPWR sky130_fd_sc_hd__tapvpwrvgnd_1
XFILLER_0_137_237 VPWR VGND VPWR VGND sky130_ef_sc_hd__decap_12
XFILLER_0_63_500 VGND VGND VPWR VPWR sky130_fd_sc_hd__decap_4
XFILLER_0_48_585 VGND VGND VPWR VPWR sky130_fd_sc_hd__decap_3
XFILLER_0_75_393 VGND VGND VPWR VPWR sky130_fd_sc_hd__fill_1
XFILLER_0_36_769 VPWR VGND VPWR VGND sky130_ef_sc_hd__decap_12
XFILLER_0_90_363 VGND VGND VPWR VPWR sky130_fd_sc_hd__fill_1
XFILLER_0_8_693 VGND VGND VPWR VPWR sky130_fd_sc_hd__decap_6
XFILLER_0_7_181 VPWR VGND VPWR VGND sky130_ef_sc_hd__decap_12
XFILLER_0_35_279 VGND VGND VPWR VPWR sky130_fd_sc_hd__fill_1
XFILLER_0_105_167 VGND VGND VPWR VPWR sky130_fd_sc_hd__fill_1
XFILLER_0_90_385 VGND VGND VPWR VPWR sky130_fd_sc_hd__fill_1
XFILLER_0_31_441 VGND VGND VPWR VPWR sky130_fd_sc_hd__decap_6
Xoutput8 net8 VGND VGND VPWR VPWR seg[1] sky130_fd_sc_hd__buf_1
XFILLER_0_102_841 VGND VGND VPWR VPWR sky130_fd_sc_hd__fill_1
Xoutput10 net10 VGND VGND VPWR VPWR seg[3] sky130_fd_sc_hd__buf_1
XTAP_TAPCELL_ROW_56_1146 VGND VPWR sky130_fd_sc_hd__tapvpwrvgnd_1
XTAP_TAPCELL_ROW_56_1135 VGND VPWR sky130_fd_sc_hd__tapvpwrvgnd_1
XFILLER_0_101_373 VPWR VGND VPWR VGND sky130_ef_sc_hd__decap_12
XFILLER_0_98_474 VGND VGND VPWR VPWR sky130_fd_sc_hd__fill_2
XFILLER_0_59_839 VGND VGND VPWR VPWR sky130_fd_sc_hd__fill_1
XFILLER_0_53_39 VPWR VGND VPWR VGND sky130_ef_sc_hd__decap_12
XFILLER_0_85_113 VPWR VGND VPWR VGND sky130_ef_sc_hd__decap_12
XFILLER_0_129_727 VGND VGND VPWR VPWR sky130_fd_sc_hd__fill_1
XFILLER_0_109_473 VPWR VGND VPWR VGND sky130_ef_sc_hd__decap_12
XTAP_TAPCELL_ROW_80_1497 VGND VPWR sky130_fd_sc_hd__tapvpwrvgnd_1
XPHY_EDGE_ROW_59_Right_59 VGND VGND VPWR VPWR sky130_fd_sc_hd__decap_3
XFILLER_0_124_421 VPWR VGND VPWR VGND sky130_ef_sc_hd__decap_12
XFILLER_0_14_419 VGND VGND VPWR VPWR sky130_fd_sc_hd__fill_1
XFILLER_0_41_205 VPWR VGND VPWR VGND sky130_ef_sc_hd__decap_12
X_2670_ _0528_ _0532_ _0542_ _0634_ VGND VGND VPWR VPWR _0635_ sky130_fd_sc_hd__and4b_1
XFILLER_0_41_249 VPWR VGND VPWR VGND sky130_ef_sc_hd__decap_12
XFILLER_0_2_825 VPWR VGND VPWR VGND sky130_ef_sc_hd__decap_12
XFILLER_0_111_137 VPWR VGND VPWR VGND sky130_ef_sc_hd__decap_12
X_4340_ _1534_ cpu_inst.regfile_inst.registers\[5\]\[20\] _2105_ VGND VGND VPWR VPWR
+ _2115_ sky130_fd_sc_hd__mux2_1
XFILLER_0_10_625 VPWR VGND VPWR VGND sky130_ef_sc_hd__decap_12
XFILLER_0_1_335 VGND VGND VPWR VPWR sky130_fd_sc_hd__fill_1
X_4271_ cpu_inst.regfile_inst.registers\[24\]\[20\] VGND VGND VPWR VPWR _2078_ sky130_fd_sc_hd__clkbuf_1
XFILLER_0_10_669 VPWR VGND VPWR VGND sky130_ef_sc_hd__decap_12
XFILLER_0_120_693 VGND VGND VPWR VPWR sky130_fd_sc_hd__decap_6
X_3222_ _0770_ _1179_ _1186_ VGND VGND VPWR VPWR _1187_ sky130_fd_sc_hd__o21a_1
XPHY_EDGE_ROW_68_Right_68 VGND VGND VPWR VPWR sky130_fd_sc_hd__decap_3
X_3153_ cpu_inst.regfile_inst.registers\[11\]\[14\] cpu_inst.regfile_inst.registers\[10\]\[14\]
+ _0620_ VGND VGND VPWR VPWR _1118_ sky130_fd_sc_hd__mux2_1
XFILLER_0_118_53 VPWR VGND VPWR VGND sky130_ef_sc_hd__decap_12
XTAP_TAPCELL_ROW_87_1607 VGND VPWR sky130_fd_sc_hd__tapvpwrvgnd_1
XFILLER_0_27_51 VGND VGND VPWR VPWR sky130_fd_sc_hd__decap_4
XFILLER_0_118_97 VPWR VGND VPWR VGND sky130_ef_sc_hd__decap_12
X_3084_ _1026_ _1047_ VGND VGND VPWR VPWR _1049_ sky130_fd_sc_hd__or2_4
XFILLER_0_77_614 VGND VGND VPWR VPWR sky130_fd_sc_hd__fill_2
XFILLER_0_49_305 VPWR VGND VPWR VGND sky130_ef_sc_hd__decap_12
XFILLER_0_134_41 VPWR VGND VPWR VGND sky130_ef_sc_hd__decap_12
XFILLER_0_49_349 VPWR VGND VPWR VGND sky130_ef_sc_hd__decap_12
XFILLER_0_134_85 VPWR VGND VPWR VGND sky130_ef_sc_hd__decap_12
XTAP_TAPCELL_ROW_46_992 VGND VPWR sky130_fd_sc_hd__tapvpwrvgnd_1
XFILLER_0_119_237 VPWR VGND VPWR VGND sky130_ef_sc_hd__decap_12
XFILLER_0_91_105 VGND VGND VPWR VPWR sky130_fd_sc_hd__decap_6
X_3986_ cpu_inst.regfile_inst.registers\[0\]\[31\] _1804_ _1805_ cpu_inst.regfile_inst.registers\[4\]\[31\]
+ _1560_ VGND VGND VPWR VPWR _1910_ sky130_fd_sc_hd__o221a_1
XPHY_EDGE_ROW_77_Right_77 VGND VGND VPWR VPWR sky130_fd_sc_hd__decap_3
XFILLER_0_18_725 VPWR VGND VPWR VGND sky130_ef_sc_hd__decap_12
XFILLER_0_91_149 VPWR VGND VPWR VGND sky130_ef_sc_hd__decap_12
X_2937_ _0890_ _0900_ _0901_ VGND VGND VPWR VPWR _0902_ sky130_fd_sc_hd__a21bo_1
XFILLER_0_57_393 VGND VGND VPWR VPWR sky130_fd_sc_hd__decap_4
XFILLER_0_18_769 VPWR VGND VPWR VGND sky130_ef_sc_hd__decap_12
XFILLER_0_128_793 VPWR VGND VPWR VGND sky130_ef_sc_hd__decap_12
XFILLER_0_127_281 VPWR VGND VPWR VGND sky130_ef_sc_hd__decap_12
XFILLER_0_94_3 VPWR VGND VPWR VGND sky130_ef_sc_hd__decap_12
XFILLER_0_72_352 VGND VGND VPWR VPWR sky130_fd_sc_hd__fill_1
XFILLER_0_5_641 VPWR VGND VPWR VGND sky130_ef_sc_hd__decap_12
XFILLER_0_17_279 VGND VGND VPWR VPWR sky130_fd_sc_hd__fill_1
XTAP_TAPCELL_ROW_98_1769 VGND VPWR sky130_fd_sc_hd__tapvpwrvgnd_1
X_4607_ _2229_ VGND VGND VPWR VPWR _2252_ sky130_fd_sc_hd__buf_2
X_2868_ cpu_inst.regfile_inst.registers\[11\]\[8\] cpu_inst.regfile_inst.registers\[10\]\[8\]
+ _0620_ VGND VGND VPWR VPWR _0833_ sky130_fd_sc_hd__mux2_1
XFILLER_0_130_413 VGND VGND VPWR VPWR sky130_fd_sc_hd__decap_6
XFILLER_0_103_627 VGND VGND VPWR VPWR sky130_fd_sc_hd__decap_3
XFILLER_0_13_441 VGND VGND VPWR VPWR sky130_fd_sc_hd__decap_6
XFILLER_0_5_685 VPWR VGND VPWR VGND sky130_ef_sc_hd__decap_12
X_2799_ cpu_inst.regfile_inst.registers\[1\]\[2\] _0627_ _0603_ cpu_inst.regfile_inst.registers\[5\]\[2\]
+ VGND VGND VPWR VPWR _0764_ sky130_fd_sc_hd__o22ai_1
XFILLER_0_130_457 VPWR VGND VPWR VGND sky130_ef_sc_hd__decap_12
X_4538_ cpu_inst.regfile_inst.registers\[11\]\[20\] VGND VGND VPWR VPWR _2217_ sky130_fd_sc_hd__clkbuf_1
XFILLER_0_4_195 VGND VGND VPWR VPWR sky130_fd_sc_hd__fill_1
XFILLER_0_13_485 VPWR VGND VPWR VGND sky130_ef_sc_hd__decap_12
XFILLER_0_41_783 VGND VGND VPWR VPWR sky130_fd_sc_hd__fill_1
XFILLER_0_41_794 VGND VGND VPWR VPWR sky130_fd_sc_hd__fill_2
XFILLER_0_111_671 VGND VGND VPWR VPWR sky130_fd_sc_hd__fill_1
X_4469_ _1456_ cpu_inst.regfile_inst.registers\[7\]\[18\] _2174_ VGND VGND VPWR VPWR
+ _2182_ sky130_fd_sc_hd__mux2_1
XPHY_EDGE_ROW_86_Right_86 VGND VGND VPWR VPWR sky130_fd_sc_hd__decap_3
XTAP_TAPCELL_ROW_129_2235 VGND VPWR sky130_fd_sc_hd__tapvpwrvgnd_1
XFILLER_0_99_205 VPWR VGND VPWR VGND sky130_ef_sc_hd__decap_12
XTAP_TAPCELL_ROW_5_378 VGND VPWR sky130_fd_sc_hd__tapvpwrvgnd_1
XTAP_TAPCELL_ROW_51_1065 VGND VPWR sky130_fd_sc_hd__tapvpwrvgnd_1
XFILLER_0_99_249 VPWR VGND VPWR VGND sky130_ef_sc_hd__decap_12
XFILLER_0_67_113 VPWR VGND VPWR VGND sky130_ef_sc_hd__decap_12
XTAP_TAPCELL_ROW_107_1898 VGND VPWR sky130_fd_sc_hd__tapvpwrvgnd_1
XPHY_EDGE_ROW_95_Right_95 VGND VGND VPWR VPWR sky130_fd_sc_hd__decap_3
XFILLER_0_138_557 VGND VGND VPWR VPWR sky130_fd_sc_hd__decap_3
XTAP_TAPCELL_ROW_24_653 VGND VPWR sky130_fd_sc_hd__tapvpwrvgnd_1
XFILLER_0_64_831 VGND VGND VPWR VPWR sky130_fd_sc_hd__decap_8
XTAP_TAPCELL_ROW_24_664 VGND VPWR sky130_fd_sc_hd__tapvpwrvgnd_1
XFILLER_0_106_421 VPWR VGND VPWR VGND sky130_ef_sc_hd__decap_12
XFILLER_0_23_205 VPWR VGND VPWR VGND sky130_ef_sc_hd__decap_12
XFILLER_0_51_503 VGND VGND VPWR VPWR sky130_fd_sc_hd__fill_1
XFILLER_0_63_396 VGND VGND VPWR VPWR sky130_fd_sc_hd__fill_1
Xrebuffer9 _0588_ VGND VGND VPWR VPWR net22 sky130_fd_sc_hd__dlygate4sd1_1
XFILLER_0_133_273 VGND VGND VPWR VPWR sky130_fd_sc_hd__decap_6
XFILLER_0_23_249 VPWR VGND VPWR VGND sky130_ef_sc_hd__decap_12
XFILLER_0_32_750 VGND VGND VPWR VPWR sky130_fd_sc_hd__decap_6
XPHY_EDGE_ROW_2_Left_141 VGND VGND VPWR VPWR sky130_fd_sc_hd__decap_3
XPHY_EDGE_ROW_39_Left_178 VGND VGND VPWR VPWR sky130_fd_sc_hd__decap_3
XFILLER_0_31_293 VPWR VGND VPWR VGND sky130_ef_sc_hd__decap_12
XFILLER_0_101_181 VPWR VGND VPWR VGND sky130_ef_sc_hd__decap_12
XFILLER_0_64_27 VGND VGND VPWR VPWR sky130_fd_sc_hd__fill_1
XTAP_TAPCELL_ROW_69_1337 VGND VPWR sky130_fd_sc_hd__tapvpwrvgnd_1
XPHY_EDGE_ROW_48_Left_187 VGND VGND VPWR VPWR sky130_fd_sc_hd__decap_3
XTAP_TAPCELL_ROW_82_1537 VGND VPWR sky130_fd_sc_hd__tapvpwrvgnd_1
XTAP_TAPCELL_ROW_82_1526 VGND VPWR sky130_fd_sc_hd__tapvpwrvgnd_1
XFILLER_0_80_15 VPWR VGND VPWR VGND sky130_ef_sc_hd__decap_12
X_3840_ cpu_inst.regfile_inst.registers\[25\]\[27\] _1310_ _1311_ _1767_ VGND VGND
+ VPWR VPWR _1768_ sky130_fd_sc_hd__o211a_1
XFILLER_0_73_105 VGND VGND VPWR VPWR sky130_fd_sc_hd__decap_6
XTAP_TAPCELL_ROW_43_940 VGND VPWR sky130_fd_sc_hd__tapvpwrvgnd_1
XTAP_TAPCELL_ROW_43_951 VGND VPWR sky130_fd_sc_hd__tapvpwrvgnd_1
XFILLER_0_104_77 VGND VGND VPWR VPWR sky130_fd_sc_hd__decap_6
X_3771_ _1686_ _1700_ _1451_ VGND VGND VPWR VPWR _1701_ sky130_fd_sc_hd__mux2_1
XFILLER_0_73_149 VPWR VGND VPWR VGND sky130_ef_sc_hd__decap_12
XFILLER_0_39_393 VPWR VGND VPWR VGND sky130_ef_sc_hd__decap_12
XFILLER_0_125_741 VPWR VGND VPWR VGND sky130_ef_sc_hd__decap_12
XFILLER_0_109_281 VPWR VGND VPWR VGND sky130_ef_sc_hd__decap_12
XFILLER_0_82_661 VGND VGND VPWR VPWR sky130_fd_sc_hd__fill_2
X_2722_ _0684_ _0685_ _0686_ VGND VGND VPWR VPWR _0687_ sky130_fd_sc_hd__o21a_2
X_5510_ clknet_leaf_26_clk _0430_ VGND VGND VPWR VPWR cpu_inst.regfile_inst.registers\[8\]\[14\]
+ sky130_fd_sc_hd__dfxtp_1
XFILLER_0_124_251 VGND VGND VPWR VPWR sky130_fd_sc_hd__fill_1
XFILLER_0_89_57 VPWR VGND VPWR VGND sky130_ef_sc_hd__decap_12
XFILLER_0_125_785 VPWR VGND VPWR VGND sky130_ef_sc_hd__decap_12
XFILLER_0_120_65 VPWR VGND VPWR VGND sky130_ef_sc_hd__decap_12
XFILLER_0_112_413 VGND VGND VPWR VPWR sky130_fd_sc_hd__decap_6
XFILLER_0_81_193 VPWR VGND VPWR VGND sky130_ef_sc_hd__decap_12
XPHY_EDGE_ROW_57_Left_196 VGND VGND VPWR VPWR sky130_fd_sc_hd__decap_3
X_2653_ cpu_inst.regfile_inst.registers\[24\]\[0\] _0612_ _0617_ VGND VGND VPWR VPWR
+ _0618_ sky130_fd_sc_hd__o21a_1
X_5441_ clknet_leaf_29_clk _0361_ VGND VGND VPWR VPWR cpu_inst.regfile_inst.registers\[0\]\[9\]
+ sky130_fd_sc_hd__dfxtp_1
XFILLER_0_112_457 VPWR VGND VPWR VGND sky130_ef_sc_hd__decap_12
X_2584_ _0521_ cpu_inst.decoder_inst.current_pc\[2\] cpu_inst.decoder_inst.current_pc\[1\]
+ VGND VGND VPWR VPWR _0549_ sky130_fd_sc_hd__or3_2
XFILLER_0_23_783 VGND VGND VPWR VPWR sky130_fd_sc_hd__fill_1
X_5372_ clknet_leaf_34_clk _0292_ VGND VGND VPWR VPWR cpu_inst.regfile_inst.registers\[10\]\[4\]
+ sky130_fd_sc_hd__dfxtp_1
X_4323_ _2106_ VGND VGND VPWR VPWR _0171_ sky130_fd_sc_hd__clkbuf_1
XFILLER_0_10_433 VPWR VGND VPWR VGND sky130_ef_sc_hd__decap_12
XFILLER_0_2_699 VGND VGND VPWR VPWR sky130_fd_sc_hd__fill_1
XTAP_TAPCELL_ROW_93_1699 VGND VPWR sky130_fd_sc_hd__tapvpwrvgnd_1
XTAP_TAPCELL_ROW_93_1688 VGND VPWR sky130_fd_sc_hd__tapvpwrvgnd_1
XFILLER_0_10_477 VPWR VGND VPWR VGND sky130_ef_sc_hd__decap_12
X_4254_ _2069_ VGND VGND VPWR VPWR _0139_ sky130_fd_sc_hd__clkbuf_1
X_3205_ _0691_ _1156_ _1169_ VGND VGND VPWR VPWR _1170_ sky130_fd_sc_hd__a21o_1
X_4185_ cpu_inst.regfile_inst.registers\[4\]\[10\] _2024_ VGND VGND VPWR VPWR _2034_
+ sky130_fd_sc_hd__and2_1
XFILLER_0_38_83 VGND VGND VPWR VPWR sky130_fd_sc_hd__fill_1
X_3136_ _0689_ _1100_ VGND VGND VPWR VPWR _1101_ sky130_fd_sc_hd__nand2_1
XTAP_TAPCELL_ROW_2_326 VGND VPWR sky130_fd_sc_hd__tapvpwrvgnd_1
XTAP_TAPCELL_ROW_2_337 VGND VPWR sky130_fd_sc_hd__tapvpwrvgnd_1
XTAP_TAPCELL_ROW_124_2154 VGND VPWR sky130_fd_sc_hd__tapvpwrvgnd_1
X_3067_ _0725_ _1030_ _1031_ VGND VGND VPWR VPWR _1032_ sky130_fd_sc_hd__or3_1
XTAP_TAPCELL_ROW_124_2165 VGND VPWR sky130_fd_sc_hd__tapvpwrvgnd_1
XFILLER_0_89_293 VPWR VGND VPWR VGND sky130_ef_sc_hd__decap_12
XFILLER_0_49_113 VPWR VGND VPWR VGND sky130_ef_sc_hd__decap_12
XFILLER_0_77_499 VGND VGND VPWR VPWR sky130_fd_sc_hd__decap_4
XFILLER_0_135_505 VPWR VGND VPWR VGND sky130_ef_sc_hd__decap_12
XFILLER_0_58_691 VGND VGND VPWR VPWR sky130_fd_sc_hd__decap_8
XFILLER_0_18_533 VPWR VGND VPWR VGND sky130_ef_sc_hd__decap_12
XTAP_TAPCELL_ROW_21_612 VGND VPWR sky130_fd_sc_hd__tapvpwrvgnd_1
X_3969_ cpu_inst.regfile_inst.registers\[25\]\[30\] _1285_ _1449_ _1874_ _1892_ VGND
+ VGND VPWR VPWR _1894_ sky130_fd_sc_hd__o2111a_1
XFILLER_0_45_385 VGND VGND VPWR VPWR sky130_fd_sc_hd__decap_6
XFILLER_0_115_273 VGND VGND VPWR VPWR sky130_fd_sc_hd__decap_6
XFILLER_0_21_709 VPWR VGND VPWR VGND sky130_ef_sc_hd__decap_12
XFILLER_0_130_221 VPWR VGND VPWR VGND sky130_ef_sc_hd__decap_12
XFILLER_0_131_777 VGND VGND VPWR VPWR sky130_fd_sc_hd__decap_6
XFILLER_0_130_265 VPWR VGND VPWR VGND sky130_ef_sc_hd__decap_12
XFILLER_0_13_293 VPWR VGND VPWR VGND sky130_ef_sc_hd__decap_12
XTAP_TAPCELL_ROW_109_1938 VGND VPWR sky130_fd_sc_hd__tapvpwrvgnd_1
XTAP_TAPCELL_ROW_29_734 VGND VPWR sky130_fd_sc_hd__tapvpwrvgnd_1
XFILLER_0_68_411 VGND VGND VPWR VPWR sky130_fd_sc_hd__decap_8
XFILLER_0_138_321 VPWR VGND VPWR VGND sky130_ef_sc_hd__decap_12
XFILLER_0_96_786 VGND VGND VPWR VPWR sky130_fd_sc_hd__fill_2
XFILLER_0_68_477 VGND VGND VPWR VPWR sky130_fd_sc_hd__decap_4
XTAP_TAPCELL_ROW_64_1267 VGND VPWR sky130_fd_sc_hd__tapvpwrvgnd_1
XTAP_TAPCELL_ROW_64_1256 VGND VPWR sky130_fd_sc_hd__tapvpwrvgnd_1
XFILLER_0_55_105 VGND VGND VPWR VPWR sky130_fd_sc_hd__decap_6
XFILLER_0_138_365 VPWR VGND VPWR VGND sky130_ef_sc_hd__decap_12
XFILLER_0_55_149 VPWR VGND VPWR VGND sky130_ef_sc_hd__decap_12
XFILLER_0_50_29 VPWR VGND VPWR VGND sky130_ef_sc_hd__decap_12
XFILLER_0_36_363 VGND VGND VPWR VPWR sky130_fd_sc_hd__fill_1
XFILLER_0_107_741 VPWR VGND VPWR VGND sky130_ef_sc_hd__decap_12
XFILLER_0_24_525 VGND VGND VPWR VPWR sky130_fd_sc_hd__decap_6
XFILLER_0_107_785 VPWR VGND VPWR VGND sky130_ef_sc_hd__decap_12
XFILLER_0_106_251 VGND VGND VPWR VPWR sky130_fd_sc_hd__fill_1
XFILLER_0_63_193 VPWR VGND VPWR VGND sky130_ef_sc_hd__decap_12
XFILLER_0_122_755 VGND VGND VPWR VPWR sky130_fd_sc_hd__fill_1
XFILLER_0_59_27 VPWR VGND VPWR VGND sky130_ef_sc_hd__decap_12
XFILLER_0_102_490 VGND VGND VPWR VPWR sky130_fd_sc_hd__fill_1
XFILLER_0_75_15 VPWR VGND VPWR VGND sky130_ef_sc_hd__decap_12
XFILLER_0_87_720 VGND VGND VPWR VPWR sky130_fd_sc_hd__decap_8
X_4941_ _1608_ cpu_inst.regfile_inst.registers\[8\]\[22\] _2449_ VGND VGND VPWR VPWR
+ _2458_ sky130_fd_sc_hd__mux2_1
XFILLER_0_91_69 VPWR VGND VPWR VGND sky130_ef_sc_hd__decap_12
XFILLER_0_24_41 VPWR VGND VPWR VGND sky130_ef_sc_hd__decap_12
X_4872_ cpu_inst.regfile_inst.registers\[9\]\[22\] VGND VGND VPWR VPWR _2421_ sky130_fd_sc_hd__clkbuf_1
XFILLER_0_87_775 VGND VGND VPWR VPWR sky130_fd_sc_hd__decap_8
XFILLER_0_59_499 VGND VGND VPWR VPWR sky130_fd_sc_hd__decap_4
XFILLER_0_24_85 VPWR VGND VPWR VGND sky130_ef_sc_hd__decap_12
XFILLER_0_117_505 VPWR VGND VPWR VGND sky130_ef_sc_hd__decap_12
X_3823_ _1724_ _1750_ _1728_ VGND VGND VPWR VPWR _1752_ sky130_fd_sc_hd__and3_1
XFILLER_0_74_447 VGND VGND VPWR VPWR sky130_fd_sc_hd__decap_8
XFILLER_0_74_436 VGND VGND VPWR VPWR sky130_fd_sc_hd__decap_6
XFILLER_0_15_503 VGND VGND VPWR VPWR sky130_fd_sc_hd__fill_1
X_3754_ _1604_ VGND VGND VPWR VPWR _1685_ sky130_fd_sc_hd__inv_2
XPHY_EDGE_ROW_65_Left_204 VGND VGND VPWR VPWR sky130_fd_sc_hd__decap_3
XFILLER_0_27_385 VGND VGND VPWR VPWR sky130_fd_sc_hd__decap_6
XFILLER_0_43_823 VGND VGND VPWR VPWR sky130_fd_sc_hd__fill_1
X_3685_ _1536_ _1614_ _1616_ _1314_ VGND VGND VPWR VPWR _1617_ sky130_fd_sc_hd__o22a_1
XTAP_TAPCELL_ROW_95_1728 VGND VPWR sky130_fd_sc_hd__tapvpwrvgnd_1
XFILLER_0_70_642 VGND VGND VPWR VPWR sky130_fd_sc_hd__fill_2
X_2705_ cpu_inst.regfile_inst.registers\[5\]\[0\] cpu_inst.regfile_inst.registers\[4\]\[0\]
+ _0648_ VGND VGND VPWR VPWR _0670_ sky130_fd_sc_hd__mux2_1
XFILLER_0_42_333 VPWR VGND VPWR VGND sky130_ef_sc_hd__decap_12
XFILLER_0_112_221 VPWR VGND VPWR VGND sky130_ef_sc_hd__decap_12
X_5424_ clknet_leaf_0_clk _0344_ net2 VGND VGND VPWR VPWR cpu_inst.decoder_inst.current_pc\[24\]
+ sky130_fd_sc_hd__dfrtp_1
X_2636_ cpu_inst.regfile_inst.registers\[5\]\[0\] _0600_ VGND VGND VPWR VPWR _0601_
+ sky130_fd_sc_hd__or2_1
XFILLER_0_42_377 VPWR VGND VPWR VGND sky130_ef_sc_hd__decap_12
XFILLER_0_113_777 VGND VGND VPWR VPWR sky130_fd_sc_hd__decap_6
XFILLER_0_112_265 VPWR VGND VPWR VGND sky130_ef_sc_hd__decap_12
X_5355_ clknet_leaf_19_clk _0275_ VGND VGND VPWR VPWR cpu_inst.regfile_inst.registers\[11\]\[19\]
+ sky130_fd_sc_hd__dfxtp_1
XFILLER_0_57_3 VPWR VGND VPWR VGND sky130_ef_sc_hd__decap_12
XFILLER_0_11_753 VPWR VGND VPWR VGND sky130_ef_sc_hd__decap_12
XTAP_TAPCELL_ROW_7_407 VGND VPWR sky130_fd_sc_hd__tapvpwrvgnd_1
X_2567_ cpu_inst.decoder_inst.current_pc\[1\] _0529_ _0531_ _0521_ VGND VGND VPWR
+ VPWR _0532_ sky130_fd_sc_hd__or4b_1
XFILLER_0_11_797 VPWR VGND VPWR VGND sky130_ef_sc_hd__decap_12
X_4306_ _1196_ cpu_inst.regfile_inst.registers\[5\]\[4\] _2092_ VGND VGND VPWR VPWR
+ _2097_ sky130_fd_sc_hd__mux2_1
XFILLER_0_49_93 VPWR VGND VPWR VGND sky130_ef_sc_hd__decap_12
X_5286_ clknet_leaf_28_clk _0206_ VGND VGND VPWR VPWR cpu_inst.regfile_inst.registers\[1\]\[14\]
+ sky130_fd_sc_hd__dfxtp_1
X_4237_ cpu_inst.regfile_inst.registers\[24\]\[3\] VGND VGND VPWR VPWR _2061_ sky130_fd_sc_hd__clkbuf_1
XPHY_EDGE_ROW_74_Left_213 VGND VGND VPWR VPWR sky130_fd_sc_hd__decap_3
XFILLER_0_97_517 VGND VGND VPWR VPWR sky130_fd_sc_hd__fill_2
XFILLER_0_65_81 VPWR VGND VPWR VGND sky130_ef_sc_hd__decap_12
X_4168_ cpu_inst.regfile_inst.registers\[4\]\[1\] _2024_ VGND VGND VPWR VPWR _2026_
+ sky130_fd_sc_hd__and2_1
X_3119_ _1078_ _1083_ _0912_ VGND VGND VPWR VPWR _1084_ sky130_fd_sc_hd__mux2_1
X_4099_ _1986_ VGND VGND VPWR VPWR _0067_ sky130_fd_sc_hd__clkbuf_1
XTAP_TAPCELL_ROW_104_1857 VGND VPWR sky130_fd_sc_hd__tapvpwrvgnd_1
XFILLER_0_65_414 VGND VGND VPWR VPWR sky130_fd_sc_hd__decap_8
XFILLER_0_37_105 VGND VGND VPWR VPWR sky130_fd_sc_hd__decap_6
XFILLER_0_38_639 VGND VGND VPWR VPWR sky130_fd_sc_hd__fill_1
XFILLER_0_136_825 VPWR VGND VPWR VGND sky130_ef_sc_hd__decap_12
XFILLER_0_92_233 VPWR VGND VPWR VGND sky130_ef_sc_hd__decap_12
XFILLER_0_37_149 VPWR VGND VPWR VGND sky130_ef_sc_hd__decap_12
XFILLER_0_135_335 VGND VGND VPWR VPWR sky130_fd_sc_hd__fill_1
XFILLER_0_92_277 VPWR VGND VPWR VGND sky130_ef_sc_hd__decap_12
XPHY_EDGE_ROW_83_Left_222 VGND VGND VPWR VPWR sky130_fd_sc_hd__decap_3
XTAP_TAPCELL_ROW_137_2356 VGND VPWR sky130_fd_sc_hd__tapvpwrvgnd_1
XFILLER_0_18_363 VGND VGND VPWR VPWR sky130_fd_sc_hd__fill_1
XFILLER_0_60_141 VPWR VGND VPWR VGND sky130_ef_sc_hd__decap_12
XFILLER_0_45_193 VPWR VGND VPWR VGND sky130_ef_sc_hd__decap_12
XFILLER_0_131_541 VPWR VGND VPWR VGND sky130_ef_sc_hd__decap_12
XFILLER_0_104_755 VGND VGND VPWR VPWR sky130_fd_sc_hd__fill_1
XFILLER_0_21_517 VPWR VGND VPWR VGND sky130_ef_sc_hd__decap_12
XFILLER_0_131_585 VPWR VGND VPWR VGND sky130_ef_sc_hd__decap_12
XPHY_EDGE_ROW_92_Left_231 VGND VGND VPWR VPWR sky130_fd_sc_hd__decap_3
XFILLER_0_61_39 VPWR VGND VPWR VGND sky130_ef_sc_hd__decap_12
XFILLER_0_56_447 VPWR VGND VPWR VGND sky130_ef_sc_hd__decap_12
XFILLER_0_126_357 VGND VGND VPWR VPWR sky130_fd_sc_hd__decap_6
XFILLER_0_52_642 VGND VGND VPWR VPWR sky130_fd_sc_hd__fill_2
XTAP_TAPCELL_ROW_12_486 VGND VPWR sky130_fd_sc_hd__tapvpwrvgnd_1
XTAP_TAPCELL_ROW_12_475 VGND VPWR sky130_fd_sc_hd__tapvpwrvgnd_1
XFILLER_0_3_205 VPWR VGND VPWR VGND sky130_ef_sc_hd__decap_12
XFILLER_0_24_333 VPWR VGND VPWR VGND sky130_ef_sc_hd__decap_12
XFILLER_0_107_593 VPWR VGND VPWR VGND sky130_ef_sc_hd__decap_12
XFILLER_0_3_249 VPWR VGND VPWR VGND sky130_ef_sc_hd__decap_12
XFILLER_0_24_377 VPWR VGND VPWR VGND sky130_ef_sc_hd__decap_12
XFILLER_0_40_826 VPWR VGND VPWR VGND sky130_ef_sc_hd__decap_12
XTAP_TAPCELL_ROW_77_1458 VGND VPWR sky130_fd_sc_hd__tapvpwrvgnd_1
X_3470_ _1376_ _1407_ VGND VGND VPWR VPWR _1408_ sky130_fd_sc_hd__nand2_1
XFILLER_0_10_65 VPWR VGND VPWR VGND sky130_ef_sc_hd__decap_12
XFILLER_0_110_725 VPWR VGND VPWR VGND sky130_ef_sc_hd__decap_12
XFILLER_0_110_769 VPWR VGND VPWR VGND sky130_ef_sc_hd__decap_12
X_5140_ clknet_leaf_7_clk _0060_ VGND VGND VPWR VPWR cpu_inst.regfile_inst.registers\[2\]\[28\]
+ sky130_fd_sc_hd__dfxtp_1
XTAP_TAPCELL_ROW_90_1647 VGND VPWR sky130_fd_sc_hd__tapvpwrvgnd_1
X_5071_ _2530_ VGND VGND VPWR VPWR _0495_ sky130_fd_sc_hd__clkbuf_1
X_4022_ _0687_ _1753_ _1759_ VGND VGND VPWR VPWR _1945_ sky130_fd_sc_hd__o21ai_1
XFILLER_0_126_53 VPWR VGND VPWR VGND sky130_ef_sc_hd__decap_12
XFILLER_0_35_51 VGND VGND VPWR VPWR sky130_fd_sc_hd__decap_4
XFILLER_0_126_97 VPWR VGND VPWR VGND sky130_ef_sc_hd__decap_12
XTAP_TAPCELL_ROW_121_2113 VGND VPWR sky130_fd_sc_hd__tapvpwrvgnd_1
X_4924_ _2431_ VGND VGND VPWR VPWR _2449_ sky130_fd_sc_hd__buf_4
XFILLER_0_19_105 VGND VGND VPWR VPWR sky130_fd_sc_hd__decap_6
XFILLER_0_118_825 VPWR VGND VPWR VGND sky130_ef_sc_hd__decap_12
XFILLER_0_74_233 VPWR VGND VPWR VGND sky130_ef_sc_hd__decap_12
XFILLER_0_47_447 VGND VGND VPWR VPWR sky130_fd_sc_hd__fill_1
XFILLER_0_117_335 VGND VGND VPWR VPWR sky130_fd_sc_hd__fill_1
X_4855_ _2412_ VGND VGND VPWR VPWR _0397_ sky130_fd_sc_hd__clkbuf_1
XFILLER_0_19_149 VPWR VGND VPWR VGND sky130_ef_sc_hd__decap_12
XFILLER_0_90_726 VGND VGND VPWR VPWR sky130_fd_sc_hd__decap_4
X_3806_ cpu_inst.regfile_inst.registers\[25\]\[26\] _1252_ _1069_ _1734_ VGND VGND
+ VPWR VPWR _1735_ sky130_fd_sc_hd__o211ai_2
XFILLER_0_74_277 VPWR VGND VPWR VGND sky130_ef_sc_hd__decap_12
XFILLER_0_28_694 VGND VGND VPWR VPWR sky130_fd_sc_hd__decap_6
XTAP_TAPCELL_ROW_31_762 VGND VPWR sky130_fd_sc_hd__tapvpwrvgnd_1
X_4786_ cpu_inst.regfile_inst.registers\[0\]\[11\] VGND VGND VPWR VPWR _2378_ sky130_fd_sc_hd__clkbuf_1
XFILLER_0_133_839 VGND VGND VPWR VPWR sky130_fd_sc_hd__fill_1
XTAP_TAPCELL_ROW_119_2086 VGND VPWR sky130_fd_sc_hd__tapvpwrvgnd_1
X_3737_ _1470_ VGND VGND VPWR VPWR _1668_ sky130_fd_sc_hd__buf_2
XFILLER_0_27_193 VPWR VGND VPWR VGND sky130_ef_sc_hd__decap_12
XFILLER_0_43_642 VGND VGND VPWR VPWR sky130_fd_sc_hd__fill_2
XFILLER_0_113_541 VPWR VGND VPWR VGND sky130_ef_sc_hd__decap_12
XFILLER_0_42_141 VPWR VGND VPWR VGND sky130_ef_sc_hd__decap_12
X_3668_ _1577_ _1576_ _1600_ VGND VGND VPWR VPWR _1601_ sky130_fd_sc_hd__a21o_1
XTAP_TAPCELL_ROW_132_2286 VGND VPWR sky130_fd_sc_hd__tapvpwrvgnd_1
XTAP_TAPCELL_ROW_132_2275 VGND VPWR sky130_fd_sc_hd__tapvpwrvgnd_1
XFILLER_0_113_585 VPWR VGND VPWR VGND sky130_ef_sc_hd__decap_12
X_3599_ _1092_ _1506_ _1533_ _1224_ VGND VGND VPWR VPWR _1534_ sky130_fd_sc_hd__a2bb2o_1
X_5407_ clknet_leaf_0_clk _0327_ net2 VGND VGND VPWR VPWR cpu_inst.decoder_inst.current_pc\[7\]
+ sky130_fd_sc_hd__dfrtp_2
XFILLER_0_11_561 VPWR VGND VPWR VGND sky130_ef_sc_hd__decap_12
XFILLER_0_3_783 VGND VGND VPWR VPWR sky130_fd_sc_hd__fill_1
X_2619_ _0583_ VGND VGND VPWR VPWR _0584_ sky130_fd_sc_hd__clkbuf_4
X_5338_ clknet_leaf_41_clk _0258_ VGND VGND VPWR VPWR cpu_inst.regfile_inst.registers\[11\]\[2\]
+ sky130_fd_sc_hd__dfxtp_1
X_5269_ clknet_leaf_6_clk _0189_ VGND VGND VPWR VPWR cpu_inst.regfile_inst.registers\[5\]\[29\]
+ sky130_fd_sc_hd__dfxtp_1
XFILLER_0_98_837 VGND VGND VPWR VPWR sky130_fd_sc_hd__decap_4
XTAP_TAPCELL_ROW_39_884 VGND VPWR sky130_fd_sc_hd__tapvpwrvgnd_1
XTAP_TAPCELL_ROW_48_1015 VGND VPWR sky130_fd_sc_hd__tapvpwrvgnd_1
XTAP_TAPCELL_ROW_48_1026 VGND VPWR sky130_fd_sc_hd__tapvpwrvgnd_1
XTAP_TAPCELL_ROW_61_1215 VGND VPWR sky130_fd_sc_hd__tapvpwrvgnd_1
XFILLER_0_93_575 VGND VGND VPWR VPWR sky130_fd_sc_hd__fill_1
XFILLER_0_108_357 VGND VGND VPWR VPWR sky130_fd_sc_hd__decap_6
XFILLER_0_53_417 VGND VGND VPWR VPWR sky130_fd_sc_hd__decap_6
XFILLER_0_34_620 VGND VGND VPWR VPWR sky130_fd_sc_hd__fill_1
XFILLER_0_136_699 VGND VGND VPWR VPWR sky130_fd_sc_hd__fill_1
XFILLER_0_123_305 VPWR VGND VPWR VGND sky130_ef_sc_hd__decap_12
XFILLER_0_123_349 VPWR VGND VPWR VGND sky130_ef_sc_hd__decap_12
XFILLER_0_1_709 VPWR VGND VPWR VGND sky130_ef_sc_hd__decap_12
XFILLER_0_22_837 VGND VGND VPWR VPWR sky130_fd_sc_hd__decap_4
XFILLER_0_131_393 VPWR VGND VPWR VGND sky130_ef_sc_hd__decap_12
XTAP_TAPCELL_ROW_59_1188 VGND VPWR sky130_fd_sc_hd__tapvpwrvgnd_1
XTAP_TAPCELL_ROW_72_1377 VGND VPWR sky130_fd_sc_hd__tapvpwrvgnd_1
XFILLER_0_89_837 VGND VGND VPWR VPWR sky130_fd_sc_hd__decap_3
XFILLER_0_72_27 VGND VGND VPWR VPWR sky130_fd_sc_hd__fill_1
XFILLER_0_69_561 VGND VGND VPWR VPWR sky130_fd_sc_hd__decap_6
XFILLER_0_9_809 VPWR VGND VPWR VGND sky130_ef_sc_hd__decap_12
X_2970_ cpu_inst.regfile_inst.registers\[25\]\[5\] _0692_ _0694_ _0928_ VGND VGND
+ VPWR VPWR _0935_ sky130_fd_sc_hd__o211a_1
XTAP_TAPCELL_ROW_17_556 VGND VPWR sky130_fd_sc_hd__tapvpwrvgnd_1
XFILLER_0_29_447 VGND VGND VPWR VPWR sky130_fd_sc_hd__fill_1
XFILLER_0_56_233 VPWR VGND VPWR VGND sky130_ef_sc_hd__decap_12
XFILLER_0_17_609 VGND VGND VPWR VPWR sky130_fd_sc_hd__decap_6
XFILLER_0_126_121 VPWR VGND VPWR VGND sky130_ef_sc_hd__decap_12
X_4640_ _1053_ _1408_ _1409_ _1420_ _1417_ VGND VGND VPWR VPWR _2273_ sky130_fd_sc_hd__a41o_1
XFILLER_0_71_225 VPWR VGND VPWR VGND sky130_ef_sc_hd__decap_12
XFILLER_0_56_277 VPWR VGND VPWR VGND sky130_ef_sc_hd__decap_12
XFILLER_0_25_620 VPWR VGND VPWR VGND sky130_ef_sc_hd__decap_12
XFILLER_0_44_428 VPWR VGND VPWR VGND sky130_ef_sc_hd__decap_12
XFILLER_0_126_165 VPWR VGND VPWR VGND sky130_ef_sc_hd__decap_12
XFILLER_0_115_839 VGND VGND VPWR VPWR sky130_fd_sc_hd__fill_1
XFILLER_0_115_3 VPWR VGND VPWR VGND sky130_ef_sc_hd__decap_12
XFILLER_0_112_77 VGND VGND VPWR VPWR sky130_fd_sc_hd__decap_6
XFILLER_0_4_525 VGND VGND VPWR VPWR sky130_fd_sc_hd__decap_6
XFILLER_0_80_770 VPWR VGND VPWR VGND sky130_ef_sc_hd__decap_12
XFILLER_0_24_141 VPWR VGND VPWR VGND sky130_ef_sc_hd__decap_12
X_4571_ _2233_ VGND VGND VPWR VPWR _0292_ sky130_fd_sc_hd__clkbuf_1
X_3522_ _1450_ _1442_ VGND VGND VPWR VPWR _1458_ sky130_fd_sc_hd__or2_1
XFILLER_0_4_569 VPWR VGND VPWR VGND sky130_ef_sc_hd__decap_12
XFILLER_0_25_697 VPWR VGND VPWR VGND sky130_ef_sc_hd__decap_12
XFILLER_0_40_645 VGND VGND VPWR VPWR sky130_fd_sc_hd__decap_8
XFILLER_0_110_533 VPWR VGND VPWR VGND sky130_ef_sc_hd__decap_12
XFILLER_0_97_57 VPWR VGND VPWR VGND sky130_ef_sc_hd__decap_12
X_3453_ _1390_ cpu_inst.regfile_inst.registers\[10\]\[17\] _1351_ VGND VGND VPWR VPWR
+ _1391_ sky130_fd_sc_hd__mux2_1
XFILLER_0_0_753 VGND VGND VPWR VPWR sky130_fd_sc_hd__decap_3
XFILLER_0_0_797 VPWR VGND VPWR VGND sky130_ef_sc_hd__decap_12
X_5123_ clknet_leaf_29_clk _0043_ VGND VGND VPWR VPWR cpu_inst.regfile_inst.registers\[2\]\[11\]
+ sky130_fd_sc_hd__dfxtp_1
X_3384_ _1333_ VGND VGND VPWR VPWR _0005_ sky130_fd_sc_hd__clkbuf_1
X_5054_ cpu_inst.display_inst.counter\[10\] _2517_ _2270_ VGND VGND VPWR VPWR _2519_
+ sky130_fd_sc_hd__a21boi_1
X_4005_ _1928_ cpu_inst.regfile_inst.registers\[6\]\[31\] _1609_ VGND VGND VPWR VPWR
+ _1929_ sky130_fd_sc_hd__mux2_1
XFILLER_0_46_83 VGND VGND VPWR VPWR sky130_fd_sc_hd__fill_1
XFILLER_0_95_807 VPWR VGND VPWR VGND sky130_ef_sc_hd__decap_12
XFILLER_0_79_369 VGND VGND VPWR VPWR sky130_fd_sc_hd__decap_3
XFILLER_0_67_509 VGND VGND VPWR VPWR sky130_fd_sc_hd__fill_1
XTAP_TAPCELL_ROW_36_843 VGND VPWR sky130_fd_sc_hd__tapvpwrvgnd_1
XTAP_TAPCELL_ROW_101_1816 VGND VPWR sky130_fd_sc_hd__tapvpwrvgnd_1
XFILLER_0_75_531 VGND VGND VPWR VPWR sky130_fd_sc_hd__decap_8
X_4907_ _2440_ VGND VGND VPWR VPWR _0421_ sky130_fd_sc_hd__clkbuf_1
XFILLER_0_35_417 VPWR VGND VPWR VGND sky130_ef_sc_hd__decap_12
X_4838_ cpu_inst.regfile_inst.registers\[9\]\[5\] VGND VGND VPWR VPWR _2404_ sky130_fd_sc_hd__clkbuf_1
XTAP_TAPCELL_ROW_134_2315 VGND VPWR sky130_fd_sc_hd__tapvpwrvgnd_1
XTAP_TAPCELL_ROW_134_2304 VGND VPWR sky130_fd_sc_hd__tapvpwrvgnd_1
XFILLER_0_118_699 VGND VGND VPWR VPWR sky130_fd_sc_hd__fill_1
XFILLER_0_105_305 VPWR VGND VPWR VGND sky130_ef_sc_hd__decap_12
XFILLER_0_121_809 VPWR VGND VPWR VGND sky130_ef_sc_hd__decap_12
XFILLER_0_105_349 VPWR VGND VPWR VGND sky130_ef_sc_hd__decap_12
XFILLER_0_7_385 VGND VGND VPWR VPWR sky130_fd_sc_hd__decap_6
X_4769_ _2369_ VGND VGND VPWR VPWR _0354_ sky130_fd_sc_hd__clkbuf_1
XFILLER_0_30_133 VGND VGND VPWR VPWR sky130_fd_sc_hd__decap_6
XFILLER_0_113_393 VPWR VGND VPWR VGND sky130_ef_sc_hd__decap_12
XFILLER_0_30_177 VPWR VGND VPWR VGND sky130_ef_sc_hd__decap_12
XFILLER_0_31_689 VGND VGND VPWR VPWR sky130_fd_sc_hd__decap_6
XTAP_TAPCELL_ROW_112_1978 VGND VPWR sky130_fd_sc_hd__tapvpwrvgnd_1
XFILLER_0_101_588 VGND VGND VPWR VPWR sky130_fd_sc_hd__fill_2
XFILLER_0_11_391 VGND VGND VPWR VPWR sky130_fd_sc_hd__fill_1
XFILLER_0_97_111 VGND VGND VPWR VPWR sky130_fd_sc_hd__fill_1
XFILLER_0_85_317 VPWR VGND VPWR VGND sky130_ef_sc_hd__decap_12
XFILLER_0_128_419 VGND VGND VPWR VPWR sky130_fd_sc_hd__fill_1
XFILLER_0_66_531 VGND VGND VPWR VPWR sky130_fd_sc_hd__fill_1
XTAP_TAPCELL_ROW_14_504 VGND VPWR sky130_fd_sc_hd__tapvpwrvgnd_1
XTAP_TAPCELL_ROW_14_515 VGND VPWR sky130_fd_sc_hd__tapvpwrvgnd_1
XFILLER_0_38_233 VPWR VGND VPWR VGND sky130_ef_sc_hd__decap_12
XFILLER_0_108_121 VPWR VGND VPWR VGND sky130_ef_sc_hd__decap_12
XFILLER_0_93_361 VPWR VGND VPWR VGND sky130_ef_sc_hd__decap_12
XFILLER_0_38_277 VPWR VGND VPWR VGND sky130_ef_sc_hd__decap_12
XFILLER_0_124_625 VPWR VGND VPWR VGND sky130_ef_sc_hd__decap_12
XFILLER_0_108_165 VPWR VGND VPWR VGND sky130_ef_sc_hd__decap_12
XFILLER_0_81_567 VGND VGND VPWR VPWR sky130_fd_sc_hd__fill_1
XFILLER_0_53_225 VPWR VGND VPWR VGND sky130_ef_sc_hd__decap_12
XFILLER_0_123_113 VPWR VGND VPWR VGND sky130_ef_sc_hd__decap_12
XFILLER_0_22_601 VPWR VGND VPWR VGND sky130_ef_sc_hd__decap_12
XFILLER_0_124_669 VPWR VGND VPWR VGND sky130_ef_sc_hd__decap_12
XFILLER_0_1_517 VPWR VGND VPWR VGND sky130_ef_sc_hd__decap_12
XPHY_EDGE_ROW_20_Left_159 VGND VGND VPWR VPWR sky130_fd_sc_hd__decap_3
XFILLER_0_21_111 VGND VGND VPWR VPWR sky130_fd_sc_hd__fill_1
XFILLER_0_22_645 VPWR VGND VPWR VGND sky130_ef_sc_hd__decap_12
XTAP_TAPCELL_ROW_74_1417 VGND VPWR sky130_fd_sc_hd__tapvpwrvgnd_1
XTAP_TAPCELL_ROW_74_1406 VGND VPWR sky130_fd_sc_hd__tapvpwrvgnd_1
XFILLER_0_67_27 VPWR VGND VPWR VGND sky130_ef_sc_hd__decap_12
XFILLER_0_83_15 VPWR VGND VPWR VGND sky130_ef_sc_hd__decap_12
XFILLER_0_107_55 VGND VGND VPWR VPWR sky130_fd_sc_hd__fill_1
XFILLER_0_88_133 VGND VGND VPWR VPWR sky130_fd_sc_hd__decap_6
Xrebuffer19 _0558_ VGND VGND VPWR VPWR net32 sky130_fd_sc_hd__dlymetal6s2s_1
XFILLER_0_16_53 VPWR VGND VPWR VGND sky130_ef_sc_hd__decap_12
XFILLER_0_88_177 VPWR VGND VPWR VGND sky130_ef_sc_hd__decap_12
XTAP_TAPCELL_ROW_85_1579 VGND VPWR sky130_fd_sc_hd__tapvpwrvgnd_1
XTAP_TAPCELL_ROW_85_1568 VGND VPWR sky130_fd_sc_hd__tapvpwrvgnd_1
XFILLER_0_9_617 VPWR VGND VPWR VGND sky130_ef_sc_hd__decap_12
XFILLER_0_16_97 VPWR VGND VPWR VGND sky130_ef_sc_hd__decap_12
XTAP_TAPCELL_ROW_33_802 VGND VPWR sky130_fd_sc_hd__tapvpwrvgnd_1
X_2953_ _0917_ _0902_ _0915_ VGND VGND VPWR VPWR _0918_ sky130_fd_sc_hd__a21o_1
XFILLER_0_69_391 VGND VGND VPWR VPWR sky130_fd_sc_hd__fill_1
XFILLER_0_57_542 VPWR VGND VPWR VGND sky130_ef_sc_hd__decap_12
XFILLER_0_127_441 VGND VGND VPWR VPWR sky130_fd_sc_hd__decap_6
XFILLER_0_17_417 VPWR VGND VPWR VGND sky130_ef_sc_hd__decap_12
XFILLER_0_32_41 VPWR VGND VPWR VGND sky130_ef_sc_hd__decap_12
XFILLER_0_127_485 VPWR VGND VPWR VGND sky130_ef_sc_hd__decap_12
X_2884_ _0821_ VGND VGND VPWR VPWR _0849_ sky130_fd_sc_hd__buf_2
XFILLER_0_32_85 VPWR VGND VPWR VGND sky130_ef_sc_hd__decap_12
XTAP_TAPCELL_ROW_116_2034 VGND VPWR sky130_fd_sc_hd__tapvpwrvgnd_1
X_4623_ _2260_ VGND VGND VPWR VPWR _0317_ sky130_fd_sc_hd__clkbuf_1
XFILLER_0_72_578 VGND VGND VPWR VPWR sky130_fd_sc_hd__decap_3
XFILLER_0_60_718 VGND VGND VPWR VPWR sky130_fd_sc_hd__fill_2
XFILLER_0_53_770 VPWR VGND VPWR VGND sky130_ef_sc_hd__decap_12
XFILLER_0_4_333 VPWR VGND VPWR VGND sky130_ef_sc_hd__decap_12
XFILLER_0_25_461 VPWR VGND VPWR VGND sky130_ef_sc_hd__decap_12
XTAP_TAPCELL_ROW_116_2045 VGND VPWR sky130_fd_sc_hd__tapvpwrvgnd_1
XFILLER_0_103_809 VPWR VGND VPWR VGND sky130_ef_sc_hd__decap_12
X_4554_ cpu_inst.regfile_inst.registers\[11\]\[28\] VGND VGND VPWR VPWR _2225_ sky130_fd_sc_hd__clkbuf_1
X_3505_ _1430_ _1441_ VGND VGND VPWR VPWR _1442_ sky130_fd_sc_hd__xnor2_1
XFILLER_0_12_133 VGND VGND VPWR VPWR sky130_fd_sc_hd__decap_6
XFILLER_0_4_377 VPWR VGND VPWR VGND sky130_ef_sc_hd__decap_12
X_4485_ _2190_ VGND VGND VPWR VPWR _0249_ sky130_fd_sc_hd__clkbuf_1
XFILLER_0_12_177 VPWR VGND VPWR VGND sky130_ef_sc_hd__decap_12
XFILLER_0_110_363 VGND VGND VPWR VPWR sky130_fd_sc_hd__fill_1
X_3436_ _1373_ _1374_ VGND VGND VPWR VPWR _1375_ sky130_fd_sc_hd__or2_1
XFILLER_0_0_561 VPWR VGND VPWR VGND sky130_ef_sc_hd__decap_12
X_3367_ net18 VGND VGND VPWR VPWR _1317_ sky130_fd_sc_hd__clkbuf_4
X_5106_ clknet_leaf_8_clk _0026_ VGND VGND VPWR VPWR cpu_inst.regfile_inst.registers\[6\]\[26\]
+ sky130_fd_sc_hd__dfxtp_1
XFILLER_0_57_93 VPWR VGND VPWR VGND sky130_ef_sc_hd__decap_12
X_3298_ _1262_ VGND VGND VPWR VPWR _1263_ sky130_fd_sc_hd__inv_2
X_5037_ _2507_ _2508_ VGND VGND VPWR VPWR _0483_ sky130_fd_sc_hd__nor2_1
XFILLER_0_79_111 VGND VGND VPWR VPWR sky130_fd_sc_hd__fill_1
XFILLER_0_73_81 VPWR VGND VPWR VGND sky130_ef_sc_hd__decap_12
XFILLER_0_95_637 VGND VGND VPWR VPWR sky130_fd_sc_hd__fill_1
XTAP_TAPCELL_ROW_0_287 VGND VPWR sky130_fd_sc_hd__tapvpwrvgnd_1
XFILLER_0_137_205 VPWR VGND VPWR VGND sky130_ef_sc_hd__decap_12
XFILLER_0_82_309 VPWR VGND VPWR VGND sky130_ef_sc_hd__decap_12
XFILLER_0_76_840 VGND VGND VPWR VPWR sky130_fd_sc_hd__fill_2
XTAP_TAPCELL_ROW_0_298 VGND VPWR sky130_fd_sc_hd__tapvpwrvgnd_1
XFILLER_0_137_249 VPWR VGND VPWR VGND sky130_ef_sc_hd__decap_12
XFILLER_0_75_361 VPWR VGND VPWR VGND sky130_ef_sc_hd__decap_12
XFILLER_0_35_225 VPWR VGND VPWR VGND sky130_ef_sc_hd__decap_12
XFILLER_0_105_113 VPWR VGND VPWR VGND sky130_ef_sc_hd__decap_12
XFILLER_0_7_193 VPWR VGND VPWR VGND sky130_ef_sc_hd__decap_12
XFILLER_0_121_617 VPWR VGND VPWR VGND sky130_ef_sc_hd__decap_12
Xoutput9 net9 VGND VGND VPWR VPWR seg[2] sky130_fd_sc_hd__buf_1
Xoutput11 net11 VGND VGND VPWR VPWR seg[4] sky130_fd_sc_hd__buf_1
XTAP_TAPCELL_ROW_56_1147 VGND VPWR sky130_fd_sc_hd__tapvpwrvgnd_1
XTAP_TAPCELL_ROW_56_1136 VGND VPWR sky130_fd_sc_hd__tapvpwrvgnd_1
XFILLER_0_9_3 VPWR VGND VPWR VGND sky130_ef_sc_hd__decap_12
XFILLER_0_101_385 VGND VGND VPWR VPWR sky130_fd_sc_hd__decap_6
XFILLER_0_85_125 VPWR VGND VPWR VGND sky130_ef_sc_hd__decap_12
XFILLER_0_58_317 VGND VGND VPWR VPWR sky130_fd_sc_hd__decap_4
XTAP_TAPCELL_ROW_67_1298 VGND VPWR sky130_fd_sc_hd__tapvpwrvgnd_1
XFILLER_0_109_441 VGND VGND VPWR VPWR sky130_fd_sc_hd__decap_6
XFILLER_0_85_169 VPWR VGND VPWR VGND sky130_ef_sc_hd__decap_12
XFILLER_0_66_372 VGND VGND VPWR VPWR sky130_fd_sc_hd__fill_1
XFILLER_0_137_783 VGND VGND VPWR VPWR sky130_fd_sc_hd__fill_1
XFILLER_0_124_433 VPWR VGND VPWR VGND sky130_ef_sc_hd__decap_12
XFILLER_0_109_485 VPWR VGND VPWR VGND sky130_ef_sc_hd__decap_12
XTAP_TAPCELL_ROW_80_1498 VGND VPWR sky130_fd_sc_hd__tapvpwrvgnd_1
XFILLER_0_78_15 VPWR VGND VPWR VGND sky130_ef_sc_hd__decap_12
XFILLER_0_35_781 VGND VGND VPWR VPWR sky130_fd_sc_hd__decap_3
XFILLER_0_41_217 VGND VGND VPWR VPWR sky130_fd_sc_hd__decap_6
XFILLER_0_124_477 VPWR VGND VPWR VGND sky130_ef_sc_hd__decap_12
XFILLER_0_111_105 VGND VGND VPWR VPWR sky130_fd_sc_hd__decap_6
XFILLER_0_2_837 VGND VGND VPWR VPWR sky130_fd_sc_hd__decap_4
XFILLER_0_111_149 VPWR VGND VPWR VGND sky130_ef_sc_hd__decap_12
XFILLER_0_22_475 VGND VGND VPWR VPWR sky130_fd_sc_hd__fill_1
X_4270_ _2077_ VGND VGND VPWR VPWR _0147_ sky130_fd_sc_hd__clkbuf_1
XFILLER_0_10_637 VGND VGND VPWR VPWR sky130_fd_sc_hd__decap_6
X_3221_ net15 _0912_ _1104_ VGND VGND VPWR VPWR _1186_ sky130_fd_sc_hd__or3_1
X_3152_ _0725_ _1115_ _1116_ VGND VGND VPWR VPWR _1117_ sky130_fd_sc_hd__or3_1
XFILLER_0_118_65 VPWR VGND VPWR VGND sky130_ef_sc_hd__decap_12
XTAP_TAPCELL_ROW_87_1608 VGND VPWR sky130_fd_sc_hd__tapvpwrvgnd_1
X_3083_ _0878_ _1026_ _1047_ VGND VGND VPWR VPWR _1048_ sky130_fd_sc_hd__nand3_1
XFILLER_0_134_53 VPWR VGND VPWR VGND sky130_ef_sc_hd__decap_12
XFILLER_0_49_317 VPWR VGND VPWR VGND sky130_ef_sc_hd__decap_12
XFILLER_0_134_97 VPWR VGND VPWR VGND sky130_ef_sc_hd__decap_12
XFILLER_0_119_205 VPWR VGND VPWR VGND sky130_ef_sc_hd__decap_12
XFILLER_0_58_840 VGND VGND VPWR VPWR sky130_fd_sc_hd__fill_2
XFILLER_0_43_51 VGND VGND VPWR VPWR sky130_fd_sc_hd__decap_4
XTAP_TAPCELL_ROW_46_993 VGND VPWR sky130_fd_sc_hd__tapvpwrvgnd_1
XFILLER_0_135_709 VPWR VGND VPWR VGND sky130_ef_sc_hd__decap_12
XFILLER_0_119_249 VPWR VGND VPWR VGND sky130_ef_sc_hd__decap_12
X_3985_ cpu_inst.regfile_inst.registers\[2\]\[31\] _1804_ _1805_ cpu_inst.regfile_inst.registers\[7\]\[31\]
+ VGND VGND VPWR VPWR _1909_ sky130_fd_sc_hd__o22a_1
XFILLER_0_64_309 VGND VGND VPWR VPWR sky130_fd_sc_hd__decap_3
XFILLER_0_9_447 VGND VGND VPWR VPWR sky130_fd_sc_hd__fill_1
XFILLER_0_18_737 VPWR VGND VPWR VGND sky130_ef_sc_hd__decap_12
X_2936_ _0892_ _0899_ VGND VGND VPWR VPWR _0901_ sky130_fd_sc_hd__nand2_1
XFILLER_0_17_225 VPWR VGND VPWR VGND sky130_ef_sc_hd__decap_12
XFILLER_0_127_293 VPWR VGND VPWR VGND sky130_ef_sc_hd__decap_12
X_2867_ _0642_ _0830_ _0831_ VGND VGND VPWR VPWR _0832_ sky130_fd_sc_hd__or3_1
XFILLER_0_33_729 VPWR VGND VPWR VGND sky130_ef_sc_hd__decap_12
X_4606_ _2251_ VGND VGND VPWR VPWR _0309_ sky130_fd_sc_hd__clkbuf_1
XFILLER_0_87_3 VPWR VGND VPWR VGND sky130_ef_sc_hd__decap_12
XFILLER_0_5_653 VPWR VGND VPWR VGND sky130_ef_sc_hd__decap_12
XFILLER_0_4_141 VPWR VGND VPWR VGND sky130_ef_sc_hd__decap_12
XFILLER_0_26_781 VPWR VGND VPWR VGND sky130_ef_sc_hd__decap_12
XFILLER_0_103_639 VGND VGND VPWR VPWR sky130_fd_sc_hd__fill_1
XFILLER_0_103_617 VGND VGND VPWR VPWR sky130_fd_sc_hd__fill_1
XFILLER_0_5_697 VPWR VGND VPWR VGND sky130_ef_sc_hd__decap_12
X_2798_ _0761_ _0720_ _0762_ VGND VGND VPWR VPWR _0763_ sky130_fd_sc_hd__a21oi_4
XFILLER_0_130_469 VGND VGND VPWR VPWR sky130_fd_sc_hd__decap_6
X_4537_ _2216_ VGND VGND VPWR VPWR _0275_ sky130_fd_sc_hd__clkbuf_1
XFILLER_0_7_51 VGND VGND VPWR VPWR sky130_fd_sc_hd__decap_4
XFILLER_0_13_497 VGND VGND VPWR VPWR sky130_fd_sc_hd__decap_6
X_4468_ _2181_ VGND VGND VPWR VPWR _0241_ sky130_fd_sc_hd__clkbuf_1
X_3419_ _1357_ _1236_ VGND VGND VPWR VPWR _1358_ sky130_fd_sc_hd__nor2_1
XTAP_TAPCELL_ROW_129_2236 VGND VPWR sky130_fd_sc_hd__tapvpwrvgnd_1
X_4399_ cpu_inst.regfile_inst.registers\[1\]\[17\] VGND VGND VPWR VPWR _2145_ sky130_fd_sc_hd__clkbuf_1
XFILLER_0_99_217 VGND VGND VPWR VPWR sky130_fd_sc_hd__decap_6
XTAP_TAPCELL_ROW_5_379 VGND VPWR sky130_fd_sc_hd__tapvpwrvgnd_1
XTAP_TAPCELL_ROW_5_368 VGND VPWR sky130_fd_sc_hd__tapvpwrvgnd_1
XTAP_TAPCELL_ROW_51_1066 VGND VPWR sky130_fd_sc_hd__tapvpwrvgnd_1
XFILLER_0_95_423 VGND VGND VPWR VPWR sky130_fd_sc_hd__fill_1
XFILLER_0_67_125 VPWR VGND VPWR VGND sky130_ef_sc_hd__decap_12
XTAP_TAPCELL_ROW_107_1899 VGND VPWR sky130_fd_sc_hd__tapvpwrvgnd_1
XFILLER_0_67_169 VPWR VGND VPWR VGND sky130_ef_sc_hd__decap_12
XTAP_TAPCELL_ROW_24_654 VGND VPWR sky130_fd_sc_hd__tapvpwrvgnd_1
XFILLER_0_119_783 VGND VGND VPWR VPWR sky130_fd_sc_hd__fill_1
XFILLER_0_82_139 VGND VGND VPWR VPWR sky130_fd_sc_hd__fill_1
XFILLER_0_76_692 VGND VGND VPWR VPWR sky130_fd_sc_hd__decap_8
XTAP_TAPCELL_ROW_24_665 VGND VPWR sky130_fd_sc_hd__tapvpwrvgnd_1
XFILLER_0_106_433 VPWR VGND VPWR VGND sky130_ef_sc_hd__decap_12
XFILLER_0_91_651 VGND VGND VPWR VPWR sky130_fd_sc_hd__decap_6
XFILLER_0_36_589 VGND VGND VPWR VPWR sky130_fd_sc_hd__decap_8
XFILLER_0_23_217 VGND VGND VPWR VPWR sky130_fd_sc_hd__decap_6
XFILLER_0_121_447 VGND VGND VPWR VPWR sky130_fd_sc_hd__fill_1
XFILLER_0_31_261 VPWR VGND VPWR VGND sky130_ef_sc_hd__decap_12
XFILLER_0_48_29 VPWR VGND VPWR VGND sky130_ef_sc_hd__decap_12
XFILLER_0_101_193 VPWR VGND VPWR VGND sky130_ef_sc_hd__decap_12
XTAP_TAPCELL_ROW_69_1338 VGND VPWR sky130_fd_sc_hd__tapvpwrvgnd_1
XPHY_EDGE_ROW_103_Left_242 VGND VGND VPWR VPWR sky130_fd_sc_hd__decap_3
XFILLER_0_129_503 VGND VGND VPWR VPWR sky130_fd_sc_hd__fill_1
XTAP_TAPCELL_ROW_82_1527 VGND VPWR sky130_fd_sc_hd__tapvpwrvgnd_1
XFILLER_0_80_27 VGND VGND VPWR VPWR sky130_fd_sc_hd__fill_1
XFILLER_0_117_709 VPWR VGND VPWR VGND sky130_ef_sc_hd__decap_12
XFILLER_0_74_629 VPWR VGND VPWR VGND sky130_ef_sc_hd__decap_12
XFILLER_0_39_361 VPWR VGND VPWR VGND sky130_ef_sc_hd__decap_12
XTAP_TAPCELL_ROW_43_941 VGND VPWR sky130_fd_sc_hd__tapvpwrvgnd_1
XTAP_TAPCELL_ROW_43_952 VGND VPWR sky130_fd_sc_hd__tapvpwrvgnd_1
XFILLER_0_46_309 VPWR VGND VPWR VGND sky130_ef_sc_hd__decap_12
X_3770_ cpu_inst.regfile_inst.registers\[25\]\[25\] _1285_ _1449_ _1699_ VGND VGND
+ VPWR VPWR _1700_ sky130_fd_sc_hd__o211a_1
XFILLER_0_70_813 VGND VGND VPWR VPWR sky130_fd_sc_hd__decap_6
X_2721_ _0548_ VGND VGND VPWR VPWR _0686_ sky130_fd_sc_hd__clkbuf_4
XPHY_EDGE_ROW_132_Right_132 VGND VGND VPWR VPWR sky130_fd_sc_hd__decap_3
XFILLER_0_125_753 VPWR VGND VPWR VGND sky130_ef_sc_hd__decap_12
XFILLER_0_109_293 VPWR VGND VPWR VGND sky130_ef_sc_hd__decap_12
XFILLER_0_81_161 VGND VGND VPWR VPWR sky130_fd_sc_hd__decap_6
XFILLER_0_54_397 VGND VGND VPWR VPWR sky130_fd_sc_hd__decap_3
XFILLER_0_15_729 VPWR VGND VPWR VGND sky130_ef_sc_hd__decap_12
X_5440_ clknet_leaf_33_clk _0360_ VGND VGND VPWR VPWR cpu_inst.regfile_inst.registers\[0\]\[8\]
+ sky130_fd_sc_hd__dfxtp_1
XFILLER_0_125_797 VPWR VGND VPWR VGND sky130_ef_sc_hd__decap_12
XFILLER_0_89_69 VPWR VGND VPWR VGND sky130_ef_sc_hd__decap_12
XFILLER_0_2_601 VPWR VGND VPWR VGND sky130_ef_sc_hd__decap_12
X_2652_ _0546_ _0616_ VGND VGND VPWR VPWR _0617_ sky130_fd_sc_hd__nor2_2
XFILLER_0_120_77 VGND VGND VPWR VPWR sky130_fd_sc_hd__decap_6
XPHY_EDGE_ROW_112_Left_251 VGND VGND VPWR VPWR sky130_fd_sc_hd__decap_3
X_2583_ _0547_ VGND VGND VPWR VPWR _0548_ sky130_fd_sc_hd__buf_6
XFILLER_0_10_401 VPWR VGND VPWR VGND sky130_ef_sc_hd__decap_12
XFILLER_0_1_111 VGND VGND VPWR VPWR sky130_fd_sc_hd__fill_1
XFILLER_0_2_645 VPWR VGND VPWR VGND sky130_ef_sc_hd__decap_12
X_5371_ clknet_leaf_41_clk _0291_ VGND VGND VPWR VPWR cpu_inst.regfile_inst.registers\[10\]\[3\]
+ sky130_fd_sc_hd__dfxtp_1
XFILLER_0_112_469 VGND VGND VPWR VPWR sky130_fd_sc_hd__decap_6
X_4322_ _1215_ cpu_inst.regfile_inst.registers\[5\]\[11\] _2105_ VGND VGND VPWR VPWR
+ _2106_ sky130_fd_sc_hd__mux2_1
XFILLER_0_10_445 VPWR VGND VPWR VGND sky130_ef_sc_hd__decap_12
XTAP_TAPCELL_ROW_93_1689 VGND VPWR sky130_fd_sc_hd__tapvpwrvgnd_1
X_4253_ cpu_inst.regfile_inst.registers\[24\]\[11\] VGND VGND VPWR VPWR _2069_ sky130_fd_sc_hd__clkbuf_1
X_3204_ _1157_ _1164_ _1168_ _0690_ _0500_ VGND VGND VPWR VPWR _1169_ sky130_fd_sc_hd__a221o_1
XFILLER_0_10_489 VPWR VGND VPWR VGND sky130_ef_sc_hd__decap_12
X_4184_ _2033_ VGND VGND VPWR VPWR _0105_ sky130_fd_sc_hd__clkbuf_1
X_3135_ _1092_ _1095_ _1099_ _1053_ VGND VGND VPWR VPWR _1100_ sky130_fd_sc_hd__a2bb2o_2
XTAP_TAPCELL_ROW_2_327 VGND VPWR sky130_fd_sc_hd__tapvpwrvgnd_1
XPHY_EDGE_ROW_121_Left_260 VGND VGND VPWR VPWR sky130_fd_sc_hd__decap_3
XFILLER_0_96_209 VPWR VGND VPWR VGND sky130_ef_sc_hd__decap_12
X_3066_ cpu_inst.regfile_inst.registers\[1\]\[13\] _0726_ _0703_ cpu_inst.regfile_inst.registers\[5\]\[13\]
+ _0562_ VGND VGND VPWR VPWR _1031_ sky130_fd_sc_hd__o221a_1
XTAP_TAPCELL_ROW_124_2166 VGND VPWR sky130_fd_sc_hd__tapvpwrvgnd_1
XTAP_TAPCELL_ROW_124_2155 VGND VPWR sky130_fd_sc_hd__tapvpwrvgnd_1
XFILLER_0_89_261 VPWR VGND VPWR VGND sky130_ef_sc_hd__decap_12
XFILLER_0_54_83 VGND VGND VPWR VPWR sky130_fd_sc_hd__fill_1
XFILLER_0_49_125 VPWR VGND VPWR VGND sky130_ef_sc_hd__decap_12
XFILLER_0_58_670 VGND VGND VPWR VPWR sky130_fd_sc_hd__decap_8
XFILLER_0_18_501 VPWR VGND VPWR VGND sky130_ef_sc_hd__decap_12
XFILLER_0_49_169 VPWR VGND VPWR VGND sky130_ef_sc_hd__decap_12
XFILLER_0_135_517 VPWR VGND VPWR VGND sky130_ef_sc_hd__decap_12
X_3968_ _1875_ _1892_ VGND VGND VPWR VPWR _1893_ sky130_fd_sc_hd__nor2_1
XFILLER_0_64_139 VGND VGND VPWR VPWR sky130_fd_sc_hd__fill_1
XFILLER_0_18_545 VPWR VGND VPWR VGND sky130_ef_sc_hd__decap_12
XFILLER_0_73_673 VGND VGND VPWR VPWR sky130_fd_sc_hd__fill_1
XTAP_TAPCELL_ROW_21_613 VGND VPWR sky130_fd_sc_hd__tapvpwrvgnd_1
X_2919_ _0881_ _0882_ _0883_ VGND VGND VPWR VPWR _0884_ sky130_fd_sc_hd__mux2_1
X_3899_ _1821_ _1724_ _1825_ VGND VGND VPWR VPWR _1826_ sky130_fd_sc_hd__o21bai_2
XFILLER_0_60_301 VGND VGND VPWR VPWR sky130_fd_sc_hd__decap_6
XFILLER_0_18_589 VPWR VGND VPWR VGND sky130_ef_sc_hd__decap_12
XFILLER_0_5_461 VPWR VGND VPWR VGND sky130_ef_sc_hd__decap_12
XFILLER_0_33_559 VGND VGND VPWR VPWR sky130_fd_sc_hd__fill_1
XFILLER_0_130_233 VPWR VGND VPWR VGND sky130_ef_sc_hd__decap_12
XFILLER_0_103_447 VGND VGND VPWR VPWR sky130_fd_sc_hd__fill_1
XFILLER_0_13_261 VPWR VGND VPWR VGND sky130_ef_sc_hd__decap_12
XFILLER_0_20_209 VPWR VGND VPWR VGND sky130_ef_sc_hd__decap_12
X_5569_ clknet_leaf_30_clk _0489_ VGND VGND VPWR VPWR cpu_inst.display_inst.counter\[9\]
+ sky130_fd_sc_hd__dfxtp_1
XFILLER_0_130_277 VPWR VGND VPWR VGND sky130_ef_sc_hd__decap_12
XTAP_TAPCELL_ROW_109_1928 VGND VPWR sky130_fd_sc_hd__tapvpwrvgnd_1
XTAP_TAPCELL_ROW_109_1939 VGND VPWR sky130_fd_sc_hd__tapvpwrvgnd_1
XTAP_TAPCELL_ROW_29_735 VGND VPWR sky130_fd_sc_hd__tapvpwrvgnd_1
XFILLER_0_138_333 VGND VGND VPWR VPWR sky130_fd_sc_hd__decap_3
XTAP_TAPCELL_ROW_64_1257 VGND VPWR sky130_fd_sc_hd__tapvpwrvgnd_1
XFILLER_0_28_309 VPWR VGND VPWR VGND sky130_ef_sc_hd__decap_12
XFILLER_0_138_377 VPWR VGND VPWR VGND sky130_ef_sc_hd__decap_12
XTAP_TAPCELL_ROW_40_900 VGND VPWR sky130_fd_sc_hd__tapvpwrvgnd_1
XFILLER_0_70_109 VPWR VGND VPWR VGND sky130_ef_sc_hd__decap_12
XFILLER_0_64_662 VPWR VGND VPWR VGND sky130_ef_sc_hd__decap_12
XFILLER_0_107_753 VPWR VGND VPWR VGND sky130_ef_sc_hd__decap_12
XFILLER_0_63_161 VGND VGND VPWR VPWR sky130_fd_sc_hd__decap_6
XFILLER_0_122_701 VPWR VGND VPWR VGND sky130_ef_sc_hd__decap_12
XFILLER_0_107_797 VPWR VGND VPWR VGND sky130_ef_sc_hd__decap_12
XFILLER_0_59_39 VPWR VGND VPWR VGND sky130_ef_sc_hd__decap_12
XFILLER_0_51_378 VGND VGND VPWR VPWR sky130_fd_sc_hd__fill_1
XFILLER_0_32_581 VGND VGND VPWR VPWR sky130_fd_sc_hd__fill_2
XFILLER_0_75_27 VPWR VGND VPWR VGND sky130_ef_sc_hd__decap_12
XFILLER_0_91_15 VPWR VGND VPWR VGND sky130_ef_sc_hd__decap_12
XFILLER_0_78_209 VPWR VGND VPWR VGND sky130_ef_sc_hd__decap_12
XFILLER_0_115_55 VGND VGND VPWR VPWR sky130_fd_sc_hd__fill_1
X_4940_ _2457_ VGND VGND VPWR VPWR _0437_ sky130_fd_sc_hd__clkbuf_1
X_4871_ _2420_ VGND VGND VPWR VPWR _0405_ sky130_fd_sc_hd__clkbuf_1
XFILLER_0_86_253 VPWR VGND VPWR VGND sky130_ef_sc_hd__decap_12
XFILLER_0_24_53 VPWR VGND VPWR VGND sky130_ef_sc_hd__decap_12
XFILLER_0_117_517 VPWR VGND VPWR VGND sky130_ef_sc_hd__decap_12
X_3822_ _1724_ _1728_ _1750_ VGND VGND VPWR VPWR _1751_ sky130_fd_sc_hd__a21oi_1
XFILLER_0_24_97 VPWR VGND VPWR VGND sky130_ef_sc_hd__decap_12
XFILLER_0_46_139 VGND VGND VPWR VPWR sky130_fd_sc_hd__fill_1
X_3753_ _1682_ _1683_ VGND VGND VPWR VPWR _1684_ sky130_fd_sc_hd__nor2_1
XFILLER_0_55_673 VPWR VGND VPWR VGND sky130_ef_sc_hd__decap_12
XFILLER_0_40_41 VPWR VGND VPWR VGND sky130_ef_sc_hd__decap_12
XFILLER_0_42_301 VGND VGND VPWR VPWR sky130_fd_sc_hd__decap_6
XFILLER_0_125_561 VPWR VGND VPWR VGND sky130_ef_sc_hd__decap_12
X_3684_ _1615_ cpu_inst.regfile_inst.registers\[10\]\[23\] _1312_ VGND VGND VPWR VPWR
+ _1616_ sky130_fd_sc_hd__mux2_1
XTAP_TAPCELL_ROW_95_1729 VGND VPWR sky130_fd_sc_hd__tapvpwrvgnd_1
XTAP_TAPCELL_ROW_95_1718 VGND VPWR sky130_fd_sc_hd__tapvpwrvgnd_1
X_2704_ _0545_ _0647_ _0668_ VGND VGND VPWR VPWR _0669_ sky130_fd_sc_hd__nand3_4
XFILLER_0_15_559 VGND VGND VPWR VPWR sky130_fd_sc_hd__fill_1
XFILLER_0_40_85 VPWR VGND VPWR VGND sky130_ef_sc_hd__decap_12
XFILLER_0_42_345 VPWR VGND VPWR VGND sky130_ef_sc_hd__decap_12
XFILLER_0_112_233 VPWR VGND VPWR VGND sky130_ef_sc_hd__decap_12
XFILLER_0_70_698 VGND VGND VPWR VPWR sky130_fd_sc_hd__fill_2
X_5423_ clknet_leaf_0_clk _0343_ net2 VGND VGND VPWR VPWR cpu_inst.decoder_inst.current_pc\[23\]
+ sky130_fd_sc_hd__dfrtp_1
XFILLER_0_42_389 VPWR VGND VPWR VGND sky130_ef_sc_hd__decap_12
X_2635_ _0553_ _0559_ VGND VGND VPWR VPWR _0600_ sky130_fd_sc_hd__and2_1
X_5354_ clknet_leaf_19_clk _0274_ VGND VGND VPWR VPWR cpu_inst.regfile_inst.registers\[11\]\[18\]
+ sky130_fd_sc_hd__dfxtp_1
XFILLER_0_11_721 VGND VGND VPWR VPWR sky130_fd_sc_hd__decap_6
XFILLER_0_2_475 VGND VGND VPWR VPWR sky130_fd_sc_hd__fill_1
XFILLER_0_112_277 VPWR VGND VPWR VGND sky130_ef_sc_hd__decap_12
X_2566_ _0530_ VGND VGND VPWR VPWR _0531_ sky130_fd_sc_hd__buf_2
XFILLER_0_11_765 VPWR VGND VPWR VGND sky130_ef_sc_hd__decap_12
XFILLER_0_10_253 VPWR VGND VPWR VGND sky130_ef_sc_hd__decap_12
XTAP_TAPCELL_ROW_7_408 VGND VPWR sky130_fd_sc_hd__tapvpwrvgnd_1
X_4305_ _2096_ VGND VGND VPWR VPWR _0163_ sky130_fd_sc_hd__clkbuf_1
X_5285_ clknet_leaf_28_clk _0205_ VGND VGND VPWR VPWR cpu_inst.regfile_inst.registers\[1\]\[13\]
+ sky130_fd_sc_hd__dfxtp_1
X_4236_ _2060_ VGND VGND VPWR VPWR _0130_ sky130_fd_sc_hd__clkbuf_1
XFILLER_0_4_41 VPWR VGND VPWR VGND sky130_ef_sc_hd__decap_12
XFILLER_0_4_85 VPWR VGND VPWR VGND sky130_ef_sc_hd__decap_12
X_4167_ _2025_ VGND VGND VPWR VPWR _0096_ sky130_fd_sc_hd__clkbuf_1
X_3118_ _1080_ _1082_ _1062_ VGND VGND VPWR VPWR _1083_ sky130_fd_sc_hd__mux2_1
XFILLER_0_65_93 VPWR VGND VPWR VGND sky130_ef_sc_hd__decap_12
X_4098_ _1205_ cpu_inst.regfile_inst.registers\[25\]\[3\] _1982_ VGND VGND VPWR VPWR
+ _1986_ sky130_fd_sc_hd__mux2_1
X_3049_ _1006_ _1013_ VGND VGND VPWR VPWR _1014_ sky130_fd_sc_hd__or2_1
XTAP_TAPCELL_ROW_104_1858 VGND VPWR sky130_fd_sc_hd__tapvpwrvgnd_1
XFILLER_0_81_81 VPWR VGND VPWR VGND sky130_ef_sc_hd__decap_12
XFILLER_0_19_821 VPWR VGND VPWR VGND sky130_ef_sc_hd__decap_12
XFILLER_0_136_837 VGND VGND VPWR VPWR sky130_fd_sc_hd__decap_4
XFILLER_0_92_245 VGND VGND VPWR VPWR sky130_fd_sc_hd__decap_6
XTAP_TAPCELL_ROW_137_2357 VGND VPWR sky130_fd_sc_hd__tapvpwrvgnd_1
XFILLER_0_92_289 VPWR VGND VPWR VGND sky130_ef_sc_hd__decap_12
XFILLER_0_80_418 VGND VGND VPWR VPWR sky130_fd_sc_hd__fill_2
XFILLER_0_61_610 VGND VGND VPWR VPWR sky130_fd_sc_hd__fill_2
XFILLER_0_34_835 VGND VGND VPWR VPWR sky130_fd_sc_hd__decap_6
XFILLER_0_45_161 VGND VGND VPWR VPWR sky130_fd_sc_hd__decap_6
XFILLER_0_46_695 VGND VGND VPWR VPWR sky130_fd_sc_hd__fill_2
XFILLER_0_52_109 VPWR VGND VPWR VGND sky130_ef_sc_hd__decap_12
XFILLER_0_104_701 VPWR VGND VPWR VGND sky130_ef_sc_hd__decap_12
XFILLER_0_6_781 VPWR VGND VPWR VGND sky130_ef_sc_hd__decap_12
XFILLER_0_60_153 VPWR VGND VPWR VGND sky130_ef_sc_hd__decap_12
XFILLER_0_21_529 VPWR VGND VPWR VGND sky130_ef_sc_hd__decap_12
XFILLER_0_131_553 VGND VGND VPWR VPWR sky130_fd_sc_hd__decap_6
XFILLER_0_60_197 VPWR VGND VPWR VGND sky130_ef_sc_hd__decap_12
XFILLER_0_14_581 VGND VGND VPWR VPWR sky130_fd_sc_hd__decap_6
XFILLER_0_131_597 VPWR VGND VPWR VGND sky130_ef_sc_hd__decap_12
XFILLER_0_68_253 VPWR VGND VPWR VGND sky130_ef_sc_hd__decap_12
XFILLER_0_138_141 VPWR VGND VPWR VGND sky130_ef_sc_hd__decap_12
XFILLER_0_84_746 VGND VGND VPWR VPWR sky130_fd_sc_hd__fill_1
XFILLER_0_83_223 VGND VGND VPWR VPWR sky130_fd_sc_hd__fill_1
XFILLER_0_28_139 VGND VGND VPWR VPWR sky130_fd_sc_hd__fill_1
XFILLER_0_56_459 VGND VGND VPWR VPWR sky130_fd_sc_hd__decap_3
XFILLER_0_24_301 VGND VGND VPWR VPWR sky130_fd_sc_hd__decap_6
XFILLER_0_52_654 VGND VGND VPWR VPWR sky130_fd_sc_hd__decap_6
XTAP_TAPCELL_ROW_12_487 VGND VPWR sky130_fd_sc_hd__tapvpwrvgnd_1
XTAP_TAPCELL_ROW_12_476 VGND VPWR sky130_fd_sc_hd__tapvpwrvgnd_1
XFILLER_0_3_217 VGND VGND VPWR VPWR sky130_fd_sc_hd__decap_6
XFILLER_0_24_345 VPWR VGND VPWR VGND sky130_ef_sc_hd__decap_12
XFILLER_0_122_531 VGND VGND VPWR VPWR sky130_fd_sc_hd__fill_1
XFILLER_0_101_57 VPWR VGND VPWR VGND sky130_ef_sc_hd__decap_12
XTAP_TAPCELL_ROW_77_1448 VGND VPWR sky130_fd_sc_hd__tapvpwrvgnd_1
XFILLER_0_40_838 VGND VGND VPWR VPWR sky130_fd_sc_hd__decap_4
XTAP_TAPCELL_ROW_77_1459 VGND VPWR sky130_fd_sc_hd__tapvpwrvgnd_1
XFILLER_0_10_77 VGND VGND VPWR VPWR sky130_fd_sc_hd__decap_6
XFILLER_0_24_389 VPWR VGND VPWR VGND sky130_ef_sc_hd__decap_12
XFILLER_0_110_737 VPWR VGND VPWR VGND sky130_ef_sc_hd__decap_12
XFILLER_0_86_15 VPWR VGND VPWR VGND sky130_ef_sc_hd__decap_12
XTAP_TAPCELL_ROW_90_1648 VGND VPWR sky130_fd_sc_hd__tapvpwrvgnd_1
X_5070_ _2270_ _2527_ _2529_ VGND VGND VPWR VPWR _2530_ sky130_fd_sc_hd__and3_1
X_4021_ _1385_ _1684_ _1691_ VGND VGND VPWR VPWR _1944_ sky130_fd_sc_hd__a21o_1
XFILLER_0_126_65 VPWR VGND VPWR VGND sky130_ef_sc_hd__decap_12
XFILLER_0_79_529 VGND VGND VPWR VPWR sky130_fd_sc_hd__fill_1
XTAP_TAPCELL_ROW_121_2114 VGND VPWR sky130_fd_sc_hd__tapvpwrvgnd_1
X_4923_ _2448_ VGND VGND VPWR VPWR _0429_ sky130_fd_sc_hd__clkbuf_1
XFILLER_0_118_837 VGND VGND VPWR VPWR sky130_fd_sc_hd__decap_4
XFILLER_0_74_245 VGND VGND VPWR VPWR sky130_fd_sc_hd__decap_6
X_4854_ cpu_inst.regfile_inst.registers\[9\]\[13\] VGND VGND VPWR VPWR _2412_ sky130_fd_sc_hd__clkbuf_1
XFILLER_0_51_51 VGND VGND VPWR VPWR sky130_fd_sc_hd__decap_4
X_3805_ _1536_ _1731_ _1733_ _1314_ VGND VGND VPWR VPWR _1734_ sky130_fd_sc_hd__o22a_1
XFILLER_0_74_289 VPWR VGND VPWR VGND sky130_ef_sc_hd__decap_12
XFILLER_0_16_813 VPWR VGND VPWR VGND sky130_ef_sc_hd__decap_12
XFILLER_0_27_161 VGND VGND VPWR VPWR sky130_fd_sc_hd__decap_6
X_4785_ _2377_ VGND VGND VPWR VPWR _0362_ sky130_fd_sc_hd__clkbuf_1
XFILLER_0_34_109 VPWR VGND VPWR VGND sky130_ef_sc_hd__decap_12
XTAP_TAPCELL_ROW_119_2087 VGND VPWR sky130_fd_sc_hd__tapvpwrvgnd_1
X_3736_ _1469_ VGND VGND VPWR VPWR _1667_ sky130_fd_sc_hd__buf_2
XTAP_TAPCELL_ROW_31_763 VGND VPWR sky130_fd_sc_hd__tapvpwrvgnd_1
XFILLER_0_125_391 VGND VGND VPWR VPWR sky130_fd_sc_hd__fill_1
XFILLER_0_42_153 VPWR VGND VPWR VGND sky130_ef_sc_hd__decap_12
XFILLER_0_43_687 VGND VGND VPWR VPWR sky130_fd_sc_hd__fill_1
XFILLER_0_113_553 VGND VGND VPWR VPWR sky130_fd_sc_hd__decap_6
X_3667_ _1584_ _1599_ VGND VGND VPWR VPWR _1600_ sky130_fd_sc_hd__xor2_1
XFILLER_0_42_197 VPWR VGND VPWR VGND sky130_ef_sc_hd__decap_12
XTAP_TAPCELL_ROW_132_2287 VGND VPWR sky130_fd_sc_hd__tapvpwrvgnd_1
XTAP_TAPCELL_ROW_132_2276 VGND VPWR sky130_fd_sc_hd__tapvpwrvgnd_1
XFILLER_0_113_597 VPWR VGND VPWR VGND sky130_ef_sc_hd__decap_12
X_3598_ _1526_ _1532_ VGND VGND VPWR VPWR _1533_ sky130_fd_sc_hd__xor2_1
X_5406_ clknet_leaf_0_clk _0326_ net2 VGND VGND VPWR VPWR cpu_inst.decoder_inst.current_pc\[6\]
+ sky130_fd_sc_hd__dfrtp_4
X_2618_ _0574_ net36 net26 VGND VGND VPWR VPWR _0583_ sky130_fd_sc_hd__nor3_1
X_2549_ _0513_ VGND VGND VPWR VPWR _0514_ sky130_fd_sc_hd__buf_2
XFILLER_0_11_573 VPWR VGND VPWR VGND sky130_ef_sc_hd__decap_12
X_5337_ clknet_leaf_37_clk _0257_ VGND VGND VPWR VPWR cpu_inst.regfile_inst.registers\[11\]\[1\]
+ sky130_fd_sc_hd__dfxtp_1
X_5268_ clknet_leaf_7_clk _0188_ VGND VGND VPWR VPWR cpu_inst.regfile_inst.registers\[5\]\[28\]
+ sky130_fd_sc_hd__dfxtp_1
X_4219_ cpu_inst.regfile_inst.registers\[4\]\[26\] _2046_ VGND VGND VPWR VPWR _2052_
+ sky130_fd_sc_hd__and2_1
X_5199_ clknet_leaf_15_clk _0119_ VGND VGND VPWR VPWR cpu_inst.regfile_inst.registers\[4\]\[23\]
+ sky130_fd_sc_hd__dfxtp_1
XFILLER_0_97_337 VPWR VGND VPWR VGND sky130_ef_sc_hd__decap_12
XTAP_TAPCELL_ROW_39_885 VGND VPWR sky130_fd_sc_hd__tapvpwrvgnd_1
XTAP_TAPCELL_ROW_48_1016 VGND VPWR sky130_fd_sc_hd__tapvpwrvgnd_1
XTAP_TAPCELL_ROW_48_1027 VGND VPWR sky130_fd_sc_hd__tapvpwrvgnd_1
XFILLER_0_66_713 VPWR VGND VPWR VGND sky130_ef_sc_hd__decap_12
XFILLER_0_65_223 VGND VGND VPWR VPWR sky130_fd_sc_hd__fill_1
XFILLER_0_38_437 VPWR VGND VPWR VGND sky130_ef_sc_hd__decap_12
XFILLER_0_136_601 VPWR VGND VPWR VGND sky130_ef_sc_hd__decap_12
XFILLER_0_93_543 VGND VGND VPWR VPWR sky130_fd_sc_hd__decap_6
XTAP_TAPCELL_ROW_61_1216 VGND VPWR sky130_fd_sc_hd__tapvpwrvgnd_1
XFILLER_0_38_459 VGND VGND VPWR VPWR sky130_fd_sc_hd__decap_8
XFILLER_0_136_645 VPWR VGND VPWR VGND sky130_ef_sc_hd__decap_12
XFILLER_0_135_111 VGND VGND VPWR VPWR sky130_fd_sc_hd__fill_1
XFILLER_0_81_727 VGND VGND VPWR VPWR sky130_fd_sc_hd__fill_1
XFILLER_0_19_673 VPWR VGND VPWR VGND sky130_ef_sc_hd__decap_12
XFILLER_0_123_317 VPWR VGND VPWR VGND sky130_ef_sc_hd__decap_12
XFILLER_0_22_805 VGND VGND VPWR VPWR sky130_fd_sc_hd__decap_6
XFILLER_0_104_542 VGND VGND VPWR VPWR sky130_fd_sc_hd__fill_1
XFILLER_0_0_209 VPWR VGND VPWR VGND sky130_ef_sc_hd__decap_12
XFILLER_0_21_337 VPWR VGND VPWR VGND sky130_ef_sc_hd__decap_12
XFILLER_0_131_361 VPWR VGND VPWR VGND sky130_ef_sc_hd__decap_12
XTAP_TAPCELL_ROW_59_1189 VGND VPWR sky130_fd_sc_hd__tapvpwrvgnd_1
XTAP_TAPCELL_ROW_59_1178 VGND VPWR sky130_fd_sc_hd__tapvpwrvgnd_1
XTAP_TAPCELL_ROW_72_1378 VGND VPWR sky130_fd_sc_hd__tapvpwrvgnd_1
XFILLER_0_56_29 VPWR VGND VPWR VGND sky130_ef_sc_hd__decap_12
XFILLER_0_8_309 VPWR VGND VPWR VGND sky130_ef_sc_hd__decap_12
XTAP_TAPCELL_ROW_17_557 VGND VPWR sky130_fd_sc_hd__tapvpwrvgnd_1
XFILLER_0_56_245 VGND VGND VPWR VPWR sky130_fd_sc_hd__decap_6
XFILLER_0_126_133 VGND VGND VPWR VPWR sky130_fd_sc_hd__decap_6
XFILLER_0_56_289 VPWR VGND VPWR VGND sky130_ef_sc_hd__decap_12
XFILLER_0_16_109 VPWR VGND VPWR VGND sky130_ef_sc_hd__decap_12
XFILLER_0_126_177 VPWR VGND VPWR VGND sky130_ef_sc_hd__decap_12
XFILLER_0_71_237 VPWR VGND VPWR VGND sky130_ef_sc_hd__decap_12
XFILLER_0_25_632 VPWR VGND VPWR VGND sky130_ef_sc_hd__decap_12
X_4570_ cpu_inst.regfile_inst.registers\[10\]\[4\] _2230_ VGND VGND VPWR VPWR _2233_
+ sky130_fd_sc_hd__and2_1
XFILLER_0_108_3 VPWR VGND VPWR VGND sky130_ef_sc_hd__decap_12
XFILLER_0_107_391 VGND VGND VPWR VPWR sky130_fd_sc_hd__fill_1
X_3521_ _1457_ VGND VGND VPWR VPWR _0018_ sky130_fd_sc_hd__clkbuf_1
XFILLER_0_24_153 VPWR VGND VPWR VGND sky130_ef_sc_hd__decap_12
XFILLER_0_80_782 VPWR VGND VPWR VGND sky130_ef_sc_hd__decap_12
XFILLER_0_52_473 VGND VGND VPWR VPWR sky130_fd_sc_hd__decap_3
XFILLER_0_24_197 VPWR VGND VPWR VGND sky130_ef_sc_hd__decap_12
XFILLER_0_110_501 VPWR VGND VPWR VGND sky130_ef_sc_hd__decap_12
XFILLER_0_97_69 VPWR VGND VPWR VGND sky130_ef_sc_hd__decap_12
X_3452_ cpu_inst.regfile_inst.registers\[9\]\[17\] cpu_inst.regfile_inst.registers\[8\]\[17\]
+ _1386_ VGND VGND VPWR VPWR _1390_ sky130_fd_sc_hd__mux2_1
XFILLER_0_110_545 VPWR VGND VPWR VGND sky130_ef_sc_hd__decap_12
X_3383_ cpu_inst.regfile_inst.registers\[6\]\[5\] _1325_ _1332_ VGND VGND VPWR VPWR
+ _1333_ sky130_fd_sc_hd__mux2_1
XFILLER_0_110_589 VPWR VGND VPWR VGND sky130_ef_sc_hd__decap_12
X_5122_ clknet_leaf_32_clk _0042_ VGND VGND VPWR VPWR cpu_inst.regfile_inst.registers\[2\]\[10\]
+ sky130_fd_sc_hd__dfxtp_1
X_5053_ _2517_ _2518_ VGND VGND VPWR VPWR _0489_ sky130_fd_sc_hd__nor2_1
X_4004_ _1224_ _1921_ _1922_ _1927_ VGND VGND VPWR VPWR _1928_ sky130_fd_sc_hd__a31o_1
XFILLER_0_79_337 VPWR VGND VPWR VGND sky130_ef_sc_hd__decap_12
XFILLER_0_95_819 VPWR VGND VPWR VGND sky130_ef_sc_hd__decap_12
XFILLER_0_94_307 VGND VGND VPWR VPWR sky130_fd_sc_hd__fill_1
XTAP_TAPCELL_ROW_36_833 VGND VPWR sky130_fd_sc_hd__tapvpwrvgnd_1
XTAP_TAPCELL_ROW_36_844 VGND VPWR sky130_fd_sc_hd__tapvpwrvgnd_1
XFILLER_0_47_223 VGND VGND VPWR VPWR sky130_fd_sc_hd__fill_1
XFILLER_0_118_601 VPWR VGND VPWR VGND sky130_ef_sc_hd__decap_12
XTAP_TAPCELL_ROW_101_1817 VGND VPWR sky130_fd_sc_hd__tapvpwrvgnd_1
XFILLER_0_62_83 VGND VGND VPWR VPWR sky130_fd_sc_hd__fill_1
X_4906_ _1325_ cpu_inst.regfile_inst.registers\[8\]\[5\] _2436_ VGND VGND VPWR VPWR
+ _2440_ sky130_fd_sc_hd__mux2_1
XFILLER_0_118_645 VPWR VGND VPWR VGND sky130_ef_sc_hd__decap_12
XFILLER_0_117_111 VGND VGND VPWR VPWR sky130_fd_sc_hd__fill_1
XFILLER_0_63_738 VGND VGND VPWR VPWR sky130_fd_sc_hd__decap_3
XFILLER_0_35_429 VGND VGND VPWR VPWR sky130_fd_sc_hd__decap_3
X_4837_ _2403_ VGND VGND VPWR VPWR _0388_ sky130_fd_sc_hd__clkbuf_1
XTAP_TAPCELL_ROW_134_2316 VGND VPWR sky130_fd_sc_hd__tapvpwrvgnd_1
XTAP_TAPCELL_ROW_134_2305 VGND VPWR sky130_fd_sc_hd__tapvpwrvgnd_1
XFILLER_0_133_615 VGND VGND VPWR VPWR sky130_fd_sc_hd__fill_1
XFILLER_0_105_317 VPWR VGND VPWR VGND sky130_ef_sc_hd__decap_12
XFILLER_0_16_643 VGND VGND VPWR VPWR sky130_fd_sc_hd__fill_1
X_4768_ cpu_inst.regfile_inst.registers\[0\]\[1\] VGND VGND VPWR VPWR _2369_ sky130_fd_sc_hd__clkbuf_1
XFILLER_0_120_309 VPWR VGND VPWR VGND sky130_ef_sc_hd__decap_12
X_3719_ _1571_ _1568_ _1649_ VGND VGND VPWR VPWR _1650_ sky130_fd_sc_hd__o21ai_1
XFILLER_0_71_793 VGND VGND VPWR VPWR sky130_fd_sc_hd__fill_1
X_4699_ cpu_inst.decoder_inst.current_pc\[12\] _2315_ cpu_inst.decoder_inst.current_pc\[13\]
+ VGND VGND VPWR VPWR _2321_ sky130_fd_sc_hd__a21oi_1
XFILLER_0_43_495 VGND VGND VPWR VPWR sky130_fd_sc_hd__decap_8
XFILLER_0_113_361 VPWR VGND VPWR VGND sky130_ef_sc_hd__decap_12
XFILLER_0_30_189 VGND VGND VPWR VPWR sky130_fd_sc_hd__decap_6
XTAP_TAPCELL_ROW_112_1979 VGND VPWR sky130_fd_sc_hd__tapvpwrvgnd_1
XFILLER_0_101_567 VGND VGND VPWR VPWR sky130_fd_sc_hd__fill_2
XFILLER_0_97_167 VGND VGND VPWR VPWR sky130_fd_sc_hd__fill_1
XFILLER_0_85_329 VGND VGND VPWR VPWR sky130_fd_sc_hd__decap_6
XFILLER_0_39_713 VGND VGND VPWR VPWR sky130_fd_sc_hd__decap_6
XFILLER_0_94_841 VGND VGND VPWR VPWR sky130_fd_sc_hd__fill_1
XTAP_TAPCELL_ROW_14_505 VGND VPWR sky130_fd_sc_hd__tapvpwrvgnd_1
XTAP_TAPCELL_ROW_14_516 VGND VPWR sky130_fd_sc_hd__tapvpwrvgnd_1
XFILLER_0_38_245 VGND VGND VPWR VPWR sky130_fd_sc_hd__decap_6
XFILLER_0_108_133 VGND VGND VPWR VPWR sky130_fd_sc_hd__decap_6
XFILLER_0_93_373 VPWR VGND VPWR VGND sky130_ef_sc_hd__decap_12
XFILLER_0_38_289 VPWR VGND VPWR VGND sky130_ef_sc_hd__decap_12
XFILLER_0_136_475 VGND VGND VPWR VPWR sky130_fd_sc_hd__fill_1
XFILLER_0_53_237 VPWR VGND VPWR VGND sky130_ef_sc_hd__decap_12
XFILLER_0_124_637 VGND VGND VPWR VPWR sky130_fd_sc_hd__decap_6
XFILLER_0_123_125 VPWR VGND VPWR VGND sky130_ef_sc_hd__decap_12
XFILLER_0_108_177 VPWR VGND VPWR VGND sky130_ef_sc_hd__decap_12
XFILLER_0_34_462 VGND VGND VPWR VPWR sky130_fd_sc_hd__fill_2
XFILLER_0_123_169 VPWR VGND VPWR VGND sky130_ef_sc_hd__decap_12
XFILLER_0_61_281 VPWR VGND VPWR VGND sky130_ef_sc_hd__decap_12
XFILLER_0_22_613 VPWR VGND VPWR VGND sky130_ef_sc_hd__decap_12
XFILLER_0_132_681 VPWR VGND VPWR VGND sky130_ef_sc_hd__decap_12
XTAP_TAPCELL_ROW_74_1407 VGND VPWR sky130_fd_sc_hd__tapvpwrvgnd_1
XFILLER_0_1_529 VPWR VGND VPWR VGND sky130_ef_sc_hd__decap_12
XFILLER_0_22_657 VPWR VGND VPWR VGND sky130_ef_sc_hd__decap_12
XFILLER_0_67_39 VPWR VGND VPWR VGND sky130_ef_sc_hd__decap_12
XFILLER_0_21_167 VGND VGND VPWR VPWR sky130_fd_sc_hd__fill_1
XFILLER_0_83_27 VPWR VGND VPWR VGND sky130_ef_sc_hd__decap_12
XFILLER_0_76_307 VGND VGND VPWR VPWR sky130_fd_sc_hd__fill_1
XFILLER_0_16_65 VPWR VGND VPWR VGND sky130_ef_sc_hd__decap_12
XFILLER_0_88_189 VGND VGND VPWR VPWR sky130_fd_sc_hd__decap_6
XTAP_TAPCELL_ROW_85_1569 VGND VPWR sky130_fd_sc_hd__tapvpwrvgnd_1
XFILLER_0_69_370 VGND VGND VPWR VPWR sky130_fd_sc_hd__fill_2
XFILLER_0_57_521 VPWR VGND VPWR VGND sky130_ef_sc_hd__decap_12
XFILLER_0_85_841 VGND VGND VPWR VPWR sky130_fd_sc_hd__fill_1
X_2952_ _0915_ _0916_ VGND VGND VPWR VPWR _0917_ sky130_fd_sc_hd__nor2_2
XFILLER_0_9_629 VPWR VGND VPWR VGND sky130_ef_sc_hd__decap_12
XFILLER_0_29_223 VGND VGND VPWR VPWR sky130_fd_sc_hd__fill_1
XFILLER_0_123_55 VGND VGND VPWR VPWR sky130_fd_sc_hd__fill_1
XFILLER_0_84_373 VGND VGND VPWR VPWR sky130_fd_sc_hd__fill_1
XFILLER_0_72_513 VPWR VGND VPWR VGND sky130_ef_sc_hd__decap_12
XFILLER_0_8_139 VGND VGND VPWR VPWR sky130_fd_sc_hd__fill_1
XFILLER_0_17_429 VPWR VGND VPWR VGND sky130_ef_sc_hd__decap_12
XFILLER_0_32_53 VPWR VGND VPWR VGND sky130_ef_sc_hd__decap_12
XFILLER_0_45_716 VGND VGND VPWR VPWR sky130_fd_sc_hd__decap_8
XFILLER_0_45_738 VGND VGND VPWR VPWR sky130_fd_sc_hd__fill_1
XFILLER_0_115_615 VGND VGND VPWR VPWR sky130_fd_sc_hd__fill_1
X_2883_ _0820_ VGND VGND VPWR VPWR _0848_ sky130_fd_sc_hd__clkbuf_4
XFILLER_0_32_97 VPWR VGND VPWR VGND sky130_ef_sc_hd__decap_12
XFILLER_0_127_497 VGND VGND VPWR VPWR sky130_fd_sc_hd__decap_6
XTAP_TAPCELL_ROW_116_2035 VGND VPWR sky130_fd_sc_hd__tapvpwrvgnd_1
X_4622_ cpu_inst.regfile_inst.registers\[10\]\[29\] _2252_ VGND VGND VPWR VPWR _2260_
+ sky130_fd_sc_hd__and2_1
XFILLER_0_4_301 VGND VGND VPWR VPWR sky130_fd_sc_hd__decap_6
XTAP_TAPCELL_ROW_116_2046 VGND VPWR sky130_fd_sc_hd__tapvpwrvgnd_1
XFILLER_0_102_309 VPWR VGND VPWR VGND sky130_ef_sc_hd__decap_12
X_4553_ _2224_ VGND VGND VPWR VPWR _0283_ sky130_fd_sc_hd__clkbuf_1
XFILLER_0_53_782 VGND VGND VPWR VPWR sky130_fd_sc_hd__fill_2
XFILLER_0_4_345 VPWR VGND VPWR VGND sky130_ef_sc_hd__decap_12
XFILLER_0_25_473 VPWR VGND VPWR VGND sky130_ef_sc_hd__decap_12
XFILLER_0_40_421 VGND VGND VPWR VPWR sky130_fd_sc_hd__fill_1
XFILLER_0_111_821 VPWR VGND VPWR VGND sky130_ef_sc_hd__decap_12
X_4484_ _1726_ cpu_inst.regfile_inst.registers\[7\]\[25\] _2186_ VGND VGND VPWR VPWR
+ _2190_ sky130_fd_sc_hd__mux2_1
X_3504_ _0610_ _1440_ VGND VGND VPWR VPWR _1441_ sky130_fd_sc_hd__or2_1
XFILLER_0_4_389 VPWR VGND VPWR VGND sky130_ef_sc_hd__decap_12
X_3435_ _1356_ _1372_ VGND VGND VPWR VPWR _1374_ sky130_fd_sc_hd__nor2_1
XFILLER_0_12_189 VGND VGND VPWR VPWR sky130_fd_sc_hd__decap_6
XFILLER_0_0_573 VPWR VGND VPWR VGND sky130_ef_sc_hd__decap_12
X_3366_ cpu_inst.regfile_inst.registers\[25\]\[0\] _1310_ _1311_ _0673_ _1315_ VGND
+ VGND VPWR VPWR _1316_ sky130_fd_sc_hd__o2111a_1
X_5105_ clknet_leaf_14_clk _0025_ VGND VGND VPWR VPWR cpu_inst.regfile_inst.registers\[6\]\[25\]
+ sky130_fd_sc_hd__dfxtp_1
X_3297_ net3 _1205_ _1216_ _1261_ VGND VGND VPWR VPWR _1262_ sky130_fd_sc_hd__o22a_2
X_5036_ cpu_inst.display_inst.counter\[3\] _2505_ VGND VGND VPWR VPWR _2508_ sky130_fd_sc_hd__nor2_1
XFILLER_0_32_3 VPWR VGND VPWR VGND sky130_ef_sc_hd__decap_12
XFILLER_0_79_167 VGND VGND VPWR VPWR sky130_fd_sc_hd__fill_1
XFILLER_0_88_690 VGND VGND VPWR VPWR sky130_fd_sc_hd__decap_8
XFILLER_0_73_93 VPWR VGND VPWR VGND sky130_ef_sc_hd__decap_12
XTAP_TAPCELL_ROW_0_288 VGND VPWR sky130_fd_sc_hd__tapvpwrvgnd_1
XFILLER_0_138_729 VPWR VGND VPWR VGND sky130_ef_sc_hd__decap_12
XFILLER_0_137_217 VGND VGND VPWR VPWR sky130_fd_sc_hd__decap_6
XTAP_TAPCELL_ROW_0_299 VGND VPWR sky130_fd_sc_hd__tapvpwrvgnd_1
XFILLER_0_75_373 VGND VGND VPWR VPWR sky130_fd_sc_hd__decap_3
XFILLER_0_118_475 VGND VGND VPWR VPWR sky130_fd_sc_hd__fill_1
XFILLER_0_90_321 VPWR VGND VPWR VGND sky130_ef_sc_hd__decap_12
XFILLER_0_63_546 VPWR VGND VPWR VGND sky130_ef_sc_hd__decap_12
XFILLER_0_35_237 VPWR VGND VPWR VGND sky130_ef_sc_hd__decap_12
XFILLER_0_105_125 VPWR VGND VPWR VGND sky130_ef_sc_hd__decap_12
XFILLER_0_90_365 VPWR VGND VPWR VGND sky130_ef_sc_hd__decap_12
XFILLER_0_63_579 VGND VGND VPWR VPWR sky130_fd_sc_hd__fill_1
XFILLER_0_7_161 VGND VGND VPWR VPWR sky130_fd_sc_hd__decap_6
XFILLER_0_44_771 VGND VGND VPWR VPWR sky130_fd_sc_hd__fill_2
XFILLER_0_121_629 VPWR VGND VPWR VGND sky130_ef_sc_hd__decap_12
XFILLER_0_114_681 VPWR VGND VPWR VGND sky130_ef_sc_hd__decap_12
XFILLER_0_105_169 VPWR VGND VPWR VGND sky130_ef_sc_hd__decap_12
XFILLER_0_102_810 VGND VGND VPWR VPWR sky130_fd_sc_hd__fill_2
XFILLER_0_43_281 VPWR VGND VPWR VGND sky130_ef_sc_hd__decap_12
XFILLER_0_120_139 VGND VGND VPWR VPWR sky130_fd_sc_hd__fill_1
Xoutput12 net12 VGND VGND VPWR VPWR seg[5] sky130_fd_sc_hd__buf_1
XTAP_TAPCELL_ROW_56_1137 VGND VPWR sky130_fd_sc_hd__tapvpwrvgnd_1
XFILLER_0_98_421 VGND VGND VPWR VPWR sky130_fd_sc_hd__decap_4
XFILLER_0_98_443 VGND VGND VPWR VPWR sky130_fd_sc_hd__fill_1
XPHY_EDGE_ROW_113_Right_113 VGND VGND VPWR VPWR sky130_fd_sc_hd__decap_3
XFILLER_0_129_729 VPWR VGND VPWR VGND sky130_ef_sc_hd__decap_12
XFILLER_0_85_137 VPWR VGND VPWR VGND sky130_ef_sc_hd__decap_12
XFILLER_0_67_841 VGND VGND VPWR VPWR sky130_fd_sc_hd__fill_1
XTAP_TAPCELL_ROW_67_1299 VGND VPWR sky130_fd_sc_hd__tapvpwrvgnd_1
XFILLER_0_82_811 VGND VGND VPWR VPWR sky130_fd_sc_hd__fill_1
XFILLER_0_54_502 VGND VGND VPWR VPWR sky130_fd_sc_hd__decap_4
XFILLER_0_27_727 VGND VGND VPWR VPWR sky130_fd_sc_hd__fill_1
XFILLER_0_93_181 VPWR VGND VPWR VGND sky130_ef_sc_hd__decap_12
XFILLER_0_124_401 VPWR VGND VPWR VGND sky130_ef_sc_hd__decap_12
XFILLER_0_109_497 VGND VGND VPWR VPWR sky130_fd_sc_hd__decap_6
XTAP_TAPCELL_ROW_80_1499 VGND VPWR sky130_fd_sc_hd__tapvpwrvgnd_1
XFILLER_0_124_445 VPWR VGND VPWR VGND sky130_ef_sc_hd__decap_12
XFILLER_0_81_387 VGND VGND VPWR VPWR sky130_fd_sc_hd__decap_4
XFILLER_0_2_805 VGND VGND VPWR VPWR sky130_fd_sc_hd__decap_6
XFILLER_0_35_793 VGND VGND VPWR VPWR sky130_fd_sc_hd__decap_4
XFILLER_0_124_489 VPWR VGND VPWR VGND sky130_ef_sc_hd__decap_12
XFILLER_0_78_27 VGND VGND VPWR VPWR sky130_fd_sc_hd__fill_1
XFILLER_0_22_421 VPWR VGND VPWR VGND sky130_ef_sc_hd__decap_12
XFILLER_0_50_741 VGND VGND VPWR VPWR sky130_fd_sc_hd__fill_1
XFILLER_0_1_337 VPWR VGND VPWR VGND sky130_ef_sc_hd__decap_12
XFILLER_0_94_15 VPWR VGND VPWR VGND sky130_ef_sc_hd__decap_12
X_3220_ _1019_ _1021_ _1025_ VGND VGND VPWR VPWR _1185_ sky130_fd_sc_hd__nand3_1
X_3151_ cpu_inst.regfile_inst.registers\[1\]\[14\] _0726_ _0703_ cpu_inst.regfile_inst.registers\[5\]\[14\]
+ _0561_ VGND VGND VPWR VPWR _1116_ sky130_fd_sc_hd__o221a_1
XTAP_TAPCELL_ROW_87_1609 VGND VPWR sky130_fd_sc_hd__tapvpwrvgnd_1
XFILLER_0_118_77 VGND VGND VPWR VPWR sky130_fd_sc_hd__decap_6
XFILLER_0_89_432 VPWR VGND VPWR VGND sky130_ef_sc_hd__decap_12
X_3082_ _1039_ _1046_ VGND VGND VPWR VPWR _1047_ sky130_fd_sc_hd__xnor2_2
XFILLER_0_89_465 VGND VGND VPWR VPWR sky130_fd_sc_hd__decap_8
XFILLER_0_49_329 VGND VGND VPWR VPWR sky130_fd_sc_hd__decap_6
XFILLER_0_134_65 VPWR VGND VPWR VGND sky130_ef_sc_hd__decap_12
XFILLER_0_119_217 VGND VGND VPWR VPWR sky130_fd_sc_hd__decap_6
XTAP_TAPCELL_ROW_46_983 VGND VPWR sky130_fd_sc_hd__tapvpwrvgnd_1
XTAP_TAPCELL_ROW_46_994 VGND VPWR sky130_fd_sc_hd__tapvpwrvgnd_1
X_3984_ cpu_inst.regfile_inst.registers\[25\]\[31\] _1310_ _1311_ _1907_ VGND VGND
+ VPWR VPWR _1908_ sky130_fd_sc_hd__o211a_1
XFILLER_0_134_209 VPWR VGND VPWR VGND sky130_ef_sc_hd__decap_12
XFILLER_0_72_321 VGND VGND VPWR VPWR sky130_fd_sc_hd__fill_2
X_2935_ _0892_ _0899_ VGND VGND VPWR VPWR _0900_ sky130_fd_sc_hd__or2_1
XFILLER_0_17_237 VPWR VGND VPWR VGND sky130_ef_sc_hd__decap_12
XFILLER_0_18_749 VGND VGND VPWR VPWR sky130_fd_sc_hd__decap_6
XFILLER_0_127_261 VPWR VGND VPWR VGND sky130_ef_sc_hd__decap_12
XFILLER_0_72_365 VGND VGND VPWR VPWR sky130_fd_sc_hd__fill_2
X_2866_ cpu_inst.regfile_inst.registers\[1\]\[8\] _0627_ _0702_ cpu_inst.regfile_inst.registers\[5\]\[8\]
+ _0561_ VGND VGND VPWR VPWR _0831_ sky130_fd_sc_hd__o221a_1
XFILLER_0_45_568 VGND VGND VPWR VPWR sky130_fd_sc_hd__decap_8
X_4605_ cpu_inst.regfile_inst.registers\[10\]\[21\] _2241_ VGND VGND VPWR VPWR _2251_
+ sky130_fd_sc_hd__and2_1
XFILLER_0_5_665 VGND VGND VPWR VPWR sky130_fd_sc_hd__decap_6
XFILLER_0_26_793 VPWR VGND VPWR VGND sky130_ef_sc_hd__decap_12
XFILLER_0_4_153 VPWR VGND VPWR VGND sky130_ef_sc_hd__decap_12
XFILLER_0_25_281 VPWR VGND VPWR VGND sky130_ef_sc_hd__decap_12
X_2797_ cpu_inst.regfile_inst.registers\[15\]\[2\] _0566_ _0571_ VGND VGND VPWR VPWR
+ _0762_ sky130_fd_sc_hd__a21o_1
XFILLER_0_102_139 VGND VGND VPWR VPWR sky130_fd_sc_hd__fill_1
X_4536_ cpu_inst.regfile_inst.registers\[11\]\[19\] VGND VGND VPWR VPWR _2216_ sky130_fd_sc_hd__clkbuf_1
XFILLER_0_4_197 VPWR VGND VPWR VGND sky130_ef_sc_hd__decap_12
XFILLER_0_40_251 VGND VGND VPWR VPWR sky130_fd_sc_hd__fill_1
XFILLER_0_111_673 VPWR VGND VPWR VGND sky130_ef_sc_hd__decap_12
X_4467_ _1418_ cpu_inst.regfile_inst.registers\[7\]\[17\] _2167_ VGND VGND VPWR VPWR
+ _2181_ sky130_fd_sc_hd__mux2_1
X_4398_ _2144_ VGND VGND VPWR VPWR _0208_ sky130_fd_sc_hd__clkbuf_1
X_3418_ cpu_inst.regfile_inst.registers\[24\]\[14\] _0698_ _0699_ _1123_ VGND VGND
+ VPWR VPWR _1357_ sky130_fd_sc_hd__o211a_1
XTAP_TAPCELL_ROW_129_2237 VGND VPWR sky130_fd_sc_hd__tapvpwrvgnd_1
X_3349_ _1302_ VGND VGND VPWR VPWR _0001_ sky130_fd_sc_hd__clkbuf_1
XTAP_TAPCELL_ROW_5_369 VGND VPWR sky130_fd_sc_hd__tapvpwrvgnd_1
XTAP_TAPCELL_ROW_51_1067 VGND VPWR sky130_fd_sc_hd__tapvpwrvgnd_1
X_5019_ cpu_inst.regfile_inst.registers\[15\]\[27\] _2491_ VGND VGND VPWR VPWR _2499_
+ sky130_fd_sc_hd__and2_1
XFILLER_0_67_137 VPWR VGND VPWR VGND sky130_ef_sc_hd__decap_12
XFILLER_0_49_841 VGND VGND VPWR VPWR sky130_fd_sc_hd__fill_1
XFILLER_0_75_181 VPWR VGND VPWR VGND sky130_ef_sc_hd__decap_12
XTAP_TAPCELL_ROW_24_655 VGND VPWR sky130_fd_sc_hd__tapvpwrvgnd_1
XTAP_TAPCELL_ROW_24_666 VGND VPWR sky130_fd_sc_hd__tapvpwrvgnd_1
XFILLER_0_48_395 VGND VGND VPWR VPWR sky130_fd_sc_hd__fill_1
XFILLER_0_106_401 VPWR VGND VPWR VGND sky130_ef_sc_hd__decap_12
XFILLER_0_90_195 VGND VGND VPWR VPWR sky130_fd_sc_hd__fill_1
XFILLER_0_31_273 VGND VGND VPWR VPWR sky130_fd_sc_hd__decap_6
XFILLER_0_102_695 VGND VGND VPWR VPWR sky130_fd_sc_hd__decap_4
XFILLER_0_101_161 VGND VGND VPWR VPWR sky130_fd_sc_hd__decap_6
XTAP_TAPCELL_ROW_69_1328 VGND VPWR sky130_fd_sc_hd__tapvpwrvgnd_1
XFILLER_0_64_29 VPWR VGND VPWR VGND sky130_ef_sc_hd__decap_12
XTAP_TAPCELL_ROW_69_1339 VGND VPWR sky130_fd_sc_hd__tapvpwrvgnd_1
XFILLER_0_99_785 VPWR VGND VPWR VGND sky130_ef_sc_hd__decap_12
XFILLER_0_98_251 VGND VGND VPWR VPWR sky130_fd_sc_hd__fill_1
XFILLER_0_59_627 VGND VGND VPWR VPWR sky130_fd_sc_hd__decap_8
XFILLER_0_86_446 VGND VGND VPWR VPWR sky130_fd_sc_hd__fill_1
XTAP_TAPCELL_ROW_82_1528 VGND VPWR sky130_fd_sc_hd__tapvpwrvgnd_1
XFILLER_0_59_649 VGND VGND VPWR VPWR sky130_fd_sc_hd__fill_1
XFILLER_0_129_559 VGND VGND VPWR VPWR sky130_fd_sc_hd__fill_1
XFILLER_0_67_671 VGND VGND VPWR VPWR sky130_fd_sc_hd__fill_1
XFILLER_0_27_502 VGND VGND VPWR VPWR sky130_fd_sc_hd__fill_2
XTAP_TAPCELL_ROW_43_942 VGND VPWR sky130_fd_sc_hd__tapvpwrvgnd_1
XFILLER_0_116_209 VPWR VGND VPWR VGND sky130_ef_sc_hd__decap_12
XFILLER_0_13_55 VGND VGND VPWR VPWR sky130_fd_sc_hd__fill_1
XFILLER_0_39_373 VPWR VGND VPWR VGND sky130_ef_sc_hd__decap_12
XFILLER_0_125_721 VGND VGND VPWR VPWR sky130_fd_sc_hd__decap_6
XFILLER_0_109_261 VPWR VGND VPWR VGND sky130_ef_sc_hd__decap_12
XFILLER_0_89_15 VPWR VGND VPWR VGND sky130_ef_sc_hd__decap_12
X_2720_ _0528_ VGND VGND VPWR VPWR _0685_ sky130_fd_sc_hd__clkbuf_4
XFILLER_0_125_765 VPWR VGND VPWR VGND sky130_ef_sc_hd__decap_12
X_2651_ _0613_ _0615_ VGND VGND VPWR VPWR _0616_ sky130_fd_sc_hd__nor2_1
XFILLER_0_124_253 VPWR VGND VPWR VGND sky130_ef_sc_hd__decap_12
XTAP_TAPCELL_ROW_97_1760 VGND VPWR sky130_fd_sc_hd__tapvpwrvgnd_1
XFILLER_0_2_613 VPWR VGND VPWR VGND sky130_ef_sc_hd__decap_12
XFILLER_0_23_741 VPWR VGND VPWR VGND sky130_ef_sc_hd__decap_12
XFILLER_0_35_590 VGND VGND VPWR VPWR sky130_fd_sc_hd__fill_2
X_2582_ _0515_ _0517_ _0544_ VGND VGND VPWR VPWR _0547_ sky130_fd_sc_hd__or3_4
XFILLER_0_2_657 VPWR VGND VPWR VGND sky130_ef_sc_hd__decap_12
XFILLER_0_22_251 VGND VGND VPWR VPWR sky130_fd_sc_hd__fill_1
XFILLER_0_23_785 VPWR VGND VPWR VGND sky130_ef_sc_hd__decap_12
X_5370_ clknet_leaf_41_clk _0290_ VGND VGND VPWR VPWR cpu_inst.regfile_inst.registers\[10\]\[2\]
+ sky130_fd_sc_hd__dfxtp_1
X_4321_ _2091_ VGND VGND VPWR VPWR _2105_ sky130_fd_sc_hd__buf_4
XFILLER_0_10_413 VGND VGND VPWR VPWR sky130_fd_sc_hd__decap_6
XFILLER_0_1_167 VGND VGND VPWR VPWR sky130_fd_sc_hd__fill_1
X_4252_ _2068_ VGND VGND VPWR VPWR _0138_ sky130_fd_sc_hd__clkbuf_1
XFILLER_0_10_457 VPWR VGND VPWR VGND sky130_ef_sc_hd__decap_12
X_3203_ _0527_ _1167_ VGND VGND VPWR VPWR _1168_ sky130_fd_sc_hd__nand2_2
XFILLER_0_38_41 VPWR VGND VPWR VGND sky130_ef_sc_hd__decap_12
XFILLER_0_38_85 VPWR VGND VPWR VGND sky130_ef_sc_hd__decap_12
X_4183_ cpu_inst.regfile_inst.registers\[4\]\[9\] _2024_ VGND VGND VPWR VPWR _2033_
+ sky130_fd_sc_hd__and2_1
X_3134_ _0976_ _1098_ VGND VGND VPWR VPWR _1099_ sky130_fd_sc_hd__xnor2_1
XTAP_TAPCELL_ROW_2_328 VGND VPWR sky130_fd_sc_hd__tapvpwrvgnd_1
X_3065_ cpu_inst.regfile_inst.registers\[0\]\[13\] _0726_ _0703_ cpu_inst.regfile_inst.registers\[4\]\[13\]
+ _0853_ VGND VGND VPWR VPWR _1030_ sky130_fd_sc_hd__o221a_1
XTAP_TAPCELL_ROW_124_2167 VGND VPWR sky130_fd_sc_hd__tapvpwrvgnd_1
XTAP_TAPCELL_ROW_124_2156 VGND VPWR sky130_fd_sc_hd__tapvpwrvgnd_1
XFILLER_0_89_273 VGND VGND VPWR VPWR sky130_fd_sc_hd__decap_6
XFILLER_0_49_137 VPWR VGND VPWR VGND sky130_ef_sc_hd__decap_12
XFILLER_0_77_468 VPWR VGND VPWR VGND sky130_ef_sc_hd__decap_12
XFILLER_0_9_223 VGND VGND VPWR VPWR sky130_fd_sc_hd__fill_1
XFILLER_0_85_490 VGND VGND VPWR VPWR sky130_fd_sc_hd__decap_8
X_3967_ _1880_ _1891_ VGND VGND VPWR VPWR _1892_ sky130_fd_sc_hd__xnor2_1
XFILLER_0_57_181 VPWR VGND VPWR VGND sky130_ef_sc_hd__decap_12
XFILLER_0_18_513 VPWR VGND VPWR VGND sky130_ef_sc_hd__decap_12
XFILLER_0_135_529 VPWR VGND VPWR VGND sky130_ef_sc_hd__decap_12
XFILLER_0_128_581 VGND VGND VPWR VPWR sky130_fd_sc_hd__decap_6
XFILLER_0_70_83 VGND VGND VPWR VPWR sky130_fd_sc_hd__fill_1
XFILLER_0_18_557 VPWR VGND VPWR VGND sky130_ef_sc_hd__decap_12
XTAP_TAPCELL_ROW_21_614 VGND VPWR sky130_fd_sc_hd__tapvpwrvgnd_1
X_2918_ _0653_ VGND VGND VPWR VPWR _0883_ sky130_fd_sc_hd__buf_4
X_3898_ _1786_ _1781_ _1820_ _1823_ _1824_ VGND VGND VPWR VPWR _1825_ sky130_fd_sc_hd__a221o_1
Xclkbuf_leaf_30_clk clknet_2_2__leaf_clk VGND VGND VPWR VPWR clknet_leaf_30_clk sky130_fd_sc_hd__clkbuf_8
XFILLER_0_72_195 VGND VGND VPWR VPWR sky130_fd_sc_hd__fill_1
X_2849_ cpu_inst.regfile_inst.registers\[24\]\[6\] _0524_ _0813_ _0606_ _0699_ VGND
+ VGND VPWR VPWR _0814_ sky130_fd_sc_hd__o221ai_4
XFILLER_0_5_473 VPWR VGND VPWR VGND sky130_ef_sc_hd__decap_12
XFILLER_0_79_81 VPWR VGND VPWR VGND sky130_ef_sc_hd__decap_12
X_5568_ clknet_leaf_30_clk _0488_ VGND VGND VPWR VPWR cpu_inst.display_inst.counter\[8\]
+ sky130_fd_sc_hd__dfxtp_1
XFILLER_0_130_245 VGND VGND VPWR VPWR sky130_fd_sc_hd__decap_6
XFILLER_0_13_273 VGND VGND VPWR VPWR sky130_fd_sc_hd__decap_6
XFILLER_0_41_582 VGND VGND VPWR VPWR sky130_fd_sc_hd__decap_4
X_4519_ _2207_ VGND VGND VPWR VPWR _0266_ sky130_fd_sc_hd__clkbuf_1
XFILLER_0_130_289 VPWR VGND VPWR VGND sky130_ef_sc_hd__decap_12
X_5499_ clknet_leaf_37_clk _0419_ VGND VGND VPWR VPWR cpu_inst.regfile_inst.registers\[8\]\[3\]
+ sky130_fd_sc_hd__dfxtp_1
XTAP_TAPCELL_ROW_109_1929 VGND VPWR sky130_fd_sc_hd__tapvpwrvgnd_1
XTAP_TAPCELL_ROW_29_736 VGND VPWR sky130_fd_sc_hd__tapvpwrvgnd_1
XTAP_TAPCELL_ROW_64_1258 VGND VPWR sky130_fd_sc_hd__tapvpwrvgnd_1
XFILLER_0_83_449 VGND VGND VPWR VPWR sky130_fd_sc_hd__fill_2
XFILLER_0_36_321 VPWR VGND VPWR VGND sky130_ef_sc_hd__decap_12
XTAP_TAPCELL_ROW_40_901 VGND VPWR sky130_fd_sc_hd__tapvpwrvgnd_1
XFILLER_0_138_389 VGND VGND VPWR VPWR sky130_fd_sc_hd__decap_3
XFILLER_0_107_721 VGND VGND VPWR VPWR sky130_fd_sc_hd__decap_6
XFILLER_0_64_641 VGND VGND VPWR VPWR sky130_fd_sc_hd__decap_3
XFILLER_0_107_765 VPWR VGND VPWR VGND sky130_ef_sc_hd__decap_12
Xclkbuf_leaf_21_clk clknet_2_3__leaf_clk VGND VGND VPWR VPWR clknet_leaf_21_clk sky130_fd_sc_hd__clkbuf_8
XFILLER_0_64_674 VGND VGND VPWR VPWR sky130_fd_sc_hd__decap_4
XFILLER_0_36_365 VPWR VGND VPWR VGND sky130_ef_sc_hd__decap_12
XFILLER_0_122_713 VPWR VGND VPWR VGND sky130_ef_sc_hd__decap_12
XFILLER_0_106_253 VPWR VGND VPWR VGND sky130_ef_sc_hd__decap_12
XFILLER_0_51_335 VGND VGND VPWR VPWR sky130_fd_sc_hd__fill_1
XFILLER_0_122_757 VPWR VGND VPWR VGND sky130_ef_sc_hd__decap_12
XFILLER_0_121_223 VGND VGND VPWR VPWR sky130_fd_sc_hd__fill_1
XTAP_TAPCELL_ROW_79_1490 VGND VPWR sky130_fd_sc_hd__tapvpwrvgnd_1
XFILLER_0_20_755 VGND VGND VPWR VPWR sky130_fd_sc_hd__fill_1
XFILLER_0_75_39 VPWR VGND VPWR VGND sky130_ef_sc_hd__decap_12
XFILLER_0_91_27 VPWR VGND VPWR VGND sky130_ef_sc_hd__decap_12
XFILLER_0_87_700 VGND VGND VPWR VPWR sky130_fd_sc_hd__decap_4
XFILLER_0_86_221 VPWR VGND VPWR VGND sky130_ef_sc_hd__decap_12
XFILLER_0_59_446 VGND VGND VPWR VPWR sky130_fd_sc_hd__fill_2
X_4870_ cpu_inst.regfile_inst.registers\[9\]\[21\] VGND VGND VPWR VPWR _2420_ sky130_fd_sc_hd__clkbuf_1
XFILLER_0_86_265 VPWR VGND VPWR VGND sky130_ef_sc_hd__decap_12
XFILLER_0_59_457 VGND VGND VPWR VPWR sky130_fd_sc_hd__fill_1
XFILLER_0_24_65 VPWR VGND VPWR VGND sky130_ef_sc_hd__decap_12
XFILLER_0_138_3 VPWR VGND VPWR VGND sky130_ef_sc_hd__decap_12
X_3821_ _1735_ _1749_ VGND VGND VPWR VPWR _1750_ sky130_fd_sc_hd__xnor2_1
XFILLER_0_28_811 VGND VGND VPWR VPWR sky130_fd_sc_hd__fill_1
XFILLER_0_117_529 VPWR VGND VPWR VGND sky130_ef_sc_hd__decap_12
XFILLER_0_67_490 VGND VGND VPWR VPWR sky130_fd_sc_hd__fill_1
XFILLER_0_7_727 VGND VGND VPWR VPWR sky130_fd_sc_hd__fill_1
XFILLER_0_39_181 VPWR VGND VPWR VGND sky130_ef_sc_hd__decap_12
XFILLER_0_131_55 VGND VGND VPWR VPWR sky130_fd_sc_hd__fill_1
X_3752_ _1648_ _1653_ _1681_ VGND VGND VPWR VPWR _1683_ sky130_fd_sc_hd__and3_1
Xclkbuf_leaf_12_clk clknet_2_3__leaf_clk VGND VGND VPWR VPWR clknet_leaf_12_clk sky130_fd_sc_hd__clkbuf_8
XFILLER_0_70_622 VPWR VGND VPWR VGND sky130_ef_sc_hd__decap_12
XFILLER_0_15_505 VPWR VGND VPWR VGND sky130_ef_sc_hd__decap_12
XFILLER_0_40_53 VPWR VGND VPWR VGND sky130_ef_sc_hd__decap_12
XFILLER_0_125_573 VPWR VGND VPWR VGND sky130_ef_sc_hd__decap_12
X_3683_ cpu_inst.regfile_inst.registers\[9\]\[23\] cpu_inst.regfile_inst.registers\[8\]\[23\]
+ _1540_ VGND VGND VPWR VPWR _1615_ sky130_fd_sc_hd__mux2_1
XTAP_TAPCELL_ROW_95_1719 VGND VPWR sky130_fd_sc_hd__tapvpwrvgnd_1
X_2703_ _0557_ net19 _0657_ VGND VGND VPWR VPWR _0668_ sky130_fd_sc_hd__and3_1
XFILLER_0_54_195 VGND VGND VPWR VPWR sky130_fd_sc_hd__fill_1
X_5422_ clknet_leaf_0_clk _0342_ net2 VGND VGND VPWR VPWR cpu_inst.decoder_inst.current_pc\[22\]
+ sky130_fd_sc_hd__dfrtp_1
XFILLER_0_2_421 VPWR VGND VPWR VGND sky130_ef_sc_hd__decap_12
XFILLER_0_40_97 VPWR VGND VPWR VGND sky130_ef_sc_hd__decap_12
X_2634_ cpu_inst.regfile_inst.registers\[4\]\[0\] _0560_ _0583_ VGND VGND VPWR VPWR
+ _0599_ sky130_fd_sc_hd__o21a_1
XFILLER_0_42_357 VGND VGND VPWR VPWR sky130_fd_sc_hd__decap_6
XFILLER_0_112_245 VGND VGND VPWR VPWR sky130_fd_sc_hd__decap_6
X_2565_ cpu_inst.decoder_inst.current_pc\[5\] cpu_inst.decoder_inst.current_pc\[4\]
+ cpu_inst.decoder_inst.current_pc\[7\] cpu_inst.decoder_inst.current_pc\[6\] VGND
+ VGND VPWR VPWR _0530_ sky130_fd_sc_hd__or4b_1
X_5353_ clknet_leaf_28_clk _0273_ VGND VGND VPWR VPWR cpu_inst.regfile_inst.registers\[11\]\[17\]
+ sky130_fd_sc_hd__dfxtp_1
XFILLER_0_112_289 VPWR VGND VPWR VGND sky130_ef_sc_hd__decap_12
XFILLER_0_11_777 VGND VGND VPWR VPWR sky130_fd_sc_hd__decap_6
XFILLER_0_10_221 VPWR VGND VPWR VGND sky130_ef_sc_hd__decap_12
XTAP_TAPCELL_ROW_7_409 VGND VPWR sky130_fd_sc_hd__tapvpwrvgnd_1
X_4304_ _1205_ cpu_inst.regfile_inst.registers\[5\]\[3\] _2092_ VGND VGND VPWR VPWR
+ _2096_ sky130_fd_sc_hd__mux2_1
XFILLER_0_49_51 VGND VGND VPWR VPWR sky130_fd_sc_hd__decap_4
X_5284_ clknet_leaf_20_clk _0204_ VGND VGND VPWR VPWR cpu_inst.regfile_inst.registers\[1\]\[12\]
+ sky130_fd_sc_hd__dfxtp_1
XFILLER_0_10_265 VPWR VGND VPWR VGND sky130_ef_sc_hd__decap_12
X_4235_ cpu_inst.regfile_inst.registers\[24\]\[2\] VGND VGND VPWR VPWR _2060_ sky130_fd_sc_hd__clkbuf_1
XFILLER_0_4_53 VPWR VGND VPWR VGND sky130_ef_sc_hd__decap_12
X_4166_ cpu_inst.regfile_inst.registers\[4\]\[0\] _2024_ VGND VGND VPWR VPWR _2025_
+ sky130_fd_sc_hd__and2_1
X_3117_ _1081_ _0929_ _1057_ VGND VGND VPWR VPWR _1082_ sky130_fd_sc_hd__mux2_1
XFILLER_0_4_97 VPWR VGND VPWR VGND sky130_ef_sc_hd__decap_12
X_4097_ _1985_ VGND VGND VPWR VPWR _0066_ sky130_fd_sc_hd__clkbuf_1
X_3048_ cpu_inst.regfile_inst.registers\[25\]\[10\] _0692_ _0694_ _1012_ VGND VGND
+ VPWR VPWR _1013_ sky130_fd_sc_hd__o211a_1
XTAP_TAPCELL_ROW_104_1859 VGND VPWR sky130_fd_sc_hd__tapvpwrvgnd_1
XFILLER_0_136_805 VGND VGND VPWR VPWR sky130_fd_sc_hd__decap_6
XFILLER_0_81_93 VPWR VGND VPWR VGND sky130_ef_sc_hd__decap_12
XFILLER_0_19_833 VGND VGND VPWR VPWR sky130_fd_sc_hd__decap_6
X_4999_ _2488_ VGND VGND VPWR VPWR _0465_ sky130_fd_sc_hd__clkbuf_1
XFILLER_0_58_490 VPWR VGND VPWR VGND sky130_ef_sc_hd__decap_12
XFILLER_0_18_321 VPWR VGND VPWR VGND sky130_ef_sc_hd__decap_12
XTAP_TAPCELL_ROW_137_2358 VGND VPWR sky130_fd_sc_hd__tapvpwrvgnd_1
XFILLER_0_135_337 VPWR VGND VPWR VGND sky130_ef_sc_hd__decap_12
XFILLER_0_18_365 VPWR VGND VPWR VGND sky130_ef_sc_hd__decap_12
XFILLER_0_104_713 VPWR VGND VPWR VGND sky130_ef_sc_hd__decap_12
XFILLER_0_60_121 VPWR VGND VPWR VGND sky130_ef_sc_hd__decap_12
XFILLER_0_33_335 VGND VGND VPWR VPWR sky130_fd_sc_hd__fill_1
XFILLER_0_104_757 VPWR VGND VPWR VGND sky130_ef_sc_hd__decap_12
XFILLER_0_103_223 VGND VGND VPWR VPWR sky130_fd_sc_hd__fill_1
XFILLER_0_60_165 VPWR VGND VPWR VGND sky130_ef_sc_hd__decap_12
XFILLER_0_6_793 VPWR VGND VPWR VGND sky130_ef_sc_hd__decap_12
XFILLER_0_5_281 VPWR VGND VPWR VGND sky130_ef_sc_hd__decap_12
XFILLER_0_69_755 VGND VGND VPWR VPWR sky130_fd_sc_hd__decap_6
XFILLER_0_68_221 VPWR VGND VPWR VGND sky130_ef_sc_hd__decap_12
XFILLER_0_96_563 VGND VGND VPWR VPWR sky130_fd_sc_hd__fill_1
XFILLER_0_68_265 VPWR VGND VPWR VGND sky130_ef_sc_hd__decap_12
XFILLER_0_138_153 VPWR VGND VPWR VGND sky130_ef_sc_hd__decap_12
XFILLER_0_84_769 VGND VGND VPWR VPWR sky130_fd_sc_hd__fill_1
XFILLER_0_138_197 VPWR VGND VPWR VGND sky130_ef_sc_hd__decap_12
XFILLER_0_83_279 VGND VGND VPWR VPWR sky130_fd_sc_hd__fill_1
XTAP_TAPCELL_ROW_12_477 VGND VPWR sky130_fd_sc_hd__tapvpwrvgnd_1
XFILLER_0_36_195 VGND VGND VPWR VPWR sky130_fd_sc_hd__fill_1
XFILLER_0_24_357 VGND VGND VPWR VPWR sky130_fd_sc_hd__decap_6
XFILLER_0_101_69 VPWR VGND VPWR VGND sky130_ef_sc_hd__decap_12
XTAP_TAPCELL_ROW_77_1449 VGND VPWR sky130_fd_sc_hd__tapvpwrvgnd_1
XFILLER_0_122_587 VGND VGND VPWR VPWR sky130_fd_sc_hd__fill_1
XFILLER_0_110_749 VGND VGND VPWR VPWR sky130_fd_sc_hd__decap_6
XFILLER_0_86_27 VGND VGND VPWR VPWR sky130_fd_sc_hd__fill_1
XTAP_TAPCELL_ROW_90_1649 VGND VPWR sky130_fd_sc_hd__tapvpwrvgnd_1
X_4020_ _1385_ _1636_ _1643_ VGND VGND VPWR VPWR _1943_ sky130_fd_sc_hd__a21o_1
Xclkbuf_leaf_1_clk clknet_2_0__leaf_clk VGND VGND VPWR VPWR clknet_leaf_1_clk sky130_fd_sc_hd__clkbuf_8
XFILLER_0_126_77 VGND VGND VPWR VPWR sky130_fd_sc_hd__decap_6
XTAP_TAPCELL_ROW_121_2115 VGND VPWR sky130_fd_sc_hd__tapvpwrvgnd_1
XFILLER_0_87_530 VGND VGND VPWR VPWR sky130_fd_sc_hd__decap_3
XFILLER_0_87_574 VGND VGND VPWR VPWR sky130_fd_sc_hd__decap_8
X_4922_ net16 cpu_inst.regfile_inst.registers\[8\]\[13\] _2432_ VGND VGND VPWR VPWR
+ _2448_ sky130_fd_sc_hd__mux2_1
XFILLER_0_47_405 VPWR VGND VPWR VGND sky130_ef_sc_hd__decap_12
XFILLER_0_118_805 VGND VGND VPWR VPWR sky130_fd_sc_hd__decap_6
X_4853_ _2411_ VGND VGND VPWR VPWR _0396_ sky130_fd_sc_hd__clkbuf_1
XFILLER_0_47_449 VGND VGND VPWR VPWR sky130_fd_sc_hd__decap_4
XFILLER_0_117_337 VPWR VGND VPWR VGND sky130_ef_sc_hd__decap_12
X_3804_ _1732_ cpu_inst.regfile_inst.registers\[10\]\[26\] _1313_ VGND VGND VPWR VPWR
+ _1733_ sky130_fd_sc_hd__mux2_1
XFILLER_0_16_825 VPWR VGND VPWR VGND sky130_ef_sc_hd__decap_12
X_4784_ cpu_inst.regfile_inst.registers\[0\]\[10\] VGND VGND VPWR VPWR _2377_ sky130_fd_sc_hd__clkbuf_1
XFILLER_0_132_307 VGND VGND VPWR VPWR sky130_fd_sc_hd__fill_1
X_3735_ cpu_inst.regfile_inst.registers\[15\]\[24\] _1665_ _1555_ VGND VGND VPWR VPWR
+ _1666_ sky130_fd_sc_hd__mux2_1
XFILLER_0_15_335 VGND VGND VPWR VPWR sky130_fd_sc_hd__fill_1
XTAP_TAPCELL_ROW_31_764 VGND VPWR sky130_fd_sc_hd__tapvpwrvgnd_1
XFILLER_0_42_121 VPWR VGND VPWR VGND sky130_ef_sc_hd__decap_12
XTAP_TAPCELL_ROW_119_2088 VGND VPWR sky130_fd_sc_hd__tapvpwrvgnd_1
X_3666_ _1587_ _1598_ VGND VGND VPWR VPWR _1599_ sky130_fd_sc_hd__xnor2_1
X_5405_ clknet_leaf_0_clk _0325_ net2 VGND VGND VPWR VPWR cpu_inst.decoder_inst.current_pc\[5\]
+ sky130_fd_sc_hd__dfrtp_2
XFILLER_0_3_741 VPWR VGND VPWR VGND sky130_ef_sc_hd__decap_12
XFILLER_0_42_165 VPWR VGND VPWR VGND sky130_ef_sc_hd__decap_12
XTAP_TAPCELL_ROW_132_2277 VGND VPWR sky130_fd_sc_hd__tapvpwrvgnd_1
X_3597_ _1529_ _1531_ VGND VGND VPWR VPWR _1532_ sky130_fd_sc_hd__and2_1
XFILLER_0_62_3 VPWR VGND VPWR VGND sky130_ef_sc_hd__decap_12
X_2617_ _0520_ _0580_ _0581_ VGND VGND VPWR VPWR _0582_ sky130_fd_sc_hd__o21ai_2
XFILLER_0_11_541 VPWR VGND VPWR VGND sky130_ef_sc_hd__decap_12
XFILLER_0_3_785 VPWR VGND VPWR VGND sky130_ef_sc_hd__decap_12
XFILLER_0_2_251 VGND VGND VPWR VPWR sky130_fd_sc_hd__fill_1
X_2548_ _0505_ _0508_ _0512_ VGND VGND VPWR VPWR _0513_ sky130_fd_sc_hd__and3_1
XFILLER_0_11_585 VPWR VGND VPWR VGND sky130_ef_sc_hd__decap_12
X_5336_ clknet_leaf_41_clk _0256_ VGND VGND VPWR VPWR cpu_inst.regfile_inst.registers\[11\]\[0\]
+ sky130_fd_sc_hd__dfxtp_1
X_5267_ clknet_leaf_7_clk _0187_ VGND VGND VPWR VPWR cpu_inst.regfile_inst.registers\[5\]\[27\]
+ sky130_fd_sc_hd__dfxtp_1
X_4218_ _2051_ VGND VGND VPWR VPWR _0121_ sky130_fd_sc_hd__clkbuf_1
X_5198_ clknet_leaf_15_clk _0118_ VGND VGND VPWR VPWR cpu_inst.regfile_inst.registers\[4\]\[22\]
+ sky130_fd_sc_hd__dfxtp_1
XFILLER_0_97_305 VPWR VGND VPWR VGND sky130_ef_sc_hd__decap_12
X_4149_ _2014_ VGND VGND VPWR VPWR _0089_ sky130_fd_sc_hd__clkbuf_1
XFILLER_0_97_349 VPWR VGND VPWR VGND sky130_ef_sc_hd__decap_12
XFILLER_0_78_530 VGND VGND VPWR VPWR sky130_fd_sc_hd__fill_2
XTAP_TAPCELL_ROW_39_886 VGND VPWR sky130_fd_sc_hd__tapvpwrvgnd_1
XTAP_TAPCELL_ROW_48_1017 VGND VPWR sky130_fd_sc_hd__tapvpwrvgnd_1
XFILLER_0_93_500 VGND VGND VPWR VPWR sky130_fd_sc_hd__fill_1
XFILLER_0_78_585 VGND VGND VPWR VPWR sky130_fd_sc_hd__decap_3
XFILLER_0_66_725 VGND VGND VPWR VPWR sky130_fd_sc_hd__decap_6
XFILLER_0_136_613 VPWR VGND VPWR VGND sky130_ef_sc_hd__decap_12
XTAP_TAPCELL_ROW_61_1217 VGND VPWR sky130_fd_sc_hd__tapvpwrvgnd_1
XFILLER_0_19_641 VPWR VGND VPWR VGND sky130_ef_sc_hd__decap_12
XFILLER_0_38_449 VGND VGND VPWR VPWR sky130_fd_sc_hd__decap_4
XFILLER_0_136_657 VPWR VGND VPWR VGND sky130_ef_sc_hd__decap_12
XFILLER_0_65_279 VGND VGND VPWR VPWR sky130_fd_sc_hd__fill_1
XFILLER_0_19_685 VPWR VGND VPWR VGND sky130_ef_sc_hd__decap_12
XFILLER_0_135_167 VGND VGND VPWR VPWR sky130_fd_sc_hd__fill_1
XFILLER_0_61_430 VGND VGND VPWR VPWR sky130_fd_sc_hd__decap_4
XFILLER_0_18_195 VGND VGND VPWR VPWR sky130_fd_sc_hd__fill_1
Xclkload0 clknet_2_0__leaf_clk VGND VGND VPWR VPWR clkload0/Y sky130_fd_sc_hd__clkinv_8
XFILLER_0_132_841 VGND VGND VPWR VPWR sky130_fd_sc_hd__fill_1
XFILLER_0_123_329 VGND VGND VPWR VPWR sky130_fd_sc_hd__decap_6
XFILLER_0_104_510 VGND VGND VPWR VPWR sky130_fd_sc_hd__decap_6
XFILLER_0_21_305 VPWR VGND VPWR VGND sky130_ef_sc_hd__decap_12
XFILLER_0_34_688 VPWR VGND VPWR VGND sky130_ef_sc_hd__decap_12
XFILLER_0_131_373 VPWR VGND VPWR VGND sky130_ef_sc_hd__decap_12
XFILLER_0_104_587 VGND VGND VPWR VPWR sky130_fd_sc_hd__fill_1
XTAP_TAPCELL_ROW_59_1179 VGND VPWR sky130_fd_sc_hd__tapvpwrvgnd_1
XFILLER_0_21_349 VPWR VGND VPWR VGND sky130_ef_sc_hd__decap_12
XTAP_TAPCELL_ROW_72_1379 VGND VPWR sky130_fd_sc_hd__tapvpwrvgnd_1
XFILLER_0_72_29 VPWR VGND VPWR VGND sky130_ef_sc_hd__decap_12
XFILLER_0_69_596 VGND VGND VPWR VPWR sky130_fd_sc_hd__decap_8
XTAP_TAPCELL_ROW_17_558 VGND VPWR sky130_fd_sc_hd__tapvpwrvgnd_1
XFILLER_0_29_405 VPWR VGND VPWR VGND sky130_ef_sc_hd__decap_12
XFILLER_0_84_533 VGND VGND VPWR VPWR sky130_fd_sc_hd__decap_3
XFILLER_0_29_449 VPWR VGND VPWR VGND sky130_ef_sc_hd__decap_12
XFILLER_0_71_205 VPWR VGND VPWR VGND sky130_ef_sc_hd__decap_12
XFILLER_0_44_419 VGND VGND VPWR VPWR sky130_fd_sc_hd__fill_1
XFILLER_0_114_307 VGND VGND VPWR VPWR sky130_fd_sc_hd__fill_1
XFILLER_0_71_249 VPWR VGND VPWR VGND sky130_ef_sc_hd__decap_12
XFILLER_0_21_55 VGND VGND VPWR VPWR sky130_fd_sc_hd__fill_1
XFILLER_0_24_121 VPWR VGND VPWR VGND sky130_ef_sc_hd__decap_12
XFILLER_0_25_644 VPWR VGND VPWR VGND sky130_ef_sc_hd__decap_12
XFILLER_0_126_189 VGND VGND VPWR VPWR sky130_fd_sc_hd__decap_6
X_3520_ _1456_ cpu_inst.regfile_inst.registers\[6\]\[18\] _1339_ VGND VGND VPWR VPWR
+ _1457_ sky130_fd_sc_hd__mux2_1
XFILLER_0_123_841 VGND VGND VPWR VPWR sky130_fd_sc_hd__fill_1
XFILLER_0_97_15 VPWR VGND VPWR VGND sky130_ef_sc_hd__decap_12
XFILLER_0_80_794 VGND VGND VPWR VPWR sky130_fd_sc_hd__decap_3
XFILLER_0_52_485 VGND VGND VPWR VPWR sky130_fd_sc_hd__fill_2
XFILLER_0_13_839 VGND VGND VPWR VPWR sky130_fd_sc_hd__fill_1
XFILLER_0_24_165 VPWR VGND VPWR VGND sky130_ef_sc_hd__decap_12
XFILLER_0_110_513 VPWR VGND VPWR VGND sky130_ef_sc_hd__decap_12
X_3451_ _1387_ _1388_ _0871_ VGND VGND VPWR VPWR _1389_ sky130_fd_sc_hd__mux2_1
XFILLER_0_110_557 VPWR VGND VPWR VGND sky130_ef_sc_hd__decap_12
X_3382_ _1330_ _1290_ _1331_ VGND VGND VPWR VPWR _1332_ sky130_fd_sc_hd__and3b_1
X_5121_ clknet_leaf_25_clk _0041_ VGND VGND VPWR VPWR cpu_inst.regfile_inst.registers\[2\]\[9\]
+ sky130_fd_sc_hd__dfxtp_1
XPHY_EDGE_ROW_127_Right_127 VGND VGND VPWR VPWR sky130_fd_sc_hd__decap_3
X_5052_ cpu_inst.display_inst.counter\[9\] _2515_ _2270_ VGND VGND VPWR VPWR _2518_
+ sky130_fd_sc_hd__o21ai_1
XFILLER_0_46_41 VPWR VGND VPWR VGND sky130_ef_sc_hd__decap_12
XFILLER_0_79_305 VPWR VGND VPWR VGND sky130_ef_sc_hd__decap_12
X_4003_ _1208_ _1923_ _1926_ _0684_ VGND VGND VPWR VPWR _1927_ sky130_fd_sc_hd__o31a_1
XFILLER_0_46_85 VPWR VGND VPWR VGND sky130_ef_sc_hd__decap_12
XFILLER_0_79_349 VPWR VGND VPWR VGND sky130_ef_sc_hd__decap_12
XTAP_TAPCELL_ROW_36_834 VGND VPWR sky130_fd_sc_hd__tapvpwrvgnd_1
XTAP_TAPCELL_ROW_36_845 VGND VPWR sky130_fd_sc_hd__tapvpwrvgnd_1
XFILLER_0_118_613 VPWR VGND VPWR VGND sky130_ef_sc_hd__decap_12
XTAP_TAPCELL_ROW_101_1818 VGND VPWR sky130_fd_sc_hd__tapvpwrvgnd_1
XFILLER_0_8_811 VGND VGND VPWR VPWR sky130_fd_sc_hd__fill_1
X_4905_ _2439_ VGND VGND VPWR VPWR _0420_ sky130_fd_sc_hd__clkbuf_1
XFILLER_0_48_769 VGND VGND VPWR VPWR sky130_fd_sc_hd__decap_3
XFILLER_0_118_657 VPWR VGND VPWR VGND sky130_ef_sc_hd__decap_12
X_4836_ cpu_inst.regfile_inst.registers\[9\]\[4\] VGND VGND VPWR VPWR _2403_ sky130_fd_sc_hd__clkbuf_1
XFILLER_0_47_279 VGND VGND VPWR VPWR sky130_fd_sc_hd__fill_1
XTAP_TAPCELL_ROW_134_2306 VGND VPWR sky130_fd_sc_hd__tapvpwrvgnd_1
XFILLER_0_117_167 VGND VGND VPWR VPWR sky130_fd_sc_hd__fill_1
XTAP_TAPCELL_ROW_134_2317 VGND VPWR sky130_fd_sc_hd__tapvpwrvgnd_1
XFILLER_0_105_329 VGND VGND VPWR VPWR sky130_fd_sc_hd__decap_6
X_4767_ _2368_ VGND VGND VPWR VPWR _0353_ sky130_fd_sc_hd__clkbuf_1
XFILLER_0_43_452 VGND VGND VPWR VPWR sky130_fd_sc_hd__fill_1
XFILLER_0_114_841 VGND VGND VPWR VPWR sky130_fd_sc_hd__fill_1
X_3718_ _1549_ _1567_ VGND VGND VPWR VPWR _1649_ sky130_fd_sc_hd__or2_1
X_4698_ cpu_inst.decoder_inst.current_pc\[13\] cpu_inst.decoder_inst.current_pc\[12\]
+ _2315_ VGND VGND VPWR VPWR _2320_ sky130_fd_sc_hd__and3_1
XFILLER_0_16_699 VGND VGND VPWR VPWR sky130_fd_sc_hd__fill_1
XFILLER_0_113_373 VPWR VGND VPWR VGND sky130_ef_sc_hd__decap_12
X_3649_ _1581_ cpu_inst.regfile_inst.registers\[10\]\[22\] _1312_ VGND VGND VPWR VPWR
+ _1582_ sky130_fd_sc_hd__mux2_1
XFILLER_0_31_647 VGND VGND VPWR VPWR sky130_fd_sc_hd__fill_1
XFILLER_0_87_81 VPWR VGND VPWR VGND sky130_ef_sc_hd__decap_12
X_5319_ clknet_leaf_22_clk _0239_ VGND VGND VPWR VPWR cpu_inst.regfile_inst.registers\[7\]\[15\]
+ sky130_fd_sc_hd__dfxtp_1
XFILLER_0_11_393 VPWR VGND VPWR VGND sky130_ef_sc_hd__decap_12
XFILLER_0_97_113 VPWR VGND VPWR VGND sky130_ef_sc_hd__decap_12
XFILLER_0_66_544 VGND VGND VPWR VPWR sky130_fd_sc_hd__decap_8
XFILLER_0_66_533 VGND VGND VPWR VPWR sky130_fd_sc_hd__fill_2
XTAP_TAPCELL_ROW_14_506 VGND VPWR sky130_fd_sc_hd__tapvpwrvgnd_1
XTAP_TAPCELL_ROW_14_517 VGND VPWR sky130_fd_sc_hd__tapvpwrvgnd_1
XFILLER_0_136_421 VPWR VGND VPWR VGND sky130_ef_sc_hd__decap_12
XFILLER_0_54_717 VGND VGND VPWR VPWR sky130_fd_sc_hd__fill_2
XFILLER_0_26_419 VGND VGND VPWR VPWR sky130_fd_sc_hd__fill_1
XFILLER_0_53_205 VPWR VGND VPWR VGND sky130_ef_sc_hd__decap_12
XFILLER_0_93_385 VGND VGND VPWR VPWR sky130_fd_sc_hd__decap_6
XFILLER_0_53_249 VPWR VGND VPWR VGND sky130_ef_sc_hd__decap_12
XFILLER_0_108_189 VGND VGND VPWR VPWR sky130_fd_sc_hd__decap_6
XFILLER_0_34_441 VGND VGND VPWR VPWR sky130_fd_sc_hd__fill_1
XFILLER_0_123_137 VPWR VGND VPWR VGND sky130_ef_sc_hd__decap_12
XFILLER_0_105_841 VGND VGND VPWR VPWR sky130_fd_sc_hd__fill_1
XFILLER_0_22_625 VPWR VGND VPWR VGND sky130_ef_sc_hd__decap_12
XFILLER_0_120_811 VGND VGND VPWR VPWR sky130_fd_sc_hd__fill_1
XTAP_TAPCELL_ROW_74_1408 VGND VPWR sky130_fd_sc_hd__tapvpwrvgnd_1
XFILLER_0_61_293 VPWR VGND VPWR VGND sky130_ef_sc_hd__decap_12
XFILLER_0_21_113 VPWR VGND VPWR VGND sky130_ef_sc_hd__decap_12
XFILLER_0_22_669 VPWR VGND VPWR VGND sky130_ef_sc_hd__decap_12
XFILLER_0_132_693 VGND VGND VPWR VPWR sky130_fd_sc_hd__decap_6
XFILLER_0_131_181 VPWR VGND VPWR VGND sky130_ef_sc_hd__decap_12
XTAP_TAPCELL_ROW_89_1640 VGND VPWR sky130_fd_sc_hd__tapvpwrvgnd_1
XFILLER_0_83_39 VPWR VGND VPWR VGND sky130_ef_sc_hd__decap_12
XFILLER_0_107_57 VPWR VGND VPWR VGND sky130_ef_sc_hd__decap_12
XFILLER_0_16_77 VGND VGND VPWR VPWR sky130_fd_sc_hd__decap_6
XFILLER_0_57_500 VGND VGND VPWR VPWR sky130_fd_sc_hd__fill_1
X_2951_ _0914_ _0910_ VGND VGND VPWR VPWR _0916_ sky130_fd_sc_hd__and2b_1
XFILLER_0_57_533 VGND VGND VPWR VPWR sky130_fd_sc_hd__decap_4
XFILLER_0_84_363 VGND VGND VPWR VPWR sky130_fd_sc_hd__fill_1
XFILLER_0_29_279 VGND VGND VPWR VPWR sky130_fd_sc_hd__fill_1
XFILLER_0_32_65 VPWR VGND VPWR VGND sky130_ef_sc_hd__decap_12
XFILLER_0_120_3 VPWR VGND VPWR VGND sky130_ef_sc_hd__decap_12
X_4621_ _2259_ VGND VGND VPWR VPWR _0316_ sky130_fd_sc_hd__clkbuf_1
X_2882_ cpu_inst.regfile_inst.registers\[15\]\[12\] _0846_ _0721_ VGND VGND VPWR VPWR
+ _0847_ sky130_fd_sc_hd__mux2_1
XFILLER_0_72_525 VGND VGND VPWR VPWR sky130_fd_sc_hd__fill_1
XFILLER_0_72_569 VGND VGND VPWR VPWR sky130_fd_sc_hd__decap_4
XFILLER_0_53_761 VGND VGND VPWR VPWR sky130_fd_sc_hd__decap_3
XFILLER_0_25_441 VGND VGND VPWR VPWR sky130_fd_sc_hd__decap_6
XTAP_TAPCELL_ROW_116_2047 VGND VPWR sky130_fd_sc_hd__tapvpwrvgnd_1
XTAP_TAPCELL_ROW_116_2036 VGND VPWR sky130_fd_sc_hd__tapvpwrvgnd_1
X_4552_ cpu_inst.regfile_inst.registers\[11\]\[27\] VGND VGND VPWR VPWR _2224_ sky130_fd_sc_hd__clkbuf_1
XFILLER_0_4_357 VGND VGND VPWR VPWR sky130_fd_sc_hd__decap_6
XFILLER_0_25_485 VPWR VGND VPWR VGND sky130_ef_sc_hd__decap_12
XFILLER_0_123_671 VGND VGND VPWR VPWR sky130_fd_sc_hd__fill_1
X_4483_ _2189_ VGND VGND VPWR VPWR _0248_ sky130_fd_sc_hd__clkbuf_1
X_3503_ _0843_ _1438_ _1439_ _0859_ VGND VGND VPWR VPWR _1440_ sky130_fd_sc_hd__o211a_1
XFILLER_0_111_833 VGND VGND VPWR VPWR sky130_fd_sc_hd__decap_6
XFILLER_0_110_321 VPWR VGND VPWR VGND sky130_ef_sc_hd__decap_12
X_3434_ _1356_ _1372_ VGND VGND VPWR VPWR _1373_ sky130_fd_sc_hd__and2_1
XFILLER_0_40_477 VGND VGND VPWR VPWR sky130_fd_sc_hd__fill_1
XFILLER_0_110_365 VPWR VGND VPWR VGND sky130_ef_sc_hd__decap_12
X_3365_ cpu_inst.regfile_inst.registers\[10\]\[0\] _1313_ _1314_ _0677_ VGND VGND
+ VPWR VPWR _1315_ sky130_fd_sc_hd__a211o_1
XFILLER_0_57_51 VGND VGND VPWR VPWR sky130_fd_sc_hd__decap_4
XFILLER_0_0_585 VGND VGND VPWR VPWR sky130_fd_sc_hd__decap_3
X_5104_ clknet_leaf_8_clk _0024_ VGND VGND VPWR VPWR cpu_inst.regfile_inst.registers\[6\]\[24\]
+ sky130_fd_sc_hd__dfxtp_1
X_3296_ _0690_ _1223_ _1260_ _0691_ _0500_ VGND VGND VPWR VPWR _1261_ sky130_fd_sc_hd__a221o_1
X_5035_ cpu_inst.display_inst.counter\[3\] _2505_ VGND VGND VPWR VPWR _2507_ sky130_fd_sc_hd__and2_1
XTAP_TAPCELL_ROW_127_2198 VGND VPWR sky130_fd_sc_hd__tapvpwrvgnd_1
XFILLER_0_79_113 VPWR VGND VPWR VGND sky130_ef_sc_hd__decap_12
XFILLER_0_25_3 VPWR VGND VPWR VGND sky130_ef_sc_hd__decap_12
XFILLER_0_95_606 VGND VGND VPWR VPWR sky130_fd_sc_hd__fill_1
XFILLER_0_95_617 VGND VGND VPWR VPWR sky130_fd_sc_hd__decap_8
XTAP_TAPCELL_ROW_0_278 VGND VPWR sky130_fd_sc_hd__tapvpwrvgnd_1
XTAP_TAPCELL_ROW_0_289 VGND VPWR sky130_fd_sc_hd__tapvpwrvgnd_1
XFILLER_0_48_533 VGND VGND VPWR VPWR sky130_fd_sc_hd__fill_1
XFILLER_0_118_421 VPWR VGND VPWR VGND sky130_ef_sc_hd__decap_12
XFILLER_0_35_205 VPWR VGND VPWR VGND sky130_ef_sc_hd__decap_12
XFILLER_0_48_566 VGND VGND VPWR VPWR sky130_fd_sc_hd__fill_2
XFILLER_0_90_333 VPWR VGND VPWR VGND sky130_ef_sc_hd__decap_12
XFILLER_0_63_525 VPWR VGND VPWR VGND sky130_ef_sc_hd__decap_12
X_4819_ _2394_ VGND VGND VPWR VPWR _0379_ sky130_fd_sc_hd__clkbuf_1
XFILLER_0_63_558 VGND VGND VPWR VPWR sky130_fd_sc_hd__fill_2
XFILLER_0_35_249 VPWR VGND VPWR VGND sky130_ef_sc_hd__decap_12
XFILLER_0_44_761 VGND VGND VPWR VPWR sky130_fd_sc_hd__fill_1
XFILLER_0_105_137 VPWR VGND VPWR VGND sky130_ef_sc_hd__decap_12
XFILLER_0_90_377 VGND VGND VPWR VPWR sky130_fd_sc_hd__decap_8
XFILLER_0_43_293 VPWR VGND VPWR VGND sky130_ef_sc_hd__decap_12
XFILLER_0_114_693 VGND VGND VPWR VPWR sky130_fd_sc_hd__decap_6
XFILLER_0_113_181 VPWR VGND VPWR VGND sky130_ef_sc_hd__decap_12
Xoutput13 net13 VGND VGND VPWR VPWR seg[6] sky130_fd_sc_hd__buf_1
XTAP_TAPCELL_ROW_56_1138 VGND VPWR sky130_fd_sc_hd__tapvpwrvgnd_1
XFILLER_0_98_477 VGND VGND VPWR VPWR sky130_fd_sc_hd__fill_1
XFILLER_0_85_105 VGND VGND VPWR VPWR sky130_fd_sc_hd__decap_6
XPHY_EDGE_ROW_19_Right_19 VGND VGND VPWR VPWR sky130_fd_sc_hd__decap_3
XFILLER_0_85_149 VPWR VGND VPWR VGND sky130_ef_sc_hd__decap_12
XFILLER_0_137_741 VPWR VGND VPWR VGND sky130_ef_sc_hd__decap_12
XFILLER_0_136_251 VGND VGND VPWR VPWR sky130_fd_sc_hd__fill_1
XFILLER_0_66_385 VGND VGND VPWR VPWR sky130_fd_sc_hd__decap_8
XFILLER_0_137_785 VPWR VGND VPWR VGND sky130_ef_sc_hd__decap_12
XFILLER_0_124_413 VGND VGND VPWR VPWR sky130_fd_sc_hd__decap_6
XFILLER_0_93_193 VPWR VGND VPWR VGND sky130_ef_sc_hd__decap_12
XFILLER_0_124_457 VPWR VGND VPWR VGND sky130_ef_sc_hd__decap_12
XFILLER_0_1_305 VPWR VGND VPWR VGND sky130_ef_sc_hd__decap_12
XFILLER_0_22_433 VPWR VGND VPWR VGND sky130_ef_sc_hd__decap_12
XFILLER_0_1_349 VPWR VGND VPWR VGND sky130_ef_sc_hd__decap_12
XFILLER_0_22_477 VPWR VGND VPWR VGND sky130_ef_sc_hd__decap_12
XPHY_EDGE_ROW_28_Right_28 VGND VGND VPWR VPWR sky130_fd_sc_hd__decap_3
XFILLER_0_94_27 VGND VGND VPWR VPWR sky130_fd_sc_hd__fill_1
X_3150_ cpu_inst.regfile_inst.registers\[0\]\[14\] _0593_ _0703_ cpu_inst.regfile_inst.registers\[4\]\[14\]
+ _0705_ VGND VGND VPWR VPWR _1115_ sky130_fd_sc_hd__o221a_1
X_3081_ cpu_inst.regfile_inst.registers\[25\]\[13\] _0692_ _0694_ _1045_ VGND VGND
+ VPWR VPWR _1046_ sky130_fd_sc_hd__o211a_1
XFILLER_0_89_444 VGND VGND VPWR VPWR sky130_fd_sc_hd__fill_1
XFILLER_0_77_606 VGND VGND VPWR VPWR sky130_fd_sc_hd__decap_8
XPHY_EDGE_ROW_37_Right_37 VGND VGND VPWR VPWR sky130_fd_sc_hd__decap_3
XFILLER_0_77_617 VGND VGND VPWR VPWR sky130_fd_sc_hd__decap_6
XFILLER_0_134_77 VGND VGND VPWR VPWR sky130_fd_sc_hd__decap_6
XFILLER_0_9_405 VPWR VGND VPWR VGND sky130_ef_sc_hd__decap_12
XTAP_TAPCELL_ROW_46_984 VGND VPWR sky130_fd_sc_hd__tapvpwrvgnd_1
XTAP_TAPCELL_ROW_46_995 VGND VPWR sky130_fd_sc_hd__tapvpwrvgnd_1
X_3983_ _1536_ _1904_ _1906_ _1314_ VGND VGND VPWR VPWR _1907_ sky130_fd_sc_hd__o22a_1
XFILLER_0_9_449 VPWR VGND VPWR VGND sky130_ef_sc_hd__decap_12
X_2934_ cpu_inst.regfile_inst.registers\[25\]\[2\] _0569_ _0663_ _0898_ VGND VGND
+ VPWR VPWR _0899_ sky130_fd_sc_hd__o211a_1
XFILLER_0_17_205 VPWR VGND VPWR VGND sky130_ef_sc_hd__decap_12
XFILLER_0_45_525 VGND VGND VPWR VPWR sky130_fd_sc_hd__fill_1
XFILLER_0_127_273 VGND VGND VPWR VPWR sky130_fd_sc_hd__decap_6
XFILLER_0_17_249 VPWR VGND VPWR VGND sky130_ef_sc_hd__decap_12
X_2865_ cpu_inst.regfile_inst.registers\[0\]\[8\] _0627_ _0603_ cpu_inst.regfile_inst.registers\[4\]\[8\]
+ _0705_ VGND VGND VPWR VPWR _0830_ sky130_fd_sc_hd__o221a_1
XFILLER_0_45_547 VPWR VGND VPWR VGND sky130_ef_sc_hd__decap_12
X_4604_ _2250_ VGND VGND VPWR VPWR _0308_ sky130_fd_sc_hd__clkbuf_1
XFILLER_0_4_121 VPWR VGND VPWR VGND sky130_ef_sc_hd__decap_12
XPHY_EDGE_ROW_46_Right_46 VGND VGND VPWR VPWR sky130_fd_sc_hd__decap_3
X_4535_ _2215_ VGND VGND VPWR VPWR _0274_ sky130_fd_sc_hd__clkbuf_1
XFILLER_0_4_165 VPWR VGND VPWR VGND sky130_ef_sc_hd__decap_12
XFILLER_0_25_293 VPWR VGND VPWR VGND sky130_ef_sc_hd__decap_12
XFILLER_0_41_720 VGND VGND VPWR VPWR sky130_fd_sc_hd__fill_1
X_2796_ cpu_inst.regfile_inst.registers\[8\]\[2\] _0760_ _0598_ VGND VGND VPWR VPWR
+ _0761_ sky130_fd_sc_hd__mux2_2
XFILLER_0_111_641 VPWR VGND VPWR VGND sky130_ef_sc_hd__decap_12
X_4466_ _2180_ VGND VGND VPWR VPWR _0240_ sky130_fd_sc_hd__clkbuf_1
XFILLER_0_111_685 VPWR VGND VPWR VGND sky130_ef_sc_hd__decap_12
X_4397_ cpu_inst.regfile_inst.registers\[1\]\[16\] VGND VGND VPWR VPWR _2144_ sky130_fd_sc_hd__clkbuf_1
X_3417_ cpu_inst.regfile_inst.registers\[25\]\[16\] _1252_ _1069_ _1355_ VGND VGND
+ VPWR VPWR _1356_ sky130_fd_sc_hd__o211ai_2
XFILLER_0_68_83 VGND VGND VPWR VPWR sky130_fd_sc_hd__fill_1
XTAP_TAPCELL_ROW_129_2238 VGND VPWR sky130_fd_sc_hd__tapvpwrvgnd_1
XFILLER_0_110_195 VGND VGND VPWR VPWR sky130_fd_sc_hd__fill_1
XFILLER_0_0_393 VPWR VGND VPWR VGND sky130_ef_sc_hd__decap_12
X_3348_ _0688_ cpu_inst.regfile_inst.registers\[6\]\[1\] _1300_ VGND VGND VPWR VPWR
+ _1302_ sky130_fd_sc_hd__mux2_1
XTAP_TAPCELL_ROW_51_1068 VGND VPWR sky130_fd_sc_hd__tapvpwrvgnd_1
X_3279_ _0863_ _1241_ _1243_ _0875_ VGND VGND VPWR VPWR _1244_ sky130_fd_sc_hd__o22a_1
XPHY_EDGE_ROW_55_Right_55 VGND VGND VPWR VPWR sky130_fd_sc_hd__decap_3
X_5018_ _2498_ VGND VGND VPWR VPWR _0474_ sky130_fd_sc_hd__clkbuf_1
XFILLER_0_67_105 VGND VGND VPWR VPWR sky130_fd_sc_hd__decap_6
XFILLER_0_138_505 VPWR VGND VPWR VGND sky130_ef_sc_hd__decap_12
XFILLER_0_95_447 VGND VGND VPWR VPWR sky130_fd_sc_hd__fill_1
XFILLER_0_67_149 VPWR VGND VPWR VGND sky130_ef_sc_hd__decap_12
XFILLER_0_95_469 VGND VGND VPWR VPWR sky130_fd_sc_hd__decap_6
XFILLER_0_48_363 VGND VGND VPWR VPWR sky130_fd_sc_hd__fill_1
XFILLER_0_119_741 VPWR VGND VPWR VGND sky130_ef_sc_hd__decap_12
XTAP_TAPCELL_ROW_24_656 VGND VPWR sky130_fd_sc_hd__tapvpwrvgnd_1
XTAP_TAPCELL_ROW_24_667 VGND VPWR sky130_fd_sc_hd__tapvpwrvgnd_1
XFILLER_0_119_785 VPWR VGND VPWR VGND sky130_ef_sc_hd__decap_12
XFILLER_0_118_251 VGND VGND VPWR VPWR sky130_fd_sc_hd__fill_1
XFILLER_0_106_413 VGND VGND VPWR VPWR sky130_fd_sc_hd__decap_6
XFILLER_0_90_141 VPWR VGND VPWR VGND sky130_ef_sc_hd__decap_12
XFILLER_0_75_193 VPWR VGND VPWR VGND sky130_ef_sc_hd__decap_12
XPHY_EDGE_ROW_64_Right_64 VGND VGND VPWR VPWR sky130_fd_sc_hd__decap_3
XFILLER_0_134_755 VGND VGND VPWR VPWR sky130_fd_sc_hd__fill_1
XFILLER_0_17_783 VGND VGND VPWR VPWR sky130_fd_sc_hd__fill_1
XFILLER_0_121_405 VPWR VGND VPWR VGND sky130_ef_sc_hd__decap_12
XFILLER_0_121_449 VPWR VGND VPWR VGND sky130_ef_sc_hd__decap_12
XFILLER_0_102_641 VGND VGND VPWR VPWR sky130_fd_sc_hd__decap_3
XPHY_EDGE_ROW_73_Right_73 VGND VGND VPWR VPWR sky130_fd_sc_hd__decap_3
XTAP_TAPCELL_ROW_69_1329 VGND VPWR sky130_fd_sc_hd__tapvpwrvgnd_1
XFILLER_0_99_797 VPWR VGND VPWR VGND sky130_ef_sc_hd__decap_12
XFILLER_0_59_606 VGND VGND VPWR VPWR sky130_fd_sc_hd__fill_2
XFILLER_0_129_505 VPWR VGND VPWR VGND sky130_ef_sc_hd__decap_12
XTAP_TAPCELL_ROW_82_1529 VGND VPWR sky130_fd_sc_hd__tapvpwrvgnd_1
XFILLER_0_80_29 VPWR VGND VPWR VGND sky130_ef_sc_hd__decap_12
XTAP_TAPCELL_ROW_43_943 VGND VPWR sky130_fd_sc_hd__tapvpwrvgnd_1
XPHY_EDGE_ROW_82_Right_82 VGND VGND VPWR VPWR sky130_fd_sc_hd__decap_3
XPHY_EDGE_ROW_17_Left_156 VGND VGND VPWR VPWR sky130_fd_sc_hd__decap_3
XFILLER_0_39_385 VGND VGND VPWR VPWR sky130_fd_sc_hd__decap_6
XFILLER_0_109_273 VGND VGND VPWR VPWR sky130_fd_sc_hd__decap_6
XFILLER_0_82_642 VGND VGND VPWR VPWR sky130_fd_sc_hd__fill_2
XFILLER_0_6_419 VGND VGND VPWR VPWR sky130_fd_sc_hd__fill_1
XFILLER_0_15_709 VPWR VGND VPWR VGND sky130_ef_sc_hd__decap_12
XFILLER_0_124_221 VPWR VGND VPWR VGND sky130_ef_sc_hd__decap_12
XFILLER_0_89_27 VPWR VGND VPWR VGND sky130_ef_sc_hd__decap_12
X_2650_ _0614_ VGND VGND VPWR VPWR _0615_ sky130_fd_sc_hd__clkbuf_8
XFILLER_0_125_777 VGND VGND VPWR VPWR sky130_fd_sc_hd__decap_6
XFILLER_0_124_265 VPWR VGND VPWR VGND sky130_ef_sc_hd__decap_12
XTAP_TAPCELL_ROW_97_1761 VGND VPWR sky130_fd_sc_hd__tapvpwrvgnd_1
XTAP_TAPCELL_ROW_97_1750 VGND VPWR sky130_fd_sc_hd__tapvpwrvgnd_1
XFILLER_0_1_113 VPWR VGND VPWR VGND sky130_ef_sc_hd__decap_12
XFILLER_0_2_625 VPWR VGND VPWR VGND sky130_ef_sc_hd__decap_12
XFILLER_0_23_753 VPWR VGND VPWR VGND sky130_ef_sc_hd__decap_12
X_2581_ _0528_ _0532_ _0542_ _0545_ VGND VGND VPWR VPWR _0546_ sky130_fd_sc_hd__and4b_2
XFILLER_0_2_669 VPWR VGND VPWR VGND sky130_ef_sc_hd__decap_12
XFILLER_0_23_797 VPWR VGND VPWR VGND sky130_ef_sc_hd__decap_12
X_4320_ _2104_ VGND VGND VPWR VPWR _0170_ sky130_fd_sc_hd__clkbuf_1
X_4251_ cpu_inst.regfile_inst.registers\[24\]\[10\] VGND VGND VPWR VPWR _2068_ sky130_fd_sc_hd__clkbuf_1
XFILLER_0_10_469 VGND VGND VPWR VPWR sky130_fd_sc_hd__decap_6
XFILLER_0_129_55 VGND VGND VPWR VPWR sky130_fd_sc_hd__fill_1
XPHY_EDGE_ROW_91_Right_91 VGND VGND VPWR VPWR sky130_fd_sc_hd__decap_3
X_3202_ _0682_ _1143_ _1166_ _1052_ VGND VGND VPWR VPWR _1167_ sky130_fd_sc_hd__a22oi_2
XPHY_EDGE_ROW_26_Left_165 VGND VGND VPWR VPWR sky130_fd_sc_hd__decap_3
XFILLER_0_38_53 VPWR VGND VPWR VGND sky130_ef_sc_hd__decap_12
X_4182_ _2032_ VGND VGND VPWR VPWR _0104_ sky130_fd_sc_hd__clkbuf_1
XFILLER_0_38_97 VPWR VGND VPWR VGND sky130_ef_sc_hd__decap_12
X_3133_ _1096_ _1097_ _0987_ VGND VGND VPWR VPWR _1098_ sky130_fd_sc_hd__a21bo_1
XTAP_TAPCELL_ROW_2_329 VGND VPWR sky130_fd_sc_hd__tapvpwrvgnd_1
X_3064_ cpu_inst.regfile_inst.registers\[2\]\[13\] _0848_ _0849_ cpu_inst.regfile_inst.registers\[7\]\[13\]
+ VGND VGND VPWR VPWR _1029_ sky130_fd_sc_hd__o22a_1
XFILLER_0_54_41 VPWR VGND VPWR VGND sky130_ef_sc_hd__decap_12
XTAP_TAPCELL_ROW_124_2157 VGND VPWR sky130_fd_sc_hd__tapvpwrvgnd_1
XFILLER_0_77_414 VGND VGND VPWR VPWR sky130_fd_sc_hd__decap_3
XFILLER_0_49_105 VGND VGND VPWR VPWR sky130_fd_sc_hd__decap_6
XFILLER_0_54_85 VPWR VGND VPWR VGND sky130_ef_sc_hd__decap_12
XTAP_TAPCELL_ROW_106_1890 VGND VPWR sky130_fd_sc_hd__tapvpwrvgnd_1
XFILLER_0_92_406 VGND VGND VPWR VPWR sky130_fd_sc_hd__decap_4
XFILLER_0_65_609 VGND VGND VPWR VPWR sky130_fd_sc_hd__decap_4
XFILLER_0_58_650 VGND VGND VPWR VPWR sky130_fd_sc_hd__decap_6
XPHY_EDGE_ROW_35_Left_174 VGND VGND VPWR VPWR sky130_fd_sc_hd__decap_3
XFILLER_0_49_149 VPWR VGND VPWR VGND sky130_ef_sc_hd__decap_12
X_3966_ net42 _1890_ _0639_ VGND VGND VPWR VPWR _1891_ sky130_fd_sc_hd__a21o_1
XFILLER_0_18_525 VGND VGND VPWR VPWR sky130_fd_sc_hd__decap_6
XFILLER_0_57_193 VPWR VGND VPWR VGND sky130_ef_sc_hd__decap_12
XFILLER_0_9_279 VGND VGND VPWR VPWR sky130_fd_sc_hd__fill_1
XFILLER_0_18_569 VPWR VGND VPWR VGND sky130_ef_sc_hd__decap_12
XTAP_TAPCELL_ROW_21_615 VGND VPWR sky130_fd_sc_hd__tapvpwrvgnd_1
X_2917_ cpu_inst.regfile_inst.registers\[7\]\[4\] cpu_inst.regfile_inst.registers\[6\]\[4\]
+ _0865_ VGND VGND VPWR VPWR _0882_ sky130_fd_sc_hd__mux2_1
XFILLER_0_116_755 VGND VGND VPWR VPWR sky130_fd_sc_hd__fill_1
XFILLER_0_92_3 VPWR VGND VPWR VGND sky130_ef_sc_hd__decap_12
X_3897_ _1786_ _1781_ _1783_ VGND VGND VPWR VPWR _1824_ sky130_fd_sc_hd__o21a_1
XFILLER_0_72_141 VPWR VGND VPWR VGND sky130_ef_sc_hd__decap_12
XFILLER_0_103_405 VPWR VGND VPWR VGND sky130_ef_sc_hd__decap_12
XFILLER_0_5_441 VGND VGND VPWR VPWR sky130_fd_sc_hd__decap_6
X_2848_ _0714_ _0808_ _0809_ _0701_ _0812_ VGND VGND VPWR VPWR _0813_ sky130_fd_sc_hd__o221a_4
XFILLER_0_103_449 VGND VGND VPWR VPWR sky130_fd_sc_hd__fill_2
XFILLER_0_5_485 VPWR VGND VPWR VGND sky130_ef_sc_hd__decap_12
X_5567_ clknet_leaf_30_clk _0487_ VGND VGND VPWR VPWR cpu_inst.display_inst.counter\[7\]
+ sky130_fd_sc_hd__dfxtp_1
X_2779_ cpu_inst.regfile_inst.registers\[8\]\[3\] _0598_ VGND VGND VPWR VPWR _0744_
+ sky130_fd_sc_hd__or2_1
XFILLER_0_41_561 VGND VGND VPWR VPWR sky130_fd_sc_hd__decap_3
XFILLER_0_79_93 VPWR VGND VPWR VGND sky130_ef_sc_hd__decap_12
X_4518_ cpu_inst.regfile_inst.registers\[11\]\[10\] VGND VGND VPWR VPWR _2207_ sky130_fd_sc_hd__clkbuf_1
XPHY_EDGE_ROW_44_Left_183 VGND VGND VPWR VPWR sky130_fd_sc_hd__decap_3
X_5498_ clknet_leaf_37_clk _0418_ VGND VGND VPWR VPWR cpu_inst.regfile_inst.registers\[8\]\[2\]
+ sky130_fd_sc_hd__dfxtp_1
X_4449_ _2171_ VGND VGND VPWR VPWR _0232_ sky130_fd_sc_hd__clkbuf_1
XFILLER_0_95_81 VPWR VGND VPWR VGND sky130_ef_sc_hd__decap_12
XTAP_TAPCELL_ROW_29_737 VGND VPWR sky130_fd_sc_hd__tapvpwrvgnd_1
XFILLER_0_96_701 VGND VGND VPWR VPWR sky130_fd_sc_hd__decap_8
XPHY_EDGE_ROW_53_Left_192 VGND VGND VPWR VPWR sky130_fd_sc_hd__decap_3
XFILLER_0_56_609 VGND VGND VPWR VPWR sky130_fd_sc_hd__decap_3
XTAP_TAPCELL_ROW_64_1259 VGND VPWR sky130_fd_sc_hd__tapvpwrvgnd_1
XTAP_TAPCELL_ROW_40_902 VGND VPWR sky130_fd_sc_hd__tapvpwrvgnd_1
XFILLER_0_49_694 VPWR VGND VPWR VGND sky130_ef_sc_hd__decap_12
XFILLER_0_36_333 VPWR VGND VPWR VGND sky130_ef_sc_hd__decap_12
XFILLER_0_106_221 VPWR VGND VPWR VGND sky130_ef_sc_hd__decap_12
XFILLER_0_36_377 VPWR VGND VPWR VGND sky130_ef_sc_hd__decap_12
XFILLER_0_107_777 VGND VGND VPWR VPWR sky130_fd_sc_hd__decap_6
XFILLER_0_106_265 VPWR VGND VPWR VGND sky130_ef_sc_hd__decap_12
XFILLER_0_91_483 VGND VGND VPWR VPWR sky130_fd_sc_hd__decap_3
XFILLER_0_122_725 VPWR VGND VPWR VGND sky130_ef_sc_hd__decap_12
XTAP_TAPCELL_ROW_79_1480 VGND VPWR sky130_fd_sc_hd__tapvpwrvgnd_1
XFILLER_0_20_701 VPWR VGND VPWR VGND sky130_ef_sc_hd__decap_12
XFILLER_0_122_769 VPWR VGND VPWR VGND sky130_ef_sc_hd__decap_12
XTAP_TAPCELL_ROW_79_1491 VGND VPWR sky130_fd_sc_hd__tapvpwrvgnd_1
XFILLER_0_121_279 VGND VGND VPWR VPWR sky130_fd_sc_hd__fill_1
XTAP_TAPCELL_ROW_9_440 VGND VPWR sky130_fd_sc_hd__tapvpwrvgnd_1
XTAP_TAPCELL_ROW_92_1680 VGND VPWR sky130_fd_sc_hd__tapvpwrvgnd_1
XFILLER_0_91_39 VPWR VGND VPWR VGND sky130_ef_sc_hd__decap_12
XFILLER_0_86_233 VPWR VGND VPWR VGND sky130_ef_sc_hd__decap_12
XFILLER_0_115_57 VPWR VGND VPWR VGND sky130_ef_sc_hd__decap_12
XFILLER_0_129_335 VGND VGND VPWR VPWR sky130_fd_sc_hd__fill_1
X_3820_ _1737_ _1748_ VGND VGND VPWR VPWR _1749_ sky130_fd_sc_hd__xor2_1
XFILLER_0_86_277 VPWR VGND VPWR VGND sky130_ef_sc_hd__decap_12
XFILLER_0_24_77 VGND VGND VPWR VPWR sky130_fd_sc_hd__decap_6
X_3751_ _1648_ _1653_ _1681_ VGND VGND VPWR VPWR _1682_ sky130_fd_sc_hd__a21oi_1
XFILLER_0_39_193 VPWR VGND VPWR VGND sky130_ef_sc_hd__decap_12
XFILLER_0_125_541 VPWR VGND VPWR VGND sky130_ef_sc_hd__decap_12
X_2702_ _0665_ _0666_ VGND VGND VPWR VPWR _0667_ sky130_fd_sc_hd__or2b_1
XFILLER_0_54_141 VPWR VGND VPWR VGND sky130_ef_sc_hd__decap_12
XFILLER_0_15_517 VPWR VGND VPWR VGND sky130_ef_sc_hd__decap_12
X_3682_ _1612_ _1613_ _1312_ VGND VGND VPWR VPWR _1614_ sky130_fd_sc_hd__mux2_1
XFILLER_0_70_645 VGND VGND VPWR VPWR sky130_fd_sc_hd__fill_2
XFILLER_0_70_634 VGND VGND VPWR VPWR sky130_fd_sc_hd__decap_8
XFILLER_0_40_65 VPWR VGND VPWR VGND sky130_ef_sc_hd__decap_12
XFILLER_0_125_585 VPWR VGND VPWR VGND sky130_ef_sc_hd__decap_12
XFILLER_0_70_667 VGND VGND VPWR VPWR sky130_fd_sc_hd__fill_1
X_5421_ clknet_leaf_0_clk _0341_ net2 VGND VGND VPWR VPWR cpu_inst.decoder_inst.current_pc\[21\]
+ sky130_fd_sc_hd__dfrtp_1
XFILLER_0_30_509 VGND VGND VPWR VPWR sky130_fd_sc_hd__fill_2
X_2633_ _0586_ VGND VGND VPWR VPWR _0598_ sky130_fd_sc_hd__buf_4
X_5352_ clknet_leaf_21_clk _0272_ VGND VGND VPWR VPWR cpu_inst.regfile_inst.registers\[11\]\[16\]
+ sky130_fd_sc_hd__dfxtp_1
X_2564_ _0505_ _0508_ VGND VGND VPWR VPWR _0529_ sky130_fd_sc_hd__nand2_4
XFILLER_0_2_433 VPWR VGND VPWR VGND sky130_ef_sc_hd__decap_12
XFILLER_0_23_561 VPWR VGND VPWR VGND sky130_ef_sc_hd__decap_12
XFILLER_0_10_233 VPWR VGND VPWR VGND sky130_ef_sc_hd__decap_12
XFILLER_0_2_477 VPWR VGND VPWR VGND sky130_ef_sc_hd__decap_12
X_4303_ _2095_ VGND VGND VPWR VPWR _0162_ sky130_fd_sc_hd__clkbuf_1
XFILLER_0_10_277 VPWR VGND VPWR VGND sky130_ef_sc_hd__decap_12
X_5283_ clknet_leaf_28_clk _0203_ VGND VGND VPWR VPWR cpu_inst.regfile_inst.registers\[1\]\[11\]
+ sky130_fd_sc_hd__dfxtp_1
X_4234_ _2059_ VGND VGND VPWR VPWR _0129_ sky130_fd_sc_hd__clkbuf_1
XFILLER_0_65_51 VGND VGND VPWR VPWR sky130_fd_sc_hd__decap_4
XFILLER_0_4_65 VPWR VGND VPWR VGND sky130_ef_sc_hd__decap_12
X_4165_ _2023_ VGND VGND VPWR VPWR _2024_ sky130_fd_sc_hd__clkbuf_4
X_3116_ cpu_inst.regfile_inst.registers\[25\]\[4\] _0903_ _0921_ _0887_ VGND VGND
+ VPWR VPWR _1081_ sky130_fd_sc_hd__o211ai_1
X_4096_ _1110_ cpu_inst.regfile_inst.registers\[25\]\[2\] _1982_ VGND VGND VPWR VPWR
+ _1985_ sky130_fd_sc_hd__mux2_1
X_3047_ _0863_ _1009_ _1011_ _0875_ VGND VGND VPWR VPWR _1012_ sky130_fd_sc_hd__o22a_1
XFILLER_0_135_305 VPWR VGND VPWR VGND sky130_ef_sc_hd__decap_12
X_4998_ cpu_inst.regfile_inst.registers\[15\]\[17\] _2480_ VGND VGND VPWR VPWR _2488_
+ sky130_fd_sc_hd__and2_1
XFILLER_0_18_333 VPWR VGND VPWR VGND sky130_ef_sc_hd__decap_12
XTAP_TAPCELL_ROW_137_2359 VGND VPWR sky130_fd_sc_hd__tapvpwrvgnd_1
XTAP_TAPCELL_ROW_137_2348 VGND VPWR sky130_fd_sc_hd__tapvpwrvgnd_1
XFILLER_0_135_349 VPWR VGND VPWR VGND sky130_ef_sc_hd__decap_12
X_3949_ _1536_ _1871_ _1873_ _1314_ VGND VGND VPWR VPWR _1874_ sky130_fd_sc_hd__o22a_1
XFILLER_0_18_377 VPWR VGND VPWR VGND sky130_ef_sc_hd__decap_12
XFILLER_0_104_725 VPWR VGND VPWR VGND sky130_ef_sc_hd__decap_12
XFILLER_0_60_133 VGND VGND VPWR VPWR sky130_fd_sc_hd__decap_6
XFILLER_0_104_769 VPWR VGND VPWR VGND sky130_ef_sc_hd__decap_12
XFILLER_0_60_177 VPWR VGND VPWR VGND sky130_ef_sc_hd__decap_12
XFILLER_0_5_293 VPWR VGND VPWR VGND sky130_ef_sc_hd__decap_12
XFILLER_0_103_279 VGND VGND VPWR VPWR sky130_fd_sc_hd__fill_1
XFILLER_0_41_391 VGND VGND VPWR VPWR sky130_fd_sc_hd__fill_1
XPHY_EDGE_ROW_61_Left_200 VGND VGND VPWR VPWR sky130_fd_sc_hd__decap_3
XFILLER_0_96_531 VGND VGND VPWR VPWR sky130_fd_sc_hd__fill_1
XFILLER_0_68_233 VPWR VGND VPWR VGND sky130_ef_sc_hd__decap_12
XFILLER_0_83_225 VPWR VGND VPWR VGND sky130_ef_sc_hd__decap_12
XFILLER_0_68_277 VPWR VGND VPWR VGND sky130_ef_sc_hd__decap_12
XFILLER_0_138_165 VGND VGND VPWR VPWR sky130_fd_sc_hd__decap_3
XFILLER_0_127_839 VGND VGND VPWR VPWR sky130_fd_sc_hd__fill_1
XFILLER_0_36_141 VPWR VGND VPWR VGND sky130_ef_sc_hd__decap_12
XFILLER_0_37_664 VGND VGND VPWR VPWR sky130_fd_sc_hd__fill_2
XFILLER_0_101_15 VPWR VGND VPWR VGND sky130_ef_sc_hd__decap_12
XFILLER_0_64_483 VGND VGND VPWR VPWR sky130_fd_sc_hd__decap_3
XFILLER_0_52_634 VGND VGND VPWR VPWR sky130_fd_sc_hd__decap_8
XTAP_TAPCELL_ROW_12_478 VGND VPWR sky130_fd_sc_hd__tapvpwrvgnd_1
XFILLER_0_51_111 VGND VGND VPWR VPWR sky130_fd_sc_hd__fill_1
XFILLER_0_122_533 VPWR VGND VPWR VGND sky130_ef_sc_hd__decap_12
XPHY_EDGE_ROW_108_Right_108 VGND VGND VPWR VPWR sky130_fd_sc_hd__decap_3
XFILLER_0_20_531 VGND VGND VPWR VPWR sky130_fd_sc_hd__fill_1
XFILLER_0_19_55 VGND VGND VPWR VPWR sky130_fd_sc_hd__fill_1
XTAP_TAPCELL_ROW_121_2116 VGND VPWR sky130_fd_sc_hd__tapvpwrvgnd_1
XFILLER_0_99_391 VGND VGND VPWR VPWR sky130_fd_sc_hd__fill_1
X_4921_ _2447_ VGND VGND VPWR VPWR _0428_ sky130_fd_sc_hd__clkbuf_1
X_4852_ cpu_inst.regfile_inst.registers\[9\]\[12\] VGND VGND VPWR VPWR _2411_ sky130_fd_sc_hd__clkbuf_1
XFILLER_0_47_417 VPWR VGND VPWR VGND sky130_ef_sc_hd__decap_12
XFILLER_0_117_305 VPWR VGND VPWR VGND sky130_ef_sc_hd__decap_12
X_3803_ cpu_inst.regfile_inst.registers\[9\]\[26\] cpu_inst.regfile_inst.registers\[8\]\[26\]
+ _1657_ VGND VGND VPWR VPWR _1732_ sky130_fd_sc_hd__mux2_1
XFILLER_0_7_503 VGND VGND VPWR VPWR sky130_fd_sc_hd__fill_1
XFILLER_0_28_642 VGND VGND VPWR VPWR sky130_fd_sc_hd__fill_2
XFILLER_0_117_349 VPWR VGND VPWR VGND sky130_ef_sc_hd__decap_12
X_4783_ _2376_ VGND VGND VPWR VPWR _0361_ sky130_fd_sc_hd__clkbuf_1
XFILLER_0_133_809 VPWR VGND VPWR VGND sky130_ef_sc_hd__decap_12
XTAP_TAPCELL_ROW_119_2078 VGND VPWR sky130_fd_sc_hd__tapvpwrvgnd_1
X_3734_ cpu_inst.regfile_inst.registers\[8\]\[24\] _1664_ _1557_ VGND VGND VPWR VPWR
+ _1665_ sky130_fd_sc_hd__mux2_1
XFILLER_0_16_837 VGND VGND VPWR VPWR sky130_fd_sc_hd__decap_4
XTAP_TAPCELL_ROW_31_765 VGND VPWR sky130_fd_sc_hd__tapvpwrvgnd_1
XFILLER_0_43_634 VGND VGND VPWR VPWR sky130_fd_sc_hd__decap_8
XTAP_TAPCELL_ROW_119_2089 VGND VPWR sky130_fd_sc_hd__tapvpwrvgnd_1
X_3665_ cpu_inst.regfile_inst.registers\[24\]\[22\] _1384_ _0700_ _1597_ _0961_ VGND
+ VGND VPWR VPWR _1598_ sky130_fd_sc_hd__o221a_1
XFILLER_0_70_464 VPWR VGND VPWR VGND sky130_ef_sc_hd__decap_12
XFILLER_0_31_818 VGND VGND VPWR VPWR sky130_fd_sc_hd__decap_3
XFILLER_0_42_133 VGND VGND VPWR VPWR sky130_fd_sc_hd__decap_6
XFILLER_0_125_393 VPWR VGND VPWR VGND sky130_ef_sc_hd__decap_12
Xclkload40 clknet_leaf_21_clk VGND VGND VPWR VPWR clkload40/X sky130_fd_sc_hd__clkbuf_4
XFILLER_0_70_497 VGND VGND VPWR VPWR sky130_fd_sc_hd__fill_1
X_5404_ clknet_leaf_42_clk _0324_ net2 VGND VGND VPWR VPWR cpu_inst.decoder_inst.current_pc\[4\]
+ sky130_fd_sc_hd__dfrtp_2
X_2616_ _0537_ _0538_ _0554_ _0551_ VGND VGND VPWR VPWR _0581_ sky130_fd_sc_hd__or4_4
XFILLER_0_3_753 VPWR VGND VPWR VGND sky130_ef_sc_hd__decap_12
XFILLER_0_42_177 VPWR VGND VPWR VGND sky130_ef_sc_hd__decap_12
XTAP_TAPCELL_ROW_132_2278 VGND VPWR sky130_fd_sc_hd__tapvpwrvgnd_1
XFILLER_0_101_717 VGND VGND VPWR VPWR sky130_fd_sc_hd__decap_8
X_3596_ _1444_ _1482_ _1528_ _1530_ _1483_ VGND VGND VPWR VPWR _1531_ sky130_fd_sc_hd__o221a_1
XFILLER_0_3_797 VPWR VGND VPWR VGND sky130_ef_sc_hd__decap_12
XFILLER_0_23_391 VGND VGND VPWR VPWR sky130_fd_sc_hd__fill_1
X_5335_ clknet_leaf_2_clk _0255_ VGND VGND VPWR VPWR cpu_inst.regfile_inst.registers\[7\]\[31\]
+ sky130_fd_sc_hd__dfxtp_1
X_2547_ _0510_ _0511_ VGND VGND VPWR VPWR _0512_ sky130_fd_sc_hd__nor2_1
XFILLER_0_11_553 VGND VGND VPWR VPWR sky130_fd_sc_hd__decap_6
X_5266_ clknet_leaf_8_clk _0186_ VGND VGND VPWR VPWR cpu_inst.regfile_inst.registers\[5\]\[26\]
+ sky130_fd_sc_hd__dfxtp_1
XFILLER_0_55_3 VPWR VGND VPWR VGND sky130_ef_sc_hd__decap_12
XFILLER_0_11_597 VPWR VGND VPWR VGND sky130_ef_sc_hd__decap_12
X_4217_ cpu_inst.regfile_inst.registers\[4\]\[25\] _2046_ VGND VGND VPWR VPWR _2051_
+ sky130_fd_sc_hd__and2_1
XFILLER_0_76_83 VGND VGND VPWR VPWR sky130_fd_sc_hd__fill_1
X_5197_ clknet_leaf_15_clk _0117_ VGND VGND VPWR VPWR cpu_inst.regfile_inst.registers\[4\]\[21\]
+ sky130_fd_sc_hd__dfxtp_1
XFILLER_0_98_807 VGND VGND VPWR VPWR sky130_fd_sc_hd__decap_4
XFILLER_0_97_317 VPWR VGND VPWR VGND sky130_ef_sc_hd__decap_12
X_4148_ _1726_ cpu_inst.regfile_inst.registers\[25\]\[25\] _2010_ VGND VGND VPWR VPWR
+ _2014_ sky130_fd_sc_hd__mux2_1
X_4079_ _1975_ VGND VGND VPWR VPWR _0058_ sky130_fd_sc_hd__clkbuf_1
XTAP_TAPCELL_ROW_39_887 VGND VPWR sky130_fd_sc_hd__tapvpwrvgnd_1
XTAP_TAPCELL_ROW_48_1018 VGND VPWR sky130_fd_sc_hd__tapvpwrvgnd_1
XFILLER_0_66_704 VGND VGND VPWR VPWR sky130_fd_sc_hd__decap_4
XFILLER_0_78_597 VGND VGND VPWR VPWR sky130_fd_sc_hd__decap_3
XFILLER_0_136_625 VPWR VGND VPWR VGND sky130_ef_sc_hd__decap_12
XFILLER_0_109_839 VGND VGND VPWR VPWR sky130_fd_sc_hd__fill_1
XFILLER_0_93_556 VGND VGND VPWR VPWR sky130_fd_sc_hd__decap_4
XFILLER_0_65_225 VPWR VGND VPWR VGND sky130_ef_sc_hd__decap_12
XTAP_TAPCELL_ROW_61_1218 VGND VPWR sky130_fd_sc_hd__tapvpwrvgnd_1
XFILLER_0_135_113 VPWR VGND VPWR VGND sky130_ef_sc_hd__decap_12
XFILLER_0_18_141 VPWR VGND VPWR VGND sky130_ef_sc_hd__decap_12
XFILLER_0_19_653 VPWR VGND VPWR VGND sky130_ef_sc_hd__decap_12
XFILLER_0_136_669 VPWR VGND VPWR VGND sky130_ef_sc_hd__decap_12
Xclkload1 clknet_2_1__leaf_clk VGND VGND VPWR VPWR clkload1/Y sky130_fd_sc_hd__inv_6
XFILLER_0_19_697 VPWR VGND VPWR VGND sky130_ef_sc_hd__decap_12
XFILLER_0_33_111 VGND VGND VPWR VPWR sky130_fd_sc_hd__fill_1
XFILLER_0_34_612 VGND VGND VPWR VPWR sky130_fd_sc_hd__decap_8
XFILLER_0_34_667 VGND VGND VPWR VPWR sky130_fd_sc_hd__decap_8
XFILLER_0_21_317 VPWR VGND VPWR VGND sky130_ef_sc_hd__decap_12
XFILLER_0_131_385 VGND VGND VPWR VPWR sky130_fd_sc_hd__decap_6
XFILLER_0_69_542 VGND VGND VPWR VPWR sky130_fd_sc_hd__decap_8
XTAP_TAPCELL_ROW_17_548 VGND VPWR sky130_fd_sc_hd__tapvpwrvgnd_1
XTAP_TAPCELL_ROW_17_559 VGND VPWR sky130_fd_sc_hd__tapvpwrvgnd_1
XFILLER_0_29_417 VPWR VGND VPWR VGND sky130_ef_sc_hd__decap_12
XFILLER_0_84_545 VGND VGND VPWR VPWR sky130_fd_sc_hd__decap_6
XFILLER_0_115_809 VPWR VGND VPWR VGND sky130_ef_sc_hd__decap_12
XFILLER_0_71_217 VGND VGND VPWR VPWR sky130_fd_sc_hd__decap_6
XFILLER_0_52_453 VPWR VGND VPWR VGND sky130_ef_sc_hd__decap_12
XFILLER_0_52_442 VGND VGND VPWR VPWR sky130_fd_sc_hd__decap_3
XFILLER_0_24_133 VGND VGND VPWR VPWR sky130_fd_sc_hd__decap_6
XFILLER_0_25_656 VPWR VGND VPWR VGND sky130_ef_sc_hd__decap_12
XFILLER_0_107_393 VPWR VGND VPWR VGND sky130_ef_sc_hd__decap_12
XFILLER_0_97_27 VPWR VGND VPWR VGND sky130_ef_sc_hd__decap_12
XFILLER_0_24_177 VPWR VGND VPWR VGND sky130_ef_sc_hd__decap_12
XFILLER_0_122_363 VGND VGND VPWR VPWR sky130_fd_sc_hd__fill_1
X_3450_ cpu_inst.regfile_inst.registers\[7\]\[17\] cpu_inst.regfile_inst.registers\[6\]\[17\]
+ _1386_ VGND VGND VPWR VPWR _1388_ sky130_fd_sc_hd__mux2_1
XFILLER_0_0_701 VPWR VGND VPWR VGND sky130_ef_sc_hd__decap_12
XFILLER_0_110_525 VGND VGND VPWR VPWR sky130_fd_sc_hd__decap_6
X_3381_ _0529_ _0549_ _0531_ _1326_ _0709_ VGND VGND VPWR VPWR _1331_ sky130_fd_sc_hd__o311a_1
XFILLER_0_110_569 VPWR VGND VPWR VGND sky130_ef_sc_hd__decap_12
X_5120_ clknet_leaf_32_clk _0040_ VGND VGND VPWR VPWR cpu_inst.regfile_inst.registers\[2\]\[8\]
+ sky130_fd_sc_hd__dfxtp_1
X_5051_ cpu_inst.display_inst.counter\[9\] _2515_ VGND VGND VPWR VPWR _2517_ sky130_fd_sc_hd__and2_1
XFILLER_0_137_55 VGND VGND VPWR VPWR sky130_fd_sc_hd__fill_1
X_4002_ _1306_ _1863_ _1925_ _1487_ VGND VGND VPWR VPWR _1926_ sky130_fd_sc_hd__o211a_1
XFILLER_0_46_53 VPWR VGND VPWR VGND sky130_ef_sc_hd__decap_12
XFILLER_0_79_317 VPWR VGND VPWR VGND sky130_ef_sc_hd__decap_12
XFILLER_0_46_97 VPWR VGND VPWR VGND sky130_ef_sc_hd__decap_12
XFILLER_0_94_309 VPWR VGND VPWR VGND sky130_ef_sc_hd__decap_12
XFILLER_0_1_55 VGND VGND VPWR VPWR sky130_fd_sc_hd__fill_1
XTAP_TAPCELL_ROW_36_835 VGND VPWR sky130_fd_sc_hd__tapvpwrvgnd_1
XFILLER_0_87_361 VPWR VGND VPWR VGND sky130_ef_sc_hd__decap_12
XFILLER_0_62_41 VPWR VGND VPWR VGND sky130_ef_sc_hd__decap_12
XPHY_EDGE_ROW_9_Left_148 VGND VGND VPWR VPWR sky130_fd_sc_hd__decap_3
XTAP_TAPCELL_ROW_36_846 VGND VPWR sky130_fd_sc_hd__tapvpwrvgnd_1
XTAP_TAPCELL_ROW_101_1819 VGND VPWR sky130_fd_sc_hd__tapvpwrvgnd_1
XTAP_TAPCELL_ROW_101_1808 VGND VPWR sky130_fd_sc_hd__tapvpwrvgnd_1
XFILLER_0_62_85 VPWR VGND VPWR VGND sky130_ef_sc_hd__decap_12
X_4904_ _1196_ cpu_inst.regfile_inst.registers\[8\]\[4\] _2432_ VGND VGND VPWR VPWR
+ _2439_ sky130_fd_sc_hd__mux2_1
XFILLER_0_47_225 VPWR VGND VPWR VGND sky130_ef_sc_hd__decap_12
XFILLER_0_118_625 VPWR VGND VPWR VGND sky130_ef_sc_hd__decap_12
XFILLER_0_117_113 VPWR VGND VPWR VGND sky130_ef_sc_hd__decap_12
XFILLER_0_16_601 VPWR VGND VPWR VGND sky130_ef_sc_hd__decap_12
X_4835_ _2402_ VGND VGND VPWR VPWR _0387_ sky130_fd_sc_hd__clkbuf_1
XTAP_TAPCELL_ROW_134_2307 VGND VPWR sky130_fd_sc_hd__tapvpwrvgnd_1
XFILLER_0_133_617 VPWR VGND VPWR VGND sky130_ef_sc_hd__decap_12
XFILLER_0_118_669 VPWR VGND VPWR VGND sky130_ef_sc_hd__decap_12
XFILLER_0_15_111 VGND VGND VPWR VPWR sky130_fd_sc_hd__fill_1
X_4766_ cpu_inst.regfile_inst.registers\[0\]\[0\] VGND VGND VPWR VPWR _2368_ sky130_fd_sc_hd__clkbuf_1
XFILLER_0_43_420 VGND VGND VPWR VPWR sky130_fd_sc_hd__fill_1
X_3717_ _1529_ _1531_ _1647_ VGND VGND VPWR VPWR _1648_ sky130_fd_sc_hd__a21o_1
XFILLER_0_16_645 VPWR VGND VPWR VGND sky130_ef_sc_hd__decap_12
X_4697_ cpu_inst.decoder_inst.current_pc\[12\] _2288_ _2318_ _2319_ VGND VGND VPWR
+ VPWR _0332_ sky130_fd_sc_hd__o22a_1
X_3648_ cpu_inst.regfile_inst.registers\[9\]\[22\] cpu_inst.regfile_inst.registers\[8\]\[22\]
+ _1540_ VGND VGND VPWR VPWR _1581_ sky130_fd_sc_hd__mux2_1
XFILLER_0_3_561 VPWR VGND VPWR VGND sky130_ef_sc_hd__decap_12
XFILLER_0_113_385 VGND VGND VPWR VPWR sky130_fd_sc_hd__decap_6
X_3579_ cpu_inst.regfile_inst.registers\[11\]\[20\] cpu_inst.regfile_inst.registers\[10\]\[20\]
+ _0731_ VGND VGND VPWR VPWR _1514_ sky130_fd_sc_hd__mux2_1
XFILLER_0_87_93 VPWR VGND VPWR VGND sky130_ef_sc_hd__decap_12
X_5318_ clknet_leaf_27_clk _0238_ VGND VGND VPWR VPWR cpu_inst.regfile_inst.registers\[7\]\[14\]
+ sky130_fd_sc_hd__dfxtp_1
XFILLER_0_11_361 VPWR VGND VPWR VGND sky130_ef_sc_hd__decap_12
X_5249_ clknet_leaf_29_clk _0169_ VGND VGND VPWR VPWR cpu_inst.regfile_inst.registers\[5\]\[9\]
+ sky130_fd_sc_hd__dfxtp_1
XFILLER_0_97_125 VPWR VGND VPWR VGND sky130_ef_sc_hd__decap_12
XFILLER_0_97_169 VPWR VGND VPWR VGND sky130_ef_sc_hd__decap_12
XFILLER_0_66_512 VPWR VGND VPWR VGND sky130_ef_sc_hd__decap_12
XTAP_TAPCELL_ROW_14_507 VGND VPWR sky130_fd_sc_hd__tapvpwrvgnd_1
XFILLER_0_136_433 VPWR VGND VPWR VGND sky130_ef_sc_hd__decap_12
XFILLER_0_66_589 VGND VGND VPWR VPWR sky130_fd_sc_hd__decap_3
XFILLER_0_19_461 VPWR VGND VPWR VGND sky130_ef_sc_hd__decap_12
XFILLER_0_53_217 VGND VGND VPWR VPWR sky130_fd_sc_hd__decap_6
XFILLER_0_136_477 VPWR VGND VPWR VGND sky130_ef_sc_hd__decap_12
XFILLER_0_123_105 VGND VGND VPWR VPWR sky130_fd_sc_hd__decap_6
XFILLER_0_123_149 VPWR VGND VPWR VGND sky130_ef_sc_hd__decap_12
XFILLER_0_61_261 VPWR VGND VPWR VGND sky130_ef_sc_hd__decap_12
XFILLER_0_104_363 VGND VGND VPWR VPWR sky130_fd_sc_hd__fill_1
XTAP_TAPCELL_ROW_74_1409 VGND VPWR sky130_fd_sc_hd__tapvpwrvgnd_1
XFILLER_0_21_125 VPWR VGND VPWR VGND sky130_ef_sc_hd__decap_12
XFILLER_0_22_637 VGND VGND VPWR VPWR sky130_fd_sc_hd__decap_6
XFILLER_0_21_169 VPWR VGND VPWR VGND sky130_ef_sc_hd__decap_12
XFILLER_0_131_193 VPWR VGND VPWR VGND sky130_ef_sc_hd__decap_12
XTAP_TAPCELL_ROW_89_1641 VGND VPWR sky130_fd_sc_hd__tapvpwrvgnd_1
XTAP_TAPCELL_ROW_89_1630 VGND VPWR sky130_fd_sc_hd__tapvpwrvgnd_1
XFILLER_0_107_69 VPWR VGND VPWR VGND sky130_ef_sc_hd__decap_12
XFILLER_0_76_309 VPWR VGND VPWR VGND sky130_ef_sc_hd__decap_12
X_2950_ _0910_ _0914_ VGND VGND VPWR VPWR _0915_ sky130_fd_sc_hd__and2b_1
XFILLER_0_9_609 VGND VGND VPWR VPWR sky130_fd_sc_hd__decap_6
XFILLER_0_29_225 VPWR VGND VPWR VGND sky130_ef_sc_hd__decap_12
XFILLER_0_123_57 VPWR VGND VPWR VGND sky130_ef_sc_hd__decap_12
X_2881_ cpu_inst.regfile_inst.registers\[8\]\[12\] _0845_ _0725_ VGND VGND VPWR VPWR
+ _0846_ sky130_fd_sc_hd__mux2_1
XFILLER_0_45_707 VGND VGND VPWR VPWR sky130_fd_sc_hd__fill_2
X_4620_ cpu_inst.regfile_inst.registers\[10\]\[28\] _2252_ VGND VGND VPWR VPWR _2259_
+ sky130_fd_sc_hd__and2_1
XFILLER_0_32_77 VGND VGND VPWR VPWR sky130_fd_sc_hd__decap_6
XFILLER_0_38_781 VGND VGND VPWR VPWR sky130_fd_sc_hd__decap_6
XFILLER_0_115_617 VPWR VGND VPWR VGND sky130_ef_sc_hd__decap_12
XFILLER_0_113_3 VPWR VGND VPWR VGND sky130_ef_sc_hd__decap_12
XTAP_TAPCELL_ROW_116_2037 VGND VPWR sky130_fd_sc_hd__tapvpwrvgnd_1
X_4551_ _2223_ VGND VGND VPWR VPWR _0282_ sky130_fd_sc_hd__clkbuf_1
XFILLER_0_13_615 VGND VGND VPWR VPWR sky130_fd_sc_hd__fill_1
XFILLER_0_40_401 VPWR VGND VPWR VGND sky130_ef_sc_hd__decap_12
X_4482_ _1692_ cpu_inst.regfile_inst.registers\[7\]\[24\] _2186_ VGND VGND VPWR VPWR
+ _2189_ sky130_fd_sc_hd__mux2_1
X_3502_ cpu_inst.regfile_inst.registers\[24\]\[18\] _0697_ VGND VGND VPWR VPWR _1439_
+ sky130_fd_sc_hd__or2_1
XFILLER_0_25_497 VGND VGND VPWR VPWR sky130_fd_sc_hd__decap_6
X_3433_ _1370_ _1371_ VGND VGND VPWR VPWR _1372_ sky130_fd_sc_hd__nor2_1
XFILLER_0_110_333 VPWR VGND VPWR VGND sky130_ef_sc_hd__decap_12
XFILLER_0_110_377 VPWR VGND VPWR VGND sky130_ef_sc_hd__decap_12
X_5103_ clknet_leaf_14_clk _0023_ VGND VGND VPWR VPWR cpu_inst.regfile_inst.registers\[6\]\[23\]
+ sky130_fd_sc_hd__dfxtp_1
X_3364_ _0876_ VGND VGND VPWR VPWR _1314_ sky130_fd_sc_hd__buf_4
XTAP_TAPCELL_ROW_111_1970 VGND VPWR sky130_fd_sc_hd__tapvpwrvgnd_1
X_3295_ _1224_ _1249_ _1250_ _1259_ _0683_ VGND VGND VPWR VPWR _1260_ sky130_fd_sc_hd__a32o_2
X_5034_ _2505_ _2506_ VGND VGND VPWR VPWR _0482_ sky130_fd_sc_hd__nor2_1
XFILLER_0_79_125 VPWR VGND VPWR VGND sky130_ef_sc_hd__decap_12
XTAP_TAPCELL_ROW_127_2199 VGND VPWR sky130_fd_sc_hd__tapvpwrvgnd_1
XFILLER_0_73_51 VGND VGND VPWR VPWR sky130_fd_sc_hd__decap_4
XFILLER_0_18_3 VPWR VGND VPWR VGND sky130_ef_sc_hd__decap_12
XFILLER_0_88_670 VGND VGND VPWR VPWR sky130_fd_sc_hd__decap_3
XFILLER_0_79_169 VPWR VGND VPWR VGND sky130_ef_sc_hd__decap_12
XTAP_TAPCELL_ROW_0_279 VGND VPWR sky130_fd_sc_hd__tapvpwrvgnd_1
XFILLER_0_94_139 VGND VGND VPWR VPWR sky130_fd_sc_hd__fill_1
XFILLER_0_118_433 VPWR VGND VPWR VGND sky130_ef_sc_hd__decap_12
XFILLER_0_90_301 VGND VGND VPWR VPWR sky130_fd_sc_hd__decap_6
XFILLER_0_63_537 VGND VGND VPWR VPWR sky130_fd_sc_hd__fill_1
XFILLER_0_35_217 VGND VGND VPWR VPWR sky130_fd_sc_hd__decap_6
XFILLER_0_48_589 VGND VGND VPWR VPWR sky130_fd_sc_hd__fill_2
XFILLER_0_118_477 VPWR VGND VPWR VGND sky130_ef_sc_hd__decap_12
XFILLER_0_105_105 VGND VGND VPWR VPWR sky130_fd_sc_hd__decap_6
X_4818_ cpu_inst.regfile_inst.registers\[0\]\[27\] VGND VGND VPWR VPWR _2394_ sky130_fd_sc_hd__clkbuf_1
XFILLER_0_90_345 VPWR VGND VPWR VGND sky130_ef_sc_hd__decap_12
XFILLER_0_133_447 VGND VGND VPWR VPWR sky130_fd_sc_hd__fill_1
XFILLER_0_105_149 VPWR VGND VPWR VGND sky130_ef_sc_hd__decap_12
XFILLER_0_90_389 VGND VGND VPWR VPWR sky130_fd_sc_hd__decap_8
X_4749_ _2293_ _2357_ cpu_inst.decoder_inst.current_pc\[26\] _2289_ VGND VGND VPWR
+ VPWR _0346_ sky130_fd_sc_hd__o2bb2a_1
XFILLER_0_16_475 VGND VGND VPWR VPWR sky130_fd_sc_hd__fill_1
XFILLER_0_43_261 VPWR VGND VPWR VGND sky130_ef_sc_hd__decap_12
XFILLER_0_50_209 VPWR VGND VPWR VGND sky130_ef_sc_hd__decap_12
XFILLER_0_121_609 VGND VGND VPWR VPWR sky130_fd_sc_hd__decap_6
XTAP_TAPCELL_ROW_56_1139 VGND VPWR sky130_fd_sc_hd__tapvpwrvgnd_1
XFILLER_0_113_193 VPWR VGND VPWR VGND sky130_ef_sc_hd__decap_12
XFILLER_0_12_681 VPWR VGND VPWR VGND sky130_ef_sc_hd__decap_12
XFILLER_0_3_391 VGND VGND VPWR VPWR sky130_fd_sc_hd__fill_1
XFILLER_0_98_401 VPWR VGND VPWR VGND sky130_ef_sc_hd__decap_12
XFILLER_0_129_709 VPWR VGND VPWR VGND sky130_ef_sc_hd__decap_12
XTAP_TAPCELL_ROW_84_1560 VGND VPWR sky130_fd_sc_hd__tapvpwrvgnd_1
XFILLER_0_94_673 VGND VGND VPWR VPWR sky130_fd_sc_hd__decap_8
XTAP_TAPCELL_ROW_27_698 VGND VPWR sky130_fd_sc_hd__tapvpwrvgnd_1
XFILLER_0_137_753 VPWR VGND VPWR VGND sky130_ef_sc_hd__decap_12
XFILLER_0_93_161 VGND VGND VPWR VPWR sky130_fd_sc_hd__decap_6
XFILLER_0_27_729 VPWR VGND VPWR VGND sky130_ef_sc_hd__decap_12
XFILLER_0_137_797 VPWR VGND VPWR VGND sky130_ef_sc_hd__decap_12
XFILLER_0_22_401 VPWR VGND VPWR VGND sky130_ef_sc_hd__decap_12
XFILLER_0_124_469 VGND VGND VPWR VPWR sky130_fd_sc_hd__decap_6
XFILLER_0_78_29 VPWR VGND VPWR VGND sky130_ef_sc_hd__decap_12
XFILLER_0_105_694 VPWR VGND VPWR VGND sky130_ef_sc_hd__decap_12
XFILLER_0_1_317 VPWR VGND VPWR VGND sky130_ef_sc_hd__decap_12
XFILLER_0_22_445 VPWR VGND VPWR VGND sky130_ef_sc_hd__decap_12
XFILLER_0_50_754 VGND VGND VPWR VPWR sky130_fd_sc_hd__fill_2
XFILLER_0_22_489 VPWR VGND VPWR VGND sky130_ef_sc_hd__decap_12
X_3080_ _0864_ _1042_ _1044_ _0875_ VGND VGND VPWR VPWR _1045_ sky130_fd_sc_hd__o22a_1
XFILLER_0_89_412 VGND VGND VPWR VPWR sky130_fd_sc_hd__fill_1
XFILLER_0_27_55 VGND VGND VPWR VPWR sky130_fd_sc_hd__fill_1
XFILLER_0_89_489 VPWR VGND VPWR VGND sky130_ef_sc_hd__decap_12
XFILLER_0_58_810 VGND VGND VPWR VPWR sky130_fd_sc_hd__fill_2
XFILLER_0_76_139 VGND VGND VPWR VPWR sky130_fd_sc_hd__fill_1
X_3982_ _1905_ cpu_inst.regfile_inst.registers\[10\]\[31\] _1313_ VGND VGND VPWR VPWR
+ _1906_ sky130_fd_sc_hd__mux2_1
XFILLER_0_9_417 VPWR VGND VPWR VGND sky130_ef_sc_hd__decap_12
XTAP_TAPCELL_ROW_46_985 VGND VPWR sky130_fd_sc_hd__tapvpwrvgnd_1
X_2933_ _0658_ _0895_ _0897_ _0657_ VGND VGND VPWR VPWR _0898_ sky130_fd_sc_hd__o22a_1
XTAP_TAPCELL_ROW_46_996 VGND VPWR sky130_fd_sc_hd__tapvpwrvgnd_1
XPHY_EDGE_ROW_99_Left_238 VGND VGND VPWR VPWR sky130_fd_sc_hd__decap_3
XFILLER_0_72_301 VGND VGND VPWR VPWR sky130_fd_sc_hd__decap_6
XFILLER_0_17_217 VGND VGND VPWR VPWR sky130_fd_sc_hd__decap_6
X_2864_ cpu_inst.regfile_inst.registers\[2\]\[8\] _0593_ _0702_ cpu_inst.regfile_inst.registers\[7\]\[8\]
+ VGND VGND VPWR VPWR _0829_ sky130_fd_sc_hd__o22a_1
XFILLER_0_45_559 VGND VGND VPWR VPWR sky130_fd_sc_hd__fill_1
XFILLER_0_115_447 VGND VGND VPWR VPWR sky130_fd_sc_hd__fill_1
X_4603_ cpu_inst.regfile_inst.registers\[10\]\[20\] _2241_ VGND VGND VPWR VPWR _2250_
+ sky130_fd_sc_hd__and2_1
XFILLER_0_4_133 VGND VGND VPWR VPWR sky130_fd_sc_hd__decap_6
XFILLER_0_25_261 VPWR VGND VPWR VGND sky130_ef_sc_hd__decap_12
XFILLER_0_32_209 VPWR VGND VPWR VGND sky130_ef_sc_hd__decap_12
X_2795_ cpu_inst.regfile_inst.registers\[10\]\[2\] cpu_inst.regfile_inst.registers\[11\]\[2\]
+ _0560_ VGND VGND VPWR VPWR _0760_ sky130_fd_sc_hd__mux2_1
X_4534_ cpu_inst.regfile_inst.registers\[11\]\[18\] VGND VGND VPWR VPWR _2215_ sky130_fd_sc_hd__clkbuf_1
XFILLER_0_4_177 VPWR VGND VPWR VGND sky130_ef_sc_hd__decap_12
XFILLER_0_40_253 VPWR VGND VPWR VGND sky130_ef_sc_hd__decap_12
XFILLER_0_111_653 VPWR VGND VPWR VGND sky130_ef_sc_hd__decap_12
XFILLER_0_110_141 VPWR VGND VPWR VGND sky130_ef_sc_hd__decap_12
X_4465_ _1382_ cpu_inst.regfile_inst.registers\[7\]\[16\] _2174_ VGND VGND VPWR VPWR
+ _2180_ sky130_fd_sc_hd__mux2_1
XFILLER_0_111_697 VPWR VGND VPWR VGND sky130_ef_sc_hd__decap_12
X_3416_ _0864_ _1352_ _1354_ _0876_ VGND VGND VPWR VPWR _1355_ sky130_fd_sc_hd__o22a_1
X_4396_ _2143_ VGND VGND VPWR VPWR _0207_ sky130_fd_sc_hd__clkbuf_1
XFILLER_0_0_361 VGND VGND VPWR VPWR sky130_fd_sc_hd__decap_3
XTAP_TAPCELL_ROW_129_2239 VGND VPWR sky130_fd_sc_hd__tapvpwrvgnd_1
XTAP_TAPCELL_ROW_129_2228 VGND VPWR sky130_fd_sc_hd__tapvpwrvgnd_1
X_3347_ _1301_ VGND VGND VPWR VPWR _0000_ sky130_fd_sc_hd__clkbuf_1
XTAP_TAPCELL_ROW_51_1058 VGND VPWR sky130_fd_sc_hd__tapvpwrvgnd_1
XTAP_TAPCELL_ROW_51_1069 VGND VPWR sky130_fd_sc_hd__tapvpwrvgnd_1
X_5017_ cpu_inst.regfile_inst.registers\[15\]\[26\] _2491_ VGND VGND VPWR VPWR _2498_
+ sky130_fd_sc_hd__and2_1
XFILLER_0_84_83 VGND VGND VPWR VPWR sky130_fd_sc_hd__fill_1
X_3278_ _1242_ cpu_inst.regfile_inst.registers\[10\]\[15\] _0870_ VGND VGND VPWR VPWR
+ _1243_ sky130_fd_sc_hd__mux2_1
XFILLER_0_68_629 VGND VGND VPWR VPWR sky130_fd_sc_hd__decap_6
XFILLER_0_138_517 VPWR VGND VPWR VGND sky130_ef_sc_hd__decap_12
XFILLER_0_82_109 VPWR VGND VPWR VGND sky130_ef_sc_hd__decap_12
XTAP_TAPCELL_ROW_66_1290 VGND VPWR sky130_fd_sc_hd__tapvpwrvgnd_1
XFILLER_0_119_753 VPWR VGND VPWR VGND sky130_ef_sc_hd__decap_12
XFILLER_0_75_161 VGND VGND VPWR VPWR sky130_fd_sc_hd__decap_6
XFILLER_0_64_813 VGND VGND VPWR VPWR sky130_fd_sc_hd__decap_3
XTAP_TAPCELL_ROW_24_657 VGND VPWR sky130_fd_sc_hd__tapvpwrvgnd_1
XFILLER_0_134_701 VPWR VGND VPWR VGND sky130_ef_sc_hd__decap_12
XFILLER_0_119_797 VPWR VGND VPWR VGND sky130_ef_sc_hd__decap_12
XFILLER_0_91_676 VGND VGND VPWR VPWR sky130_fd_sc_hd__decap_6
XFILLER_0_90_153 VPWR VGND VPWR VGND sky130_ef_sc_hd__decap_12
XFILLER_0_121_417 VPWR VGND VPWR VGND sky130_ef_sc_hd__decap_12
XFILLER_0_90_197 VPWR VGND VPWR VGND sky130_ef_sc_hd__decap_12
XFILLER_0_7_3 VPWR VGND VPWR VGND sky130_ef_sc_hd__decap_12
XFILLER_0_99_721 VGND VGND VPWR VPWR sky130_fd_sc_hd__decap_4
XTAP_TAPCELL_ROW_4_360 VGND VPWR sky130_fd_sc_hd__tapvpwrvgnd_1
XFILLER_0_98_253 VPWR VGND VPWR VGND sky130_ef_sc_hd__decap_12
XFILLER_0_129_517 VPWR VGND VPWR VGND sky130_ef_sc_hd__decap_12
XFILLER_0_86_437 VGND VGND VPWR VPWR sky130_fd_sc_hd__fill_2
XFILLER_0_58_139 VGND VGND VPWR VPWR sky130_fd_sc_hd__fill_1
XFILLER_0_104_15 VPWR VGND VPWR VGND sky130_ef_sc_hd__decap_12
XTAP_TAPCELL_ROW_43_944 VGND VPWR sky130_fd_sc_hd__tapvpwrvgnd_1
XFILLER_0_55_824 VPWR VGND VPWR VGND sky130_ef_sc_hd__decap_12
XFILLER_0_54_301 VGND VGND VPWR VPWR sky130_fd_sc_hd__decap_6
XFILLER_0_13_57 VPWR VGND VPWR VGND sky130_ef_sc_hd__decap_12
XFILLER_0_137_561 VPWR VGND VPWR VGND sky130_ef_sc_hd__decap_12
XFILLER_0_124_233 VPWR VGND VPWR VGND sky130_ef_sc_hd__decap_12
XFILLER_0_89_39 VPWR VGND VPWR VGND sky130_ef_sc_hd__decap_12
XFILLER_0_54_389 VGND VGND VPWR VPWR sky130_fd_sc_hd__fill_1
XFILLER_0_14_209 VPWR VGND VPWR VGND sky130_ef_sc_hd__decap_12
XTAP_TAPCELL_ROW_97_1751 VGND VPWR sky130_fd_sc_hd__tapvpwrvgnd_1
XFILLER_0_23_721 VGND VGND VPWR VPWR sky130_fd_sc_hd__decap_6
XFILLER_0_124_277 VPWR VGND VPWR VGND sky130_ef_sc_hd__decap_12
XTAP_TAPCELL_ROW_97_1762 VGND VPWR sky130_fd_sc_hd__tapvpwrvgnd_1
X_2580_ _0543_ _0544_ _0537_ _0538_ VGND VGND VPWR VPWR _0545_ sky130_fd_sc_hd__a211o_2
XFILLER_0_1_125 VPWR VGND VPWR VGND sky130_ef_sc_hd__decap_12
XFILLER_0_2_637 VGND VGND VPWR VPWR sky130_fd_sc_hd__decap_6
XFILLER_0_22_253 VPWR VGND VPWR VGND sky130_ef_sc_hd__decap_12
XFILLER_0_23_765 VPWR VGND VPWR VGND sky130_ef_sc_hd__decap_12
XFILLER_0_1_169 VPWR VGND VPWR VGND sky130_ef_sc_hd__decap_12
X_4250_ _2067_ VGND VGND VPWR VPWR _0137_ sky130_fd_sc_hd__clkbuf_1
X_3201_ _0949_ _1165_ VGND VGND VPWR VPWR _1166_ sky130_fd_sc_hd__xor2_1
X_4181_ cpu_inst.regfile_inst.registers\[4\]\[8\] _2024_ VGND VGND VPWR VPWR _2032_
+ sky130_fd_sc_hd__and2_1
X_3132_ _0988_ VGND VGND VPWR VPWR _1097_ sky130_fd_sc_hd__inv_2
XFILLER_0_38_65 VPWR VGND VPWR VGND sky130_ef_sc_hd__decap_12
X_3063_ _0735_ VGND VGND VPWR VPWR _1028_ sky130_fd_sc_hd__clkbuf_4
XTAP_TAPCELL_ROW_124_2158 VGND VPWR sky130_fd_sc_hd__tapvpwrvgnd_1
XFILLER_0_54_53 VPWR VGND VPWR VGND sky130_ef_sc_hd__decap_12
XFILLER_0_54_97 VPWR VGND VPWR VGND sky130_ef_sc_hd__decap_12
XTAP_TAPCELL_ROW_106_1891 VGND VPWR sky130_fd_sc_hd__tapvpwrvgnd_1
XFILLER_0_9_225 VPWR VGND VPWR VGND sky130_ef_sc_hd__decap_12
XFILLER_0_73_621 VPWR VGND VPWR VGND sky130_ef_sc_hd__decap_12
X_3965_ cpu_inst.regfile_inst.registers\[24\]\[30\] _1889_ _0640_ VGND VGND VPWR VPWR
+ _1890_ sky130_fd_sc_hd__mux2_1
XFILLER_0_70_41 VPWR VGND VPWR VGND sky130_ef_sc_hd__decap_12
XFILLER_0_64_109 VPWR VGND VPWR VGND sky130_ef_sc_hd__decap_12
XFILLER_0_57_161 VGND VGND VPWR VPWR sky130_fd_sc_hd__decap_6
XFILLER_0_46_813 VPWR VGND VPWR VGND sky130_ef_sc_hd__decap_12
XFILLER_0_116_701 VPWR VGND VPWR VGND sky130_ef_sc_hd__decap_12
X_3896_ _1700_ _1822_ _1722_ VGND VGND VPWR VPWR _1823_ sky130_fd_sc_hd__a21bo_1
XFILLER_0_70_85 VPWR VGND VPWR VGND sky130_ef_sc_hd__decap_12
XTAP_TAPCELL_ROW_21_616 VGND VPWR sky130_fd_sc_hd__tapvpwrvgnd_1
X_2916_ cpu_inst.regfile_inst.registers\[5\]\[4\] cpu_inst.regfile_inst.registers\[4\]\[4\]
+ _0865_ VGND VGND VPWR VPWR _0881_ sky130_fd_sc_hd__mux2_1
XFILLER_0_72_153 VPWR VGND VPWR VGND sky130_ef_sc_hd__decap_12
X_2847_ _0613_ _0810_ _0811_ VGND VGND VPWR VPWR _0812_ sky130_fd_sc_hd__or3_4
XFILLER_0_85_3 VPWR VGND VPWR VGND sky130_ef_sc_hd__decap_12
XFILLER_0_72_197 VPWR VGND VPWR VGND sky130_ef_sc_hd__decap_12
XFILLER_0_60_348 VGND VGND VPWR VPWR sky130_fd_sc_hd__fill_2
XFILLER_0_60_326 VGND VGND VPWR VPWR sky130_fd_sc_hd__fill_1
XFILLER_0_26_581 VGND VGND VPWR VPWR sky130_fd_sc_hd__decap_6
XFILLER_0_103_417 VGND VGND VPWR VPWR sky130_fd_sc_hd__decap_4
XFILLER_0_5_497 VGND VGND VPWR VPWR sky130_fd_sc_hd__decap_6
X_5566_ clknet_leaf_30_clk _0486_ VGND VGND VPWR VPWR cpu_inst.display_inst.counter\[6\]
+ sky130_fd_sc_hd__dfxtp_1
X_2778_ cpu_inst.regfile_inst.registers\[11\]\[3\] cpu_inst.regfile_inst.registers\[10\]\[3\]
+ _0620_ VGND VGND VPWR VPWR _0743_ sky130_fd_sc_hd__mux2_1
X_4517_ _2206_ VGND VGND VPWR VPWR _0265_ sky130_fd_sc_hd__clkbuf_1
X_5497_ clknet_leaf_40_clk _0417_ VGND VGND VPWR VPWR cpu_inst.regfile_inst.registers\[8\]\[1\]
+ sky130_fd_sc_hd__dfxtp_1
XFILLER_0_111_461 VPWR VGND VPWR VGND sky130_ef_sc_hd__decap_12
X_4448_ _1183_ cpu_inst.regfile_inst.registers\[7\]\[8\] _2161_ VGND VGND VPWR VPWR
+ _2171_ sky130_fd_sc_hd__mux2_1
XFILLER_0_95_93 VPWR VGND VPWR VGND sky130_ef_sc_hd__decap_12
X_4379_ cpu_inst.regfile_inst.registers\[1\]\[7\] VGND VGND VPWR VPWR _2135_ sky130_fd_sc_hd__clkbuf_1
XTAP_TAPCELL_ROW_29_738 VGND VPWR sky130_fd_sc_hd__tapvpwrvgnd_1
XFILLER_0_96_757 VGND VGND VPWR VPWR sky130_fd_sc_hd__decap_3
XFILLER_0_95_223 VGND VGND VPWR VPWR sky130_fd_sc_hd__fill_1
XFILLER_0_68_448 VPWR VGND VPWR VGND sky130_ef_sc_hd__decap_12
XFILLER_0_36_301 VGND VGND VPWR VPWR sky130_fd_sc_hd__decap_6
XTAP_TAPCELL_ROW_40_903 VGND VPWR sky130_fd_sc_hd__tapvpwrvgnd_1
XFILLER_0_119_561 VPWR VGND VPWR VGND sky130_ef_sc_hd__decap_12
XFILLER_0_36_345 VPWR VGND VPWR VGND sky130_ef_sc_hd__decap_12
XFILLER_0_134_531 VGND VGND VPWR VPWR sky130_fd_sc_hd__fill_1
XFILLER_0_91_462 VGND VGND VPWR VPWR sky130_fd_sc_hd__decap_4
XFILLER_0_64_687 VGND VGND VPWR VPWR sky130_fd_sc_hd__decap_8
XFILLER_0_106_233 VPWR VGND VPWR VGND sky130_ef_sc_hd__decap_12
XFILLER_0_64_698 VGND VGND VPWR VPWR sky130_fd_sc_hd__fill_2
XFILLER_0_36_389 VPWR VGND VPWR VGND sky130_ef_sc_hd__decap_12
XFILLER_0_51_337 VPWR VGND VPWR VGND sky130_ef_sc_hd__decap_12
XFILLER_0_122_737 VPWR VGND VPWR VGND sky130_ef_sc_hd__decap_12
XFILLER_0_121_225 VPWR VGND VPWR VGND sky130_ef_sc_hd__decap_12
XFILLER_0_106_277 VPWR VGND VPWR VGND sky130_ef_sc_hd__decap_12
XTAP_TAPCELL_ROW_79_1492 VGND VPWR sky130_fd_sc_hd__tapvpwrvgnd_1
XTAP_TAPCELL_ROW_79_1481 VGND VPWR sky130_fd_sc_hd__tapvpwrvgnd_1
XFILLER_0_20_713 VPWR VGND VPWR VGND sky130_ef_sc_hd__decap_12
XFILLER_0_130_781 VPWR VGND VPWR VGND sky130_ef_sc_hd__decap_12
XFILLER_0_102_450 VGND VGND VPWR VPWR sky130_fd_sc_hd__fill_1
XTAP_TAPCELL_ROW_9_441 VGND VPWR sky130_fd_sc_hd__tapvpwrvgnd_1
XTAP_TAPCELL_ROW_9_430 VGND VPWR sky130_fd_sc_hd__tapvpwrvgnd_1
XFILLER_0_20_757 VPWR VGND VPWR VGND sky130_ef_sc_hd__decap_12
XTAP_TAPCELL_ROW_92_1681 VGND VPWR sky130_fd_sc_hd__tapvpwrvgnd_1
XFILLER_0_115_69 VPWR VGND VPWR VGND sky130_ef_sc_hd__decap_12
XFILLER_0_86_245 VGND VGND VPWR VPWR sky130_fd_sc_hd__decap_6
XFILLER_0_86_289 VPWR VGND VPWR VGND sky130_ef_sc_hd__decap_12
XFILLER_0_39_161 VGND VGND VPWR VPWR sky130_fd_sc_hd__decap_6
XFILLER_0_46_109 VPWR VGND VPWR VGND sky130_ef_sc_hd__decap_12
X_3750_ _1678_ _1680_ VGND VGND VPWR VPWR _1681_ sky130_fd_sc_hd__nand2_1
XFILLER_0_7_729 VPWR VGND VPWR VGND sky130_ef_sc_hd__decap_12
XFILLER_0_137_391 VGND VGND VPWR VPWR sky130_fd_sc_hd__fill_1
XFILLER_0_131_57 VPWR VGND VPWR VGND sky130_ef_sc_hd__decap_12
X_2701_ _0645_ _0646_ _0664_ VGND VGND VPWR VPWR _0666_ sky130_fd_sc_hd__a21o_1
XFILLER_0_54_153 VPWR VGND VPWR VGND sky130_ef_sc_hd__decap_12
XFILLER_0_125_553 VGND VGND VPWR VPWR sky130_fd_sc_hd__decap_6
X_3681_ cpu_inst.regfile_inst.registers\[7\]\[23\] cpu_inst.regfile_inst.registers\[6\]\[23\]
+ _1540_ VGND VGND VPWR VPWR _1613_ sky130_fd_sc_hd__mux2_1
XFILLER_0_82_495 VGND VGND VPWR VPWR sky130_fd_sc_hd__fill_1
XFILLER_0_54_197 VPWR VGND VPWR VGND sky130_ef_sc_hd__decap_12
XFILLER_0_15_529 VPWR VGND VPWR VGND sky130_ef_sc_hd__decap_12
XFILLER_0_40_77 VGND VGND VPWR VPWR sky130_fd_sc_hd__decap_6
XFILLER_0_125_597 VPWR VGND VPWR VGND sky130_ef_sc_hd__decap_12
X_5420_ clknet_leaf_0_clk _0340_ net2 VGND VGND VPWR VPWR cpu_inst.decoder_inst.current_pc\[20\]
+ sky130_fd_sc_hd__dfrtp_1
XFILLER_0_2_401 VPWR VGND VPWR VGND sky130_ef_sc_hd__decap_12
X_2632_ cpu_inst.regfile_inst.registers\[2\]\[0\] _0596_ _0584_ VGND VGND VPWR VPWR
+ _0597_ sky130_fd_sc_hd__mux2_2
X_5351_ clknet_leaf_27_clk _0271_ VGND VGND VPWR VPWR cpu_inst.regfile_inst.registers\[11\]\[15\]
+ sky130_fd_sc_hd__dfxtp_1
X_2563_ _0524_ _0527_ VGND VGND VPWR VPWR _0528_ sky130_fd_sc_hd__nand2_2
XFILLER_0_2_445 VPWR VGND VPWR VGND sky130_ef_sc_hd__decap_12
XFILLER_0_23_573 VPWR VGND VPWR VGND sky130_ef_sc_hd__decap_12
XFILLER_0_2_489 VPWR VGND VPWR VGND sky130_ef_sc_hd__decap_12
X_5282_ clknet_leaf_32_clk _0202_ VGND VGND VPWR VPWR cpu_inst.regfile_inst.registers\[1\]\[10\]
+ sky130_fd_sc_hd__dfxtp_1
X_4302_ _1110_ cpu_inst.regfile_inst.registers\[5\]\[2\] _2092_ VGND VGND VPWR VPWR
+ _2095_ sky130_fd_sc_hd__mux2_1
X_4233_ cpu_inst.regfile_inst.registers\[24\]\[1\] VGND VGND VPWR VPWR _2059_ sky130_fd_sc_hd__clkbuf_1
XFILLER_0_10_245 VGND VGND VPWR VPWR sky130_fd_sc_hd__decap_6
XFILLER_0_10_289 VPWR VGND VPWR VGND sky130_ef_sc_hd__decap_12
X_4164_ _0511_ _2022_ VGND VGND VPWR VPWR _2023_ sky130_fd_sc_hd__or2_4
X_3115_ _1079_ _0910_ _1057_ VGND VGND VPWR VPWR _1080_ sky130_fd_sc_hd__mux2_1
X_4095_ _1984_ VGND VGND VPWR VPWR _0065_ sky130_fd_sc_hd__clkbuf_1
XFILLER_0_4_77 VGND VGND VPWR VPWR sky130_fd_sc_hd__decap_6
XTAP_TAPCELL_ROW_108_1920 VGND VPWR sky130_fd_sc_hd__tapvpwrvgnd_1
X_3046_ _1010_ cpu_inst.regfile_inst.registers\[10\]\[10\] _0883_ VGND VGND VPWR VPWR
+ _1011_ sky130_fd_sc_hd__mux2_1
XFILLER_0_78_735 VGND VGND VPWR VPWR sky130_fd_sc_hd__fill_2
XFILLER_0_77_223 VGND VGND VPWR VPWR sky130_fd_sc_hd__fill_1
XFILLER_0_81_51 VGND VGND VPWR VPWR sky130_fd_sc_hd__decap_4
XFILLER_0_78_757 VGND VGND VPWR VPWR sky130_fd_sc_hd__fill_2
XFILLER_0_93_727 VGND VGND VPWR VPWR sky130_fd_sc_hd__fill_1
XFILLER_0_18_301 VGND VGND VPWR VPWR sky130_fd_sc_hd__decap_6
XFILLER_0_135_317 VPWR VGND VPWR VGND sky130_ef_sc_hd__decap_12
X_4997_ _2487_ VGND VGND VPWR VPWR _0464_ sky130_fd_sc_hd__clkbuf_1
XTAP_TAPCELL_ROW_137_2349 VGND VPWR sky130_fd_sc_hd__tapvpwrvgnd_1
XFILLER_0_116_531 VGND VGND VPWR VPWR sky130_fd_sc_hd__fill_1
X_3948_ _1872_ cpu_inst.regfile_inst.registers\[10\]\[30\] _1313_ VGND VGND VPWR VPWR
+ _1873_ sky130_fd_sc_hd__mux2_1
XFILLER_0_18_345 VPWR VGND VPWR VGND sky130_ef_sc_hd__decap_12
XFILLER_0_46_687 VGND VGND VPWR VPWR sky130_fd_sc_hd__fill_2
X_3879_ cpu_inst.regfile_inst.registers\[2\]\[28\] _1804_ _1805_ cpu_inst.regfile_inst.registers\[7\]\[28\]
+ VGND VGND VPWR VPWR _1806_ sky130_fd_sc_hd__o22a_1
XFILLER_0_18_389 VPWR VGND VPWR VGND sky130_ef_sc_hd__decap_12
XFILLER_0_33_337 VPWR VGND VPWR VGND sky130_ef_sc_hd__decap_12
XFILLER_0_104_737 VPWR VGND VPWR VGND sky130_ef_sc_hd__decap_12
XFILLER_0_5_261 VPWR VGND VPWR VGND sky130_ef_sc_hd__decap_12
XFILLER_0_103_225 VPWR VGND VPWR VGND sky130_ef_sc_hd__decap_12
X_5549_ clknet_leaf_16_clk _0469_ VGND VGND VPWR VPWR cpu_inst.regfile_inst.registers\[15\]\[21\]
+ sky130_fd_sc_hd__dfxtp_1
XFILLER_0_60_189 VGND VGND VPWR VPWR sky130_fd_sc_hd__decap_6
XFILLER_0_112_781 VPWR VGND VPWR VGND sky130_ef_sc_hd__decap_12
XFILLER_0_68_245 VGND VGND VPWR VPWR sky130_fd_sc_hd__decap_6
XFILLER_0_68_289 VPWR VGND VPWR VGND sky130_ef_sc_hd__decap_12
XFILLER_0_28_109 VPWR VGND VPWR VGND sky130_ef_sc_hd__decap_12
XFILLER_0_83_237 VPWR VGND VPWR VGND sky130_ef_sc_hd__decap_12
XFILLER_0_49_481 VGND VGND VPWR VPWR sky130_fd_sc_hd__decap_6
XFILLER_0_36_153 VPWR VGND VPWR VGND sky130_ef_sc_hd__decap_12
XFILLER_0_119_391 VGND VGND VPWR VPWR sky130_fd_sc_hd__fill_1
XFILLER_0_91_281 VPWR VGND VPWR VGND sky130_ef_sc_hd__decap_12
XFILLER_0_52_613 VGND VGND VPWR VPWR sky130_fd_sc_hd__fill_2
XTAP_TAPCELL_ROW_12_479 VGND VPWR sky130_fd_sc_hd__tapvpwrvgnd_1
XFILLER_0_122_501 VPWR VGND VPWR VGND sky130_ef_sc_hd__decap_12
XFILLER_0_101_27 VPWR VGND VPWR VGND sky130_ef_sc_hd__decap_12
XFILLER_0_36_197 VPWR VGND VPWR VGND sky130_ef_sc_hd__decap_12
XFILLER_0_122_545 VPWR VGND VPWR VGND sky130_ef_sc_hd__decap_12
XTAP_TAPCELL_ROW_94_1710 VGND VPWR sky130_fd_sc_hd__tapvpwrvgnd_1
XFILLER_0_51_167 VGND VGND VPWR VPWR sky130_fd_sc_hd__fill_1
XFILLER_0_122_589 VPWR VGND VPWR VGND sky130_ef_sc_hd__decap_12
XFILLER_0_86_29 VPWR VGND VPWR VGND sky130_ef_sc_hd__decap_12
XFILLER_0_20_587 VGND VGND VPWR VPWR sky130_fd_sc_hd__fill_1
XTAP_TAPCELL_ROW_121_2117 VGND VPWR sky130_fd_sc_hd__tapvpwrvgnd_1
XFILLER_0_35_55 VGND VGND VPWR VPWR sky130_fd_sc_hd__fill_1
X_4920_ _1192_ cpu_inst.regfile_inst.registers\[8\]\[12\] _2432_ VGND VGND VPWR VPWR
+ _2447_ sky130_fd_sc_hd__mux2_1
XFILLER_0_59_223 VGND VGND VPWR VPWR sky130_fd_sc_hd__fill_1
XFILLER_0_129_111 VGND VGND VPWR VPWR sky130_fd_sc_hd__fill_1
XFILLER_0_75_727 VGND VGND VPWR VPWR sky130_fd_sc_hd__fill_1
XFILLER_0_75_716 VGND VGND VPWR VPWR sky130_fd_sc_hd__decap_8
X_4851_ _2410_ VGND VGND VPWR VPWR _0395_ sky130_fd_sc_hd__clkbuf_1
XFILLER_0_47_429 VPWR VGND VPWR VGND sky130_ef_sc_hd__decap_12
XFILLER_0_117_317 VPWR VGND VPWR VGND sky130_ef_sc_hd__decap_12
XTAP_TAPCELL_ROW_103_1850 VGND VPWR sky130_fd_sc_hd__tapvpwrvgnd_1
X_3802_ _1729_ _1730_ _1312_ VGND VGND VPWR VPWR _1731_ sky130_fd_sc_hd__mux2_1
XFILLER_0_83_760 VGND VGND VPWR VPWR sky130_fd_sc_hd__fill_1
XFILLER_0_16_805 VGND VGND VPWR VPWR sky130_fd_sc_hd__decap_6
X_4782_ cpu_inst.regfile_inst.registers\[0\]\[9\] VGND VGND VPWR VPWR _2376_ sky130_fd_sc_hd__clkbuf_1
XFILLER_0_132_309 VPWR VGND VPWR VGND sky130_ef_sc_hd__decap_12
X_3733_ cpu_inst.regfile_inst.registers\[11\]\[24\] cpu_inst.regfile_inst.registers\[10\]\[24\]
+ _1592_ VGND VGND VPWR VPWR _1664_ sky130_fd_sc_hd__mux2_1
XFILLER_0_70_421 VPWR VGND VPWR VGND sky130_ef_sc_hd__decap_12
XFILLER_0_55_484 VPWR VGND VPWR VGND sky130_ef_sc_hd__decap_12
XFILLER_0_7_559 VGND VGND VPWR VPWR sky130_fd_sc_hd__fill_1
XTAP_TAPCELL_ROW_31_766 VGND VPWR sky130_fd_sc_hd__tapvpwrvgnd_1
XFILLER_0_125_361 VPWR VGND VPWR VGND sky130_ef_sc_hd__decap_12
XTAP_TAPCELL_ROW_119_2079 VGND VPWR sky130_fd_sc_hd__tapvpwrvgnd_1
X_3664_ _1028_ _1588_ _1591_ _1596_ VGND VGND VPWR VPWR _1597_ sky130_fd_sc_hd__o211a_1
XFILLER_0_3_721 VGND VGND VPWR VPWR sky130_fd_sc_hd__decap_6
XFILLER_0_15_337 VPWR VGND VPWR VGND sky130_ef_sc_hd__decap_12
XFILLER_0_43_668 VGND VGND VPWR VPWR sky130_fd_sc_hd__fill_1
Xclkload41 clknet_leaf_23_clk VGND VGND VPWR VPWR clkload41/Y sky130_fd_sc_hd__inv_6
X_2615_ _0537_ _0538_ _0549_ VGND VGND VPWR VPWR _0580_ sky130_fd_sc_hd__or3_4
Xclkload30 clknet_leaf_36_clk VGND VGND VPWR VPWR clkload30/Y sky130_fd_sc_hd__inv_12
X_5403_ clknet_leaf_42_clk _0323_ net2 VGND VGND VPWR VPWR cpu_inst.decoder_inst.current_pc\[3\]
+ sky130_fd_sc_hd__dfrtp_1
XFILLER_0_30_307 VGND VGND VPWR VPWR sky130_fd_sc_hd__fill_1
XFILLER_0_42_189 VGND VGND VPWR VPWR sky130_fd_sc_hd__decap_6
XTAP_TAPCELL_ROW_132_2279 VGND VPWR sky130_fd_sc_hd__tapvpwrvgnd_1
X_3595_ _1393_ _1406_ _1411_ VGND VGND VPWR VPWR _1530_ sky130_fd_sc_hd__o21a_1
XFILLER_0_3_765 VPWR VGND VPWR VGND sky130_ef_sc_hd__decap_12
XFILLER_0_2_253 VPWR VGND VPWR VGND sky130_ef_sc_hd__decap_12
X_5334_ clknet_leaf_4_clk _0254_ VGND VGND VPWR VPWR cpu_inst.regfile_inst.registers\[7\]\[30\]
+ sky130_fd_sc_hd__dfxtp_1
X_2546_ cpu_inst.decoder_inst.current_pc\[7\] cpu_inst.decoder_inst.current_pc\[6\]
+ cpu_inst.decoder_inst.current_pc\[5\] cpu_inst.decoder_inst.current_pc\[4\] VGND
+ VGND VPWR VPWR _0511_ sky130_fd_sc_hd__or4bb_4
X_5265_ clknet_leaf_14_clk _0185_ VGND VGND VPWR VPWR cpu_inst.regfile_inst.registers\[5\]\[25\]
+ sky130_fd_sc_hd__dfxtp_1
X_4216_ _2050_ VGND VGND VPWR VPWR _0120_ sky130_fd_sc_hd__clkbuf_1
X_5196_ clknet_leaf_20_clk _0116_ VGND VGND VPWR VPWR cpu_inst.regfile_inst.registers\[4\]\[20\]
+ sky130_fd_sc_hd__dfxtp_1
XFILLER_0_48_3 VPWR VGND VPWR VGND sky130_ef_sc_hd__decap_12
X_4147_ _2013_ VGND VGND VPWR VPWR _0088_ sky130_fd_sc_hd__clkbuf_1
X_4078_ cpu_inst.regfile_inst.registers\[2\]\[26\] VGND VGND VPWR VPWR _1975_ sky130_fd_sc_hd__clkbuf_1
XFILLER_0_97_329 VGND VGND VPWR VPWR sky130_fd_sc_hd__decap_6
XFILLER_0_78_510 VPWR VGND VPWR VGND sky130_ef_sc_hd__decap_12
XTAP_TAPCELL_ROW_48_1019 VGND VPWR sky130_fd_sc_hd__tapvpwrvgnd_1
XFILLER_0_92_83 VGND VGND VPWR VPWR sky130_fd_sc_hd__fill_1
X_3029_ _0993_ _0992_ VGND VGND VPWR VPWR _0994_ sky130_fd_sc_hd__xnor2_2
XTAP_TAPCELL_ROW_39_888 VGND VPWR sky130_fd_sc_hd__tapvpwrvgnd_1
XTAP_TAPCELL_ROW_19_590 VGND VPWR sky130_fd_sc_hd__tapvpwrvgnd_1
XFILLER_0_65_237 VPWR VGND VPWR VGND sky130_ef_sc_hd__decap_12
XTAP_TAPCELL_ROW_61_1219 VGND VPWR sky130_fd_sc_hd__tapvpwrvgnd_1
XTAP_TAPCELL_ROW_61_1208 VGND VPWR sky130_fd_sc_hd__tapvpwrvgnd_1
XFILLER_0_136_637 VGND VGND VPWR VPWR sky130_fd_sc_hd__decap_6
XFILLER_0_135_125 VPWR VGND VPWR VGND sky130_ef_sc_hd__decap_12
XFILLER_0_18_153 VPWR VGND VPWR VGND sky130_ef_sc_hd__decap_12
XFILLER_0_19_665 VGND VGND VPWR VPWR sky130_fd_sc_hd__decap_6
XFILLER_0_46_440 VGND VGND VPWR VPWR sky130_fd_sc_hd__decap_6
XFILLER_0_135_169 VPWR VGND VPWR VGND sky130_ef_sc_hd__decap_12
Xclkload2 clknet_2_3__leaf_clk VGND VGND VPWR VPWR clkload2/X sky130_fd_sc_hd__clkbuf_8
XFILLER_0_73_281 VPWR VGND VPWR VGND sky130_ef_sc_hd__decap_12
XFILLER_0_6_581 VGND VGND VPWR VPWR sky130_fd_sc_hd__decap_6
XFILLER_0_18_197 VPWR VGND VPWR VGND sky130_ef_sc_hd__decap_12
XFILLER_0_61_476 VGND VGND VPWR VPWR sky130_fd_sc_hd__fill_1
XFILLER_0_21_329 VGND VGND VPWR VPWR sky130_fd_sc_hd__decap_6
XFILLER_0_33_167 VGND VGND VPWR VPWR sky130_fd_sc_hd__fill_1
XTAP_TAPCELL_ROW_76_1440 VGND VPWR sky130_fd_sc_hd__tapvpwrvgnd_1
XFILLER_0_100_784 VPWR VGND VPWR VGND sky130_ef_sc_hd__decap_12
XFILLER_0_88_307 VGND VGND VPWR VPWR sky130_fd_sc_hd__fill_1
XFILLER_0_97_841 VGND VGND VPWR VPWR sky130_fd_sc_hd__fill_1
XFILLER_0_57_705 VGND VGND VPWR VPWR sky130_fd_sc_hd__fill_2
XTAP_TAPCELL_ROW_17_549 VGND VPWR sky130_fd_sc_hd__tapvpwrvgnd_1
XFILLER_0_29_429 VPWR VGND VPWR VGND sky130_ef_sc_hd__decap_12
XFILLER_0_127_615 VGND VGND VPWR VPWR sky130_fd_sc_hd__fill_1
XFILLER_0_96_395 VGND VGND VPWR VPWR sky130_fd_sc_hd__fill_1
XFILLER_0_112_15 VPWR VGND VPWR VGND sky130_ef_sc_hd__decap_12
XFILLER_0_52_421 VGND VGND VPWR VPWR sky130_fd_sc_hd__decap_4
XFILLER_0_37_462 VGND VGND VPWR VPWR sky130_fd_sc_hd__fill_1
XFILLER_0_123_821 VPWR VGND VPWR VGND sky130_ef_sc_hd__decap_12
XFILLER_0_114_309 VPWR VGND VPWR VGND sky130_ef_sc_hd__decap_12
XFILLER_0_107_361 VPWR VGND VPWR VGND sky130_ef_sc_hd__decap_12
XFILLER_0_21_57 VPWR VGND VPWR VGND sky130_ef_sc_hd__decap_12
XFILLER_0_25_668 VGND VGND VPWR VPWR sky130_fd_sc_hd__decap_4
XFILLER_0_52_465 VGND VGND VPWR VPWR sky130_fd_sc_hd__decap_8
XFILLER_0_12_307 VGND VGND VPWR VPWR sky130_fd_sc_hd__fill_1
XFILLER_0_97_39 VPWR VGND VPWR VGND sky130_ef_sc_hd__decap_12
XFILLER_0_0_713 VPWR VGND VPWR VGND sky130_ef_sc_hd__decap_12
XFILLER_0_21_841 VGND VGND VPWR VPWR sky130_fd_sc_hd__fill_1
XFILLER_0_24_189 VGND VGND VPWR VPWR sky130_fd_sc_hd__decap_6
X_3380_ net39 _1326_ _1327_ _1328_ _1329_ VGND VGND VPWR VPWR _1330_ sky130_fd_sc_hd__a311o_1
XFILLER_0_0_757 VPWR VGND VPWR VGND sky130_ef_sc_hd__decap_12
X_5050_ _2515_ _2516_ VGND VGND VPWR VPWR _0488_ sky130_fd_sc_hd__nor2_1
X_4001_ _1176_ _1924_ VGND VGND VPWR VPWR _1925_ sky130_fd_sc_hd__or2_1
XFILLER_0_46_65 VPWR VGND VPWR VGND sky130_ef_sc_hd__decap_12
XFILLER_0_79_329 VGND VGND VPWR VPWR sky130_fd_sc_hd__decap_6
XFILLER_0_88_841 VGND VGND VPWR VPWR sky130_fd_sc_hd__fill_1
XTAP_TAPCELL_ROW_36_836 VGND VPWR sky130_fd_sc_hd__tapvpwrvgnd_1
XFILLER_0_87_373 VPWR VGND VPWR VGND sky130_ef_sc_hd__decap_12
XFILLER_0_75_502 VGND VGND VPWR VPWR sky130_fd_sc_hd__fill_2
XFILLER_0_62_53 VPWR VGND VPWR VGND sky130_ef_sc_hd__decap_12
XTAP_TAPCELL_ROW_36_847 VGND VPWR sky130_fd_sc_hd__tapvpwrvgnd_1
X_4903_ _2438_ VGND VGND VPWR VPWR _0419_ sky130_fd_sc_hd__clkbuf_1
XTAP_TAPCELL_ROW_101_1809 VGND VPWR sky130_fd_sc_hd__tapvpwrvgnd_1
XPHY_EDGE_ROW_80_Left_219 VGND VGND VPWR VPWR sky130_fd_sc_hd__decap_3
XFILLER_0_62_97 VPWR VGND VPWR VGND sky130_ef_sc_hd__decap_12
XFILLER_0_8_813 VPWR VGND VPWR VGND sky130_ef_sc_hd__decap_12
XFILLER_0_47_237 VPWR VGND VPWR VGND sky130_ef_sc_hd__decap_12
XFILLER_0_118_637 VGND VGND VPWR VPWR sky130_fd_sc_hd__decap_6
XFILLER_0_117_125 VPWR VGND VPWR VGND sky130_ef_sc_hd__decap_12
X_4834_ cpu_inst.regfile_inst.registers\[9\]\[3\] VGND VGND VPWR VPWR _2402_ sky130_fd_sc_hd__clkbuf_1
XFILLER_0_90_527 VGND VGND VPWR VPWR sky130_fd_sc_hd__decap_4
XFILLER_0_16_613 VPWR VGND VPWR VGND sky130_ef_sc_hd__decap_12
X_4765_ _2367_ VGND VGND VPWR VPWR _0352_ sky130_fd_sc_hd__clkbuf_1
XTAP_TAPCELL_ROW_134_2308 VGND VPWR sky130_fd_sc_hd__tapvpwrvgnd_1
XFILLER_0_133_629 VPWR VGND VPWR VGND sky130_ef_sc_hd__decap_12
XFILLER_0_126_681 VPWR VGND VPWR VGND sky130_ef_sc_hd__decap_12
XFILLER_0_117_169 VPWR VGND VPWR VGND sky130_ef_sc_hd__decap_12
X_3716_ _1526_ _1570_ _1646_ VGND VGND VPWR VPWR _1647_ sky130_fd_sc_hd__or3b_1
XFILLER_0_71_763 VGND VGND VPWR VPWR sky130_fd_sc_hd__fill_1
XFILLER_0_55_281 VPWR VGND VPWR VGND sky130_ef_sc_hd__decap_12
XFILLER_0_16_657 VPWR VGND VPWR VGND sky130_ef_sc_hd__decap_12
XFILLER_0_132_139 VGND VGND VPWR VPWR sky130_fd_sc_hd__fill_1
XFILLER_0_71_785 VGND VGND VPWR VPWR sky130_fd_sc_hd__decap_8
XFILLER_0_70_251 VGND VGND VPWR VPWR sky130_fd_sc_hd__fill_1
X_4696_ cpu_inst.decoder_inst.current_pc\[12\] _2315_ VGND VGND VPWR VPWR _2319_ sky130_fd_sc_hd__xor2_1
XFILLER_0_15_167 VGND VGND VPWR VPWR sky130_fd_sc_hd__fill_1
X_3647_ _1578_ _1579_ _1312_ VGND VGND VPWR VPWR _1580_ sky130_fd_sc_hd__mux2_1
XFILLER_0_12_841 VGND VGND VPWR VPWR sky130_fd_sc_hd__fill_1
XFILLER_0_3_573 VPWR VGND VPWR VGND sky130_ef_sc_hd__decap_12
XFILLER_0_101_548 VGND VGND VPWR VPWR sky130_fd_sc_hd__fill_1
X_3578_ _0850_ _1511_ _1512_ VGND VGND VPWR VPWR _1513_ sky130_fd_sc_hd__or3_1
XTAP_TAPCELL_ROW_58_1170 VGND VPWR sky130_fd_sc_hd__tapvpwrvgnd_1
X_5317_ clknet_leaf_22_clk _0237_ VGND VGND VPWR VPWR cpu_inst.regfile_inst.registers\[7\]\[13\]
+ sky130_fd_sc_hd__dfxtp_1
XFILLER_0_11_373 VPWR VGND VPWR VGND sky130_ef_sc_hd__decap_12
XTAP_TAPCELL_ROW_71_1370 VGND VPWR sky130_fd_sc_hd__tapvpwrvgnd_1
X_5248_ clknet_leaf_33_clk _0168_ VGND VGND VPWR VPWR cpu_inst.regfile_inst.registers\[5\]\[8\]
+ sky130_fd_sc_hd__dfxtp_1
X_5179_ clknet_leaf_39_clk _0099_ VGND VGND VPWR VPWR cpu_inst.regfile_inst.registers\[4\]\[3\]
+ sky130_fd_sc_hd__dfxtp_1
XFILLER_0_97_137 VPWR VGND VPWR VGND sky130_ef_sc_hd__decap_12
XFILLER_0_79_841 VGND VGND VPWR VPWR sky130_fd_sc_hd__fill_1
XPHY_EDGE_ROW_119_Left_258 VGND VGND VPWR VPWR sky130_fd_sc_hd__decap_3
XFILLER_0_94_811 VGND VGND VPWR VPWR sky130_fd_sc_hd__fill_1
XFILLER_0_66_502 VGND VGND VPWR VPWR sky130_fd_sc_hd__fill_1
XFILLER_0_109_615 VGND VGND VPWR VPWR sky130_fd_sc_hd__fill_1
XFILLER_0_78_395 VGND VGND VPWR VPWR sky130_fd_sc_hd__fill_2
XTAP_TAPCELL_ROW_14_508 VGND VPWR sky130_fd_sc_hd__tapvpwrvgnd_1
XFILLER_0_39_738 VGND VGND VPWR VPWR sky130_fd_sc_hd__decap_6
XFILLER_0_136_401 VPWR VGND VPWR VGND sky130_ef_sc_hd__decap_12
XFILLER_0_81_505 VGND VGND VPWR VPWR sky130_fd_sc_hd__fill_2
XFILLER_0_136_445 VPWR VGND VPWR VGND sky130_ef_sc_hd__decap_12
XFILLER_0_19_473 VPWR VGND VPWR VGND sky130_ef_sc_hd__decap_12
XFILLER_0_47_782 VGND VGND VPWR VPWR sky130_fd_sc_hd__fill_2
XFILLER_0_136_489 VPWR VGND VPWR VGND sky130_ef_sc_hd__decap_12
XFILLER_0_105_821 VPWR VGND VPWR VGND sky130_ef_sc_hd__decap_12
XFILLER_0_34_421 VPWR VGND VPWR VGND sky130_ef_sc_hd__decap_12
XFILLER_0_34_454 VGND VGND VPWR VPWR sky130_fd_sc_hd__decap_8
XPHY_EDGE_ROW_128_Left_267 VGND VGND VPWR VPWR sky130_fd_sc_hd__decap_3
XFILLER_0_120_813 VPWR VGND VPWR VGND sky130_ef_sc_hd__decap_12
XFILLER_0_61_273 VGND VGND VPWR VPWR sky130_fd_sc_hd__decap_6
XFILLER_0_21_137 VPWR VGND VPWR VGND sky130_ef_sc_hd__decap_12
XFILLER_0_131_161 VGND VGND VPWR VPWR sky130_fd_sc_hd__decap_6
XFILLER_0_107_15 VPWR VGND VPWR VGND sky130_ef_sc_hd__decap_12
XTAP_TAPCELL_ROW_89_1631 VGND VPWR sky130_fd_sc_hd__tapvpwrvgnd_1
XTAP_TAPCELL_ROW_89_1642 VGND VPWR sky130_fd_sc_hd__tapvpwrvgnd_1
XPHY_EDGE_ROW_137_Left_276 VGND VGND VPWR VPWR sky130_fd_sc_hd__decap_3
XFILLER_0_97_671 VGND VGND VPWR VPWR sky130_fd_sc_hd__fill_1
XFILLER_0_84_321 VPWR VGND VPWR VGND sky130_ef_sc_hd__decap_12
XFILLER_0_8_109 VPWR VGND VPWR VGND sky130_ef_sc_hd__decap_12
XFILLER_0_29_237 VPWR VGND VPWR VGND sky130_ef_sc_hd__decap_12
XFILLER_0_123_69 VPWR VGND VPWR VGND sky130_ef_sc_hd__decap_12
XFILLER_0_84_365 VGND VGND VPWR VPWR sky130_fd_sc_hd__decap_8
X_2880_ cpu_inst.regfile_inst.registers\[11\]\[12\] cpu_inst.regfile_inst.registers\[10\]\[12\]
+ _0731_ VGND VGND VPWR VPWR _0845_ sky130_fd_sc_hd__mux2_1
XFILLER_0_115_629 VPWR VGND VPWR VGND sky130_ef_sc_hd__decap_12
XFILLER_0_37_281 VPWR VGND VPWR VGND sky130_ef_sc_hd__decap_12
XTAP_TAPCELL_ROW_116_2038 VGND VPWR sky130_fd_sc_hd__tapvpwrvgnd_1
XFILLER_0_114_139 VGND VGND VPWR VPWR sky130_fd_sc_hd__fill_1
XFILLER_0_108_681 VPWR VGND VPWR VGND sky130_ef_sc_hd__decap_12
XFILLER_0_106_3 VPWR VGND VPWR VGND sky130_ef_sc_hd__decap_12
X_4550_ cpu_inst.regfile_inst.registers\[11\]\[26\] VGND VGND VPWR VPWR _2223_ sky130_fd_sc_hd__clkbuf_1
XFILLER_0_53_785 VGND VGND VPWR VPWR sky130_fd_sc_hd__decap_4
XFILLER_0_52_251 VGND VGND VPWR VPWR sky130_fd_sc_hd__fill_1
XFILLER_0_123_673 VPWR VGND VPWR VGND sky130_ef_sc_hd__decap_12
X_4481_ _2188_ VGND VGND VPWR VPWR _0247_ sky130_fd_sc_hd__clkbuf_1
X_3501_ _0844_ _1433_ _1434_ _1437_ VGND VGND VPWR VPWR _1438_ sky130_fd_sc_hd__o22a_1
XFILLER_0_40_413 VGND VGND VPWR VPWR sky130_fd_sc_hd__decap_4
XFILLER_0_110_301 VGND VGND VPWR VPWR sky130_fd_sc_hd__decap_6
X_3432_ _1022_ _1369_ _1359_ _1295_ VGND VGND VPWR VPWR _1371_ sky130_fd_sc_hd__a211oi_1
XFILLER_0_110_345 VPWR VGND VPWR VGND sky130_ef_sc_hd__decap_12
X_3363_ _1312_ VGND VGND VPWR VPWR _1313_ sky130_fd_sc_hd__clkbuf_4
XFILLER_0_21_671 VGND VGND VPWR VPWR sky130_fd_sc_hd__fill_1
XFILLER_0_110_389 VPWR VGND VPWR VGND sky130_ef_sc_hd__decap_12
X_5102_ clknet_leaf_14_clk _0022_ VGND VGND VPWR VPWR cpu_inst.regfile_inst.registers\[6\]\[22\]
+ sky130_fd_sc_hd__dfxtp_1
XTAP_TAPCELL_ROW_111_1971 VGND VPWR sky130_fd_sc_hd__tapvpwrvgnd_1
XTAP_TAPCELL_ROW_111_1960 VGND VPWR sky130_fd_sc_hd__tapvpwrvgnd_1
X_3294_ _1208_ _1222_ _1258_ VGND VGND VPWR VPWR _1259_ sky130_fd_sc_hd__a21o_1
X_5033_ cpu_inst.display_inst.counter\[1\] cpu_inst.display_inst.counter\[0\] cpu_inst.display_inst.counter\[2\]
+ VGND VGND VPWR VPWR _2506_ sky130_fd_sc_hd__a21oi_1
XFILLER_0_79_137 VPWR VGND VPWR VGND sky130_ef_sc_hd__decap_12
XFILLER_0_87_181 VPWR VGND VPWR VGND sky130_ef_sc_hd__decap_12
XFILLER_0_118_401 VPWR VGND VPWR VGND sky130_ef_sc_hd__decap_12
XFILLER_0_63_505 VPWR VGND VPWR VGND sky130_ef_sc_hd__decap_12
XFILLER_0_118_445 VPWR VGND VPWR VGND sky130_ef_sc_hd__decap_12
X_4817_ _2393_ VGND VGND VPWR VPWR _0378_ sky130_fd_sc_hd__clkbuf_1
XFILLER_0_8_643 VGND VGND VPWR VPWR sky130_fd_sc_hd__fill_1
XFILLER_0_118_489 VPWR VGND VPWR VGND sky130_ef_sc_hd__decap_12
XFILLER_0_90_357 VGND VGND VPWR VPWR sky130_fd_sc_hd__decap_6
XFILLER_0_16_421 VPWR VGND VPWR VGND sky130_ef_sc_hd__decap_12
X_4748_ _2355_ _2356_ VGND VGND VPWR VPWR _2357_ sky130_fd_sc_hd__or2_1
XFILLER_0_120_109 VPWR VGND VPWR VGND sky130_ef_sc_hd__decap_12
XFILLER_0_102_813 VPWR VGND VPWR VGND sky130_ef_sc_hd__decap_12
XFILLER_0_102_802 VGND VGND VPWR VPWR sky130_fd_sc_hd__decap_8
X_4679_ _2306_ VGND VGND VPWR VPWR _0327_ sky130_fd_sc_hd__clkbuf_1
XFILLER_0_43_273 VGND VGND VPWR VPWR sky130_fd_sc_hd__decap_6
XFILLER_0_44_796 VPWR VGND VPWR VGND sky130_ef_sc_hd__decap_12
XFILLER_0_113_161 VGND VGND VPWR VPWR sky130_fd_sc_hd__decap_6
XPHY_EDGE_ROW_1_Right_1 VGND VGND VPWR VPWR sky130_fd_sc_hd__decap_3
XFILLER_0_12_693 VGND VGND VPWR VPWR sky130_fd_sc_hd__decap_6
XFILLER_0_11_181 VPWR VGND VPWR VGND sky130_ef_sc_hd__decap_12
XFILLER_0_98_413 VGND VGND VPWR VPWR sky130_fd_sc_hd__decap_6
XFILLER_0_98_435 VGND VGND VPWR VPWR sky130_fd_sc_hd__fill_1
XFILLER_0_128_209 VPWR VGND VPWR VGND sky130_ef_sc_hd__decap_12
XTAP_TAPCELL_ROW_84_1561 VGND VPWR sky130_fd_sc_hd__tapvpwrvgnd_1
XFILLER_0_67_833 VGND VGND VPWR VPWR sky130_fd_sc_hd__decap_4
XFILLER_0_39_535 VPWR VGND VPWR VGND sky130_ef_sc_hd__decap_12
XFILLER_0_137_721 VGND VGND VPWR VPWR sky130_fd_sc_hd__decap_6
XTAP_TAPCELL_ROW_27_699 VGND VPWR sky130_fd_sc_hd__tapvpwrvgnd_1
XFILLER_0_137_765 VPWR VGND VPWR VGND sky130_ef_sc_hd__decap_12
XFILLER_0_66_398 VGND VGND VPWR VPWR sky130_fd_sc_hd__fill_1
XFILLER_0_136_253 VPWR VGND VPWR VGND sky130_ef_sc_hd__decap_12
XFILLER_0_81_335 VGND VGND VPWR VPWR sky130_fd_sc_hd__fill_1
XFILLER_0_19_281 VPWR VGND VPWR VGND sky130_ef_sc_hd__decap_12
XFILLER_0_34_251 VGND VGND VPWR VPWR sky130_fd_sc_hd__fill_1
XFILLER_0_35_785 VGND VGND VPWR VPWR sky130_fd_sc_hd__decap_4
XFILLER_0_62_582 VGND VGND VPWR VPWR sky130_fd_sc_hd__decap_6
XFILLER_0_22_413 VGND VGND VPWR VPWR sky130_fd_sc_hd__decap_6
XFILLER_0_1_329 VGND VGND VPWR VPWR sky130_fd_sc_hd__decap_6
XFILLER_0_22_457 VPWR VGND VPWR VGND sky130_ef_sc_hd__decap_12
XFILLER_0_120_643 VGND VGND VPWR VPWR sky130_fd_sc_hd__fill_1
XFILLER_0_94_29 VPWR VGND VPWR VGND sky130_ef_sc_hd__decap_12
X_3981_ cpu_inst.regfile_inst.registers\[9\]\[31\] cpu_inst.regfile_inst.registers\[8\]\[31\]
+ _1797_ VGND VGND VPWR VPWR _1905_ sky130_fd_sc_hd__mux2_1
XFILLER_0_69_181 VPWR VGND VPWR VGND sky130_ef_sc_hd__decap_12
XFILLER_0_43_55 VGND VGND VPWR VPWR sky130_fd_sc_hd__fill_1
XTAP_TAPCELL_ROW_46_986 VGND VPWR sky130_fd_sc_hd__tapvpwrvgnd_1
XFILLER_0_9_429 VPWR VGND VPWR VGND sky130_ef_sc_hd__decap_12
X_2932_ _0896_ cpu_inst.regfile_inst.registers\[10\]\[2\] _0653_ VGND VGND VPWR VPWR
+ _0897_ sky130_fd_sc_hd__mux2_1
XTAP_TAPCELL_ROW_46_997 VGND VPWR sky130_fd_sc_hd__tapvpwrvgnd_1
XFILLER_0_85_696 VGND VGND VPWR VPWR sky130_fd_sc_hd__decap_6
XFILLER_0_57_365 VGND VGND VPWR VPWR sky130_fd_sc_hd__decap_3
Xclkbuf_leaf_42_clk clknet_2_0__leaf_clk VGND VGND VPWR VPWR clknet_leaf_42_clk sky130_fd_sc_hd__clkbuf_8
XFILLER_0_45_505 VGND VGND VPWR VPWR sky130_fd_sc_hd__fill_1
XFILLER_0_84_195 VGND VGND VPWR VPWR sky130_fd_sc_hd__fill_1
X_2863_ cpu_inst.regfile_inst.registers\[24\]\[9\] _0524_ VGND VGND VPWR VPWR _0828_
+ sky130_fd_sc_hd__or2_1
X_4602_ _2249_ VGND VGND VPWR VPWR _0307_ sky130_fd_sc_hd__clkbuf_1
XFILLER_0_41_700 VGND VGND VPWR VPWR sky130_fd_sc_hd__decap_4
X_2794_ _0701_ _0758_ VGND VGND VPWR VPWR _0759_ sky130_fd_sc_hd__nor2_1
XFILLER_0_25_273 VGND VGND VPWR VPWR sky130_fd_sc_hd__decap_6
X_4533_ _2214_ VGND VGND VPWR VPWR _0273_ sky130_fd_sc_hd__clkbuf_1
XFILLER_0_102_109 VPWR VGND VPWR VGND sky130_ef_sc_hd__decap_12
XFILLER_0_4_189 VGND VGND VPWR VPWR sky130_fd_sc_hd__decap_6
XFILLER_0_40_221 VPWR VGND VPWR VGND sky130_ef_sc_hd__decap_12
X_4464_ _2179_ VGND VGND VPWR VPWR _0239_ sky130_fd_sc_hd__clkbuf_1
XFILLER_0_68_41 VPWR VGND VPWR VGND sky130_ef_sc_hd__decap_12
XFILLER_0_7_55 VGND VGND VPWR VPWR sky130_fd_sc_hd__fill_1
XFILLER_0_1_841 VGND VGND VPWR VPWR sky130_fd_sc_hd__fill_1
XFILLER_0_40_265 VPWR VGND VPWR VGND sky130_ef_sc_hd__decap_12
XFILLER_0_111_665 VGND VGND VPWR VPWR sky130_fd_sc_hd__decap_6
XFILLER_0_110_153 VPWR VGND VPWR VGND sky130_ef_sc_hd__decap_12
X_3415_ _1353_ cpu_inst.regfile_inst.registers\[10\]\[16\] _1351_ VGND VGND VPWR VPWR
+ _1354_ sky130_fd_sc_hd__mux2_1
X_4395_ cpu_inst.regfile_inst.registers\[1\]\[15\] VGND VGND VPWR VPWR _2143_ sky130_fd_sc_hd__clkbuf_1
XFILLER_0_68_85 VPWR VGND VPWR VGND sky130_ef_sc_hd__decap_12
XTAP_TAPCELL_ROW_129_2229 VGND VPWR sky130_fd_sc_hd__tapvpwrvgnd_1
XFILLER_0_110_197 VPWR VGND VPWR VGND sky130_ef_sc_hd__decap_12
X_3346_ _1174_ cpu_inst.regfile_inst.registers\[6\]\[0\] _1300_ VGND VGND VPWR VPWR
+ _1301_ sky130_fd_sc_hd__mux2_1
XTAP_TAPCELL_ROW_51_1059 VGND VPWR sky130_fd_sc_hd__tapvpwrvgnd_1
X_5016_ _2497_ VGND VGND VPWR VPWR _0473_ sky130_fd_sc_hd__clkbuf_1
X_3277_ cpu_inst.regfile_inst.registers\[9\]\[15\] cpu_inst.regfile_inst.registers\[8\]\[15\]
+ _0866_ VGND VGND VPWR VPWR _1242_ sky130_fd_sc_hd__mux2_1
XFILLER_0_30_3 VPWR VGND VPWR VGND sky130_ef_sc_hd__decap_12
XFILLER_0_68_619 VGND VGND VPWR VPWR sky130_fd_sc_hd__fill_1
XFILLER_0_95_449 VGND VGND VPWR VPWR sky130_fd_sc_hd__fill_1
XFILLER_0_138_529 VGND VGND VPWR VPWR sky130_fd_sc_hd__decap_3
XFILLER_0_119_721 VGND VGND VPWR VPWR sky130_fd_sc_hd__decap_6
XFILLER_0_48_321 VPWR VGND VPWR VGND sky130_ef_sc_hd__decap_12
XTAP_TAPCELL_ROW_66_1291 VGND VPWR sky130_fd_sc_hd__tapvpwrvgnd_1
XTAP_TAPCELL_ROW_24_658 VGND VPWR sky130_fd_sc_hd__tapvpwrvgnd_1
Xclkbuf_leaf_33_clk clknet_2_2__leaf_clk VGND VGND VPWR VPWR clknet_leaf_33_clk sky130_fd_sc_hd__clkbuf_8
XFILLER_0_36_505 VGND VGND VPWR VPWR sky130_fd_sc_hd__decap_3
XFILLER_0_36_516 VGND VGND VPWR VPWR sky130_fd_sc_hd__fill_1
XFILLER_0_48_365 VPWR VGND VPWR VGND sky130_ef_sc_hd__decap_12
XFILLER_0_134_713 VPWR VGND VPWR VGND sky130_ef_sc_hd__decap_12
XFILLER_0_119_765 VPWR VGND VPWR VGND sky130_ef_sc_hd__decap_12
XFILLER_0_118_253 VPWR VGND VPWR VGND sky130_ef_sc_hd__decap_12
XFILLER_0_90_121 VPWR VGND VPWR VGND sky130_ef_sc_hd__decap_12
XFILLER_0_17_741 VPWR VGND VPWR VGND sky130_ef_sc_hd__decap_12
XFILLER_0_36_549 VGND VGND VPWR VPWR sky130_fd_sc_hd__fill_2
XFILLER_0_134_757 VPWR VGND VPWR VGND sky130_ef_sc_hd__decap_12
XFILLER_0_133_223 VGND VGND VPWR VPWR sky130_fd_sc_hd__fill_1
XFILLER_0_90_165 VPWR VGND VPWR VGND sky130_ef_sc_hd__decap_12
XFILLER_0_16_251 VGND VGND VPWR VPWR sky130_fd_sc_hd__fill_1
XFILLER_0_17_785 VPWR VGND VPWR VGND sky130_ef_sc_hd__decap_12
XFILLER_0_121_429 VPWR VGND VPWR VGND sky130_ef_sc_hd__decap_12
XFILLER_0_102_654 VGND VGND VPWR VPWR sky130_fd_sc_hd__fill_2
XFILLER_0_102_665 VGND VGND VPWR VPWR sky130_fd_sc_hd__fill_2
XFILLER_0_98_221 VPWR VGND VPWR VGND sky130_ef_sc_hd__decap_12
XTAP_TAPCELL_ROW_4_361 VGND VPWR sky130_fd_sc_hd__tapvpwrvgnd_1
XFILLER_0_98_265 VPWR VGND VPWR VGND sky130_ef_sc_hd__decap_12
XFILLER_0_129_529 VPWR VGND VPWR VGND sky130_ef_sc_hd__decap_12
XFILLER_0_104_27 VGND VGND VPWR VPWR sky130_fd_sc_hd__fill_1
XTAP_TAPCELL_ROW_43_945 VGND VPWR sky130_fd_sc_hd__tapvpwrvgnd_1
Xclkbuf_leaf_24_clk clknet_2_2__leaf_clk VGND VGND VPWR VPWR clknet_leaf_24_clk sky130_fd_sc_hd__clkbuf_8
XFILLER_0_55_836 VGND VGND VPWR VPWR sky130_fd_sc_hd__decap_4
XFILLER_0_137_573 VPWR VGND VPWR VGND sky130_ef_sc_hd__decap_12
XFILLER_0_94_493 VGND VGND VPWR VPWR sky130_fd_sc_hd__fill_2
XFILLER_0_66_195 VGND VGND VPWR VPWR sky130_fd_sc_hd__fill_1
XFILLER_0_54_335 VGND VGND VPWR VPWR sky130_fd_sc_hd__decap_3
XFILLER_0_13_69 VPWR VGND VPWR VGND sky130_ef_sc_hd__decap_12
XFILLER_0_120_15 VPWR VGND VPWR VGND sky130_ef_sc_hd__decap_12
XFILLER_0_124_245 VGND VGND VPWR VPWR sky130_fd_sc_hd__decap_6
XTAP_TAPCELL_ROW_97_1752 VGND VPWR sky130_fd_sc_hd__tapvpwrvgnd_1
XFILLER_0_124_289 VPWR VGND VPWR VGND sky130_ef_sc_hd__decap_12
XFILLER_0_22_221 VPWR VGND VPWR VGND sky130_ef_sc_hd__decap_12
XFILLER_0_1_137 VPWR VGND VPWR VGND sky130_ef_sc_hd__decap_12
XFILLER_0_22_265 VPWR VGND VPWR VGND sky130_ef_sc_hd__decap_12
XFILLER_0_23_777 VGND VGND VPWR VPWR sky130_fd_sc_hd__decap_6
XFILLER_0_129_57 VPWR VGND VPWR VGND sky130_ef_sc_hd__decap_12
X_3200_ _0920_ _0934_ _0936_ VGND VGND VPWR VPWR _1165_ sky130_fd_sc_hd__a21o_1
X_4180_ _2031_ VGND VGND VPWR VPWR _0103_ sky130_fd_sc_hd__clkbuf_1
X_3131_ _0950_ _0960_ _1018_ VGND VGND VPWR VPWR _1096_ sky130_fd_sc_hd__a21oi_2
XFILLER_0_38_77 VGND VGND VPWR VPWR sky130_fd_sc_hd__decap_6
X_3062_ _0548_ _0861_ _0842_ VGND VGND VPWR VPWR _1027_ sky130_fd_sc_hd__a21o_1
XTAP_TAPCELL_ROW_124_2159 VGND VPWR sky130_fd_sc_hd__tapvpwrvgnd_1
XFILLER_0_77_405 VGND VGND VPWR VPWR sky130_fd_sc_hd__decap_6
XFILLER_0_54_65 VPWR VGND VPWR VGND sky130_ef_sc_hd__decap_12
XTAP_TAPCELL_ROW_106_1892 VGND VPWR sky130_fd_sc_hd__tapvpwrvgnd_1
Xclkbuf_leaf_15_clk clknet_2_3__leaf_clk VGND VGND VPWR VPWR clknet_leaf_15_clk sky130_fd_sc_hd__clkbuf_8
X_3964_ _1709_ _1881_ _1888_ VGND VGND VPWR VPWR _1889_ sky130_fd_sc_hd__o21a_1
XFILLER_0_70_53 VPWR VGND VPWR VGND sky130_ef_sc_hd__decap_12
XFILLER_0_9_237 VPWR VGND VPWR VGND sky130_ef_sc_hd__decap_12
XFILLER_0_46_825 VPWR VGND VPWR VGND sky130_ef_sc_hd__decap_12
XFILLER_0_116_713 VPWR VGND VPWR VGND sky130_ef_sc_hd__decap_12
X_3895_ _1720_ VGND VGND VPWR VPWR _1822_ sky130_fd_sc_hd__inv_2
XFILLER_0_73_633 VGND VGND VPWR VPWR sky130_fd_sc_hd__decap_3
XFILLER_0_72_121 VPWR VGND VPWR VGND sky130_ef_sc_hd__decap_12
X_2915_ _0782_ _0879_ VGND VGND VPWR VPWR _0880_ sky130_fd_sc_hd__xor2_1
XTAP_TAPCELL_ROW_21_617 VGND VPWR sky130_fd_sc_hd__tapvpwrvgnd_1
XFILLER_0_45_335 VGND VGND VPWR VPWR sky130_fd_sc_hd__fill_1
XFILLER_0_115_223 VGND VGND VPWR VPWR sky130_fd_sc_hd__fill_1
XFILLER_0_72_165 VPWR VGND VPWR VGND sky130_ef_sc_hd__decap_12
XFILLER_0_70_97 VPWR VGND VPWR VGND sky130_ef_sc_hd__decap_12
XFILLER_0_61_828 VPWR VGND VPWR VGND sky130_ef_sc_hd__decap_12
X_2846_ cpu_inst.regfile_inst.registers\[1\]\[6\] _0627_ _0603_ cpu_inst.regfile_inst.registers\[5\]\[6\]
+ _0561_ VGND VGND VPWR VPWR _0811_ sky130_fd_sc_hd__o221a_1
XFILLER_0_116_757 VPWR VGND VPWR VGND sky130_ef_sc_hd__decap_12
XFILLER_0_131_727 VGND VGND VPWR VPWR sky130_fd_sc_hd__fill_1
XFILLER_0_79_51 VGND VGND VPWR VPWR sky130_fd_sc_hd__decap_4
XFILLER_0_78_3 VPWR VGND VPWR VGND sky130_ef_sc_hd__decap_12
XFILLER_0_14_755 VGND VGND VPWR VPWR sky130_fd_sc_hd__fill_1
X_5565_ clknet_leaf_30_clk _0485_ VGND VGND VPWR VPWR cpu_inst.display_inst.counter\[5\]
+ sky130_fd_sc_hd__dfxtp_1
X_2777_ _0607_ _0636_ _0741_ _0732_ _0635_ VGND VGND VPWR VPWR _0742_ sky130_fd_sc_hd__a32o_2
X_4516_ cpu_inst.regfile_inst.registers\[11\]\[9\] VGND VGND VPWR VPWR _2206_ sky130_fd_sc_hd__clkbuf_1
X_5496_ clknet_leaf_41_clk _0416_ VGND VGND VPWR VPWR cpu_inst.regfile_inst.registers\[8\]\[0\]
+ sky130_fd_sc_hd__dfxtp_1
XFILLER_0_111_473 VPWR VGND VPWR VGND sky130_ef_sc_hd__decap_12
XFILLER_0_1_671 VGND VGND VPWR VPWR sky130_fd_sc_hd__fill_1
X_4447_ _2170_ VGND VGND VPWR VPWR _0231_ sky130_fd_sc_hd__clkbuf_1
XFILLER_0_0_181 VPWR VGND VPWR VGND sky130_ef_sc_hd__decap_12
X_4378_ _2134_ VGND VGND VPWR VPWR _0198_ sky130_fd_sc_hd__clkbuf_1
X_3329_ _0709_ _0550_ _1283_ VGND VGND VPWR VPWR _1284_ sky130_fd_sc_hd__nand3_1
XTAP_TAPCELL_ROW_29_728 VGND VPWR sky130_fd_sc_hd__tapvpwrvgnd_1
XTAP_TAPCELL_ROW_68_1320 VGND VPWR sky130_fd_sc_hd__tapvpwrvgnd_1
XTAP_TAPCELL_ROW_1_320 VGND VPWR sky130_fd_sc_hd__tapvpwrvgnd_1
XTAP_TAPCELL_ROW_29_739 VGND VPWR sky130_fd_sc_hd__tapvpwrvgnd_1
XFILLER_0_96_725 VGND VGND VPWR VPWR sky130_fd_sc_hd__decap_8
XFILLER_0_68_427 VGND VGND VPWR VPWR sky130_fd_sc_hd__fill_1
XFILLER_0_138_337 VPWR VGND VPWR VGND sky130_ef_sc_hd__decap_12
XFILLER_0_95_279 VGND VGND VPWR VPWR sky130_fd_sc_hd__fill_1
XTAP_TAPCELL_ROW_81_1520 VGND VPWR sky130_fd_sc_hd__tapvpwrvgnd_1
XFILLER_0_119_573 VPWR VGND VPWR VGND sky130_ef_sc_hd__decap_12
XTAP_TAPCELL_ROW_40_904 VGND VPWR sky130_fd_sc_hd__tapvpwrvgnd_1
XFILLER_0_48_195 VGND VGND VPWR VPWR sky130_fd_sc_hd__fill_1
XFILLER_0_36_357 VGND VGND VPWR VPWR sky130_fd_sc_hd__decap_6
XFILLER_0_51_305 VPWR VGND VPWR VGND sky130_ef_sc_hd__decap_12
XFILLER_0_106_245 VGND VGND VPWR VPWR sky130_fd_sc_hd__decap_6
XFILLER_0_134_587 VGND VGND VPWR VPWR sky130_fd_sc_hd__fill_1
XFILLER_0_122_749 VGND VGND VPWR VPWR sky130_fd_sc_hd__decap_6
XFILLER_0_106_289 VPWR VGND VPWR VGND sky130_ef_sc_hd__decap_12
XFILLER_0_51_349 VPWR VGND VPWR VGND sky130_ef_sc_hd__decap_12
XFILLER_0_121_237 VPWR VGND VPWR VGND sky130_ef_sc_hd__decap_12
XTAP_TAPCELL_ROW_79_1482 VGND VPWR sky130_fd_sc_hd__tapvpwrvgnd_1
XFILLER_0_20_725 VPWR VGND VPWR VGND sky130_ef_sc_hd__decap_12
XTAP_TAPCELL_ROW_9_442 VGND VPWR sky130_fd_sc_hd__tapvpwrvgnd_1
XTAP_TAPCELL_ROW_9_431 VGND VPWR sky130_fd_sc_hd__tapvpwrvgnd_1
XFILLER_0_130_793 VPWR VGND VPWR VGND sky130_ef_sc_hd__decap_12
XTAP_TAPCELL_ROW_92_1682 VGND VPWR sky130_fd_sc_hd__tapvpwrvgnd_1
XFILLER_0_20_769 VPWR VGND VPWR VGND sky130_ef_sc_hd__decap_12
XFILLER_0_115_15 VPWR VGND VPWR VGND sky130_ef_sc_hd__decap_12
XFILLER_0_87_747 VGND VGND VPWR VPWR sky130_fd_sc_hd__decap_6
XFILLER_0_59_449 VGND VGND VPWR VPWR sky130_fd_sc_hd__decap_8
XFILLER_0_129_337 VPWR VGND VPWR VGND sky130_ef_sc_hd__decap_12
XFILLER_0_74_419 VGND VGND VPWR VPWR sky130_fd_sc_hd__fill_1
XFILLER_0_54_121 VPWR VGND VPWR VGND sky130_ef_sc_hd__decap_12
XFILLER_0_27_335 VGND VGND VPWR VPWR sky130_fd_sc_hd__fill_1
X_2700_ _0645_ _0646_ _0664_ VGND VGND VPWR VPWR _0665_ sky130_fd_sc_hd__and3_1
XFILLER_0_131_69 VPWR VGND VPWR VGND sky130_ef_sc_hd__decap_12
X_3680_ cpu_inst.regfile_inst.registers\[5\]\[23\] cpu_inst.regfile_inst.registers\[4\]\[23\]
+ _1540_ VGND VGND VPWR VPWR _1612_ sky130_fd_sc_hd__mux2_1
XFILLER_0_54_165 VPWR VGND VPWR VGND sky130_ef_sc_hd__decap_12
XFILLER_0_113_727 VGND VGND VPWR VPWR sky130_fd_sc_hd__fill_1
XFILLER_0_2_413 VGND VGND VPWR VPWR sky130_fd_sc_hd__decap_6
XFILLER_0_23_541 VPWR VGND VPWR VGND sky130_ef_sc_hd__decap_12
X_2631_ cpu_inst.regfile_inst.registers\[1\]\[0\] cpu_inst.regfile_inst.registers\[0\]\[0\]
+ _0595_ VGND VGND VPWR VPWR _0596_ sky130_fd_sc_hd__mux2_1
X_2562_ net17 _0518_ _0523_ _0526_ VGND VGND VPWR VPWR _0527_ sky130_fd_sc_hd__or4_4
XFILLER_0_2_457 VPWR VGND VPWR VGND sky130_ef_sc_hd__decap_12
XFILLER_0_23_585 VPWR VGND VPWR VGND sky130_ef_sc_hd__decap_12
X_5350_ clknet_leaf_28_clk _0270_ VGND VGND VPWR VPWR cpu_inst.regfile_inst.registers\[11\]\[14\]
+ sky130_fd_sc_hd__dfxtp_1
X_4301_ _2094_ VGND VGND VPWR VPWR _0161_ sky130_fd_sc_hd__clkbuf_1
X_5281_ clknet_leaf_29_clk _0201_ VGND VGND VPWR VPWR cpu_inst.regfile_inst.registers\[1\]\[9\]
+ sky130_fd_sc_hd__dfxtp_1
X_4232_ _2058_ VGND VGND VPWR VPWR _0128_ sky130_fd_sc_hd__clkbuf_1
Xclkbuf_leaf_4_clk clknet_2_1__leaf_clk VGND VGND VPWR VPWR clknet_leaf_4_clk sky130_fd_sc_hd__clkbuf_8
X_4163_ _2021_ _1990_ VGND VGND VPWR VPWR _2022_ sky130_fd_sc_hd__nand2_1
X_4094_ _0688_ cpu_inst.regfile_inst.registers\[25\]\[1\] _1982_ VGND VGND VPWR VPWR
+ _1984_ sky130_fd_sc_hd__mux2_1
X_3114_ cpu_inst.regfile_inst.registers\[25\]\[2\] _0903_ _0669_ _0898_ VGND VGND
+ VPWR VPWR _1079_ sky130_fd_sc_hd__o211ai_1
XTAP_TAPCELL_ROW_108_1921 VGND VPWR sky130_fd_sc_hd__tapvpwrvgnd_1
X_3045_ cpu_inst.regfile_inst.registers\[9\]\[10\] cpu_inst.regfile_inst.registers\[8\]\[10\]
+ _0922_ VGND VGND VPWR VPWR _1010_ sky130_fd_sc_hd__mux2_1
XFILLER_0_78_725 VGND VGND VPWR VPWR sky130_fd_sc_hd__fill_1
XFILLER_0_77_279 VGND VGND VPWR VPWR sky130_fd_sc_hd__fill_1
X_4996_ cpu_inst.regfile_inst.registers\[15\]\[16\] _2480_ VGND VGND VPWR VPWR _2487_
+ sky130_fd_sc_hd__and2_1
XFILLER_0_105_81 VPWR VGND VPWR VGND sky130_ef_sc_hd__decap_12
X_3947_ cpu_inst.regfile_inst.registers\[9\]\[30\] cpu_inst.regfile_inst.registers\[8\]\[30\]
+ _1797_ VGND VGND VPWR VPWR _1872_ sky130_fd_sc_hd__mux2_1
XTAP_TAPCELL_ROW_63_1250 VGND VPWR sky130_fd_sc_hd__tapvpwrvgnd_1
XFILLER_0_135_329 VGND VGND VPWR VPWR sky130_fd_sc_hd__decap_6
XFILLER_0_18_357 VGND VGND VPWR VPWR sky130_fd_sc_hd__decap_6
XFILLER_0_34_817 VGND VGND VPWR VPWR sky130_fd_sc_hd__decap_6
XFILLER_0_46_655 VGND VGND VPWR VPWR sky130_fd_sc_hd__decap_8
X_3878_ _1668_ VGND VGND VPWR VPWR _1805_ sky130_fd_sc_hd__buf_2
XFILLER_0_73_496 VGND VGND VPWR VPWR sky130_fd_sc_hd__decap_4
XFILLER_0_33_305 VPWR VGND VPWR VGND sky130_ef_sc_hd__decap_12
XFILLER_0_116_587 VGND VGND VPWR VPWR sky130_fd_sc_hd__fill_1
XFILLER_0_61_669 VGND VGND VPWR VPWR sky130_fd_sc_hd__decap_3
XFILLER_0_5_273 VGND VGND VPWR VPWR sky130_fd_sc_hd__decap_6
XFILLER_0_33_349 VPWR VGND VPWR VGND sky130_ef_sc_hd__decap_12
X_2829_ _0785_ _0789_ _0793_ _0611_ VGND VGND VPWR VPWR _0794_ sky130_fd_sc_hd__a31o_1
XFILLER_0_104_749 VGND VGND VPWR VPWR sky130_fd_sc_hd__decap_6
XFILLER_0_103_237 VPWR VGND VPWR VGND sky130_ef_sc_hd__decap_12
X_5548_ clknet_leaf_16_clk _0468_ VGND VGND VPWR VPWR cpu_inst.regfile_inst.registers\[15\]\[20\]
+ sky130_fd_sc_hd__dfxtp_1
XFILLER_0_41_393 VPWR VGND VPWR VGND sky130_ef_sc_hd__decap_12
XFILLER_0_112_793 VPWR VGND VPWR VGND sky130_ef_sc_hd__decap_12
XFILLER_0_111_281 VPWR VGND VPWR VGND sky130_ef_sc_hd__decap_12
X_5479_ clknet_leaf_27_clk _0399_ VGND VGND VPWR VPWR cpu_inst.regfile_inst.registers\[9\]\[15\]
+ sky130_fd_sc_hd__dfxtp_1
XPHY_EDGE_ROW_122_Right_122 VGND VGND VPWR VPWR sky130_fd_sc_hd__decap_3
XPHY_EDGE_ROW_100_Left_239 VGND VGND VPWR VPWR sky130_fd_sc_hd__decap_3
XFILLER_0_96_511 VGND VGND VPWR VPWR sky130_fd_sc_hd__fill_1
XFILLER_0_96_544 VGND VGND VPWR VPWR sky130_fd_sc_hd__decap_3
XFILLER_0_83_205 VPWR VGND VPWR VGND sky130_ef_sc_hd__decap_12
XFILLER_0_56_419 VGND VGND VPWR VPWR sky130_fd_sc_hd__fill_1
XFILLER_0_126_307 VGND VGND VPWR VPWR sky130_fd_sc_hd__fill_1
XFILLER_0_83_249 VPWR VGND VPWR VGND sky130_ef_sc_hd__decap_12
XFILLER_0_37_611 VGND VGND VPWR VPWR sky130_fd_sc_hd__decap_4
XFILLER_0_49_493 VGND VGND VPWR VPWR sky130_fd_sc_hd__fill_2
XFILLER_0_36_121 VPWR VGND VPWR VGND sky130_ef_sc_hd__decap_12
XFILLER_0_135_841 VGND VGND VPWR VPWR sky130_fd_sc_hd__fill_1
XFILLER_0_64_474 VGND VGND VPWR VPWR sky130_fd_sc_hd__fill_2
XFILLER_0_25_839 VGND VGND VPWR VPWR sky130_fd_sc_hd__fill_1
XFILLER_0_36_165 VPWR VGND VPWR VGND sky130_ef_sc_hd__decap_12
XFILLER_0_51_113 VPWR VGND VPWR VGND sky130_ef_sc_hd__decap_12
XFILLER_0_122_513 VPWR VGND VPWR VGND sky130_ef_sc_hd__decap_12
XFILLER_0_101_39 VPWR VGND VPWR VGND sky130_ef_sc_hd__decap_12
XFILLER_0_91_293 VPWR VGND VPWR VGND sky130_ef_sc_hd__decap_12
XFILLER_0_10_15 VPWR VGND VPWR VGND sky130_ef_sc_hd__decap_12
XFILLER_0_122_557 VPWR VGND VPWR VGND sky130_ef_sc_hd__decap_12
XTAP_TAPCELL_ROW_94_1711 VGND VPWR sky130_fd_sc_hd__tapvpwrvgnd_1
XFILLER_0_20_533 VPWR VGND VPWR VGND sky130_ef_sc_hd__decap_12
XFILLER_0_19_57 VPWR VGND VPWR VGND sky130_ef_sc_hd__decap_12
XTAP_TAPCELL_ROW_121_2118 VGND VPWR sky130_fd_sc_hd__tapvpwrvgnd_1
XFILLER_0_99_393 VPWR VGND VPWR VGND sky130_ef_sc_hd__decap_12
XFILLER_0_87_555 VGND VGND VPWR VPWR sky130_fd_sc_hd__fill_2
XFILLER_0_87_588 VGND VGND VPWR VPWR sky130_fd_sc_hd__fill_2
XFILLER_0_59_279 VGND VGND VPWR VPWR sky130_fd_sc_hd__fill_1
X_4850_ cpu_inst.regfile_inst.registers\[9\]\[11\] VGND VGND VPWR VPWR _2410_ sky130_fd_sc_hd__clkbuf_1
XFILLER_0_136_3 VPWR VGND VPWR VGND sky130_ef_sc_hd__decap_12
XFILLER_0_129_167 VGND VGND VPWR VPWR sky130_fd_sc_hd__fill_1
XTAP_TAPCELL_ROW_103_1851 VGND VPWR sky130_fd_sc_hd__tapvpwrvgnd_1
XTAP_TAPCELL_ROW_103_1840 VGND VPWR sky130_fd_sc_hd__tapvpwrvgnd_1
X_3801_ cpu_inst.regfile_inst.registers\[7\]\[26\] cpu_inst.regfile_inst.registers\[6\]\[26\]
+ _1657_ VGND VGND VPWR VPWR _1730_ sky130_fd_sc_hd__mux2_1
XFILLER_0_7_505 VPWR VGND VPWR VGND sky130_ef_sc_hd__decap_12
XFILLER_0_117_329 VGND VGND VPWR VPWR sky130_fd_sc_hd__decap_6
XFILLER_0_55_441 VGND VGND VPWR VPWR sky130_fd_sc_hd__decap_6
XFILLER_0_55_430 VGND VGND VPWR VPWR sky130_fd_sc_hd__fill_2
X_4781_ _2375_ VGND VGND VPWR VPWR _0360_ sky130_fd_sc_hd__clkbuf_1
XFILLER_0_51_55 VGND VGND VPWR VPWR sky130_fd_sc_hd__fill_1
XFILLER_0_126_841 VGND VGND VPWR VPWR sky130_fd_sc_hd__fill_1
X_3732_ _1586_ _1619_ _1662_ _0696_ VGND VGND VPWR VPWR _1663_ sky130_fd_sc_hd__a31o_1
XFILLER_0_83_772 VGND VGND VPWR VPWR sky130_fd_sc_hd__decap_3
XFILLER_0_55_496 VGND VGND VPWR VPWR sky130_fd_sc_hd__decap_8
XFILLER_0_15_305 VPWR VGND VPWR VGND sky130_ef_sc_hd__decap_12
XTAP_TAPCELL_ROW_31_767 VGND VPWR sky130_fd_sc_hd__tapvpwrvgnd_1
XFILLER_0_125_373 VPWR VGND VPWR VGND sky130_ef_sc_hd__decap_12
X_3663_ cpu_inst.regfile_inst.registers\[15\]\[22\] _0729_ _1595_ _0844_ VGND VGND
+ VPWR VPWR _1596_ sky130_fd_sc_hd__a211o_1
XFILLER_0_70_433 VGND VGND VPWR VPWR sky130_fd_sc_hd__decap_3
Xclkload20 clknet_leaf_25_clk VGND VGND VPWR VPWR clkload20/Y sky130_fd_sc_hd__clkinv_4
XFILLER_0_15_349 VPWR VGND VPWR VGND sky130_ef_sc_hd__decap_12
Xclkload31 clknet_leaf_12_clk VGND VGND VPWR VPWR clkload31/Y sky130_fd_sc_hd__clkinv_8
XFILLER_0_70_477 VPWR VGND VPWR VGND sky130_ef_sc_hd__decap_12
X_5402_ clknet_leaf_0_clk _0322_ net2 VGND VGND VPWR VPWR cpu_inst.decoder_inst.current_pc\[2\]
+ sky130_fd_sc_hd__dfrtp_4
X_2614_ _0575_ _0539_ _0578_ _0577_ VGND VGND VPWR VPWR _0579_ sky130_fd_sc_hd__a211o_1
XFILLER_0_2_221 VPWR VGND VPWR VGND sky130_ef_sc_hd__decap_12
X_5333_ clknet_leaf_6_clk _0253_ VGND VGND VPWR VPWR cpu_inst.regfile_inst.registers\[7\]\[29\]
+ sky130_fd_sc_hd__dfxtp_1
X_3594_ _1347_ _1346_ _1375_ _1527_ _1528_ VGND VGND VPWR VPWR _1529_ sky130_fd_sc_hd__a2111o_1
XFILLER_0_3_777 VGND VGND VPWR VPWR sky130_fd_sc_hd__decap_6
XFILLER_0_2_265 VPWR VGND VPWR VGND sky130_ef_sc_hd__decap_12
XFILLER_0_23_393 VPWR VGND VPWR VGND sky130_ef_sc_hd__decap_12
X_2545_ _0509_ VGND VGND VPWR VPWR _0510_ sky130_fd_sc_hd__clkbuf_2
X_5264_ clknet_leaf_9_clk _0184_ VGND VGND VPWR VPWR cpu_inst.regfile_inst.registers\[5\]\[24\]
+ sky130_fd_sc_hd__dfxtp_1
XFILLER_0_76_41 VPWR VGND VPWR VGND sky130_ef_sc_hd__decap_12
X_4215_ cpu_inst.regfile_inst.registers\[4\]\[24\] _2046_ VGND VGND VPWR VPWR _2050_
+ sky130_fd_sc_hd__and2_1
X_5195_ clknet_leaf_18_clk _0115_ VGND VGND VPWR VPWR cpu_inst.regfile_inst.registers\[4\]\[19\]
+ sky130_fd_sc_hd__dfxtp_1
XFILLER_0_76_85 VPWR VGND VPWR VGND sky130_ef_sc_hd__decap_12
X_4146_ _1692_ cpu_inst.regfile_inst.registers\[25\]\[24\] _2010_ VGND VGND VPWR VPWR
+ _2013_ sky130_fd_sc_hd__mux2_1
X_4077_ _1974_ VGND VGND VPWR VPWR _0057_ sky130_fd_sc_hd__clkbuf_1
XFILLER_0_78_522 VGND VGND VPWR VPWR sky130_fd_sc_hd__decap_3
XTAP_TAPCELL_ROW_39_878 VGND VPWR sky130_fd_sc_hd__tapvpwrvgnd_1
X_3028_ _0639_ _0739_ VGND VGND VPWR VPWR _0993_ sky130_fd_sc_hd__nor2_1
XTAP_TAPCELL_ROW_39_889 VGND VPWR sky130_fd_sc_hd__tapvpwrvgnd_1
XFILLER_0_65_205 VPWR VGND VPWR VGND sky130_ef_sc_hd__decap_12
XTAP_TAPCELL_ROW_19_580 VGND VPWR sky130_fd_sc_hd__tapvpwrvgnd_1
XTAP_TAPCELL_ROW_19_591 VGND VPWR sky130_fd_sc_hd__tapvpwrvgnd_1
XFILLER_0_38_419 VGND VGND VPWR VPWR sky130_fd_sc_hd__fill_1
XFILLER_0_108_307 VGND VGND VPWR VPWR sky130_fd_sc_hd__fill_1
XTAP_TAPCELL_ROW_61_1209 VGND VPWR sky130_fd_sc_hd__tapvpwrvgnd_1
XFILLER_0_65_249 VPWR VGND VPWR VGND sky130_ef_sc_hd__decap_12
XFILLER_0_18_121 VPWR VGND VPWR VGND sky130_ef_sc_hd__decap_12
X_4979_ cpu_inst.regfile_inst.registers\[15\]\[8\] _2469_ VGND VGND VPWR VPWR _2478_
+ sky130_fd_sc_hd__and2_1
XFILLER_0_135_137 VPWR VGND VPWR VGND sky130_ef_sc_hd__decap_12
XFILLER_0_117_841 VGND VGND VPWR VPWR sky130_fd_sc_hd__fill_1
XFILLER_0_74_783 VGND VGND VPWR VPWR sky130_fd_sc_hd__fill_2
Xclkload3 clknet_leaf_0_clk VGND VGND VPWR VPWR clkload3/Y sky130_fd_sc_hd__inv_2
XFILLER_0_18_165 VPWR VGND VPWR VGND sky130_ef_sc_hd__decap_12
XFILLER_0_34_636 VGND VGND VPWR VPWR sky130_fd_sc_hd__decap_8
XFILLER_0_132_811 VGND VGND VPWR VPWR sky130_fd_sc_hd__fill_1
XFILLER_0_73_293 VPWR VGND VPWR VGND sky130_ef_sc_hd__decap_12
XFILLER_0_61_444 VGND VGND VPWR VPWR sky130_fd_sc_hd__decap_4
XFILLER_0_33_113 VPWR VGND VPWR VGND sky130_ef_sc_hd__decap_12
XTAP_TAPCELL_ROW_76_1441 VGND VPWR sky130_fd_sc_hd__tapvpwrvgnd_1
XFILLER_0_100_796 VPWR VGND VPWR VGND sky130_ef_sc_hd__decap_12
XFILLER_0_69_500 VGND VGND VPWR VPWR sky130_fd_sc_hd__decap_4
XFILLER_0_69_522 VGND VGND VPWR VPWR sky130_fd_sc_hd__decap_4
XFILLER_0_96_363 VGND VGND VPWR VPWR sky130_fd_sc_hd__fill_1
XFILLER_0_112_27 VGND VGND VPWR VPWR sky130_fd_sc_hd__fill_1
XFILLER_0_65_783 VGND VGND VPWR VPWR sky130_fd_sc_hd__fill_1
XFILLER_0_52_411 VGND VGND VPWR VPWR sky130_fd_sc_hd__decap_8
XFILLER_0_135_671 VGND VGND VPWR VPWR sky130_fd_sc_hd__fill_1
XFILLER_0_107_373 VPWR VGND VPWR VGND sky130_ef_sc_hd__decap_12
XFILLER_0_13_809 VPWR VGND VPWR VGND sky130_ef_sc_hd__decap_12
XFILLER_0_21_69 VPWR VGND VPWR VGND sky130_ef_sc_hd__decap_12
XFILLER_0_123_833 VGND VGND VPWR VPWR sky130_fd_sc_hd__decap_6
XFILLER_0_122_321 VPWR VGND VPWR VGND sky130_ef_sc_hd__decap_12
XFILLER_0_52_477 VGND VGND VPWR VPWR sky130_fd_sc_hd__decap_8
XFILLER_0_122_365 VPWR VGND VPWR VGND sky130_ef_sc_hd__decap_12
XFILLER_0_33_691 VGND VGND VPWR VPWR sky130_fd_sc_hd__decap_6
XFILLER_0_0_725 VGND VGND VPWR VPWR sky130_fd_sc_hd__decap_3
XFILLER_0_0_769 VPWR VGND VPWR VGND sky130_ef_sc_hd__decap_12
XFILLER_0_20_363 VGND VGND VPWR VPWR sky130_fd_sc_hd__fill_1
X_4000_ _1908_ _1875_ _1317_ VGND VGND VPWR VPWR _1924_ sky130_fd_sc_hd__mux2_1
XFILLER_0_137_57 VPWR VGND VPWR VGND sky130_ef_sc_hd__decap_12
XFILLER_0_46_77 VGND VGND VPWR VPWR sky130_fd_sc_hd__decap_6
XFILLER_0_75_514 VGND VGND VPWR VPWR sky130_fd_sc_hd__decap_3
XFILLER_0_1_57 VPWR VGND VPWR VGND sky130_ef_sc_hd__decap_12
XTAP_TAPCELL_ROW_36_837 VGND VPWR sky130_fd_sc_hd__tapvpwrvgnd_1
X_4902_ _1205_ cpu_inst.regfile_inst.registers\[8\]\[3\] _2432_ VGND VGND VPWR VPWR
+ _2438_ sky130_fd_sc_hd__mux2_1
XFILLER_0_47_205 VPWR VGND VPWR VGND sky130_ef_sc_hd__decap_12
XFILLER_0_87_385 VGND VGND VPWR VPWR sky130_fd_sc_hd__decap_4
XFILLER_0_62_65 VPWR VGND VPWR VGND sky130_ef_sc_hd__decap_12
XFILLER_0_56_761 VGND VGND VPWR VPWR sky130_fd_sc_hd__fill_1
XFILLER_0_8_825 VPWR VGND VPWR VGND sky130_ef_sc_hd__decap_12
X_4833_ _2401_ VGND VGND VPWR VPWR _0386_ sky130_fd_sc_hd__clkbuf_1
XFILLER_0_47_249 VPWR VGND VPWR VGND sky130_ef_sc_hd__decap_12
XFILLER_0_117_137 VPWR VGND VPWR VGND sky130_ef_sc_hd__decap_12
XFILLER_0_90_517 VGND VGND VPWR VPWR sky130_fd_sc_hd__fill_1
XFILLER_0_7_335 VGND VGND VPWR VPWR sky130_fd_sc_hd__fill_1
XFILLER_0_16_625 VPWR VGND VPWR VGND sky130_ef_sc_hd__decap_12
X_4764_ cpu_inst.decoder_inst.current_pc\[1\] VGND VGND VPWR VPWR _2367_ sky130_fd_sc_hd__clkbuf_1
XTAP_TAPCELL_ROW_134_2309 VGND VPWR sky130_fd_sc_hd__tapvpwrvgnd_1
XFILLER_0_114_811 VGND VGND VPWR VPWR sky130_fd_sc_hd__fill_1
X_3715_ _1600_ _1633_ VGND VGND VPWR VPWR _1646_ sky130_fd_sc_hd__nor2_1
XFILLER_0_55_293 VPWR VGND VPWR VGND sky130_ef_sc_hd__decap_12
XFILLER_0_15_113 VPWR VGND VPWR VGND sky130_ef_sc_hd__decap_12
XFILLER_0_126_693 VGND VGND VPWR VPWR sky130_fd_sc_hd__decap_6
XFILLER_0_125_181 VPWR VGND VPWR VGND sky130_ef_sc_hd__decap_12
X_4695_ _1988_ _2284_ VGND VGND VPWR VPWR _2318_ sky130_fd_sc_hd__nand2_1
XFILLER_0_16_669 VPWR VGND VPWR VGND sky130_ef_sc_hd__decap_12
X_3646_ cpu_inst.regfile_inst.registers\[7\]\[22\] cpu_inst.regfile_inst.registers\[6\]\[22\]
+ _1540_ VGND VGND VPWR VPWR _1579_ sky130_fd_sc_hd__mux2_1
XFILLER_0_3_541 VPWR VGND VPWR VGND sky130_ef_sc_hd__decap_12
XFILLER_0_87_51 VGND VGND VPWR VPWR sky130_fd_sc_hd__decap_4
X_3577_ cpu_inst.regfile_inst.registers\[1\]\[20\] _0820_ _0821_ cpu_inst.regfile_inst.registers\[5\]\[20\]
+ _0562_ VGND VGND VPWR VPWR _1512_ sky130_fd_sc_hd__o221a_1
XFILLER_0_60_3 VPWR VGND VPWR VGND sky130_ef_sc_hd__decap_12
XTAP_TAPCELL_ROW_58_1171 VGND VPWR sky130_fd_sc_hd__tapvpwrvgnd_1
XFILLER_0_3_585 VPWR VGND VPWR VGND sky130_ef_sc_hd__decap_12
X_5316_ clknet_leaf_21_clk _0236_ VGND VGND VPWR VPWR cpu_inst.regfile_inst.registers\[7\]\[12\]
+ sky130_fd_sc_hd__dfxtp_1
XFILLER_0_11_385 VGND VGND VPWR VPWR sky130_fd_sc_hd__decap_6
X_5247_ clknet_leaf_34_clk _0167_ VGND VGND VPWR VPWR cpu_inst.regfile_inst.registers\[5\]\[7\]
+ sky130_fd_sc_hd__dfxtp_1
XTAP_TAPCELL_ROW_71_1371 VGND VPWR sky130_fd_sc_hd__tapvpwrvgnd_1
XTAP_TAPCELL_ROW_71_1360 VGND VPWR sky130_fd_sc_hd__tapvpwrvgnd_1
X_5178_ clknet_leaf_41_clk _0098_ VGND VGND VPWR VPWR cpu_inst.regfile_inst.registers\[4\]\[2\]
+ sky130_fd_sc_hd__dfxtp_1
XFILLER_0_98_617 VGND VGND VPWR VPWR sky130_fd_sc_hd__fill_2
XFILLER_0_97_105 VGND VGND VPWR VPWR sky130_fd_sc_hd__decap_6
X_4129_ _1382_ cpu_inst.regfile_inst.registers\[25\]\[16\] _1998_ VGND VGND VPWR VPWR
+ _2004_ sky130_fd_sc_hd__mux2_1
XFILLER_0_97_149 VPWR VGND VPWR VGND sky130_ef_sc_hd__decap_12
XFILLER_0_78_363 VGND VGND VPWR VPWR sky130_fd_sc_hd__fill_1
XTAP_TAPCELL_ROW_14_509 VGND VPWR sky130_fd_sc_hd__tapvpwrvgnd_1
XFILLER_0_136_413 VGND VGND VPWR VPWR sky130_fd_sc_hd__decap_6
XFILLER_0_19_441 VGND VGND VPWR VPWR sky130_fd_sc_hd__decap_6
XFILLER_0_136_457 VPWR VGND VPWR VGND sky130_ef_sc_hd__decap_12
XFILLER_0_93_399 VGND VGND VPWR VPWR sky130_fd_sc_hd__fill_1
XFILLER_0_19_485 VPWR VGND VPWR VGND sky130_ef_sc_hd__decap_12
XFILLER_0_47_794 VGND VGND VPWR VPWR sky130_fd_sc_hd__fill_2
XFILLER_0_117_671 VGND VGND VPWR VPWR sky130_fd_sc_hd__fill_1
XFILLER_0_34_433 VGND VGND VPWR VPWR sky130_fd_sc_hd__decap_8
XFILLER_0_105_833 VGND VGND VPWR VPWR sky130_fd_sc_hd__decap_6
XFILLER_0_104_321 VPWR VGND VPWR VGND sky130_ef_sc_hd__decap_12
XFILLER_0_21_105 VGND VGND VPWR VPWR sky130_fd_sc_hd__decap_6
XFILLER_0_120_825 VPWR VGND VPWR VGND sky130_ef_sc_hd__decap_12
XFILLER_0_104_365 VPWR VGND VPWR VGND sky130_ef_sc_hd__decap_12
XFILLER_0_21_149 VPWR VGND VPWR VGND sky130_ef_sc_hd__decap_12
XFILLER_0_30_661 VGND VGND VPWR VPWR sky130_fd_sc_hd__fill_1
XFILLER_0_30_672 VGND VGND VPWR VPWR sky130_fd_sc_hd__fill_1
XTAP_TAPCELL_ROW_89_1632 VGND VPWR sky130_fd_sc_hd__tapvpwrvgnd_1
XFILLER_0_107_27 VPWR VGND VPWR VGND sky130_ef_sc_hd__decap_12
XFILLER_0_69_330 VGND VGND VPWR VPWR sky130_fd_sc_hd__decap_6
XFILLER_0_97_661 VGND VGND VPWR VPWR sky130_fd_sc_hd__decap_3
XFILLER_0_123_15 VPWR VGND VPWR VGND sky130_ef_sc_hd__decap_12
XFILLER_0_29_205 VPWR VGND VPWR VGND sky130_ef_sc_hd__decap_12
XFILLER_0_84_333 VPWR VGND VPWR VGND sky130_ef_sc_hd__decap_12
XFILLER_0_57_569 VPWR VGND VPWR VGND sky130_ef_sc_hd__decap_12
XFILLER_0_29_249 VPWR VGND VPWR VGND sky130_ef_sc_hd__decap_12
XFILLER_0_53_753 VGND VGND VPWR VPWR sky130_fd_sc_hd__decap_8
XFILLER_0_5_839 VGND VGND VPWR VPWR sky130_fd_sc_hd__fill_1
XFILLER_0_37_293 VPWR VGND VPWR VGND sky130_ef_sc_hd__decap_12
XTAP_TAPCELL_ROW_116_2039 VGND VPWR sky130_fd_sc_hd__tapvpwrvgnd_1
XFILLER_0_108_693 VGND VGND VPWR VPWR sky130_fd_sc_hd__decap_6
XFILLER_0_107_181 VPWR VGND VPWR VGND sky130_ef_sc_hd__decap_12
X_3500_ cpu_inst.regfile_inst.registers\[0\]\[18\] _0615_ _1435_ _0853_ _1436_ VGND
+ VGND VPWR VPWR _1437_ sky130_fd_sc_hd__o221a_1
XFILLER_0_13_617 VPWR VGND VPWR VGND sky130_ef_sc_hd__decap_12
XFILLER_0_123_641 VPWR VGND VPWR VGND sky130_ef_sc_hd__decap_12
X_4480_ _1644_ cpu_inst.regfile_inst.registers\[7\]\[23\] _2186_ VGND VGND VPWR VPWR
+ _2188_ sky130_fd_sc_hd__mux2_1
XFILLER_0_123_685 VPWR VGND VPWR VGND sky130_ef_sc_hd__decap_12
X_3431_ _1295_ _1359_ _1369_ _1022_ VGND VGND VPWR VPWR _1370_ sky130_fd_sc_hd__o211a_1
XFILLER_0_122_195 VGND VGND VPWR VPWR sky130_fd_sc_hd__fill_1
XFILLER_0_110_357 VGND VGND VPWR VPWR sky130_fd_sc_hd__decap_6
X_3362_ _0871_ VGND VGND VPWR VPWR _1312_ sky130_fd_sc_hd__buf_4
XFILLER_0_0_533 VPWR VGND VPWR VGND sky130_ef_sc_hd__decap_12
X_5101_ clknet_leaf_16_clk _0021_ VGND VGND VPWR VPWR cpu_inst.regfile_inst.registers\[6\]\[21\]
+ sky130_fd_sc_hd__dfxtp_1
XTAP_TAPCELL_ROW_111_1972 VGND VPWR sky130_fd_sc_hd__tapvpwrvgnd_1
XTAP_TAPCELL_ROW_111_1961 VGND VPWR sky130_fd_sc_hd__tapvpwrvgnd_1
X_3293_ _1251_ _1212_ _1257_ _1153_ VGND VGND VPWR VPWR _1258_ sky130_fd_sc_hd__o211a_1
X_5032_ cpu_inst.display_inst.counter\[1\] cpu_inst.display_inst.counter\[0\] cpu_inst.display_inst.counter\[2\]
+ VGND VGND VPWR VPWR _2505_ sky130_fd_sc_hd__and3_1
XTAP_TAPCELL_ROW_53_1090 VGND VPWR sky130_fd_sc_hd__tapvpwrvgnd_1
XFILLER_0_79_105 VGND VGND VPWR VPWR sky130_fd_sc_hd__decap_6
XFILLER_0_79_149 VPWR VGND VPWR VGND sky130_ef_sc_hd__decap_12
XFILLER_0_118_413 VGND VGND VPWR VPWR sky130_fd_sc_hd__decap_6
XFILLER_0_87_193 VPWR VGND VPWR VGND sky130_ef_sc_hd__decap_12
XFILLER_0_48_558 VGND VGND VPWR VPWR sky130_fd_sc_hd__decap_8
XFILLER_0_118_457 VPWR VGND VPWR VGND sky130_ef_sc_hd__decap_12
X_4816_ cpu_inst.regfile_inst.registers\[0\]\[26\] VGND VGND VPWR VPWR _2393_ sky130_fd_sc_hd__clkbuf_1
XFILLER_0_91_815 VPWR VGND VPWR VGND sky130_ef_sc_hd__decap_12
XFILLER_0_29_783 VGND VGND VPWR VPWR sky130_fd_sc_hd__fill_1
XFILLER_0_133_405 VPWR VGND VPWR VGND sky130_ef_sc_hd__decap_12
XFILLER_0_113_81 VPWR VGND VPWR VGND sky130_ef_sc_hd__decap_12
XFILLER_0_16_433 VPWR VGND VPWR VGND sky130_ef_sc_hd__decap_12
XFILLER_0_133_449 VPWR VGND VPWR VGND sky130_ef_sc_hd__decap_12
XFILLER_0_71_561 VPWR VGND VPWR VGND sky130_ef_sc_hd__decap_12
X_4747_ cpu_inst.decoder_inst.current_pc\[26\] _2351_ VGND VGND VPWR VPWR _2356_ sky130_fd_sc_hd__nor2_1
XFILLER_0_8_699 VGND VGND VPWR VPWR sky130_fd_sc_hd__fill_1
XFILLER_0_16_477 VPWR VGND VPWR VGND sky130_ef_sc_hd__decap_12
X_4678_ cpu_inst.decoder_inst.current_pc\[7\] _2305_ _2285_ VGND VGND VPWR VPWR _2306_
+ sky130_fd_sc_hd__mux2_1
XFILLER_0_102_825 VPWR VGND VPWR VGND sky130_ef_sc_hd__decap_12
X_3629_ _1552_ _1556_ _1558_ _1562_ VGND VGND VPWR VPWR _1563_ sky130_fd_sc_hd__o22a_1
XFILLER_0_98_83 VGND VGND VPWR VPWR sky130_fd_sc_hd__fill_1
XTAP_TAPCELL_ROW_73_1400 VGND VPWR sky130_fd_sc_hd__tapvpwrvgnd_1
XFILLER_0_31_447 VGND VGND VPWR VPWR sky130_fd_sc_hd__fill_1
XFILLER_0_101_335 VGND VGND VPWR VPWR sky130_fd_sc_hd__fill_1
XFILLER_0_3_393 VPWR VGND VPWR VGND sky130_ef_sc_hd__decap_12
XFILLER_0_11_193 VPWR VGND VPWR VGND sky130_ef_sc_hd__decap_12
XFILLER_0_98_425 VGND VGND VPWR VPWR sky130_fd_sc_hd__fill_1
XFILLER_0_79_650 VGND VGND VPWR VPWR sky130_fd_sc_hd__fill_1
XTAP_TAPCELL_ROW_84_1562 VGND VPWR sky130_fd_sc_hd__tapvpwrvgnd_1
XFILLER_0_27_709 VPWR VGND VPWR VGND sky130_ef_sc_hd__decap_12
XFILLER_0_39_547 VGND VGND VPWR VPWR sky130_fd_sc_hd__fill_1
XFILLER_0_136_221 VPWR VGND VPWR VGND sky130_ef_sc_hd__decap_12
XFILLER_0_82_837 VGND VGND VPWR VPWR sky130_fd_sc_hd__fill_2
XFILLER_0_137_777 VGND VGND VPWR VPWR sky130_fd_sc_hd__decap_6
XFILLER_0_136_265 VPWR VGND VPWR VGND sky130_ef_sc_hd__decap_12
XFILLER_0_19_293 VPWR VGND VPWR VGND sky130_ef_sc_hd__decap_12
XFILLER_0_22_469 VGND VGND VPWR VPWR sky130_fd_sc_hd__decap_6
XFILLER_0_104_195 VGND VGND VPWR VPWR sky130_fd_sc_hd__fill_1
XFILLER_0_120_699 VGND VGND VPWR VPWR sky130_fd_sc_hd__fill_1
XFILLER_0_27_57 VPWR VGND VPWR VGND sky130_ef_sc_hd__decap_12
XTAP_TAPCELL_ROW_126_2190 VGND VPWR sky130_fd_sc_hd__tapvpwrvgnd_1
XFILLER_0_97_480 VGND VGND VPWR VPWR sky130_fd_sc_hd__fill_2
X_3980_ _1902_ _1903_ _1313_ VGND VGND VPWR VPWR _1904_ sky130_fd_sc_hd__mux2_1
XFILLER_0_69_193 VPWR VGND VPWR VGND sky130_ef_sc_hd__decap_12
X_2931_ cpu_inst.regfile_inst.registers\[9\]\[2\] cpu_inst.regfile_inst.registers\[8\]\[2\]
+ _0675_ VGND VGND VPWR VPWR _0896_ sky130_fd_sc_hd__mux2_1
XTAP_TAPCELL_ROW_46_987 VGND VPWR sky130_fd_sc_hd__tapvpwrvgnd_1
XFILLER_0_128_755 VGND VGND VPWR VPWR sky130_fd_sc_hd__fill_1
XFILLER_0_84_141 VPWR VGND VPWR VGND sky130_ef_sc_hd__decap_12
Xclkbuf_0_clk clk VGND VGND VPWR VPWR clknet_0_clk sky130_fd_sc_hd__clkbuf_16
XFILLER_0_115_405 VPWR VGND VPWR VGND sky130_ef_sc_hd__decap_12
X_4601_ cpu_inst.regfile_inst.registers\[10\]\[19\] _2241_ VGND VGND VPWR VPWR _2249_
+ sky130_fd_sc_hd__and2_1
X_2862_ _0819_ _0826_ _0611_ VGND VGND VPWR VPWR _0827_ sky130_fd_sc_hd__a21o_1
XFILLER_0_115_449 VPWR VGND VPWR VGND sky130_ef_sc_hd__decap_12
XFILLER_0_53_561 VGND VGND VPWR VPWR sky130_fd_sc_hd__fill_2
X_2793_ cpu_inst.regfile_inst.registers\[2\]\[2\] _0627_ _0702_ cpu_inst.regfile_inst.registers\[7\]\[2\]
+ VGND VGND VPWR VPWR _0758_ sky130_fd_sc_hd__o22a_1
X_4532_ cpu_inst.regfile_inst.registers\[11\]\[17\] VGND VGND VPWR VPWR _2214_ sky130_fd_sc_hd__clkbuf_1
XFILLER_0_130_419 VGND VGND VPWR VPWR sky130_fd_sc_hd__fill_1
XFILLER_0_80_391 VGND VGND VPWR VPWR sky130_fd_sc_hd__decap_3
X_4463_ _1260_ cpu_inst.regfile_inst.registers\[7\]\[15\] _2174_ VGND VGND VPWR VPWR
+ _2179_ sky130_fd_sc_hd__mux2_1
XFILLER_0_13_447 VGND VGND VPWR VPWR sky130_fd_sc_hd__fill_1
XFILLER_0_40_233 VPWR VGND VPWR VGND sky130_ef_sc_hd__decap_12
XFILLER_0_110_121 VPWR VGND VPWR VGND sky130_ef_sc_hd__decap_12
X_3414_ cpu_inst.regfile_inst.registers\[9\]\[16\] cpu_inst.regfile_inst.registers\[8\]\[16\]
+ _1348_ VGND VGND VPWR VPWR _1353_ sky130_fd_sc_hd__mux2_1
XFILLER_0_68_53 VPWR VGND VPWR VGND sky130_ef_sc_hd__decap_12
XFILLER_0_40_277 VPWR VGND VPWR VGND sky130_ef_sc_hd__decap_12
XFILLER_0_110_165 VPWR VGND VPWR VGND sky130_ef_sc_hd__decap_12
XTAP_TAPCELL_ROW_55_1130 VGND VPWR sky130_fd_sc_hd__tapvpwrvgnd_1
XPHY_EDGE_ROW_15_Right_15 VGND VGND VPWR VPWR sky130_fd_sc_hd__decap_3
X_4394_ _2142_ VGND VGND VPWR VPWR _0206_ sky130_fd_sc_hd__clkbuf_1
XFILLER_0_68_97 VPWR VGND VPWR VGND sky130_ef_sc_hd__decap_12
X_3345_ _1299_ VGND VGND VPWR VPWR _1300_ sky130_fd_sc_hd__buf_4
XFILLER_0_84_41 VPWR VGND VPWR VGND sky130_ef_sc_hd__decap_12
X_3276_ _1239_ _1240_ _0870_ VGND VGND VPWR VPWR _1241_ sky130_fd_sc_hd__mux2_1
X_5015_ cpu_inst.regfile_inst.registers\[15\]\[25\] _2491_ VGND VGND VPWR VPWR _2497_
+ sky130_fd_sc_hd__and2_1
XFILLER_0_84_85 VPWR VGND VPWR VGND sky130_ef_sc_hd__decap_12
XFILLER_0_23_3 VPWR VGND VPWR VGND sky130_ef_sc_hd__decap_12
XPHY_EDGE_ROW_24_Right_24 VGND VGND VPWR VPWR sky130_fd_sc_hd__decap_3
XFILLER_0_76_631 VPWR VGND VPWR VGND sky130_ef_sc_hd__decap_12
XFILLER_0_48_333 VPWR VGND VPWR VGND sky130_ef_sc_hd__decap_12
XFILLER_0_118_221 VPWR VGND VPWR VGND sky130_ef_sc_hd__decap_12
XFILLER_0_76_675 VGND VGND VPWR VPWR sky130_fd_sc_hd__fill_1
XTAP_TAPCELL_ROW_66_1292 VGND VPWR sky130_fd_sc_hd__tapvpwrvgnd_1
XTAP_TAPCELL_ROW_24_659 VGND VPWR sky130_fd_sc_hd__tapvpwrvgnd_1
XFILLER_0_48_377 VPWR VGND VPWR VGND sky130_ef_sc_hd__decap_12
XFILLER_0_119_777 VGND VGND VPWR VPWR sky130_fd_sc_hd__decap_6
XFILLER_0_118_265 VPWR VGND VPWR VGND sky130_ef_sc_hd__decap_12
XFILLER_0_134_725 VPWR VGND VPWR VGND sky130_ef_sc_hd__decap_12
XFILLER_0_91_667 VGND VGND VPWR VPWR sky130_fd_sc_hd__fill_1
XFILLER_0_90_133 VGND VGND VPWR VPWR sky130_fd_sc_hd__decap_6
XFILLER_0_17_753 VPWR VGND VPWR VGND sky130_ef_sc_hd__decap_12
XFILLER_0_134_769 VPWR VGND VPWR VGND sky130_ef_sc_hd__decap_12
XFILLER_0_90_177 VPWR VGND VPWR VGND sky130_ef_sc_hd__decap_12
XFILLER_0_17_797 VPWR VGND VPWR VGND sky130_ef_sc_hd__decap_12
XFILLER_0_133_279 VGND VGND VPWR VPWR sky130_fd_sc_hd__fill_1
XFILLER_0_102_622 VGND VGND VPWR VPWR sky130_fd_sc_hd__fill_2
XPHY_EDGE_ROW_33_Right_33 VGND VGND VPWR VPWR sky130_fd_sc_hd__decap_3
XFILLER_0_102_699 VGND VGND VPWR VPWR sky130_fd_sc_hd__fill_1
XTAP_TAPCELL_ROW_4_362 VGND VPWR sky130_fd_sc_hd__tapvpwrvgnd_1
XFILLER_0_98_233 VPWR VGND VPWR VGND sky130_ef_sc_hd__decap_12
XPHY_EDGE_ROW_42_Right_42 VGND VGND VPWR VPWR sky130_fd_sc_hd__decap_3
XFILLER_0_98_277 VPWR VGND VPWR VGND sky130_ef_sc_hd__decap_12
XFILLER_0_13_15 VPWR VGND VPWR VGND sky130_ef_sc_hd__decap_12
XFILLER_0_66_141 VPWR VGND VPWR VGND sky130_ef_sc_hd__decap_12
XTAP_TAPCELL_ROW_43_946 VGND VPWR sky130_fd_sc_hd__tapvpwrvgnd_1
XFILLER_0_137_541 VPWR VGND VPWR VGND sky130_ef_sc_hd__decap_12
XFILLER_0_81_111 VGND VGND VPWR VPWR sky130_fd_sc_hd__fill_1
XFILLER_0_137_585 VPWR VGND VPWR VGND sky130_ef_sc_hd__decap_12
XFILLER_0_54_358 VGND VGND VPWR VPWR sky130_fd_sc_hd__decap_6
XFILLER_0_120_27 VGND VGND VPWR VPWR sky130_fd_sc_hd__fill_1
XPHY_EDGE_ROW_51_Right_51 VGND VGND VPWR VPWR sky130_fd_sc_hd__decap_3
XFILLER_0_112_419 VGND VGND VPWR VPWR sky130_fd_sc_hd__fill_1
XTAP_TAPCELL_ROW_97_1753 VGND VPWR sky130_fd_sc_hd__tapvpwrvgnd_1
XFILLER_0_1_105 VGND VGND VPWR VPWR sky130_fd_sc_hd__decap_6
XFILLER_0_22_233 VPWR VGND VPWR VGND sky130_ef_sc_hd__decap_12
XPHY_EDGE_ROW_136_Right_136 VGND VGND VPWR VPWR sky130_fd_sc_hd__decap_3
XFILLER_0_1_149 VPWR VGND VPWR VGND sky130_ef_sc_hd__decap_12
XFILLER_0_22_277 VPWR VGND VPWR VGND sky130_ef_sc_hd__decap_12
XFILLER_0_129_69 VPWR VGND VPWR VGND sky130_ef_sc_hd__decap_12
X_3130_ _0911_ _1055_ _1078_ _1094_ VGND VGND VPWR VPWR _1095_ sky130_fd_sc_hd__o31a_1
X_3061_ _1021_ _1019_ _1025_ VGND VGND VPWR VPWR _1026_ sky130_fd_sc_hd__a21o_1
XPHY_EDGE_ROW_60_Right_60 VGND VGND VPWR VPWR sky130_fd_sc_hd__decap_3
XFILLER_0_54_77 VGND VGND VPWR VPWR sky130_fd_sc_hd__decap_6
XFILLER_0_58_631 VPWR VGND VPWR VGND sky130_ef_sc_hd__decap_12
XFILLER_0_9_205 VPWR VGND VPWR VGND sky130_ef_sc_hd__decap_12
XTAP_TAPCELL_ROW_106_1893 VGND VPWR sky130_fd_sc_hd__tapvpwrvgnd_1
X_3963_ _1552_ _1884_ _1887_ _1739_ VGND VGND VPWR VPWR _1888_ sky130_fd_sc_hd__o22a_1
XFILLER_0_9_249 VPWR VGND VPWR VGND sky130_ef_sc_hd__decap_12
XFILLER_0_46_804 VGND VGND VPWR VPWR sky130_fd_sc_hd__decap_8
X_3894_ _1820_ VGND VGND VPWR VPWR _1821_ sky130_fd_sc_hd__inv_2
XFILLER_0_70_65 VPWR VGND VPWR VGND sky130_ef_sc_hd__decap_12
X_2914_ _0548_ _0771_ VGND VGND VPWR VPWR _0879_ sky130_fd_sc_hd__nand2_1
XTAP_TAPCELL_ROW_21_618 VGND VPWR sky130_fd_sc_hd__tapvpwrvgnd_1
XFILLER_0_46_837 VGND VGND VPWR VPWR sky130_fd_sc_hd__decap_4
XFILLER_0_116_725 VPWR VGND VPWR VGND sky130_ef_sc_hd__decap_12
XFILLER_0_72_133 VGND VGND VPWR VPWR sky130_fd_sc_hd__decap_6
XFILLER_0_61_818 VGND VGND VPWR VPWR sky130_fd_sc_hd__decap_4
X_2845_ cpu_inst.regfile_inst.registers\[0\]\[6\] _0592_ _0603_ cpu_inst.regfile_inst.registers\[4\]\[6\]
+ _0705_ VGND VGND VPWR VPWR _0810_ sky130_fd_sc_hd__o221a_1
XFILLER_0_116_769 VPWR VGND VPWR VGND sky130_ef_sc_hd__decap_12
XFILLER_0_72_177 VPWR VGND VPWR VGND sky130_ef_sc_hd__decap_12
XFILLER_0_14_701 VPWR VGND VPWR VGND sky130_ef_sc_hd__decap_12
X_5564_ clknet_leaf_30_clk _0484_ VGND VGND VPWR VPWR cpu_inst.display_inst.counter\[4\]
+ sky130_fd_sc_hd__dfxtp_1
XFILLER_0_115_279 VGND VGND VPWR VPWR sky130_fd_sc_hd__fill_1
XFILLER_0_53_380 VGND VGND VPWR VPWR sky130_fd_sc_hd__decap_4
X_4515_ _2205_ VGND VGND VPWR VPWR _0264_ sky130_fd_sc_hd__clkbuf_1
X_2776_ cpu_inst.regfile_inst.registers\[24\]\[0\] _0640_ VGND VGND VPWR VPWR _0741_
+ sky130_fd_sc_hd__or2_1
XPHY_EDGE_ROW_103_Right_103 VGND VGND VPWR VPWR sky130_fd_sc_hd__decap_3
X_5495_ clknet_leaf_4_clk _0415_ VGND VGND VPWR VPWR cpu_inst.regfile_inst.registers\[9\]\[31\]
+ sky130_fd_sc_hd__dfxtp_1
XFILLER_0_41_575 VGND VGND VPWR VPWR sky130_fd_sc_hd__fill_1
XFILLER_0_41_586 VGND VGND VPWR VPWR sky130_fd_sc_hd__fill_1
XFILLER_0_111_441 VGND VGND VPWR VPWR sky130_fd_sc_hd__decap_6
X_4446_ _1223_ cpu_inst.regfile_inst.registers\[7\]\[7\] _2161_ VGND VGND VPWR VPWR
+ _2170_ sky130_fd_sc_hd__mux2_1
XFILLER_0_111_485 VPWR VGND VPWR VGND sky130_ef_sc_hd__decap_12
X_4377_ cpu_inst.regfile_inst.registers\[1\]\[6\] VGND VGND VPWR VPWR _2134_ sky130_fd_sc_hd__clkbuf_1
XFILLER_0_95_51 VGND VGND VPWR VPWR sky130_fd_sc_hd__decap_4
XFILLER_0_0_193 VGND VGND VPWR VPWR sky130_fd_sc_hd__decap_3
X_3328_ _0655_ _0558_ _1282_ VGND VGND VPWR VPWR _1283_ sky130_fd_sc_hd__and3_1
XPHY_EDGE_ROW_13_Left_152 VGND VGND VPWR VPWR sky130_fd_sc_hd__decap_3
X_3259_ _1053_ VGND VGND VPWR VPWR _1224_ sky130_fd_sc_hd__buf_2
XTAP_TAPCELL_ROW_68_1321 VGND VPWR sky130_fd_sc_hd__tapvpwrvgnd_1
XTAP_TAPCELL_ROW_1_310 VGND VPWR sky130_fd_sc_hd__tapvpwrvgnd_1
XTAP_TAPCELL_ROW_1_321 VGND VPWR sky130_fd_sc_hd__tapvpwrvgnd_1
XTAP_TAPCELL_ROW_29_729 VGND VPWR sky130_fd_sc_hd__tapvpwrvgnd_1
XFILLER_0_138_305 VGND VGND VPWR VPWR sky130_fd_sc_hd__decap_3
XFILLER_0_95_225 VPWR VGND VPWR VGND sky130_ef_sc_hd__decap_12
XTAP_TAPCELL_ROW_81_1510 VGND VPWR sky130_fd_sc_hd__tapvpwrvgnd_1
XFILLER_0_138_349 VPWR VGND VPWR VGND sky130_ef_sc_hd__decap_12
XTAP_TAPCELL_ROW_81_1521 VGND VPWR sky130_fd_sc_hd__tapvpwrvgnd_1
XFILLER_0_64_601 VGND VGND VPWR VPWR sky130_fd_sc_hd__decap_3
XFILLER_0_48_141 VPWR VGND VPWR VGND sky130_ef_sc_hd__decap_12
XFILLER_0_49_686 VGND VGND VPWR VPWR sky130_fd_sc_hd__fill_1
XFILLER_0_119_541 VPWR VGND VPWR VGND sky130_ef_sc_hd__decap_12
XFILLER_0_63_111 VGND VGND VPWR VPWR sky130_fd_sc_hd__fill_1
XPHY_EDGE_ROW_22_Left_161 VGND VGND VPWR VPWR sky130_fd_sc_hd__decap_3
XTAP_TAPCELL_ROW_40_905 VGND VPWR sky130_fd_sc_hd__tapvpwrvgnd_1
XFILLER_0_119_585 VPWR VGND VPWR VGND sky130_ef_sc_hd__decap_12
XFILLER_0_64_678 VGND VGND VPWR VPWR sky130_fd_sc_hd__fill_1
XFILLER_0_9_783 VGND VGND VPWR VPWR sky130_fd_sc_hd__fill_1
XFILLER_0_134_533 VPWR VGND VPWR VGND sky130_ef_sc_hd__decap_12
XFILLER_0_52_829 VPWR VGND VPWR VGND sky130_ef_sc_hd__decap_12
XFILLER_0_17_561 VPWR VGND VPWR VGND sky130_ef_sc_hd__decap_12
XFILLER_0_51_317 VPWR VGND VPWR VGND sky130_ef_sc_hd__decap_12
XFILLER_0_121_205 VPWR VGND VPWR VGND sky130_ef_sc_hd__decap_12
XFILLER_0_60_840 VGND VGND VPWR VPWR sky130_fd_sc_hd__fill_2
XFILLER_0_121_249 VPWR VGND VPWR VGND sky130_ef_sc_hd__decap_12
XTAP_TAPCELL_ROW_79_1483 VGND VPWR sky130_fd_sc_hd__tapvpwrvgnd_1
XTAP_TAPCELL_ROW_9_432 VGND VPWR sky130_fd_sc_hd__tapvpwrvgnd_1
XFILLER_0_20_737 VPWR VGND VPWR VGND sky130_ef_sc_hd__decap_12
XTAP_TAPCELL_ROW_92_1683 VGND VPWR sky130_fd_sc_hd__tapvpwrvgnd_1
XPHY_EDGE_ROW_31_Left_170 VGND VGND VPWR VPWR sky130_fd_sc_hd__decap_3
XFILLER_0_99_520 VGND VGND VPWR VPWR sky130_fd_sc_hd__decap_8
XFILLER_0_115_27 VPWR VGND VPWR VGND sky130_ef_sc_hd__decap_12
XFILLER_0_129_305 VPWR VGND VPWR VGND sky130_ef_sc_hd__decap_12
XFILLER_0_129_349 VPWR VGND VPWR VGND sky130_ef_sc_hd__decap_12
XFILLER_0_67_461 VGND VGND VPWR VPWR sky130_fd_sc_hd__decap_4
XFILLER_0_131_15 VPWR VGND VPWR VGND sky130_ef_sc_hd__decap_12
XFILLER_0_67_472 VGND VGND VPWR VPWR sky130_fd_sc_hd__fill_1
XFILLER_0_7_709 VPWR VGND VPWR VGND sky130_ef_sc_hd__decap_12
XFILLER_0_70_604 VGND VGND VPWR VPWR sky130_fd_sc_hd__decap_4
XFILLER_0_55_667 VGND VGND VPWR VPWR sky130_fd_sc_hd__decap_4
XFILLER_0_55_656 VGND VGND VPWR VPWR sky130_fd_sc_hd__fill_2
XFILLER_0_54_133 VGND VGND VPWR VPWR sky130_fd_sc_hd__decap_6
XFILLER_0_137_393 VPWR VGND VPWR VGND sky130_ef_sc_hd__decap_12
XFILLER_0_82_475 VGND VGND VPWR VPWR sky130_fd_sc_hd__fill_1
XFILLER_0_70_615 VGND VGND VPWR VPWR sky130_fd_sc_hd__decap_4
XFILLER_0_55_689 VGND VGND VPWR VPWR sky130_fd_sc_hd__decap_4
XFILLER_0_54_177 VPWR VGND VPWR VGND sky130_ef_sc_hd__decap_12
X_2630_ _0579_ _0558_ _0569_ _0594_ VGND VGND VPWR VPWR _0595_ sky130_fd_sc_hd__and4b_2
XFILLER_0_70_659 VGND VGND VPWR VPWR sky130_fd_sc_hd__decap_8
XFILLER_0_35_391 VGND VGND VPWR VPWR sky130_fd_sc_hd__fill_1
X_2561_ cpu_inst.decoder_inst.current_pc\[6\] _0525_ VGND VGND VPWR VPWR _0526_ sky130_fd_sc_hd__nand2_1
XFILLER_0_23_553 VGND VGND VPWR VPWR sky130_fd_sc_hd__decap_6
XFILLER_0_2_469 VGND VGND VPWR VPWR sky130_fd_sc_hd__decap_6
XFILLER_0_23_597 VPWR VGND VPWR VGND sky130_ef_sc_hd__decap_12
X_5280_ clknet_leaf_33_clk _0200_ VGND VGND VPWR VPWR cpu_inst.regfile_inst.registers\[1\]\[8\]
+ sky130_fd_sc_hd__dfxtp_1
X_4300_ _0688_ cpu_inst.regfile_inst.registers\[5\]\[1\] _2092_ VGND VGND VPWR VPWR
+ _2094_ sky130_fd_sc_hd__mux2_1
XFILLER_0_49_55 VGND VGND VPWR VPWR sky130_fd_sc_hd__fill_1
XFILLER_0_121_783 VGND VGND VPWR VPWR sky130_fd_sc_hd__fill_1
X_4231_ cpu_inst.regfile_inst.registers\[24\]\[0\] VGND VGND VPWR VPWR _2058_ sky130_fd_sc_hd__clkbuf_1
X_4162_ _0521_ cpu_inst.decoder_inst.current_pc\[2\] cpu_inst.decoder_inst.current_pc\[1\]
+ VGND VGND VPWR VPWR _2021_ sky130_fd_sc_hd__nor3_2
X_4093_ _1983_ VGND VGND VPWR VPWR _0064_ sky130_fd_sc_hd__clkbuf_1
X_3113_ net15 _1077_ VGND VGND VPWR VPWR _1078_ sky130_fd_sc_hd__or2_1
XTAP_TAPCELL_ROW_108_1922 VGND VPWR sky130_fd_sc_hd__tapvpwrvgnd_1
X_3044_ _1007_ _1008_ _0883_ VGND VGND VPWR VPWR _1009_ sky130_fd_sc_hd__mux2_1
XFILLER_0_77_225 VPWR VGND VPWR VGND sky130_ef_sc_hd__decap_12
XFILLER_0_93_707 VGND VGND VPWR VPWR sky130_fd_sc_hd__decap_8
X_4995_ _2486_ VGND VGND VPWR VPWR _0463_ sky130_fd_sc_hd__clkbuf_1
XFILLER_0_58_450 VPWR VGND VPWR VGND sky130_ef_sc_hd__decap_12
XFILLER_0_105_93 VPWR VGND VPWR VGND sky130_ef_sc_hd__decap_12
X_3946_ _1869_ _1870_ _1313_ VGND VGND VPWR VPWR _1871_ sky130_fd_sc_hd__mux2_1
XFILLER_0_73_420 VGND VGND VPWR VPWR sky130_fd_sc_hd__decap_8
XTAP_TAPCELL_ROW_63_1251 VGND VPWR sky130_fd_sc_hd__tapvpwrvgnd_1
XTAP_TAPCELL_ROW_63_1240 VGND VPWR sky130_fd_sc_hd__tapvpwrvgnd_1
XFILLER_0_45_111 VGND VGND VPWR VPWR sky130_fd_sc_hd__fill_1
XFILLER_0_46_645 VGND VGND VPWR VPWR sky130_fd_sc_hd__fill_2
XFILLER_0_116_533 VPWR VGND VPWR VGND sky130_ef_sc_hd__decap_12
X_3877_ _1667_ VGND VGND VPWR VPWR _1804_ sky130_fd_sc_hd__buf_2
XFILLER_0_90_3 VPWR VGND VPWR VGND sky130_ef_sc_hd__decap_12
XFILLER_0_33_317 VPWR VGND VPWR VGND sky130_ef_sc_hd__decap_12
XFILLER_0_131_503 VGND VGND VPWR VPWR sky130_fd_sc_hd__fill_1
XFILLER_0_121_81 VPWR VGND VPWR VGND sky130_ef_sc_hd__decap_12
XFILLER_0_103_205 VPWR VGND VPWR VGND sky130_ef_sc_hd__decap_12
XFILLER_0_14_531 VGND VGND VPWR VPWR sky130_fd_sc_hd__fill_1
X_2828_ _0790_ _0792_ _0613_ VGND VGND VPWR VPWR _0793_ sky130_fd_sc_hd__a21o_1
XFILLER_0_103_249 VPWR VGND VPWR VGND sky130_ef_sc_hd__decap_12
X_5547_ clknet_leaf_19_clk _0467_ VGND VGND VPWR VPWR cpu_inst.regfile_inst.registers\[15\]\[19\]
+ sky130_fd_sc_hd__dfxtp_1
XFILLER_0_41_361 VPWR VGND VPWR VGND sky130_ef_sc_hd__decap_12
X_2759_ cpu_inst.regfile_inst.registers\[15\]\[11\] _0710_ _0721_ _0723_ _0714_ VGND
+ VGND VPWR VPWR _0724_ sky130_fd_sc_hd__a221o_1
X_5478_ clknet_leaf_26_clk _0398_ VGND VGND VPWR VPWR cpu_inst.regfile_inst.registers\[9\]\[14\]
+ sky130_fd_sc_hd__dfxtp_1
X_4429_ _1298_ _2090_ _1290_ VGND VGND VPWR VPWR _2160_ sky130_fd_sc_hd__or3b_2
XFILLER_0_111_293 VPWR VGND VPWR VGND sky130_ef_sc_hd__decap_12
XFILLER_0_10_781 VPWR VGND VPWR VGND sky130_ef_sc_hd__decap_12
XFILLER_0_138_113 VPWR VGND VPWR VGND sky130_ef_sc_hd__decap_12
XFILLER_0_56_409 VGND VGND VPWR VPWR sky130_fd_sc_hd__fill_1
XFILLER_0_127_809 VPWR VGND VPWR VGND sky130_ef_sc_hd__decap_12
XFILLER_0_83_217 VGND VGND VPWR VPWR sky130_fd_sc_hd__decap_6
XFILLER_0_107_500 VGND VGND VPWR VPWR sky130_fd_sc_hd__fill_1
XFILLER_0_92_762 VGND VGND VPWR VPWR sky130_fd_sc_hd__decap_6
XFILLER_0_64_453 VPWR VGND VPWR VGND sky130_ef_sc_hd__decap_12
XFILLER_0_36_133 VGND VGND VPWR VPWR sky130_fd_sc_hd__decap_6
XFILLER_0_119_393 VPWR VGND VPWR VGND sky130_ef_sc_hd__decap_12
XFILLER_0_107_555 VGND VGND VPWR VPWR sky130_fd_sc_hd__decap_4
XFILLER_0_91_261 VPWR VGND VPWR VGND sky130_ef_sc_hd__decap_12
XFILLER_0_36_177 VPWR VGND VPWR VGND sky130_ef_sc_hd__decap_12
XFILLER_0_134_363 VGND VGND VPWR VPWR sky130_fd_sc_hd__fill_1
XFILLER_0_10_27 VGND VGND VPWR VPWR sky130_fd_sc_hd__fill_1
XFILLER_0_17_391 VGND VGND VPWR VPWR sky130_fd_sc_hd__fill_1
XFILLER_0_51_125 VPWR VGND VPWR VGND sky130_ef_sc_hd__decap_12
XFILLER_0_122_525 VGND VGND VPWR VPWR sky130_fd_sc_hd__decap_6
XTAP_TAPCELL_ROW_94_1712 VGND VPWR sky130_fd_sc_hd__tapvpwrvgnd_1
XFILLER_0_20_501 VPWR VGND VPWR VGND sky130_ef_sc_hd__decap_12
XFILLER_0_51_169 VPWR VGND VPWR VGND sky130_ef_sc_hd__decap_12
XFILLER_0_122_569 VPWR VGND VPWR VGND sky130_ef_sc_hd__decap_12
XFILLER_0_60_681 VGND VGND VPWR VPWR sky130_fd_sc_hd__fill_1
XFILLER_0_103_783 VGND VGND VPWR VPWR sky130_fd_sc_hd__fill_1
XFILLER_0_20_545 VPWR VGND VPWR VGND sky130_ef_sc_hd__decap_12
XFILLER_0_20_589 VPWR VGND VPWR VGND sky130_ef_sc_hd__decap_12
XFILLER_0_19_69 VPWR VGND VPWR VGND sky130_ef_sc_hd__decap_12
XFILLER_0_126_15 VPWR VGND VPWR VGND sky130_ef_sc_hd__decap_12
XTAP_TAPCELL_ROW_121_2108 VGND VPWR sky130_fd_sc_hd__tapvpwrvgnd_1
XFILLER_0_99_361 VPWR VGND VPWR VGND sky130_ef_sc_hd__decap_12
XFILLER_0_35_57 VPWR VGND VPWR VGND sky130_ef_sc_hd__decap_12
XTAP_TAPCELL_ROW_121_2119 VGND VPWR sky130_fd_sc_hd__tapvpwrvgnd_1
XFILLER_0_59_225 VPWR VGND VPWR VGND sky130_ef_sc_hd__decap_12
XFILLER_0_129_113 VPWR VGND VPWR VGND sky130_ef_sc_hd__decap_12
XFILLER_0_75_729 VPWR VGND VPWR VGND sky130_ef_sc_hd__decap_12
XTAP_TAPCELL_ROW_103_1852 VGND VPWR sky130_fd_sc_hd__tapvpwrvgnd_1
X_3800_ cpu_inst.regfile_inst.registers\[5\]\[26\] cpu_inst.regfile_inst.registers\[4\]\[26\]
+ _1657_ VGND VGND VPWR VPWR _1729_ sky130_fd_sc_hd__mux2_1
XTAP_TAPCELL_ROW_103_1841 VGND VPWR sky130_fd_sc_hd__tapvpwrvgnd_1
XFILLER_0_68_770 VGND VGND VPWR VPWR sky130_fd_sc_hd__fill_1
XFILLER_0_27_111 VGND VGND VPWR VPWR sky130_fd_sc_hd__fill_1
X_4780_ cpu_inst.regfile_inst.registers\[0\]\[8\] VGND VGND VPWR VPWR _2375_ sky130_fd_sc_hd__clkbuf_1
XFILLER_0_129_3 VPWR VGND VPWR VGND sky130_ef_sc_hd__decap_12
X_3731_ _1630_ VGND VGND VPWR VPWR _1662_ sky130_fd_sc_hd__inv_2
XFILLER_0_7_517 VPWR VGND VPWR VGND sky130_ef_sc_hd__decap_12
XFILLER_0_15_317 VPWR VGND VPWR VGND sky130_ef_sc_hd__decap_12
XTAP_TAPCELL_ROW_31_768 VGND VPWR sky130_fd_sc_hd__tapvpwrvgnd_1
XFILLER_0_43_615 VGND VGND VPWR VPWR sky130_fd_sc_hd__fill_1
XTAP_TAPCELL_ROW_136_2340 VGND VPWR sky130_fd_sc_hd__tapvpwrvgnd_1
XFILLER_0_113_503 VGND VGND VPWR VPWR sky130_fd_sc_hd__fill_1
X_3662_ _1028_ _1593_ _1594_ _0721_ VGND VGND VPWR VPWR _1595_ sky130_fd_sc_hd__o211a_1
Xclkload10 clknet_leaf_2_clk VGND VGND VPWR VPWR clkload10/Y sky130_fd_sc_hd__clkinv_4
XFILLER_0_125_385 VGND VGND VPWR VPWR sky130_fd_sc_hd__decap_6
Xclkload32 clknet_leaf_13_clk VGND VGND VPWR VPWR clkload32/Y sky130_fd_sc_hd__inv_6
X_3593_ _1445_ _1484_ VGND VGND VPWR VPWR _1528_ sky130_fd_sc_hd__or2_1
XFILLER_0_70_489 VGND VGND VPWR VPWR sky130_fd_sc_hd__decap_8
Xclkload21 clknet_leaf_26_clk VGND VGND VPWR VPWR clkload21/Y sky130_fd_sc_hd__inv_8
X_5401_ clknet_leaf_27_clk _0321_ VGND VGND VPWR VPWR cpu_inst.display_inst.digit_select\[1\]
+ sky130_fd_sc_hd__dfxtp_1
X_2613_ net17 _0518_ _0523_ _0531_ VGND VGND VPWR VPWR _0578_ sky130_fd_sc_hd__nor4_4
XTAP_TAPCELL_ROW_11_470 VGND VPWR sky130_fd_sc_hd__tapvpwrvgnd_1
XFILLER_0_30_309 VPWR VGND VPWR VGND sky130_ef_sc_hd__decap_12
X_5332_ clknet_leaf_7_clk _0252_ VGND VGND VPWR VPWR cpu_inst.regfile_inst.registers\[7\]\[28\]
+ sky130_fd_sc_hd__dfxtp_1
X_2544_ cpu_inst.decoder_inst.current_pc\[2\] cpu_inst.decoder_inst.current_pc\[1\]
+ cpu_inst.decoder_inst.current_pc\[3\] VGND VGND VPWR VPWR _0509_ sky130_fd_sc_hd__or3b_1
XFILLER_0_2_233 VPWR VGND VPWR VGND sky130_ef_sc_hd__decap_12
XFILLER_0_23_361 VPWR VGND VPWR VGND sky130_ef_sc_hd__decap_12
XFILLER_0_2_277 VPWR VGND VPWR VGND sky130_ef_sc_hd__decap_12
X_5263_ clknet_leaf_15_clk _0183_ VGND VGND VPWR VPWR cpu_inst.regfile_inst.registers\[5\]\[23\]
+ sky130_fd_sc_hd__dfxtp_1
X_4214_ _2049_ VGND VGND VPWR VPWR _0119_ sky130_fd_sc_hd__clkbuf_1
X_5194_ clknet_leaf_20_clk _0114_ VGND VGND VPWR VPWR cpu_inst.regfile_inst.registers\[4\]\[18\]
+ sky130_fd_sc_hd__dfxtp_1
XFILLER_0_76_53 VPWR VGND VPWR VGND sky130_ef_sc_hd__decap_12
X_4145_ _2012_ VGND VGND VPWR VPWR _0087_ sky130_fd_sc_hd__clkbuf_1
XFILLER_0_76_97 VPWR VGND VPWR VGND sky130_ef_sc_hd__decap_12
X_4076_ cpu_inst.regfile_inst.registers\[2\]\[25\] VGND VGND VPWR VPWR _1974_ sky130_fd_sc_hd__clkbuf_1
XFILLER_0_92_41 VPWR VGND VPWR VGND sky130_ef_sc_hd__decap_12
XFILLER_0_92_85 VPWR VGND VPWR VGND sky130_ef_sc_hd__decap_12
X_3027_ _0840_ _0816_ _0991_ _0514_ VGND VGND VPWR VPWR _0992_ sky130_fd_sc_hd__a31o_1
XTAP_TAPCELL_ROW_39_879 VGND VPWR sky130_fd_sc_hd__tapvpwrvgnd_1
XFILLER_0_78_589 VGND VGND VPWR VPWR sky130_fd_sc_hd__decap_8
XTAP_TAPCELL_ROW_19_581 VGND VPWR sky130_fd_sc_hd__tapvpwrvgnd_1
XTAP_TAPCELL_ROW_19_592 VGND VPWR sky130_fd_sc_hd__tapvpwrvgnd_1
XFILLER_0_109_809 VPWR VGND VPWR VGND sky130_ef_sc_hd__decap_12
XFILLER_0_65_217 VGND VGND VPWR VPWR sky130_fd_sc_hd__decap_6
XFILLER_0_135_105 VGND VGND VPWR VPWR sky130_fd_sc_hd__decap_6
XFILLER_0_18_133 VGND VGND VPWR VPWR sky130_fd_sc_hd__decap_6
X_4978_ _2477_ VGND VGND VPWR VPWR _0455_ sky130_fd_sc_hd__clkbuf_1
XFILLER_0_135_149 VPWR VGND VPWR VGND sky130_ef_sc_hd__decap_12
X_3929_ _1841_ _1854_ VGND VGND VPWR VPWR _1855_ sky130_fd_sc_hd__nor2_1
XFILLER_0_80_209 VPWR VGND VPWR VGND sky130_ef_sc_hd__decap_12
XFILLER_0_73_261 VPWR VGND VPWR VGND sky130_ef_sc_hd__decap_12
Xclkload4 clknet_leaf_1_clk VGND VGND VPWR VPWR clkload4/Y sky130_fd_sc_hd__inv_6
XFILLER_0_61_412 VGND VGND VPWR VPWR sky130_fd_sc_hd__decap_4
XFILLER_0_18_177 VPWR VGND VPWR VGND sky130_ef_sc_hd__decap_12
XFILLER_0_46_475 VGND VGND VPWR VPWR sky130_fd_sc_hd__fill_1
XFILLER_0_116_363 VGND VGND VPWR VPWR sky130_fd_sc_hd__fill_1
XFILLER_0_61_434 VGND VGND VPWR VPWR sky130_fd_sc_hd__fill_1
XFILLER_0_33_125 VPWR VGND VPWR VGND sky130_ef_sc_hd__decap_12
XFILLER_0_34_648 VPWR VGND VPWR VGND sky130_ef_sc_hd__decap_12
XFILLER_0_33_169 VPWR VGND VPWR VGND sky130_ef_sc_hd__decap_12
XFILLER_0_104_569 VPWR VGND VPWR VGND sky130_ef_sc_hd__decap_12
XTAP_TAPCELL_ROW_76_1442 VGND VPWR sky130_fd_sc_hd__tapvpwrvgnd_1
XFILLER_0_88_309 VPWR VGND VPWR VGND sky130_ef_sc_hd__decap_12
XFILLER_0_69_534 VGND VGND VPWR VPWR sky130_fd_sc_hd__decap_3
XFILLER_0_69_556 VGND VGND VPWR VPWR sky130_fd_sc_hd__decap_4
XFILLER_0_127_617 VPWR VGND VPWR VGND sky130_ef_sc_hd__decap_12
XFILLER_0_37_442 VGND VGND VPWR VPWR sky130_fd_sc_hd__decap_6
XFILLER_0_21_15 VPWR VGND VPWR VGND sky130_ef_sc_hd__decap_12
XFILLER_0_52_434 VGND VGND VPWR VPWR sky130_fd_sc_hd__decap_8
XTAP_TAPCELL_ROW_118_2070 VGND VPWR sky130_fd_sc_hd__tapvpwrvgnd_1
XFILLER_0_107_385 VGND VGND VPWR VPWR sky130_fd_sc_hd__decap_6
XFILLER_0_12_309 VPWR VGND VPWR VGND sky130_ef_sc_hd__decap_12
XFILLER_0_122_333 VPWR VGND VPWR VGND sky130_ef_sc_hd__decap_12
XFILLER_0_21_821 VPWR VGND VPWR VGND sky130_ef_sc_hd__decap_12
XFILLER_0_122_377 VPWR VGND VPWR VGND sky130_ef_sc_hd__decap_12
XTAP_TAPCELL_ROW_131_2270 VGND VPWR sky130_fd_sc_hd__tapvpwrvgnd_1
XFILLER_0_137_69 VPWR VGND VPWR VGND sky130_ef_sc_hd__decap_12
XFILLER_0_1_69 VPWR VGND VPWR VGND sky130_ef_sc_hd__decap_12
XTAP_TAPCELL_ROW_36_838 VGND VPWR sky130_fd_sc_hd__tapvpwrvgnd_1
X_4901_ _2437_ VGND VGND VPWR VPWR _0418_ sky130_fd_sc_hd__clkbuf_1
XTAP_TAPCELL_ROW_47_1010 VGND VPWR sky130_fd_sc_hd__tapvpwrvgnd_1
XFILLER_0_62_77 VGND VGND VPWR VPWR sky130_fd_sc_hd__decap_6
XTAP_TAPCELL_ROW_16_540 VGND VPWR sky130_fd_sc_hd__tapvpwrvgnd_1
XFILLER_0_47_217 VGND VGND VPWR VPWR sky130_fd_sc_hd__decap_6
XFILLER_0_117_105 VGND VGND VPWR VPWR sky130_fd_sc_hd__decap_6
XFILLER_0_8_837 VGND VGND VPWR VPWR sky130_fd_sc_hd__decap_4
X_4832_ cpu_inst.regfile_inst.registers\[9\]\[2\] VGND VGND VPWR VPWR _2401_ sky130_fd_sc_hd__clkbuf_1
XFILLER_0_117_149 VPWR VGND VPWR VGND sky130_ef_sc_hd__decap_12
XFILLER_0_62_209 VPWR VGND VPWR VGND sky130_ef_sc_hd__decap_12
X_4763_ _2292_ _2366_ cpu_inst.decoder_inst.current_pc\[31\] _2288_ VGND VGND VPWR
+ VPWR _0351_ sky130_fd_sc_hd__o2bb2a_1
XFILLER_0_55_261 VPWR VGND VPWR VGND sky130_ef_sc_hd__decap_12
XFILLER_0_28_475 VGND VGND VPWR VPWR sky130_fd_sc_hd__fill_1
XFILLER_0_133_609 VGND VGND VPWR VPWR sky130_fd_sc_hd__decap_6
X_3714_ _1645_ VGND VGND VPWR VPWR _0023_ sky130_fd_sc_hd__clkbuf_1
X_4694_ _2293_ _2317_ cpu_inst.decoder_inst.current_pc\[11\] _2289_ VGND VGND VPWR
+ VPWR _0331_ sky130_fd_sc_hd__o2bb2a_1
XFILLER_0_15_125 VPWR VGND VPWR VGND sky130_ef_sc_hd__decap_12
XFILLER_0_16_637 VGND VGND VPWR VPWR sky130_fd_sc_hd__decap_6
XFILLER_0_70_253 VPWR VGND VPWR VGND sky130_ef_sc_hd__decap_12
XFILLER_0_15_169 VPWR VGND VPWR VGND sky130_ef_sc_hd__decap_12
XFILLER_0_125_193 VPWR VGND VPWR VGND sky130_ef_sc_hd__decap_12
X_3645_ cpu_inst.regfile_inst.registers\[5\]\[22\] cpu_inst.regfile_inst.registers\[4\]\[22\]
+ _1540_ VGND VGND VPWR VPWR _1578_ sky130_fd_sc_hd__mux2_1
XFILLER_0_102_83 VGND VGND VPWR VPWR sky130_fd_sc_hd__fill_1
XFILLER_0_11_81 VPWR VGND VPWR VGND sky130_ef_sc_hd__decap_12
XFILLER_0_3_553 VGND VGND VPWR VPWR sky130_fd_sc_hd__decap_6
XFILLER_0_24_681 VPWR VGND VPWR VGND sky130_ef_sc_hd__decap_12
X_3576_ cpu_inst.regfile_inst.registers\[0\]\[20\] _0820_ _0821_ cpu_inst.regfile_inst.registers\[4\]\[20\]
+ _0853_ VGND VGND VPWR VPWR _1511_ sky130_fd_sc_hd__o221a_1
XFILLER_0_3_597 VPWR VGND VPWR VGND sky130_ef_sc_hd__decap_12
XFILLER_0_30_139 VGND VGND VPWR VPWR sky130_fd_sc_hd__fill_1
XTAP_TAPCELL_ROW_58_1172 VGND VPWR sky130_fd_sc_hd__tapvpwrvgnd_1
X_5315_ clknet_leaf_29_clk _0235_ VGND VGND VPWR VPWR cpu_inst.regfile_inst.registers\[7\]\[11\]
+ sky130_fd_sc_hd__dfxtp_1
X_5246_ clknet_leaf_34_clk _0166_ VGND VGND VPWR VPWR cpu_inst.regfile_inst.registers\[5\]\[6\]
+ sky130_fd_sc_hd__dfxtp_1
XFILLER_0_53_3 VPWR VGND VPWR VGND sky130_ef_sc_hd__decap_12
XPHY_EDGE_ROW_89_Right_89 VGND VGND VPWR VPWR sky130_fd_sc_hd__decap_3
XTAP_TAPCELL_ROW_71_1372 VGND VPWR sky130_fd_sc_hd__tapvpwrvgnd_1
XTAP_TAPCELL_ROW_71_1361 VGND VPWR sky130_fd_sc_hd__tapvpwrvgnd_1
XFILLER_0_98_607 VGND VGND VPWR VPWR sky130_fd_sc_hd__fill_1
X_5177_ clknet_leaf_40_clk _0097_ VGND VGND VPWR VPWR cpu_inst.regfile_inst.registers\[4\]\[1\]
+ sky130_fd_sc_hd__dfxtp_1
X_4128_ _2003_ VGND VGND VPWR VPWR _0079_ sky130_fd_sc_hd__clkbuf_1
X_4059_ _1965_ VGND VGND VPWR VPWR _0048_ sky130_fd_sc_hd__clkbuf_1
XFILLER_0_94_813 VPWR VGND VPWR VGND sky130_ef_sc_hd__decap_12
XFILLER_0_109_617 VPWR VGND VPWR VGND sky130_ef_sc_hd__decap_12
XPHY_EDGE_ROW_98_Right_98 VGND VGND VPWR VPWR sky130_fd_sc_hd__decap_3
XFILLER_0_34_401 VPWR VGND VPWR VGND sky130_ef_sc_hd__decap_12
XFILLER_0_136_469 VGND VGND VPWR VPWR sky130_fd_sc_hd__decap_6
XFILLER_0_62_743 VGND VGND VPWR VPWR sky130_fd_sc_hd__fill_1
XFILLER_0_19_497 VGND VGND VPWR VPWR sky130_fd_sc_hd__decap_6
XFILLER_0_62_787 VPWR VGND VPWR VGND sky130_ef_sc_hd__decap_12
XFILLER_0_104_333 VPWR VGND VPWR VGND sky130_ef_sc_hd__decap_12
XFILLER_0_120_837 VGND VGND VPWR VPWR sky130_fd_sc_hd__decap_4
XFILLER_0_104_377 VPWR VGND VPWR VGND sky130_ef_sc_hd__decap_12
XPHY_EDGE_ROW_5_Left_144 VGND VGND VPWR VPWR sky130_fd_sc_hd__decap_3
XFILLER_0_107_39 VPWR VGND VPWR VGND sky130_ef_sc_hd__decap_12
XTAP_TAPCELL_ROW_89_1633 VGND VPWR sky130_fd_sc_hd__tapvpwrvgnd_1
XFILLER_0_16_15 VPWR VGND VPWR VGND sky130_ef_sc_hd__decap_12
XFILLER_0_88_139 VGND VGND VPWR VPWR sky130_fd_sc_hd__fill_1
XFILLER_0_97_673 VGND VGND VPWR VPWR sky130_fd_sc_hd__fill_2
XFILLER_0_84_301 VGND VGND VPWR VPWR sky130_fd_sc_hd__decap_6
XFILLER_0_29_217 VGND VGND VPWR VPWR sky130_fd_sc_hd__decap_6
XFILLER_0_123_27 VPWR VGND VPWR VGND sky130_ef_sc_hd__decap_12
XTAP_TAPCELL_ROW_100_1800 VGND VPWR sky130_fd_sc_hd__tapvpwrvgnd_1
XFILLER_0_84_345 VPWR VGND VPWR VGND sky130_ef_sc_hd__decap_12
XFILLER_0_127_447 VGND VGND VPWR VPWR sky130_fd_sc_hd__fill_1
XFILLER_0_37_261 VPWR VGND VPWR VGND sky130_ef_sc_hd__decap_12
XFILLER_0_44_209 VPWR VGND VPWR VGND sky130_ef_sc_hd__decap_12
XFILLER_0_115_609 VGND VGND VPWR VPWR sky130_fd_sc_hd__decap_6
XFILLER_0_53_721 VGND VGND VPWR VPWR sky130_fd_sc_hd__decap_3
XFILLER_0_80_551 VGND VGND VPWR VPWR sky130_fd_sc_hd__decap_3
XFILLER_0_52_253 VPWR VGND VPWR VGND sky130_ef_sc_hd__decap_12
XFILLER_0_123_653 VPWR VGND VPWR VGND sky130_ef_sc_hd__decap_12
XFILLER_0_107_193 VPWR VGND VPWR VGND sky130_ef_sc_hd__decap_12
XFILLER_0_13_629 VPWR VGND VPWR VGND sky130_ef_sc_hd__decap_12
XFILLER_0_123_697 VPWR VGND VPWR VGND sky130_ef_sc_hd__decap_12
XFILLER_0_122_141 VPWR VGND VPWR VGND sky130_ef_sc_hd__decap_12
X_3430_ _0698_ _1367_ _1368_ VGND VGND VPWR VPWR _1369_ sky130_fd_sc_hd__a21o_1
XFILLER_0_12_139 VGND VGND VPWR VPWR sky130_fd_sc_hd__fill_1
XFILLER_0_0_501 VGND VGND VPWR VPWR sky130_fd_sc_hd__decap_3
X_3361_ _0695_ VGND VGND VPWR VPWR _1311_ sky130_fd_sc_hd__clkbuf_4
XFILLER_0_0_545 VPWR VGND VPWR VGND sky130_ef_sc_hd__decap_12
XFILLER_0_21_673 VPWR VGND VPWR VGND sky130_ef_sc_hd__decap_12
X_5100_ clknet_leaf_17_clk _0020_ VGND VGND VPWR VPWR cpu_inst.regfile_inst.registers\[6\]\[20\]
+ sky130_fd_sc_hd__dfxtp_1
XFILLER_0_0_589 VPWR VGND VPWR VGND sky130_ef_sc_hd__decap_12
XTAP_TAPCELL_ROW_111_1962 VGND VPWR sky130_fd_sc_hd__tapvpwrvgnd_1
X_3292_ _1251_ _1256_ VGND VGND VPWR VPWR _1257_ sky130_fd_sc_hd__nand2_1
XFILLER_0_57_55 VGND VGND VPWR VPWR sky130_fd_sc_hd__fill_1
X_5031_ cpu_inst.display_inst.counter\[1\] cpu_inst.display_inst.counter\[0\] VGND
+ VGND VPWR VPWR _0481_ sky130_fd_sc_hd__xor2_1
XTAP_TAPCELL_ROW_53_1091 VGND VPWR sky130_fd_sc_hd__tapvpwrvgnd_1
XFILLER_0_94_109 VPWR VGND VPWR VGND sky130_ef_sc_hd__decap_12
XFILLER_0_87_161 VGND VGND VPWR VPWR sky130_fd_sc_hd__decap_6
XFILLER_0_48_537 VGND VGND VPWR VPWR sky130_fd_sc_hd__fill_2
XFILLER_0_8_601 VPWR VGND VPWR VGND sky130_ef_sc_hd__decap_12
X_4815_ _2392_ VGND VGND VPWR VPWR _0377_ sky130_fd_sc_hd__clkbuf_1
XFILLER_0_91_827 VPWR VGND VPWR VGND sky130_ef_sc_hd__decap_12
XFILLER_0_8_645 VPWR VGND VPWR VGND sky130_ef_sc_hd__decap_12
XFILLER_0_7_111 VGND VGND VPWR VPWR sky130_fd_sc_hd__fill_1
XFILLER_0_118_469 VGND VGND VPWR VPWR sky130_fd_sc_hd__decap_6
XFILLER_0_16_401 VPWR VGND VPWR VGND sky130_ef_sc_hd__decap_12
XFILLER_0_133_417 VPWR VGND VPWR VGND sky130_ef_sc_hd__decap_12
XFILLER_0_113_93 VPWR VGND VPWR VGND sky130_ef_sc_hd__decap_12
X_4746_ cpu_inst.decoder_inst.current_pc\[26\] _2351_ VGND VGND VPWR VPWR _2355_ sky130_fd_sc_hd__and2_1
XFILLER_0_16_445 VPWR VGND VPWR VGND sky130_ef_sc_hd__decap_12
XFILLER_0_44_754 VGND VGND VPWR VPWR sky130_fd_sc_hd__fill_2
XFILLER_0_71_573 VGND VGND VPWR VPWR sky130_fd_sc_hd__decap_6
X_4677_ _2303_ _2304_ VGND VGND VPWR VPWR _2305_ sky130_fd_sc_hd__nor2_1
XFILLER_0_16_489 VPWR VGND VPWR VGND sky130_ef_sc_hd__decap_12
XFILLER_0_102_837 VGND VGND VPWR VPWR sky130_fd_sc_hd__decap_4
X_3628_ cpu_inst.regfile_inst.registers\[0\]\[21\] _0615_ _1559_ _1560_ _1561_ VGND
+ VGND VPWR VPWR _1562_ sky130_fd_sc_hd__o221a_1
XFILLER_0_3_361 VPWR VGND VPWR VGND sky130_ef_sc_hd__decap_12
XTAP_TAPCELL_ROW_73_1401 VGND VPWR sky130_fd_sc_hd__tapvpwrvgnd_1
X_3559_ _1494_ VGND VGND VPWR VPWR _0019_ sky130_fd_sc_hd__clkbuf_1
XFILLER_0_11_161 VGND VGND VPWR VPWR sky130_fd_sc_hd__decap_6
X_5229_ clknet_leaf_16_clk _0149_ VGND VGND VPWR VPWR cpu_inst.regfile_inst.registers\[24\]\[21\]
+ sky130_fd_sc_hd__dfxtp_1
XFILLER_0_98_448 VGND VGND VPWR VPWR sky130_fd_sc_hd__fill_1
XFILLER_0_67_802 VGND VGND VPWR VPWR sky130_fd_sc_hd__fill_1
XFILLER_0_79_673 VGND VGND VPWR VPWR sky130_fd_sc_hd__fill_1
XFILLER_0_67_824 VGND VGND VPWR VPWR sky130_fd_sc_hd__decap_6
XFILLER_0_66_301 VGND VGND VPWR VPWR sky130_fd_sc_hd__decap_6
XFILLER_0_94_654 VPWR VGND VPWR VGND sky130_ef_sc_hd__decap_12
XFILLER_0_94_643 VGND VGND VPWR VPWR sky130_fd_sc_hd__fill_1
XFILLER_0_94_632 VGND VGND VPWR VPWR sky130_fd_sc_hd__decap_8
XTAP_TAPCELL_ROW_84_1563 VGND VPWR sky130_fd_sc_hd__tapvpwrvgnd_1
XFILLER_0_136_233 VPWR VGND VPWR VGND sky130_ef_sc_hd__decap_12
XFILLER_0_109_447 VGND VGND VPWR VPWR sky130_fd_sc_hd__fill_1
XFILLER_0_26_209 VPWR VGND VPWR VGND sky130_ef_sc_hd__decap_12
XPHY_EDGE_ROW_117_Right_117 VGND VGND VPWR VPWR sky130_fd_sc_hd__decap_3
XFILLER_0_81_337 VPWR VGND VPWR VGND sky130_ef_sc_hd__decap_12
XFILLER_0_19_261 VPWR VGND VPWR VGND sky130_ef_sc_hd__decap_12
XFILLER_0_136_277 VPWR VGND VPWR VGND sky130_ef_sc_hd__decap_12
XFILLER_0_62_540 VGND VGND VPWR VPWR sky130_fd_sc_hd__decap_6
XFILLER_0_62_573 VGND VGND VPWR VPWR sky130_fd_sc_hd__fill_2
XFILLER_0_34_253 VPWR VGND VPWR VGND sky130_ef_sc_hd__decap_12
XFILLER_0_50_735 VGND VGND VPWR VPWR sky130_fd_sc_hd__decap_6
XFILLER_0_120_601 VPWR VGND VPWR VGND sky130_ef_sc_hd__decap_12
XFILLER_0_104_141 VPWR VGND VPWR VGND sky130_ef_sc_hd__decap_12
XFILLER_0_120_645 VPWR VGND VPWR VGND sky130_ef_sc_hd__decap_12
XFILLER_0_118_27 VGND VGND VPWR VPWR sky130_fd_sc_hd__fill_1
XFILLER_0_27_69 VPWR VGND VPWR VGND sky130_ef_sc_hd__decap_12
XFILLER_0_134_15 VPWR VGND VPWR VGND sky130_ef_sc_hd__decap_12
XTAP_TAPCELL_ROW_126_2191 VGND VPWR sky130_fd_sc_hd__tapvpwrvgnd_1
XFILLER_0_76_109 VPWR VGND VPWR VGND sky130_ef_sc_hd__decap_12
XFILLER_0_69_161 VGND VGND VPWR VPWR sky130_fd_sc_hd__decap_6
XFILLER_0_128_701 VPWR VGND VPWR VGND sky130_ef_sc_hd__decap_12
X_2930_ _0893_ _0894_ _0653_ VGND VGND VPWR VPWR _0895_ sky130_fd_sc_hd__mux2_1
XFILLER_0_43_57 VPWR VGND VPWR VGND sky130_ef_sc_hd__decap_12
XTAP_TAPCELL_ROW_46_988 VGND VPWR sky130_fd_sc_hd__tapvpwrvgnd_1
XFILLER_0_84_153 VPWR VGND VPWR VGND sky130_ef_sc_hd__decap_12
XTAP_TAPCELL_ROW_26_690 VGND VPWR sky130_fd_sc_hd__tapvpwrvgnd_1
X_4600_ _2248_ VGND VGND VPWR VPWR _0306_ sky130_fd_sc_hd__clkbuf_1
XFILLER_0_84_197 VPWR VGND VPWR VGND sky130_ef_sc_hd__decap_12
XFILLER_0_72_326 VPWR VGND VPWR VGND sky130_ef_sc_hd__decap_12
X_2861_ _0735_ _0822_ _0825_ _0714_ VGND VGND VPWR VPWR _0826_ sky130_fd_sc_hd__o22a_1
XFILLER_0_115_417 VPWR VGND VPWR VGND sky130_ef_sc_hd__decap_12
XFILLER_0_111_3 VPWR VGND VPWR VGND sky130_ef_sc_hd__decap_12
X_2792_ cpu_inst.regfile_inst.registers\[24\]\[2\] _0612_ VGND VGND VPWR VPWR _0757_
+ sky130_fd_sc_hd__or2_1
XFILLER_0_5_615 VGND VGND VPWR VPWR sky130_fd_sc_hd__fill_1
X_4531_ _2213_ VGND VGND VPWR VPWR _0272_ sky130_fd_sc_hd__clkbuf_1
XPHY_EDGE_ROW_68_Left_207 VGND VGND VPWR VPWR sky130_fd_sc_hd__decap_3
XFILLER_0_41_724 VGND VGND VPWR VPWR sky130_fd_sc_hd__decap_4
XFILLER_0_123_461 VPWR VGND VPWR VGND sky130_ef_sc_hd__decap_12
X_4462_ _2178_ VGND VGND VPWR VPWR _0238_ sky130_fd_sc_hd__clkbuf_1
XFILLER_0_40_245 VGND VGND VPWR VPWR sky130_fd_sc_hd__decap_6
X_3413_ _1349_ _1350_ _1351_ VGND VGND VPWR VPWR _1352_ sky130_fd_sc_hd__mux2_1
XFILLER_0_7_57 VPWR VGND VPWR VGND sky130_ef_sc_hd__decap_12
XFILLER_0_1_821 VPWR VGND VPWR VGND sky130_ef_sc_hd__decap_12
XFILLER_0_110_133 VGND VGND VPWR VPWR sky130_fd_sc_hd__decap_6
XFILLER_0_68_65 VPWR VGND VPWR VGND sky130_ef_sc_hd__decap_12
XTAP_TAPCELL_ROW_55_1131 VGND VPWR sky130_fd_sc_hd__tapvpwrvgnd_1
XTAP_TAPCELL_ROW_55_1120 VGND VPWR sky130_fd_sc_hd__tapvpwrvgnd_1
X_4393_ cpu_inst.regfile_inst.registers\[1\]\[14\] VGND VGND VPWR VPWR _2142_ sky130_fd_sc_hd__clkbuf_1
XFILLER_0_40_289 VPWR VGND VPWR VGND sky130_ef_sc_hd__decap_12
XFILLER_0_110_177 VPWR VGND VPWR VGND sky130_ef_sc_hd__decap_12
X_3344_ _1284_ _1298_ _1290_ VGND VGND VPWR VPWR _1299_ sky130_fd_sc_hd__or3b_2
X_3275_ cpu_inst.regfile_inst.registers\[7\]\[15\] cpu_inst.regfile_inst.registers\[6\]\[15\]
+ _0866_ VGND VGND VPWR VPWR _1240_ sky130_fd_sc_hd__mux2_1
X_5014_ _2496_ VGND VGND VPWR VPWR _0472_ sky130_fd_sc_hd__clkbuf_1
XFILLER_0_84_53 VPWR VGND VPWR VGND sky130_ef_sc_hd__decap_12
XFILLER_0_84_97 VPWR VGND VPWR VGND sky130_ef_sc_hd__decap_12
XPHY_EDGE_ROW_77_Left_216 VGND VGND VPWR VPWR sky130_fd_sc_hd__decap_3
XFILLER_0_16_3 VPWR VGND VPWR VGND sky130_ef_sc_hd__decap_12
XFILLER_0_48_301 VGND VGND VPWR VPWR sky130_fd_sc_hd__decap_6
XFILLER_0_49_813 VPWR VGND VPWR VGND sky130_ef_sc_hd__decap_12
XFILLER_0_76_643 VGND VGND VPWR VPWR sky130_fd_sc_hd__fill_1
XFILLER_0_48_345 VPWR VGND VPWR VGND sky130_ef_sc_hd__decap_12
XFILLER_0_91_613 VGND VGND VPWR VPWR sky130_fd_sc_hd__decap_3
XTAP_TAPCELL_ROW_66_1293 VGND VPWR sky130_fd_sc_hd__tapvpwrvgnd_1
XFILLER_0_118_233 VPWR VGND VPWR VGND sky130_ef_sc_hd__decap_12
XFILLER_0_17_721 VGND VGND VPWR VPWR sky130_fd_sc_hd__decap_6
XFILLER_0_48_389 VGND VGND VPWR VPWR sky130_fd_sc_hd__decap_6
XFILLER_0_134_737 VPWR VGND VPWR VGND sky130_ef_sc_hd__decap_12
XFILLER_0_133_225 VPWR VGND VPWR VGND sky130_ef_sc_hd__decap_12
XFILLER_0_118_277 VPWR VGND VPWR VGND sky130_ef_sc_hd__decap_12
XFILLER_0_91_657 VGND VGND VPWR VPWR sky130_fd_sc_hd__fill_1
XPHY_EDGE_ROW_86_Left_225 VGND VGND VPWR VPWR sky130_fd_sc_hd__decap_3
XFILLER_0_8_475 VGND VGND VPWR VPWR sky130_fd_sc_hd__fill_1
XFILLER_0_17_765 VPWR VGND VPWR VGND sky130_ef_sc_hd__decap_12
XFILLER_0_90_189 VGND VGND VPWR VPWR sky130_fd_sc_hd__decap_6
X_4729_ cpu_inst.decoder_inst.current_pc\[21\] cpu_inst.decoder_inst.current_pc\[22\]
+ _2338_ VGND VGND VPWR VPWR _2342_ sky130_fd_sc_hd__and3_1
XFILLER_0_16_253 VPWR VGND VPWR VGND sky130_ef_sc_hd__decap_12
XFILLER_0_44_584 VGND VGND VPWR VPWR sky130_fd_sc_hd__decap_4
XFILLER_0_102_612 VGND VGND VPWR VPWR sky130_fd_sc_hd__fill_1
XFILLER_0_31_223 VGND VGND VPWR VPWR sky130_fd_sc_hd__fill_1
XFILLER_0_32_757 VPWR VGND VPWR VGND sky130_ef_sc_hd__decap_12
XFILLER_0_101_111 VGND VGND VPWR VPWR sky130_fd_sc_hd__fill_1
XFILLER_0_4_681 VPWR VGND VPWR VGND sky130_ef_sc_hd__decap_12
XPHY_EDGE_ROW_95_Left_234 VGND VGND VPWR VPWR sky130_fd_sc_hd__decap_3
XFILLER_0_99_735 VGND VGND VPWR VPWR sky130_fd_sc_hd__fill_1
XTAP_TAPCELL_ROW_4_363 VGND VPWR sky130_fd_sc_hd__tapvpwrvgnd_1
XFILLER_0_98_245 VGND VGND VPWR VPWR sky130_fd_sc_hd__decap_6
XFILLER_0_98_289 VPWR VGND VPWR VGND sky130_ef_sc_hd__decap_12
XFILLER_0_86_418 VGND VGND VPWR VPWR sky130_fd_sc_hd__fill_2
XFILLER_0_58_109 VPWR VGND VPWR VGND sky130_ef_sc_hd__decap_12
XFILLER_0_79_492 VGND VGND VPWR VPWR sky130_fd_sc_hd__fill_2
XFILLER_0_104_29 VPWR VGND VPWR VGND sky130_ef_sc_hd__decap_12
XFILLER_0_66_153 VPWR VGND VPWR VGND sky130_ef_sc_hd__decap_12
XFILLER_0_13_27 VPWR VGND VPWR VGND sky130_ef_sc_hd__decap_12
XTAP_TAPCELL_ROW_43_947 VGND VPWR sky130_fd_sc_hd__tapvpwrvgnd_1
XFILLER_0_137_553 VGND VGND VPWR VPWR sky130_fd_sc_hd__decap_6
XFILLER_0_66_197 VPWR VGND VPWR VGND sky130_ef_sc_hd__decap_12
XFILLER_0_137_597 VPWR VGND VPWR VGND sky130_ef_sc_hd__decap_12
XFILLER_0_82_679 VGND VGND VPWR VPWR sky130_fd_sc_hd__decap_3
XFILLER_0_81_167 VGND VGND VPWR VPWR sky130_fd_sc_hd__fill_1
XFILLER_0_105_461 VGND VGND VPWR VPWR sky130_fd_sc_hd__decap_6
XTAP_TAPCELL_ROW_97_1754 VGND VPWR sky130_fd_sc_hd__tapvpwrvgnd_1
XFILLER_0_22_245 VGND VGND VPWR VPWR sky130_fd_sc_hd__decap_6
XFILLER_0_50_565 VGND VGND VPWR VPWR sky130_fd_sc_hd__decap_4
XFILLER_0_129_15 VPWR VGND VPWR VGND sky130_ef_sc_hd__decap_12
XFILLER_0_22_289 VPWR VGND VPWR VGND sky130_ef_sc_hd__decap_12
XFILLER_0_120_475 VGND VGND VPWR VPWR sky130_fd_sc_hd__fill_1
XTAP_TAPCELL_ROW_128_2220 VGND VPWR sky130_fd_sc_hd__tapvpwrvgnd_1
X_3060_ _1024_ _0878_ VGND VGND VPWR VPWR _1025_ sky130_fd_sc_hd__nand2_1
XFILLER_0_89_223 VGND VGND VPWR VPWR sky130_fd_sc_hd__fill_1
XTAP_TAPCELL_ROW_50_1050 VGND VPWR sky130_fd_sc_hd__tapvpwrvgnd_1
XFILLER_0_58_643 VGND VGND VPWR VPWR sky130_fd_sc_hd__fill_1
XFILLER_0_128_531 VGND VGND VPWR VPWR sky130_fd_sc_hd__fill_1
XTAP_TAPCELL_ROW_106_1894 VGND VPWR sky130_fd_sc_hd__tapvpwrvgnd_1
XTAP_TAPCELL_ROW_106_1883 VGND VPWR sky130_fd_sc_hd__tapvpwrvgnd_1
X_3962_ _1560_ _1885_ _1886_ VGND VGND VPWR VPWR _1887_ sky130_fd_sc_hd__o21a_1
XFILLER_0_9_217 VGND VGND VPWR VPWR sky130_fd_sc_hd__decap_6
X_3893_ _1750_ _1782_ VGND VGND VPWR VPWR _1820_ sky130_fd_sc_hd__and2b_1
X_2913_ cpu_inst.regfile_inst.registers\[25\]\[12\] _0693_ _0695_ _0862_ _0877_ VGND
+ VGND VPWR VPWR _0878_ sky130_fd_sc_hd__o2111ai_4
XFILLER_0_73_613 VGND VGND VPWR VPWR sky130_fd_sc_hd__decap_3
XFILLER_0_70_77 VGND VGND VPWR VPWR sky130_fd_sc_hd__decap_6
XTAP_TAPCELL_ROW_21_608 VGND VPWR sky130_fd_sc_hd__tapvpwrvgnd_1
XTAP_TAPCELL_ROW_21_619 VGND VPWR sky130_fd_sc_hd__tapvpwrvgnd_1
XFILLER_0_45_337 VPWR VGND VPWR VGND sky130_ef_sc_hd__decap_12
XFILLER_0_116_737 VPWR VGND VPWR VGND sky130_ef_sc_hd__decap_12
X_2844_ cpu_inst.regfile_inst.registers\[2\]\[6\] _0593_ _0702_ cpu_inst.regfile_inst.registers\[7\]\[6\]
+ VGND VGND VPWR VPWR _0809_ sky130_fd_sc_hd__o22a_1
XFILLER_0_115_225 VPWR VGND VPWR VGND sky130_ef_sc_hd__decap_12
XFILLER_0_72_189 VGND VGND VPWR VPWR sky130_fd_sc_hd__decap_6
XFILLER_0_60_318 VGND VGND VPWR VPWR sky130_fd_sc_hd__decap_3
XFILLER_0_60_307 VGND VGND VPWR VPWR sky130_fd_sc_hd__fill_1
XFILLER_0_14_713 VPWR VGND VPWR VGND sky130_ef_sc_hd__decap_12
X_5563_ clknet_leaf_31_clk _0483_ VGND VGND VPWR VPWR cpu_inst.display_inst.counter\[3\]
+ sky130_fd_sc_hd__dfxtp_1
XFILLER_0_131_729 VPWR VGND VPWR VGND sky130_ef_sc_hd__decap_12
X_2775_ _0633_ _0636_ _0641_ _0643_ VGND VGND VPWR VPWR _0740_ sky130_fd_sc_hd__a31o_1
XFILLER_0_13_223 VGND VGND VPWR VPWR sky130_fd_sc_hd__fill_1
XFILLER_0_14_757 VPWR VGND VPWR VGND sky130_ef_sc_hd__decap_12
X_4514_ cpu_inst.regfile_inst.registers\[11\]\[8\] VGND VGND VPWR VPWR _2205_ sky130_fd_sc_hd__clkbuf_1
XFILLER_0_124_781 VPWR VGND VPWR VGND sky130_ef_sc_hd__decap_12
X_5494_ clknet_leaf_4_clk _0414_ VGND VGND VPWR VPWR cpu_inst.regfile_inst.registers\[9\]\[30\]
+ sky130_fd_sc_hd__dfxtp_1
XFILLER_0_41_554 VGND VGND VPWR VPWR sky130_fd_sc_hd__decap_6
XFILLER_0_110_83 VGND VGND VPWR VPWR sky130_fd_sc_hd__fill_1
X_4445_ _2169_ VGND VGND VPWR VPWR _0230_ sky130_fd_sc_hd__clkbuf_1
XFILLER_0_111_497 VGND VGND VPWR VPWR sky130_fd_sc_hd__decap_6
XFILLER_0_1_673 VPWR VGND VPWR VGND sky130_ef_sc_hd__decap_12
X_4376_ _2133_ VGND VGND VPWR VPWR _0197_ sky130_fd_sc_hd__clkbuf_1
X_3327_ _0520_ _0580_ _0541_ VGND VGND VPWR VPWR _1282_ sky130_fd_sc_hd__o21a_1
XFILLER_0_119_81 VPWR VGND VPWR VGND sky130_ef_sc_hd__decap_12
X_3258_ _1053_ _1219_ _1220_ _1222_ _0682_ VGND VGND VPWR VPWR _1223_ sky130_fd_sc_hd__a32o_2
X_3189_ _1144_ _1148_ _1152_ _1153_ VGND VGND VPWR VPWR _1154_ sky130_fd_sc_hd__o211a_1
XTAP_TAPCELL_ROW_68_1322 VGND VPWR sky130_fd_sc_hd__tapvpwrvgnd_1
XTAP_TAPCELL_ROW_1_311 VGND VPWR sky130_fd_sc_hd__tapvpwrvgnd_1
XTAP_TAPCELL_ROW_1_322 VGND VPWR sky130_fd_sc_hd__tapvpwrvgnd_1
XFILLER_0_95_237 VPWR VGND VPWR VGND sky130_ef_sc_hd__decap_12
XTAP_TAPCELL_ROW_81_1522 VGND VPWR sky130_fd_sc_hd__tapvpwrvgnd_1
XTAP_TAPCELL_ROW_81_1511 VGND VPWR sky130_fd_sc_hd__tapvpwrvgnd_1
XFILLER_0_48_153 VPWR VGND VPWR VGND sky130_ef_sc_hd__decap_12
XFILLER_0_49_676 VGND VGND VPWR VPWR sky130_fd_sc_hd__decap_3
XFILLER_0_119_553 VGND VGND VPWR VPWR sky130_fd_sc_hd__decap_6
XFILLER_0_37_838 VGND VGND VPWR VPWR sky130_fd_sc_hd__fill_2
XTAP_TAPCELL_ROW_40_906 VGND VPWR sky130_fd_sc_hd__tapvpwrvgnd_1
XFILLER_0_134_501 VPWR VGND VPWR VGND sky130_ef_sc_hd__decap_12
XFILLER_0_119_597 VPWR VGND VPWR VGND sky130_ef_sc_hd__decap_12
XFILLER_0_52_808 VGND VGND VPWR VPWR sky130_fd_sc_hd__fill_1
XFILLER_0_48_197 VPWR VGND VPWR VGND sky130_ef_sc_hd__decap_12
XFILLER_0_134_545 VPWR VGND VPWR VGND sky130_ef_sc_hd__decap_12
XFILLER_0_63_167 VGND VGND VPWR VPWR sky130_fd_sc_hd__fill_1
XFILLER_0_17_573 VPWR VGND VPWR VGND sky130_ef_sc_hd__decap_12
XFILLER_0_51_329 VGND VGND VPWR VPWR sky130_fd_sc_hd__decap_6
XFILLER_0_134_589 VPWR VGND VPWR VGND sky130_ef_sc_hd__decap_12
XFILLER_0_32_543 VGND VGND VPWR VPWR sky130_fd_sc_hd__fill_1
XFILLER_0_121_217 VGND VGND VPWR VPWR sky130_fd_sc_hd__decap_6
XTAP_TAPCELL_ROW_79_1484 VGND VPWR sky130_fd_sc_hd__tapvpwrvgnd_1
XFILLER_0_102_442 VGND VGND VPWR VPWR sky130_fd_sc_hd__decap_8
XTAP_TAPCELL_ROW_9_433 VGND VPWR sky130_fd_sc_hd__tapvpwrvgnd_1
XFILLER_0_20_749 VGND VGND VPWR VPWR sky130_fd_sc_hd__decap_6
XFILLER_0_102_486 VGND VGND VPWR VPWR sky130_fd_sc_hd__decap_4
XTAP_TAPCELL_ROW_92_1673 VGND VPWR sky130_fd_sc_hd__tapvpwrvgnd_1
XFILLER_0_5_3 VPWR VGND VPWR VGND sky130_ef_sc_hd__decap_12
XTAP_TAPCELL_ROW_92_1684 VGND VPWR sky130_fd_sc_hd__tapvpwrvgnd_1
XTAP_TAPCELL_ROW_123_2150 VGND VPWR sky130_fd_sc_hd__tapvpwrvgnd_1
XFILLER_0_59_407 VGND VGND VPWR VPWR sky130_fd_sc_hd__fill_2
XFILLER_0_24_15 VPWR VGND VPWR VGND sky130_ef_sc_hd__decap_12
XFILLER_0_115_39 VPWR VGND VPWR VGND sky130_ef_sc_hd__decap_12
Xclkbuf_2_0__f_clk clknet_0_clk VGND VGND VPWR VPWR clknet_2_0__leaf_clk sky130_fd_sc_hd__clkbuf_16
XFILLER_0_129_317 VPWR VGND VPWR VGND sky130_ef_sc_hd__decap_12
XFILLER_0_67_440 VGND VGND VPWR VPWR sky130_fd_sc_hd__decap_8
XFILLER_0_67_484 VGND VGND VPWR VPWR sky130_fd_sc_hd__decap_6
XFILLER_0_137_361 VPWR VGND VPWR VGND sky130_ef_sc_hd__decap_12
XFILLER_0_131_27 VPWR VGND VPWR VGND sky130_ef_sc_hd__decap_12
XFILLER_0_6_209 VPWR VGND VPWR VGND sky130_ef_sc_hd__decap_12
XFILLER_0_27_337 VPWR VGND VPWR VGND sky130_ef_sc_hd__decap_12
XFILLER_0_42_307 VGND VGND VPWR VPWR sky130_fd_sc_hd__fill_1
XFILLER_0_113_729 VPWR VGND VPWR VGND sky130_ef_sc_hd__decap_12
XFILLER_0_54_189 VGND VGND VPWR VPWR sky130_fd_sc_hd__decap_6
XFILLER_0_51_830 VGND VGND VPWR VPWR sky130_fd_sc_hd__decap_8
XFILLER_0_51_841 VGND VGND VPWR VPWR sky130_fd_sc_hd__fill_1
XFILLER_0_106_781 VPWR VGND VPWR VGND sky130_ef_sc_hd__decap_12
X_2560_ cpu_inst.decoder_inst.current_pc\[5\] cpu_inst.decoder_inst.current_pc\[7\]
+ cpu_inst.decoder_inst.current_pc\[4\] VGND VGND VPWR VPWR _0525_ sky130_fd_sc_hd__nor3b_1
XFILLER_0_11_727 VGND VGND VPWR VPWR sky130_fd_sc_hd__fill_1
X_4230_ _2057_ VGND VGND VPWR VPWR _0127_ sky130_fd_sc_hd__clkbuf_1
X_4161_ _2020_ VGND VGND VPWR VPWR _0095_ sky130_fd_sc_hd__clkbuf_1
X_3112_ _1057_ _1076_ _0680_ VGND VGND VPWR VPWR _1077_ sky130_fd_sc_hd__a21o_1
X_4092_ _1174_ cpu_inst.regfile_inst.registers\[25\]\[0\] _1982_ VGND VGND VPWR VPWR
+ _1983_ sky130_fd_sc_hd__mux2_1
XFILLER_0_65_55 VGND VGND VPWR VPWR sky130_fd_sc_hd__fill_1
XTAP_TAPCELL_ROW_108_1923 VGND VPWR sky130_fd_sc_hd__tapvpwrvgnd_1
X_3043_ cpu_inst.regfile_inst.registers\[7\]\[10\] cpu_inst.regfile_inst.registers\[6\]\[10\]
+ _0922_ VGND VGND VPWR VPWR _1008_ sky130_fd_sc_hd__mux2_1
XFILLER_0_77_237 VPWR VGND VPWR VGND sky130_ef_sc_hd__decap_12
X_4994_ cpu_inst.regfile_inst.registers\[15\]\[15\] _2480_ VGND VGND VPWR VPWR _2486_
+ sky130_fd_sc_hd__and2_1
XFILLER_0_86_782 VGND VGND VPWR VPWR sky130_fd_sc_hd__fill_1
X_3945_ cpu_inst.regfile_inst.registers\[7\]\[30\] cpu_inst.regfile_inst.registers\[6\]\[30\]
+ _1797_ VGND VGND VPWR VPWR _1870_ sky130_fd_sc_hd__mux2_1
XFILLER_0_73_410 VGND VGND VPWR VPWR sky130_fd_sc_hd__fill_1
XTAP_TAPCELL_ROW_63_1252 VGND VPWR sky130_fd_sc_hd__tapvpwrvgnd_1
XTAP_TAPCELL_ROW_63_1241 VGND VPWR sky130_fd_sc_hd__tapvpwrvgnd_1
XFILLER_0_58_462 VPWR VGND VPWR VGND sky130_ef_sc_hd__decap_12
XFILLER_0_116_501 VPWR VGND VPWR VGND sky130_ef_sc_hd__decap_12
XFILLER_0_85_281 VPWR VGND VPWR VGND sky130_ef_sc_hd__decap_12
XFILLER_0_116_545 VPWR VGND VPWR VGND sky130_ef_sc_hd__decap_12
X_3876_ _0686_ _1802_ _1769_ VGND VGND VPWR VPWR _1803_ sky130_fd_sc_hd__a21bo_1
XFILLER_0_45_167 VGND VGND VPWR VPWR sky130_fd_sc_hd__fill_1
XFILLER_0_46_679 VGND VGND VPWR VPWR sky130_fd_sc_hd__decap_8
XFILLER_0_116_589 VPWR VGND VPWR VGND sky130_ef_sc_hd__decap_12
XFILLER_0_83_3 VPWR VGND VPWR VGND sky130_ef_sc_hd__decap_12
XFILLER_0_61_649 VPWR VGND VPWR VGND sky130_ef_sc_hd__decap_12
XFILLER_0_61_638 VGND VGND VPWR VPWR sky130_fd_sc_hd__decap_4
XFILLER_0_33_329 VGND VGND VPWR VPWR sky130_fd_sc_hd__decap_6
X_2827_ cpu_inst.regfile_inst.registers\[0\]\[7\] _0614_ _0791_ _0705_ VGND VGND VPWR
+ VPWR _0792_ sky130_fd_sc_hd__o22a_1
XFILLER_0_121_93 VPWR VGND VPWR VGND sky130_ef_sc_hd__decap_12
XFILLER_0_103_217 VGND VGND VPWR VPWR sky130_fd_sc_hd__decap_6
X_5546_ clknet_leaf_19_clk _0466_ VGND VGND VPWR VPWR cpu_inst.regfile_inst.registers\[15\]\[18\]
+ sky130_fd_sc_hd__dfxtp_1
X_2758_ cpu_inst.regfile_inst.registers\[8\]\[11\] _0722_ _0642_ VGND VGND VPWR VPWR
+ _0723_ sky130_fd_sc_hd__mux2_1
XFILLER_0_131_559 VGND VGND VPWR VPWR sky130_fd_sc_hd__fill_1
X_5477_ clknet_leaf_26_clk _0397_ VGND VGND VPWR VPWR cpu_inst.regfile_inst.registers\[9\]\[13\]
+ sky130_fd_sc_hd__dfxtp_1
XFILLER_0_14_587 VGND VGND VPWR VPWR sky130_fd_sc_hd__fill_1
XFILLER_0_41_373 VPWR VGND VPWR VGND sky130_ef_sc_hd__decap_12
XFILLER_0_111_261 VPWR VGND VPWR VGND sky130_ef_sc_hd__decap_12
X_4428_ _2159_ VGND VGND VPWR VPWR _0223_ sky130_fd_sc_hd__clkbuf_1
X_2689_ _0649_ _0650_ _0653_ VGND VGND VPWR VPWR _0654_ sky130_fd_sc_hd__mux2_1
X_4359_ _1867_ cpu_inst.regfile_inst.registers\[5\]\[29\] _2117_ VGND VGND VPWR VPWR
+ _2125_ sky130_fd_sc_hd__mux2_1
XFILLER_0_10_793 VPWR VGND VPWR VGND sky130_ef_sc_hd__decap_12
XFILLER_0_138_125 VPWR VGND VPWR VGND sky130_ef_sc_hd__decap_12
XFILLER_0_138_169 VPWR VGND VPWR VGND sky130_ef_sc_hd__decap_12
XFILLER_0_135_821 VPWR VGND VPWR VGND sky130_ef_sc_hd__decap_12
XFILLER_0_126_309 VPWR VGND VPWR VGND sky130_ef_sc_hd__decap_12
XFILLER_0_119_361 VPWR VGND VPWR VGND sky130_ef_sc_hd__decap_12
XFILLER_0_37_646 VGND VGND VPWR VPWR sky130_fd_sc_hd__fill_2
XFILLER_0_91_273 VGND VGND VPWR VPWR sky130_fd_sc_hd__decap_6
XFILLER_0_24_307 VGND VGND VPWR VPWR sky130_fd_sc_hd__fill_1
XFILLER_0_33_841 VGND VGND VPWR VPWR sky130_fd_sc_hd__fill_1
XFILLER_0_36_189 VGND VGND VPWR VPWR sky130_fd_sc_hd__decap_6
XFILLER_0_51_137 VPWR VGND VPWR VGND sky130_ef_sc_hd__decap_12
XTAP_TAPCELL_ROW_94_1713 VGND VPWR sky130_fd_sc_hd__tapvpwrvgnd_1
XFILLER_0_60_660 VGND VGND VPWR VPWR sky130_fd_sc_hd__decap_4
XFILLER_0_20_513 VPWR VGND VPWR VGND sky130_ef_sc_hd__decap_12
XFILLER_0_130_581 VGND VGND VPWR VPWR sky130_fd_sc_hd__decap_6
XFILLER_0_20_557 VPWR VGND VPWR VGND sky130_ef_sc_hd__decap_12
XFILLER_0_19_15 VPWR VGND VPWR VGND sky130_ef_sc_hd__decap_12
XFILLER_0_126_27 VGND VGND VPWR VPWR sky130_fd_sc_hd__fill_1
XTAP_TAPCELL_ROW_121_2109 VGND VPWR sky130_fd_sc_hd__tapvpwrvgnd_1
XFILLER_0_99_373 VPWR VGND VPWR VGND sky130_ef_sc_hd__decap_12
XFILLER_0_59_237 VPWR VGND VPWR VGND sky130_ef_sc_hd__decap_12
XFILLER_0_35_69 VPWR VGND VPWR VGND sky130_ef_sc_hd__decap_12
XFILLER_0_129_125 VPWR VGND VPWR VGND sky130_ef_sc_hd__decap_12
XTAP_TAPCELL_ROW_103_1842 VGND VPWR sky130_fd_sc_hd__tapvpwrvgnd_1
XFILLER_0_129_169 VPWR VGND VPWR VGND sky130_ef_sc_hd__decap_12
X_3730_ cpu_inst.regfile_inst.registers\[25\]\[24\] _1310_ _1311_ _1660_ VGND VGND
+ VPWR VPWR _1661_ sky130_fd_sc_hd__o211ai_1
XFILLER_0_67_281 VPWR VGND VPWR VGND sky130_ef_sc_hd__decap_12
XFILLER_0_7_529 VPWR VGND VPWR VGND sky130_ef_sc_hd__decap_12
XFILLER_0_51_57 VPWR VGND VPWR VGND sky130_ef_sc_hd__decap_12
XFILLER_0_82_251 VGND VGND VPWR VPWR sky130_fd_sc_hd__fill_1
XFILLER_0_70_402 VGND VGND VPWR VPWR sky130_fd_sc_hd__fill_2
XFILLER_0_27_167 VGND VGND VPWR VPWR sky130_fd_sc_hd__fill_1
XTAP_TAPCELL_ROW_31_758 VGND VPWR sky130_fd_sc_hd__tapvpwrvgnd_1
XTAP_TAPCELL_ROW_31_769 VGND VPWR sky130_fd_sc_hd__tapvpwrvgnd_1
XTAP_TAPCELL_ROW_136_2341 VGND VPWR sky130_fd_sc_hd__tapvpwrvgnd_1
X_3661_ cpu_inst.regfile_inst.registers\[8\]\[22\] _0850_ VGND VGND VPWR VPWR _1594_
+ sky130_fd_sc_hd__or2_1
XFILLER_0_15_329 VGND VGND VPWR VPWR sky130_fd_sc_hd__decap_6
XFILLER_0_24_841 VGND VGND VPWR VPWR sky130_fd_sc_hd__fill_1
Xclkload33 clknet_leaf_14_clk VGND VGND VPWR VPWR clkload33/Y sky130_fd_sc_hd__clkinvlp_4
Xclkload11 clknet_leaf_3_clk VGND VGND VPWR VPWR clkload11/Y sky130_fd_sc_hd__clkinv_8
X_3592_ _1407_ VGND VGND VPWR VPWR _1527_ sky130_fd_sc_hd__inv_2
X_2612_ _0505_ _0508_ _0576_ VGND VGND VPWR VPWR _0577_ sky130_fd_sc_hd__and3_1
Xclkload22 clknet_leaf_27_clk VGND VGND VPWR VPWR clkload22/Y sky130_fd_sc_hd__clkinv_8
X_5400_ clknet_leaf_27_clk _0320_ VGND VGND VPWR VPWR cpu_inst.display_inst.digit_select\[0\]
+ sky130_fd_sc_hd__dfxtp_1
XTAP_TAPCELL_ROW_11_471 VGND VPWR sky130_fd_sc_hd__tapvpwrvgnd_1
XTAP_TAPCELL_ROW_11_460 VGND VPWR sky130_fd_sc_hd__tapvpwrvgnd_1
XFILLER_0_113_559 VGND VGND VPWR VPWR sky130_fd_sc_hd__fill_1
X_5331_ clknet_leaf_7_clk _0251_ VGND VGND VPWR VPWR cpu_inst.regfile_inst.registers\[7\]\[27\]
+ sky130_fd_sc_hd__dfxtp_1
X_2543_ _0506_ _0507_ VGND VGND VPWR VPWR _0508_ sky130_fd_sc_hd__nor2_1
XFILLER_0_2_245 VGND VGND VPWR VPWR sky130_fd_sc_hd__decap_6
XFILLER_0_23_373 VPWR VGND VPWR VGND sky130_ef_sc_hd__decap_12
XFILLER_0_100_209 VPWR VGND VPWR VGND sky130_ef_sc_hd__decap_12
XFILLER_0_2_289 VPWR VGND VPWR VGND sky130_ef_sc_hd__decap_12
X_5262_ clknet_leaf_15_clk _0182_ VGND VGND VPWR VPWR cpu_inst.regfile_inst.registers\[5\]\[22\]
+ sky130_fd_sc_hd__dfxtp_1
X_4213_ cpu_inst.regfile_inst.registers\[4\]\[23\] _2046_ VGND VGND VPWR VPWR _2049_
+ sky130_fd_sc_hd__and2_1
XFILLER_0_76_65 VPWR VGND VPWR VGND sky130_ef_sc_hd__decap_12
X_5193_ clknet_leaf_25_clk _0113_ VGND VGND VPWR VPWR cpu_inst.regfile_inst.registers\[4\]\[17\]
+ sky130_fd_sc_hd__dfxtp_1
X_4144_ _1644_ cpu_inst.regfile_inst.registers\[25\]\[23\] _2010_ VGND VGND VPWR VPWR
+ _2012_ sky130_fd_sc_hd__mux2_1
X_4075_ _1973_ VGND VGND VPWR VPWR _0056_ sky130_fd_sc_hd__clkbuf_1
XFILLER_0_92_53 VPWR VGND VPWR VGND sky130_ef_sc_hd__decap_12
XPHY_EDGE_ROW_50_Left_189 VGND VGND VPWR VPWR sky130_fd_sc_hd__decap_3
XFILLER_0_92_97 VPWR VGND VPWR VGND sky130_ef_sc_hd__decap_12
XFILLER_0_78_546 VGND VGND VPWR VPWR sky130_fd_sc_hd__fill_2
X_3026_ _0990_ VGND VGND VPWR VPWR _0991_ sky130_fd_sc_hd__inv_2
XFILLER_0_66_708 VGND VGND VPWR VPWR sky130_fd_sc_hd__fill_1
XTAP_TAPCELL_ROW_19_582 VGND VPWR sky130_fd_sc_hd__tapvpwrvgnd_1
XFILLER_0_59_782 VGND VGND VPWR VPWR sky130_fd_sc_hd__fill_2
XFILLER_0_117_821 VPWR VGND VPWR VGND sky130_ef_sc_hd__decap_12
XFILLER_0_108_309 VPWR VGND VPWR VGND sky130_ef_sc_hd__decap_12
XFILLER_0_93_549 VGND VGND VPWR VPWR sky130_fd_sc_hd__fill_1
XFILLER_0_46_421 VGND VGND VPWR VPWR sky130_fd_sc_hd__fill_1
X_4977_ cpu_inst.regfile_inst.registers\[15\]\[7\] _2469_ VGND VGND VPWR VPWR _2477_
+ sky130_fd_sc_hd__and2_1
X_3928_ _1842_ _1853_ VGND VGND VPWR VPWR _1854_ sky130_fd_sc_hd__xnor2_1
XFILLER_0_34_627 VGND VGND VPWR VPWR sky130_fd_sc_hd__decap_6
Xclkload5 clknet_leaf_37_clk VGND VGND VPWR VPWR clkload5/Y sky130_fd_sc_hd__clkinv_1
XFILLER_0_132_813 VPWR VGND VPWR VGND sky130_ef_sc_hd__decap_12
X_3859_ _1754_ _1786_ _1451_ VGND VGND VPWR VPWR _1787_ sky130_fd_sc_hd__mux2_1
XFILLER_0_73_273 VGND VGND VPWR VPWR sky130_fd_sc_hd__decap_6
XFILLER_0_18_189 VGND VGND VPWR VPWR sky130_fd_sc_hd__decap_6
XFILLER_0_33_137 VPWR VGND VPWR VGND sky130_ef_sc_hd__decap_12
XFILLER_0_15_841 VGND VGND VPWR VPWR sky130_fd_sc_hd__fill_1
XTAP_TAPCELL_ROW_76_1443 VGND VPWR sky130_fd_sc_hd__tapvpwrvgnd_1
X_5529_ clknet_leaf_37_clk _0449_ VGND VGND VPWR VPWR cpu_inst.regfile_inst.registers\[15\]\[1\]
+ sky130_fd_sc_hd__dfxtp_1
XFILLER_0_41_181 VPWR VGND VPWR VGND sky130_ef_sc_hd__decap_12
XFILLER_0_112_581 VGND VGND VPWR VPWR sky130_fd_sc_hd__decap_6
XFILLER_0_96_321 VPWR VGND VPWR VGND sky130_ef_sc_hd__decap_12
XFILLER_0_96_365 VPWR VGND VPWR VGND sky130_ef_sc_hd__decap_12
XFILLER_0_84_516 VGND VGND VPWR VPWR sky130_fd_sc_hd__fill_1
XFILLER_0_127_629 VPWR VGND VPWR VGND sky130_ef_sc_hd__decap_12
XFILLER_0_49_281 VPWR VGND VPWR VGND sky130_ef_sc_hd__decap_12
XFILLER_0_126_139 VGND VGND VPWR VPWR sky130_fd_sc_hd__fill_1
XFILLER_0_112_29 VPWR VGND VPWR VGND sky130_ef_sc_hd__decap_12
XFILLER_0_64_251 VGND VGND VPWR VPWR sky130_fd_sc_hd__fill_1
XFILLER_0_21_27 VPWR VGND VPWR VGND sky130_ef_sc_hd__decap_12
XFILLER_0_135_673 VPWR VGND VPWR VGND sky130_ef_sc_hd__decap_12
XFILLER_0_122_301 VGND VGND VPWR VPWR sky130_fd_sc_hd__decap_6
XTAP_TAPCELL_ROW_118_2071 VGND VPWR sky130_fd_sc_hd__tapvpwrvgnd_1
XFILLER_0_80_755 VGND VGND VPWR VPWR sky130_fd_sc_hd__fill_1
XFILLER_0_122_345 VPWR VGND VPWR VGND sky130_ef_sc_hd__decap_12
XFILLER_0_21_833 VGND VGND VPWR VPWR sky130_fd_sc_hd__decap_6
XTAP_TAPCELL_ROW_131_2260 VGND VPWR sky130_fd_sc_hd__tapvpwrvgnd_1
XFILLER_0_122_389 VPWR VGND VPWR VGND sky130_ef_sc_hd__decap_12
XFILLER_0_20_321 VPWR VGND VPWR VGND sky130_ef_sc_hd__decap_12
XTAP_TAPCELL_ROW_131_2271 VGND VPWR sky130_fd_sc_hd__tapvpwrvgnd_1
XFILLER_0_103_581 VPWR VGND VPWR VGND sky130_ef_sc_hd__decap_12
XFILLER_0_20_365 VPWR VGND VPWR VGND sky130_ef_sc_hd__decap_12
XFILLER_0_137_15 VPWR VGND VPWR VGND sky130_ef_sc_hd__decap_12
XFILLER_0_99_181 VPWR VGND VPWR VGND sky130_ef_sc_hd__decap_12
XFILLER_0_1_15 VPWR VGND VPWR VGND sky130_ef_sc_hd__decap_12
XTAP_TAPCELL_ROW_36_839 VGND VPWR sky130_fd_sc_hd__tapvpwrvgnd_1
X_4900_ _1934_ cpu_inst.regfile_inst.registers\[8\]\[2\] _2436_ VGND VGND VPWR VPWR
+ _2437_ sky130_fd_sc_hd__mux2_1
XTAP_TAPCELL_ROW_47_1000 VGND VPWR sky130_fd_sc_hd__tapvpwrvgnd_1
XTAP_TAPCELL_ROW_47_1011 VGND VPWR sky130_fd_sc_hd__tapvpwrvgnd_1
XFILLER_0_8_805 VGND VGND VPWR VPWR sky130_fd_sc_hd__decap_6
XTAP_TAPCELL_ROW_16_541 VGND VPWR sky130_fd_sc_hd__tapvpwrvgnd_1
X_4831_ _2400_ VGND VGND VPWR VPWR _0385_ sky130_fd_sc_hd__clkbuf_1
XTAP_TAPCELL_ROW_60_1200 VGND VPWR sky130_fd_sc_hd__tapvpwrvgnd_1
XFILLER_0_56_752 VGND VGND VPWR VPWR sky130_fd_sc_hd__decap_4
XFILLER_0_28_421 VPWR VGND VPWR VGND sky130_ef_sc_hd__decap_12
X_4762_ cpu_inst.decoder_inst.current_pc\[31\] _2363_ VGND VGND VPWR VPWR _2366_ sky130_fd_sc_hd__xnor2_1
XFILLER_0_7_337 VPWR VGND VPWR VGND sky130_ef_sc_hd__decap_12
XFILLER_0_132_109 VPWR VGND VPWR VGND sky130_ef_sc_hd__decap_12
X_3713_ _1644_ cpu_inst.regfile_inst.registers\[6\]\[23\] _1609_ VGND VGND VPWR VPWR
+ _1645_ sky130_fd_sc_hd__mux2_1
XFILLER_0_71_733 VGND VGND VPWR VPWR sky130_fd_sc_hd__fill_1
XFILLER_0_70_221 VPWR VGND VPWR VGND sky130_ef_sc_hd__decap_12
X_4693_ _2315_ _2316_ VGND VGND VPWR VPWR _2317_ sky130_fd_sc_hd__or2_1
XFILLER_0_55_273 VGND VGND VPWR VPWR sky130_fd_sc_hd__decap_6
XFILLER_0_125_161 VGND VGND VPWR VPWR sky130_fd_sc_hd__decap_6
XFILLER_0_114_813 VPWR VGND VPWR VGND sky130_ef_sc_hd__decap_12
X_3644_ _1525_ _1569_ _1568_ VGND VGND VPWR VPWR _1577_ sky130_fd_sc_hd__o21bai_1
XFILLER_0_15_137 VPWR VGND VPWR VGND sky130_ef_sc_hd__decap_12
XFILLER_0_43_468 VGND VGND VPWR VPWR sky130_fd_sc_hd__decap_4
XFILLER_0_70_265 VPWR VGND VPWR VGND sky130_ef_sc_hd__decap_12
XFILLER_0_12_811 VGND VGND VPWR VPWR sky130_fd_sc_hd__fill_1
XFILLER_0_11_93 VPWR VGND VPWR VGND sky130_ef_sc_hd__decap_12
X_3575_ cpu_inst.regfile_inst.registers\[2\]\[20\] _0848_ _0849_ cpu_inst.regfile_inst.registers\[7\]\[20\]
+ VGND VGND VPWR VPWR _1510_ sky130_fd_sc_hd__o22a_1
XFILLER_0_23_181 VPWR VGND VPWR VGND sky130_ef_sc_hd__decap_12
XFILLER_0_24_693 VGND VGND VPWR VPWR sky130_fd_sc_hd__decap_6
XTAP_TAPCELL_ROW_58_1173 VGND VPWR sky130_fd_sc_hd__tapvpwrvgnd_1
X_5314_ clknet_leaf_32_clk _0234_ VGND VGND VPWR VPWR cpu_inst.regfile_inst.registers\[7\]\[10\]
+ sky130_fd_sc_hd__dfxtp_1
X_5245_ clknet_leaf_35_clk _0165_ VGND VGND VPWR VPWR cpu_inst.regfile_inst.registers\[5\]\[5\]
+ sky130_fd_sc_hd__dfxtp_1
XTAP_TAPCELL_ROW_71_1362 VGND VPWR sky130_fd_sc_hd__tapvpwrvgnd_1
XFILLER_0_46_3 VPWR VGND VPWR VGND sky130_ef_sc_hd__decap_12
X_5176_ clknet_leaf_40_clk _0096_ VGND VGND VPWR VPWR cpu_inst.regfile_inst.registers\[4\]\[0\]
+ sky130_fd_sc_hd__dfxtp_1
XFILLER_0_79_811 VPWR VGND VPWR VGND sky130_ef_sc_hd__decap_12
X_4127_ _1260_ cpu_inst.regfile_inst.registers\[25\]\[15\] _1998_ VGND VGND VPWR VPWR
+ _2003_ sky130_fd_sc_hd__mux2_1
XFILLER_0_127_81 VPWR VGND VPWR VGND sky130_ef_sc_hd__decap_12
X_4058_ cpu_inst.regfile_inst.registers\[2\]\[16\] VGND VGND VPWR VPWR _1965_ sky130_fd_sc_hd__clkbuf_1
XFILLER_0_78_321 VPWR VGND VPWR VGND sky130_ef_sc_hd__decap_12
X_3009_ _0973_ _0966_ VGND VGND VPWR VPWR _0974_ sky130_fd_sc_hd__nor2_1
XFILLER_0_94_825 VPWR VGND VPWR VGND sky130_ef_sc_hd__decap_12
XFILLER_0_78_387 VGND VGND VPWR VPWR sky130_fd_sc_hd__decap_8
XFILLER_0_78_365 VPWR VGND VPWR VGND sky130_ef_sc_hd__decap_12
XFILLER_0_66_527 VGND VGND VPWR VPWR sky130_fd_sc_hd__decap_4
XFILLER_0_109_629 VPWR VGND VPWR VGND sky130_ef_sc_hd__decap_12
XFILLER_0_93_335 VGND VGND VPWR VPWR sky130_fd_sc_hd__fill_1
XFILLER_0_47_741 VGND VGND VPWR VPWR sky130_fd_sc_hd__fill_1
XFILLER_0_108_139 VGND VGND VPWR VPWR sky130_fd_sc_hd__fill_1
XFILLER_0_46_251 VGND VGND VPWR VPWR sky130_fd_sc_hd__fill_1
XFILLER_0_62_722 VGND VGND VPWR VPWR sky130_fd_sc_hd__fill_2
XFILLER_0_34_413 VGND VGND VPWR VPWR sky130_fd_sc_hd__decap_6
XFILLER_0_117_673 VPWR VGND VPWR VGND sky130_ef_sc_hd__decap_12
XFILLER_0_104_301 VGND VGND VPWR VPWR sky130_fd_sc_hd__decap_6
XFILLER_0_62_755 VGND VGND VPWR VPWR sky130_fd_sc_hd__fill_1
XFILLER_0_132_643 VGND VGND VPWR VPWR sky130_fd_sc_hd__fill_1
XFILLER_0_120_805 VGND VGND VPWR VPWR sky130_fd_sc_hd__decap_6
XFILLER_0_104_345 VPWR VGND VPWR VGND sky130_ef_sc_hd__decap_12
XFILLER_0_62_799 VGND VGND VPWR VPWR sky130_fd_sc_hd__decap_3
XFILLER_0_15_671 VGND VGND VPWR VPWR sky130_fd_sc_hd__fill_1
XFILLER_0_104_389 VPWR VGND VPWR VGND sky130_ef_sc_hd__decap_12
XTAP_TAPCELL_ROW_89_1634 VGND VPWR sky130_fd_sc_hd__tapvpwrvgnd_1
XFILLER_0_16_27 VGND VGND VPWR VPWR sky130_fd_sc_hd__fill_1
XFILLER_0_97_641 VGND VGND VPWR VPWR sky130_fd_sc_hd__fill_1
XFILLER_0_85_825 VPWR VGND VPWR VGND sky130_ef_sc_hd__decap_12
XFILLER_0_123_39 VPWR VGND VPWR VGND sky130_ef_sc_hd__decap_12
XPHY_EDGE_ROW_106_Left_245 VGND VGND VPWR VPWR sky130_fd_sc_hd__decap_3
XTAP_TAPCELL_ROW_100_1801 VGND VPWR sky130_fd_sc_hd__tapvpwrvgnd_1
XFILLER_0_96_195 VGND VGND VPWR VPWR sky130_fd_sc_hd__fill_1
XTAP_TAPCELL_ROW_13_500 VGND VPWR sky130_fd_sc_hd__tapvpwrvgnd_1
XFILLER_0_32_15 VPWR VGND VPWR VGND sky130_ef_sc_hd__decap_12
XFILLER_0_84_357 VGND VGND VPWR VPWR sky130_fd_sc_hd__decap_6
XFILLER_0_65_593 VGND VGND VPWR VPWR sky130_fd_sc_hd__decap_6
XFILLER_0_4_307 VGND VGND VPWR VPWR sky130_fd_sc_hd__fill_1
XFILLER_0_37_273 VGND VGND VPWR VPWR sky130_fd_sc_hd__decap_6
XTAP_TAPCELL_ROW_133_2300 VGND VPWR sky130_fd_sc_hd__tapvpwrvgnd_1
XFILLER_0_114_109 VPWR VGND VPWR VGND sky130_ef_sc_hd__decap_12
XFILLER_0_107_161 VGND VGND VPWR VPWR sky130_fd_sc_hd__decap_6
XFILLER_0_80_541 VGND VGND VPWR VPWR sky130_fd_sc_hd__fill_1
XFILLER_0_52_221 VPWR VGND VPWR VGND sky130_ef_sc_hd__decap_12
XFILLER_0_80_563 VGND VGND VPWR VPWR sky130_fd_sc_hd__fill_1
XFILLER_0_52_265 VPWR VGND VPWR VGND sky130_ef_sc_hd__decap_12
XFILLER_0_123_665 VGND VGND VPWR VPWR sky130_fd_sc_hd__decap_6
XFILLER_0_122_153 VPWR VGND VPWR VGND sky130_ef_sc_hd__decap_12
XFILLER_0_21_641 VPWR VGND VPWR VGND sky130_ef_sc_hd__decap_12
XFILLER_0_33_490 VGND VGND VPWR VPWR sky130_fd_sc_hd__fill_2
XFILLER_0_122_197 VPWR VGND VPWR VGND sky130_ef_sc_hd__decap_12
XPHY_EDGE_ROW_115_Left_254 VGND VGND VPWR VPWR sky130_fd_sc_hd__decap_3
X_3360_ _0693_ VGND VGND VPWR VPWR _1310_ sky130_fd_sc_hd__clkbuf_4
XFILLER_0_0_557 VGND VGND VPWR VPWR sky130_fd_sc_hd__decap_3
XFILLER_0_21_685 VPWR VGND VPWR VGND sky130_ef_sc_hd__decap_12
XTAP_TAPCELL_ROW_111_1963 VGND VPWR sky130_fd_sc_hd__tapvpwrvgnd_1
X_3291_ _1071_ _1254_ _1255_ VGND VGND VPWR VPWR _1256_ sky130_fd_sc_hd__mux2_1
XFILLER_0_20_195 VGND VGND VPWR VPWR sky130_fd_sc_hd__fill_1
X_5030_ _2504_ VGND VGND VPWR VPWR _0480_ sky130_fd_sc_hd__clkbuf_1
XTAP_TAPCELL_ROW_53_1092 VGND VPWR sky130_fd_sc_hd__tapvpwrvgnd_1
XFILLER_0_73_55 VGND VGND VPWR VPWR sky130_fd_sc_hd__fill_1
XFILLER_0_88_652 VGND VGND VPWR VPWR sky130_fd_sc_hd__fill_1
XPHY_EDGE_ROW_124_Left_263 VGND VGND VPWR VPWR sky130_fd_sc_hd__decap_3
XFILLER_0_75_335 VGND VGND VPWR VPWR sky130_fd_sc_hd__fill_1
XFILLER_0_8_613 VPWR VGND VPWR VGND sky130_ef_sc_hd__decap_12
XFILLER_0_29_741 VPWR VGND VPWR VGND sky130_ef_sc_hd__decap_12
X_4814_ cpu_inst.regfile_inst.registers\[0\]\[25\] VGND VGND VPWR VPWR _2392_ sky130_fd_sc_hd__clkbuf_1
XFILLER_0_28_251 VGND VGND VPWR VPWR sky130_fd_sc_hd__fill_1
XFILLER_0_91_839 VGND VGND VPWR VPWR sky130_fd_sc_hd__fill_1
X_4745_ cpu_inst.decoder_inst.current_pc\[25\] _1288_ _2297_ _2354_ VGND VGND VPWR
+ VPWR _0345_ sky130_fd_sc_hd__a22o_1
XFILLER_0_8_657 VPWR VGND VPWR VGND sky130_ef_sc_hd__decap_12
XFILLER_0_16_413 VGND VGND VPWR VPWR sky130_fd_sc_hd__decap_6
XFILLER_0_29_785 VGND VGND VPWR VPWR sky130_fd_sc_hd__fill_2
XFILLER_0_133_429 VPWR VGND VPWR VGND sky130_ef_sc_hd__decap_12
XFILLER_0_83_390 VGND VGND VPWR VPWR sky130_fd_sc_hd__fill_2
XFILLER_0_7_167 VGND VGND VPWR VPWR sky130_fd_sc_hd__fill_1
XFILLER_0_16_457 VPWR VGND VPWR VGND sky130_ef_sc_hd__decap_12
XFILLER_0_114_643 VGND VGND VPWR VPWR sky130_fd_sc_hd__fill_1
XFILLER_0_98_41 VPWR VGND VPWR VGND sky130_ef_sc_hd__decap_12
X_4676_ cpu_inst.decoder_inst.current_pc\[6\] _2299_ cpu_inst.decoder_inst.current_pc\[7\]
+ VGND VGND VPWR VPWR _2304_ sky130_fd_sc_hd__a21oi_1
XFILLER_0_31_405 VPWR VGND VPWR VGND sky130_ef_sc_hd__decap_12
XPHY_EDGE_ROW_133_Left_272 VGND VGND VPWR VPWR sky130_fd_sc_hd__decap_3
X_3627_ cpu_inst.regfile_inst.registers\[4\]\[21\] _0854_ _1028_ VGND VGND VPWR VPWR
+ _1561_ sky130_fd_sc_hd__o21a_1
XFILLER_0_98_85 VPWR VGND VPWR VGND sky130_ef_sc_hd__decap_12
XFILLER_0_31_449 VPWR VGND VPWR VGND sky130_ef_sc_hd__decap_12
XFILLER_0_101_337 VPWR VGND VPWR VGND sky130_ef_sc_hd__decap_12
X_3558_ _1493_ cpu_inst.regfile_inst.registers\[6\]\[19\] _1339_ VGND VGND VPWR VPWR
+ _1494_ sky130_fd_sc_hd__mux2_1
XTAP_TAPCELL_ROW_73_1402 VGND VPWR sky130_fd_sc_hd__tapvpwrvgnd_1
XFILLER_0_3_373 VPWR VGND VPWR VGND sky130_ef_sc_hd__decap_12
X_3489_ _1425_ cpu_inst.regfile_inst.registers\[10\]\[18\] _1351_ VGND VGND VPWR VPWR
+ _1426_ sky130_fd_sc_hd__mux2_1
X_5228_ clknet_leaf_13_clk _0148_ VGND VGND VPWR VPWR cpu_inst.regfile_inst.registers\[24\]\[20\]
+ sky130_fd_sc_hd__dfxtp_1
X_5159_ clknet_leaf_23_clk _0079_ VGND VGND VPWR VPWR cpu_inst.regfile_inst.registers\[25\]\[15\]
+ sky130_fd_sc_hd__dfxtp_1
XTAP_TAPCELL_ROW_84_1553 VGND VPWR sky130_fd_sc_hd__tapvpwrvgnd_1
XFILLER_0_79_696 VGND VGND VPWR VPWR sky130_fd_sc_hd__decap_3
Xclkbuf_leaf_36_clk clknet_2_2__leaf_clk VGND VGND VPWR VPWR clknet_leaf_36_clk sky130_fd_sc_hd__clkbuf_8
XFILLER_0_39_505 VGND VGND VPWR VPWR sky130_fd_sc_hd__fill_1
XTAP_TAPCELL_ROW_84_1564 VGND VPWR sky130_fd_sc_hd__tapvpwrvgnd_1
XFILLER_0_78_195 VGND VGND VPWR VPWR sky130_fd_sc_hd__fill_1
XFILLER_0_66_335 VGND VGND VPWR VPWR sky130_fd_sc_hd__decap_4
XFILLER_0_81_305 VPWR VGND VPWR VGND sky130_ef_sc_hd__decap_12
XFILLER_0_35_700 VGND VGND VPWR VPWR sky130_fd_sc_hd__fill_2
XFILLER_0_136_245 VGND VGND VPWR VPWR sky130_fd_sc_hd__decap_6
XFILLER_0_94_699 VGND VGND VPWR VPWR sky130_fd_sc_hd__fill_1
XFILLER_0_19_273 VGND VGND VPWR VPWR sky130_fd_sc_hd__decap_6
XFILLER_0_35_711 VGND VGND VPWR VPWR sky130_fd_sc_hd__fill_1
XFILLER_0_136_289 VPWR VGND VPWR VGND sky130_ef_sc_hd__decap_12
XFILLER_0_81_349 VPWR VGND VPWR VGND sky130_ef_sc_hd__decap_12
XFILLER_0_34_221 VPWR VGND VPWR VGND sky130_ef_sc_hd__decap_12
XTAP_TAPCELL_ROW_115_2030 VGND VPWR sky130_fd_sc_hd__tapvpwrvgnd_1
XFILLER_0_34_265 VPWR VGND VPWR VGND sky130_ef_sc_hd__decap_12
XFILLER_0_120_613 VPWR VGND VPWR VGND sky130_ef_sc_hd__decap_12
XFILLER_0_104_153 VPWR VGND VPWR VGND sky130_ef_sc_hd__decap_12
XFILLER_0_104_197 VPWR VGND VPWR VGND sky130_ef_sc_hd__decap_12
XFILLER_0_120_657 VPWR VGND VPWR VGND sky130_ef_sc_hd__decap_12
XFILLER_0_27_15 VPWR VGND VPWR VGND sky130_ef_sc_hd__decap_12
XFILLER_0_134_27 VGND VGND VPWR VPWR sky130_fd_sc_hd__fill_1
XTAP_TAPCELL_ROW_126_2192 VGND VPWR sky130_fd_sc_hd__tapvpwrvgnd_1
Xclkbuf_leaf_27_clk clknet_2_2__leaf_clk VGND VGND VPWR VPWR clknet_leaf_27_clk sky130_fd_sc_hd__clkbuf_8
XFILLER_0_128_713 VPWR VGND VPWR VGND sky130_ef_sc_hd__decap_12
XFILLER_0_84_121 VPWR VGND VPWR VGND sky130_ef_sc_hd__decap_12
XFILLER_0_43_69 VPWR VGND VPWR VGND sky130_ef_sc_hd__decap_12
XTAP_TAPCELL_ROW_46_989 VGND VPWR sky130_fd_sc_hd__tapvpwrvgnd_1
XFILLER_0_127_223 VGND VGND VPWR VPWR sky130_fd_sc_hd__fill_1
XFILLER_0_85_666 VGND VGND VPWR VPWR sky130_fd_sc_hd__decap_3
XFILLER_0_73_817 VGND VGND VPWR VPWR sky130_fd_sc_hd__fill_1
XTAP_TAPCELL_ROW_26_691 VGND VPWR sky130_fd_sc_hd__tapvpwrvgnd_1
X_2860_ cpu_inst.regfile_inst.registers\[15\]\[9\] _0824_ _0720_ VGND VGND VPWR VPWR
+ _0825_ sky130_fd_sc_hd__mux2_1
XFILLER_0_128_757 VPWR VGND VPWR VGND sky130_ef_sc_hd__decap_12
XFILLER_0_84_165 VPWR VGND VPWR VGND sky130_ef_sc_hd__decap_12
XFILLER_0_73_839 VGND VGND VPWR VPWR sky130_fd_sc_hd__fill_1
XFILLER_0_72_338 VGND VGND VPWR VPWR sky130_fd_sc_hd__fill_1
XFILLER_0_115_429 VPWR VGND VPWR VGND sky130_ef_sc_hd__decap_12
XFILLER_0_26_755 VGND VGND VPWR VPWR sky130_fd_sc_hd__fill_1
X_2791_ _0753_ _0754_ _0755_ VGND VGND VPWR VPWR _0756_ sky130_fd_sc_hd__o21ai_4
XFILLER_0_104_3 VPWR VGND VPWR VGND sky130_ef_sc_hd__decap_12
XFILLER_0_80_371 VGND VGND VPWR VPWR sky130_fd_sc_hd__fill_1
X_4530_ cpu_inst.regfile_inst.registers\[11\]\[16\] VGND VGND VPWR VPWR _2213_ sky130_fd_sc_hd__clkbuf_1
XFILLER_0_13_405 VPWR VGND VPWR VGND sky130_ef_sc_hd__decap_12
XFILLER_0_41_714 VGND VGND VPWR VPWR sky130_fd_sc_hd__decap_6
X_4461_ _1156_ cpu_inst.regfile_inst.registers\[7\]\[14\] _2174_ VGND VGND VPWR VPWR
+ _2178_ sky130_fd_sc_hd__mux2_1
XFILLER_0_13_449 VPWR VGND VPWR VGND sky130_ef_sc_hd__decap_12
XFILLER_0_123_473 VPWR VGND VPWR VGND sky130_ef_sc_hd__decap_12
X_3412_ _0871_ VGND VGND VPWR VPWR _1351_ sky130_fd_sc_hd__buf_4
XFILLER_0_7_69 VPWR VGND VPWR VGND sky130_ef_sc_hd__decap_12
XFILLER_0_0_321 VPWR VGND VPWR VGND sky130_ef_sc_hd__decap_12
XFILLER_0_1_833 VGND VGND VPWR VPWR sky130_fd_sc_hd__decap_6
XFILLER_0_68_77 VGND VGND VPWR VPWR sky130_fd_sc_hd__decap_6
XTAP_TAPCELL_ROW_55_1132 VGND VPWR sky130_fd_sc_hd__tapvpwrvgnd_1
XTAP_TAPCELL_ROW_55_1121 VGND VPWR sky130_fd_sc_hd__tapvpwrvgnd_1
X_4392_ _2141_ VGND VGND VPWR VPWR _0205_ sky130_fd_sc_hd__clkbuf_1
XFILLER_0_110_189 VGND VGND VPWR VPWR sky130_fd_sc_hd__decap_6
X_3343_ _1286_ _1292_ _1297_ VGND VGND VPWR VPWR _1298_ sky130_fd_sc_hd__or3_1
XFILLER_0_0_365 VPWR VGND VPWR VGND sky130_ef_sc_hd__decap_12
X_3274_ cpu_inst.regfile_inst.registers\[5\]\[15\] cpu_inst.regfile_inst.registers\[4\]\[15\]
+ _0866_ VGND VGND VPWR VPWR _1239_ sky130_fd_sc_hd__mux2_1
X_5013_ cpu_inst.regfile_inst.registers\[15\]\[24\] _2491_ VGND VGND VPWR VPWR _2496_
+ sky130_fd_sc_hd__and2_1
XFILLER_0_84_65 VPWR VGND VPWR VGND sky130_ef_sc_hd__decap_12
XFILLER_0_108_83 VGND VGND VPWR VPWR sky130_fd_sc_hd__fill_1
XFILLER_0_17_81 VPWR VGND VPWR VGND sky130_ef_sc_hd__decap_12
Xclkbuf_leaf_18_clk clknet_2_3__leaf_clk VGND VGND VPWR VPWR clknet_leaf_18_clk sky130_fd_sc_hd__clkbuf_8
XPHY_EDGE_ROW_5_Right_5 VGND VGND VPWR VPWR sky130_fd_sc_hd__decap_3
XFILLER_0_49_825 VPWR VGND VPWR VGND sky130_ef_sc_hd__decap_12
XFILLER_0_88_493 VGND VGND VPWR VPWR sky130_fd_sc_hd__fill_2
XTAP_TAPCELL_ROW_66_1294 VGND VPWR sky130_fd_sc_hd__tapvpwrvgnd_1
XTAP_TAPCELL_ROW_66_1283 VGND VPWR sky130_fd_sc_hd__tapvpwrvgnd_1
XFILLER_0_8_421 VPWR VGND VPWR VGND sky130_ef_sc_hd__decap_12
XFILLER_0_48_357 VGND VGND VPWR VPWR sky130_fd_sc_hd__decap_6
XFILLER_0_118_245 VGND VGND VPWR VPWR sky130_fd_sc_hd__decap_6
XFILLER_0_64_839 VGND VGND VPWR VPWR sky130_fd_sc_hd__decap_3
XFILLER_0_118_289 VPWR VGND VPWR VGND sky130_ef_sc_hd__decap_12
XFILLER_0_16_221 VPWR VGND VPWR VGND sky130_ef_sc_hd__decap_12
X_2989_ cpu_inst.regfile_inst.registers\[7\]\[7\] cpu_inst.regfile_inst.registers\[6\]\[7\]
+ _0866_ VGND VGND VPWR VPWR _0954_ sky130_fd_sc_hd__mux2_1
XFILLER_0_134_749 VGND VGND VPWR VPWR sky130_fd_sc_hd__decap_6
XFILLER_0_133_237 VPWR VGND VPWR VGND sky130_ef_sc_hd__decap_12
X_4728_ _2293_ _2341_ cpu_inst.decoder_inst.current_pc\[21\] _2289_ VGND VGND VPWR
+ VPWR _0341_ sky130_fd_sc_hd__o2bb2a_1
XFILLER_0_16_265 VPWR VGND VPWR VGND sky130_ef_sc_hd__decap_12
XFILLER_0_17_777 VGND VGND VPWR VPWR sky130_fd_sc_hd__decap_6
X_4659_ _2284_ _2290_ _0685_ _1288_ VGND VGND VPWR VPWR _2291_ sky130_fd_sc_hd__a211o_1
XFILLER_0_4_693 VGND VGND VPWR VPWR sky130_fd_sc_hd__decap_6
XFILLER_0_3_181 VPWR VGND VPWR VGND sky130_ef_sc_hd__decap_12
XFILLER_0_32_769 VPWR VGND VPWR VGND sky130_ef_sc_hd__decap_12
XFILLER_0_31_279 VGND VGND VPWR VPWR sky130_fd_sc_hd__fill_1
XFILLER_0_101_167 VGND VGND VPWR VPWR sky130_fd_sc_hd__fill_1
XTAP_TAPCELL_ROW_4_364 VGND VPWR sky130_fd_sc_hd__tapvpwrvgnd_1
XTAP_TAPCELL_ROW_4_353 VGND VPWR sky130_fd_sc_hd__tapvpwrvgnd_1
XFILLER_0_66_121 VPWR VGND VPWR VGND sky130_ef_sc_hd__decap_12
XFILLER_0_39_335 VGND VGND VPWR VPWR sky130_fd_sc_hd__fill_1
XFILLER_0_13_39 VPWR VGND VPWR VGND sky130_ef_sc_hd__decap_12
XTAP_TAPCELL_ROW_43_948 VGND VPWR sky130_fd_sc_hd__tapvpwrvgnd_1
XFILLER_0_109_223 VGND VGND VPWR VPWR sky130_fd_sc_hd__fill_1
XFILLER_0_94_485 VGND VGND VPWR VPWR sky130_fd_sc_hd__fill_1
XFILLER_0_81_113 VPWR VGND VPWR VGND sky130_ef_sc_hd__decap_12
XFILLER_0_66_165 VPWR VGND VPWR VGND sky130_ef_sc_hd__decap_12
XTAP_TAPCELL_ROW_23_650 VGND VPWR sky130_fd_sc_hd__tapvpwrvgnd_1
XFILLER_0_125_727 VGND VGND VPWR VPWR sky130_fd_sc_hd__fill_1
XFILLER_0_120_29 VPWR VGND VPWR VGND sky130_ef_sc_hd__decap_12
XTAP_TAPCELL_ROW_97_1755 VGND VPWR sky130_fd_sc_hd__tapvpwrvgnd_1
XFILLER_0_120_421 VPWR VGND VPWR VGND sky130_ef_sc_hd__decap_12
XFILLER_0_50_577 VGND VGND VPWR VPWR sky130_fd_sc_hd__decap_8
XFILLER_0_10_419 VGND VGND VPWR VPWR sky130_fd_sc_hd__fill_1
XFILLER_0_31_791 VGND VGND VPWR VPWR sky130_fd_sc_hd__fill_1
XFILLER_0_129_27 VPWR VGND VPWR VGND sky130_ef_sc_hd__decap_12
XTAP_TAPCELL_ROW_128_2221 VGND VPWR sky130_fd_sc_hd__tapvpwrvgnd_1
XTAP_TAPCELL_ROW_50_1051 VGND VPWR sky130_fd_sc_hd__tapvpwrvgnd_1
XFILLER_0_89_279 VGND VGND VPWR VPWR sky130_fd_sc_hd__fill_1
X_3961_ cpu_inst.regfile_inst.registers\[4\]\[30\] _0854_ _0615_ cpu_inst.regfile_inst.registers\[0\]\[30\]
+ VGND VGND VPWR VPWR _1886_ sky130_fd_sc_hd__o22a_1
XTAP_TAPCELL_ROW_106_1895 VGND VPWR sky130_fd_sc_hd__tapvpwrvgnd_1
XTAP_TAPCELL_ROW_106_1884 VGND VPWR sky130_fd_sc_hd__tapvpwrvgnd_1
X_2912_ _0864_ _0872_ _0874_ _0876_ VGND VGND VPWR VPWR _0877_ sky130_fd_sc_hd__o22a_1
X_3892_ _1817_ _1818_ VGND VGND VPWR VPWR _1819_ sky130_fd_sc_hd__nor2_1
XFILLER_0_58_699 VGND VGND VPWR VPWR sky130_fd_sc_hd__fill_1
XTAP_TAPCELL_ROW_21_609 VGND VPWR sky130_fd_sc_hd__tapvpwrvgnd_1
XFILLER_0_45_305 VPWR VGND VPWR VGND sky130_ef_sc_hd__decap_12
XFILLER_0_128_587 VGND VGND VPWR VPWR sky130_fd_sc_hd__fill_1
X_2843_ cpu_inst.regfile_inst.registers\[15\]\[6\] _0807_ _0720_ VGND VGND VPWR VPWR
+ _0808_ sky130_fd_sc_hd__mux2_4
XFILLER_0_45_349 VPWR VGND VPWR VGND sky130_ef_sc_hd__decap_12
XFILLER_0_116_749 VGND VGND VPWR VPWR sky130_fd_sc_hd__decap_6
XFILLER_0_115_237 VPWR VGND VPWR VGND sky130_ef_sc_hd__decap_12
X_5562_ clknet_leaf_30_clk _0482_ VGND VGND VPWR VPWR cpu_inst.display_inst.counter\[2\]
+ sky130_fd_sc_hd__dfxtp_1
XFILLER_0_41_500 VGND VGND VPWR VPWR sky130_fd_sc_hd__decap_4
X_2774_ cpu_inst.regfile_inst.registers\[24\]\[11\] _0697_ _0637_ _0738_ VGND VGND
+ VPWR VPWR _0739_ sky130_fd_sc_hd__o211a_1
XFILLER_0_53_393 VPWR VGND VPWR VGND sky130_ef_sc_hd__decap_12
XFILLER_0_14_725 VPWR VGND VPWR VGND sky130_ef_sc_hd__decap_12
X_4513_ _2204_ VGND VGND VPWR VPWR _0263_ sky130_fd_sc_hd__clkbuf_1
XFILLER_0_124_793 VPWR VGND VPWR VGND sky130_ef_sc_hd__decap_12
XFILLER_0_123_281 VPWR VGND VPWR VGND sky130_ef_sc_hd__decap_12
X_5493_ clknet_leaf_6_clk _0413_ VGND VGND VPWR VPWR cpu_inst.regfile_inst.registers\[9\]\[29\]
+ sky130_fd_sc_hd__dfxtp_1
XFILLER_0_14_769 VPWR VGND VPWR VGND sky130_ef_sc_hd__decap_12
Xclkbuf_leaf_7_clk clknet_2_1__leaf_clk VGND VGND VPWR VPWR clknet_leaf_7_clk sky130_fd_sc_hd__clkbuf_8
XFILLER_0_13_279 VGND VGND VPWR VPWR sky130_fd_sc_hd__fill_1
XFILLER_0_1_641 VPWR VGND VPWR VGND sky130_ef_sc_hd__decap_12
X_4444_ _1168_ cpu_inst.regfile_inst.registers\[7\]\[6\] _2161_ VGND VGND VPWR VPWR
+ _2169_ sky130_fd_sc_hd__mux2_1
XFILLER_0_1_685 VPWR VGND VPWR VGND sky130_ef_sc_hd__decap_12
X_4375_ cpu_inst.regfile_inst.registers\[1\]\[5\] VGND VGND VPWR VPWR _2133_ sky130_fd_sc_hd__clkbuf_1
X_3326_ _0691_ VGND VGND VPWR VPWR net6 sky130_fd_sc_hd__inv_2
XFILLER_0_119_93 VPWR VGND VPWR VGND sky130_ef_sc_hd__decap_12
X_3257_ _1055_ _1211_ _1221_ VGND VGND VPWR VPWR _1222_ sky130_fd_sc_hd__o21a_1
X_3188_ _0911_ VGND VGND VPWR VPWR _1153_ sky130_fd_sc_hd__buf_2
XTAP_TAPCELL_ROW_68_1323 VGND VPWR sky130_fd_sc_hd__tapvpwrvgnd_1
XTAP_TAPCELL_ROW_1_312 VGND VPWR sky130_fd_sc_hd__tapvpwrvgnd_1
XFILLER_0_95_205 VPWR VGND VPWR VGND sky130_ef_sc_hd__decap_12
XFILLER_0_68_419 VGND VGND VPWR VPWR sky130_fd_sc_hd__fill_1
XFILLER_0_135_81 VPWR VGND VPWR VGND sky130_ef_sc_hd__decap_12
XFILLER_0_95_249 VPWR VGND VPWR VGND sky130_ef_sc_hd__decap_12
XFILLER_0_49_611 VGND VGND VPWR VPWR sky130_fd_sc_hd__decap_4
XTAP_TAPCELL_ROW_81_1512 VGND VPWR sky130_fd_sc_hd__tapvpwrvgnd_1
XFILLER_0_37_817 VGND VGND VPWR VPWR sky130_fd_sc_hd__fill_1
XFILLER_0_48_121 VPWR VGND VPWR VGND sky130_ef_sc_hd__decap_12
XFILLER_0_63_113 VPWR VGND VPWR VGND sky130_ef_sc_hd__decap_12
XFILLER_0_9_741 VPWR VGND VPWR VGND sky130_ef_sc_hd__decap_12
XTAP_TAPCELL_ROW_40_907 VGND VPWR sky130_fd_sc_hd__tapvpwrvgnd_1
XFILLER_0_48_165 VPWR VGND VPWR VGND sky130_ef_sc_hd__decap_12
XFILLER_0_134_513 VPWR VGND VPWR VGND sky130_ef_sc_hd__decap_12
XFILLER_0_107_727 VGND VGND VPWR VPWR sky130_fd_sc_hd__fill_1
XFILLER_0_9_785 VPWR VGND VPWR VGND sky130_ef_sc_hd__decap_12
XFILLER_0_8_251 VGND VGND VPWR VPWR sky130_fd_sc_hd__fill_1
XFILLER_0_17_541 VPWR VGND VPWR VGND sky130_ef_sc_hd__decap_12
XFILLER_0_134_557 VPWR VGND VPWR VGND sky130_ef_sc_hd__decap_12
XFILLER_0_91_466 VGND VGND VPWR VPWR sky130_fd_sc_hd__fill_1
XFILLER_0_72_691 VGND VGND VPWR VPWR sky130_fd_sc_hd__fill_2
XFILLER_0_17_585 VPWR VGND VPWR VGND sky130_ef_sc_hd__decap_12
XFILLER_0_32_533 VGND VGND VPWR VPWR sky130_fd_sc_hd__fill_1
XFILLER_0_102_421 VGND VGND VPWR VPWR sky130_fd_sc_hd__fill_1
XTAP_TAPCELL_ROW_79_1485 VGND VPWR sky130_fd_sc_hd__tapvpwrvgnd_1
XFILLER_0_32_566 VGND VGND VPWR VPWR sky130_fd_sc_hd__decap_8
XTAP_TAPCELL_ROW_9_434 VGND VPWR sky130_fd_sc_hd__tapvpwrvgnd_1
XTAP_TAPCELL_ROW_92_1685 VGND VPWR sky130_fd_sc_hd__tapvpwrvgnd_1
XTAP_TAPCELL_ROW_92_1674 VGND VPWR sky130_fd_sc_hd__tapvpwrvgnd_1
XTAP_TAPCELL_ROW_123_2140 VGND VPWR sky130_fd_sc_hd__tapvpwrvgnd_1
XFILLER_0_99_577 VGND VGND VPWR VPWR sky130_fd_sc_hd__decap_3
XTAP_TAPCELL_ROW_28_720 VGND VPWR sky130_fd_sc_hd__tapvpwrvgnd_1
XTAP_TAPCELL_ROW_123_2151 VGND VPWR sky130_fd_sc_hd__tapvpwrvgnd_1
XFILLER_0_99_599 VGND VGND VPWR VPWR sky130_fd_sc_hd__fill_1
XFILLER_0_24_27 VGND VGND VPWR VPWR sky130_fd_sc_hd__fill_1
XFILLER_0_129_329 VGND VGND VPWR VPWR sky130_fd_sc_hd__decap_6
XFILLER_0_138_841 VGND VGND VPWR VPWR sky130_fd_sc_hd__fill_1
XFILLER_0_95_783 VGND VGND VPWR VPWR sky130_fd_sc_hd__fill_1
XFILLER_0_27_305 VPWR VGND VPWR VGND sky130_ef_sc_hd__decap_12
XFILLER_0_137_373 VPWR VGND VPWR VGND sky130_ef_sc_hd__decap_12
XFILLER_0_131_39 VPWR VGND VPWR VGND sky130_ef_sc_hd__decap_12
XFILLER_0_82_444 VGND VGND VPWR VPWR sky130_fd_sc_hd__fill_1
XFILLER_0_27_349 VPWR VGND VPWR VGND sky130_ef_sc_hd__decap_12
XFILLER_0_40_15 VPWR VGND VPWR VGND sky130_ef_sc_hd__decap_12
XFILLER_0_82_477 VGND VGND VPWR VPWR sky130_fd_sc_hd__decap_3
XFILLER_0_63_691 VPWR VGND VPWR VGND sky130_ef_sc_hd__decap_12
XFILLER_0_35_393 VPWR VGND VPWR VGND sky130_ef_sc_hd__decap_12
XFILLER_0_106_793 VPWR VGND VPWR VGND sky130_ef_sc_hd__decap_12
XFILLER_0_121_741 VPWR VGND VPWR VGND sky130_ef_sc_hd__decap_12
XFILLER_0_105_281 VPWR VGND VPWR VGND sky130_ef_sc_hd__decap_12
XFILLER_0_50_363 VGND VGND VPWR VPWR sky130_fd_sc_hd__fill_1
XFILLER_0_121_785 VPWR VGND VPWR VGND sky130_ef_sc_hd__decap_12
XFILLER_0_120_251 VGND VGND VPWR VPWR sky130_fd_sc_hd__fill_1
XFILLER_0_49_57 VPWR VGND VPWR VGND sky130_ef_sc_hd__decap_12
XFILLER_0_50_396 VGND VGND VPWR VPWR sky130_fd_sc_hd__fill_1
X_4160_ _1928_ cpu_inst.regfile_inst.registers\[25\]\[31\] _2010_ VGND VGND VPWR VPWR
+ _2020_ sky130_fd_sc_hd__mux2_1
XFILLER_0_4_15 VPWR VGND VPWR VGND sky130_ef_sc_hd__decap_12
X_3111_ cpu_inst.regfile_inst.registers\[25\]\[1\] _0903_ _0661_ _0921_ VGND VGND
+ VPWR VPWR _1076_ sky130_fd_sc_hd__o211ai_1
X_4091_ _1981_ VGND VGND VPWR VPWR _1982_ sky130_fd_sc_hd__clkbuf_4
XTAP_TAPCELL_ROW_108_1924 VGND VPWR sky130_fd_sc_hd__tapvpwrvgnd_1
XTAP_TAPCELL_ROW_108_1913 VGND VPWR sky130_fd_sc_hd__tapvpwrvgnd_1
X_3042_ cpu_inst.regfile_inst.registers\[5\]\[10\] cpu_inst.regfile_inst.registers\[4\]\[10\]
+ _0922_ VGND VGND VPWR VPWR _1007_ sky130_fd_sc_hd__mux2_1
XFILLER_0_78_717 VGND VGND VPWR VPWR sky130_fd_sc_hd__decap_8
XFILLER_0_77_205 VPWR VGND VPWR VGND sky130_ef_sc_hd__decap_12
XFILLER_0_105_51 VGND VGND VPWR VPWR sky130_fd_sc_hd__decap_4
XFILLER_0_81_55 VGND VGND VPWR VPWR sky130_fd_sc_hd__fill_1
XFILLER_0_77_249 VPWR VGND VPWR VGND sky130_ef_sc_hd__decap_12
X_4993_ _2485_ VGND VGND VPWR VPWR _0462_ sky130_fd_sc_hd__clkbuf_1
XFILLER_0_129_841 VGND VGND VPWR VPWR sky130_fd_sc_hd__fill_1
X_3944_ cpu_inst.regfile_inst.registers\[5\]\[30\] cpu_inst.regfile_inst.registers\[4\]\[30\]
+ _1797_ VGND VGND VPWR VPWR _1869_ sky130_fd_sc_hd__mux2_1
XTAP_TAPCELL_ROW_63_1242 VGND VPWR sky130_fd_sc_hd__tapvpwrvgnd_1
XFILLER_0_58_474 VGND VGND VPWR VPWR sky130_fd_sc_hd__fill_2
XFILLER_0_19_839 VGND VGND VPWR VPWR sky130_fd_sc_hd__fill_1
XFILLER_0_46_614 VGND VGND VPWR VPWR sky130_fd_sc_hd__decap_4
XFILLER_0_116_513 VPWR VGND VPWR VGND sky130_ef_sc_hd__decap_12
X_3875_ net42 _1778_ _1779_ VGND VGND VPWR VPWR _1802_ sky130_fd_sc_hd__and3_1
XFILLER_0_85_293 VPWR VGND VPWR VGND sky130_ef_sc_hd__decap_12
XFILLER_0_45_113 VPWR VGND VPWR VGND sky130_ef_sc_hd__decap_12
X_2826_ cpu_inst.regfile_inst.registers\[1\]\[7\] _0592_ net38 cpu_inst.regfile_inst.registers\[5\]\[7\]
+ VGND VGND VPWR VPWR _0791_ sky130_fd_sc_hd__o22a_1
XFILLER_0_131_505 VPWR VGND VPWR VGND sky130_ef_sc_hd__decap_12
XFILLER_0_116_557 VPWR VGND VPWR VGND sky130_ef_sc_hd__decap_12
XFILLER_0_6_755 VGND VGND VPWR VPWR sky130_fd_sc_hd__fill_1
XFILLER_0_14_533 VPWR VGND VPWR VGND sky130_ef_sc_hd__decap_12
X_5545_ clknet_leaf_26_clk _0465_ VGND VGND VPWR VPWR cpu_inst.regfile_inst.registers\[15\]\[17\]
+ sky130_fd_sc_hd__dfxtp_1
X_2757_ cpu_inst.regfile_inst.registers\[11\]\[11\] cpu_inst.regfile_inst.registers\[10\]\[11\]
+ _0620_ VGND VGND VPWR VPWR _0722_ sky130_fd_sc_hd__mux2_1
XFILLER_0_76_3 VPWR VGND VPWR VGND sky130_ef_sc_hd__decap_12
X_5476_ clknet_leaf_21_clk _0396_ VGND VGND VPWR VPWR cpu_inst.regfile_inst.registers\[9\]\[12\]
+ sky130_fd_sc_hd__dfxtp_1
X_2688_ _0652_ VGND VGND VPWR VPWR _0653_ sky130_fd_sc_hd__clkbuf_4
XFILLER_0_41_385 VGND VGND VPWR VPWR sky130_fd_sc_hd__decap_6
X_4427_ cpu_inst.regfile_inst.registers\[1\]\[31\] VGND VGND VPWR VPWR _2159_ sky130_fd_sc_hd__clkbuf_1
XFILLER_0_111_273 VGND VGND VPWR VPWR sky130_fd_sc_hd__decap_6
X_4358_ _2124_ VGND VGND VPWR VPWR _0188_ sky130_fd_sc_hd__clkbuf_1
X_4289_ cpu_inst.regfile_inst.registers\[24\]\[29\] VGND VGND VPWR VPWR _2087_ sky130_fd_sc_hd__clkbuf_1
X_3309_ _1172_ _1263_ VGND VGND VPWR VPWR _1272_ sky130_fd_sc_hd__nor2_1
XFILLER_0_96_536 VGND VGND VPWR VPWR sky130_fd_sc_hd__decap_8
XFILLER_0_138_137 VGND VGND VPWR VPWR sky130_fd_sc_hd__decap_3
XFILLER_0_77_794 VGND VGND VPWR VPWR sky130_fd_sc_hd__fill_2
XFILLER_0_77_783 VGND VGND VPWR VPWR sky130_fd_sc_hd__fill_1
XFILLER_0_107_513 VGND VGND VPWR VPWR sky130_fd_sc_hd__fill_2
XFILLER_0_25_809 VPWR VGND VPWR VGND sky130_ef_sc_hd__decap_12
XFILLER_0_135_833 VGND VGND VPWR VPWR sky130_fd_sc_hd__decap_6
XFILLER_0_134_321 VPWR VGND VPWR VGND sky130_ef_sc_hd__decap_12
XFILLER_0_119_373 VPWR VGND VPWR VGND sky130_ef_sc_hd__decap_12
XFILLER_0_134_365 VPWR VGND VPWR VGND sky130_ef_sc_hd__decap_12
XFILLER_0_51_105 VGND VGND VPWR VPWR sky130_fd_sc_hd__decap_6
XTAP_TAPCELL_ROW_94_1714 VGND VPWR sky130_fd_sc_hd__tapvpwrvgnd_1
XTAP_TAPCELL_ROW_94_1703 VGND VPWR sky130_fd_sc_hd__tapvpwrvgnd_1
XFILLER_0_10_29 VPWR VGND VPWR VGND sky130_ef_sc_hd__decap_12
XFILLER_0_17_393 VPWR VGND VPWR VGND sky130_ef_sc_hd__decap_12
XFILLER_0_51_149 VPWR VGND VPWR VGND sky130_ef_sc_hd__decap_12
XFILLER_0_103_741 VPWR VGND VPWR VGND sky130_ef_sc_hd__decap_12
XFILLER_0_60_694 VGND VGND VPWR VPWR sky130_fd_sc_hd__decap_6
XFILLER_0_20_525 VGND VGND VPWR VPWR sky130_fd_sc_hd__decap_6
XFILLER_0_32_363 VGND VGND VPWR VPWR sky130_fd_sc_hd__fill_1
XFILLER_0_103_785 VPWR VGND VPWR VGND sky130_ef_sc_hd__decap_12
XFILLER_0_102_251 VGND VGND VPWR VPWR sky130_fd_sc_hd__fill_1
XFILLER_0_19_27 VPWR VGND VPWR VGND sky130_ef_sc_hd__decap_12
XFILLER_0_20_569 VPWR VGND VPWR VGND sky130_ef_sc_hd__decap_12
XFILLER_0_35_15 VPWR VGND VPWR VGND sky130_ef_sc_hd__decap_12
XFILLER_0_99_385 VGND VGND VPWR VPWR sky130_fd_sc_hd__decap_6
XFILLER_0_87_547 VGND VGND VPWR VPWR sky130_fd_sc_hd__decap_8
XFILLER_0_59_205 VPWR VGND VPWR VGND sky130_ef_sc_hd__decap_12
XFILLER_0_59_249 VPWR VGND VPWR VGND sky130_ef_sc_hd__decap_12
XFILLER_0_129_137 VPWR VGND VPWR VGND sky130_ef_sc_hd__decap_12
XTAP_TAPCELL_ROW_103_1843 VGND VPWR sky130_fd_sc_hd__tapvpwrvgnd_1
XFILLER_0_126_811 VGND VGND VPWR VPWR sky130_fd_sc_hd__fill_1
XFILLER_0_83_742 VGND VGND VPWR VPWR sky130_fd_sc_hd__fill_2
XFILLER_0_67_293 VGND VGND VPWR VPWR sky130_fd_sc_hd__decap_8
XFILLER_0_27_113 VPWR VGND VPWR VGND sky130_ef_sc_hd__decap_12
XFILLER_0_51_69 VPWR VGND VPWR VGND sky130_ef_sc_hd__decap_12
XFILLER_0_137_181 VPWR VGND VPWR VGND sky130_ef_sc_hd__decap_12
XFILLER_0_83_764 VGND VGND VPWR VPWR sky130_fd_sc_hd__decap_8
XTAP_TAPCELL_ROW_31_759 VGND VPWR sky130_fd_sc_hd__tapvpwrvgnd_1
XTAP_TAPCELL_ROW_136_2342 VGND VPWR sky130_fd_sc_hd__tapvpwrvgnd_1
XFILLER_0_113_505 VPWR VGND VPWR VGND sky130_ef_sc_hd__decap_12
X_3660_ cpu_inst.regfile_inst.registers\[11\]\[22\] cpu_inst.regfile_inst.registers\[10\]\[22\]
+ _1592_ VGND VGND VPWR VPWR _1593_ sky130_fd_sc_hd__mux2_1
Xclkload34 clknet_leaf_15_clk VGND VGND VPWR VPWR clkload34/Y sky130_fd_sc_hd__clkinv_1
X_3591_ _1524_ _1525_ VGND VGND VPWR VPWR _1526_ sky130_fd_sc_hd__or2_1
Xclkload12 clknet_leaf_4_clk VGND VGND VPWR VPWR clkload12/X sky130_fd_sc_hd__clkbuf_4
X_2611_ _0510_ _0554_ VGND VGND VPWR VPWR _0576_ sky130_fd_sc_hd__nor2_1
XTAP_TAPCELL_ROW_11_472 VGND VPWR sky130_fd_sc_hd__tapvpwrvgnd_1
XTAP_TAPCELL_ROW_11_461 VGND VPWR sky130_fd_sc_hd__tapvpwrvgnd_1
Xclkload23 clknet_leaf_28_clk VGND VGND VPWR VPWR clkload23/Y sky130_fd_sc_hd__inv_8
X_5330_ clknet_leaf_8_clk _0250_ VGND VGND VPWR VPWR cpu_inst.regfile_inst.registers\[7\]\[26\]
+ sky130_fd_sc_hd__dfxtp_1
X_2542_ cpu_inst.decoder_inst.current_pc\[9\] cpu_inst.decoder_inst.current_pc\[8\]
+ cpu_inst.decoder_inst.current_pc\[11\] cpu_inst.decoder_inst.current_pc\[12\] VGND
+ VGND VPWR VPWR _0507_ sky130_fd_sc_hd__or4_4
XFILLER_0_11_503 VGND VGND VPWR VPWR sky130_fd_sc_hd__fill_1
XFILLER_0_51_683 VGND VGND VPWR VPWR sky130_fd_sc_hd__fill_1
X_5261_ clknet_leaf_18_clk _0181_ VGND VGND VPWR VPWR cpu_inst.regfile_inst.registers\[5\]\[21\]
+ sky130_fd_sc_hd__dfxtp_1
XFILLER_0_23_385 VGND VGND VPWR VPWR sky130_fd_sc_hd__decap_6
X_4212_ _2048_ VGND VGND VPWR VPWR _0118_ sky130_fd_sc_hd__clkbuf_1
X_5192_ clknet_leaf_20_clk _0112_ VGND VGND VPWR VPWR cpu_inst.regfile_inst.registers\[4\]\[16\]
+ sky130_fd_sc_hd__dfxtp_1
X_4143_ _2011_ VGND VGND VPWR VPWR _0086_ sky130_fd_sc_hd__clkbuf_1
XFILLER_0_76_77 VGND VGND VPWR VPWR sky130_fd_sc_hd__decap_6
X_4074_ cpu_inst.regfile_inst.registers\[2\]\[24\] VGND VGND VPWR VPWR _1973_ sky130_fd_sc_hd__clkbuf_1
X_3025_ cpu_inst.regfile_inst.registers\[24\]\[10\] _0697_ _0961_ _0717_ VGND VGND
+ VPWR VPWR _0990_ sky130_fd_sc_hd__o211a_1
XFILLER_0_92_65 VPWR VGND VPWR VGND sky130_ef_sc_hd__decap_12
XFILLER_0_116_83 VGND VGND VPWR VPWR sky130_fd_sc_hd__fill_1
XTAP_TAPCELL_ROW_19_583 VGND VPWR sky130_fd_sc_hd__tapvpwrvgnd_1
XFILLER_0_25_81 VPWR VGND VPWR VGND sky130_ef_sc_hd__decap_12
XFILLER_0_129_671 VGND VGND VPWR VPWR sky130_fd_sc_hd__fill_1
X_4976_ _2476_ VGND VGND VPWR VPWR _0454_ sky130_fd_sc_hd__clkbuf_1
XFILLER_0_117_833 VGND VGND VPWR VPWR sky130_fd_sc_hd__decap_6
XFILLER_0_116_321 VPWR VGND VPWR VGND sky130_ef_sc_hd__decap_12
X_3927_ _0610_ _1852_ VGND VGND VPWR VPWR _1853_ sky130_fd_sc_hd__or2_1
XFILLER_0_46_477 VPWR VGND VPWR VGND sky130_ef_sc_hd__decap_12
X_3858_ cpu_inst.regfile_inst.registers\[25\]\[27\] _1285_ _1449_ _1767_ VGND VGND
+ VPWR VPWR _1786_ sky130_fd_sc_hd__o211a_1
Xclkload6 clknet_leaf_39_clk VGND VGND VPWR VPWR clkload6/Y sky130_fd_sc_hd__bufinv_16
XFILLER_0_33_105 VGND VGND VPWR VPWR sky130_fd_sc_hd__decap_6
XFILLER_0_132_825 VPWR VGND VPWR VGND sky130_ef_sc_hd__decap_12
XFILLER_0_116_365 VPWR VGND VPWR VGND sky130_ef_sc_hd__decap_12
X_3789_ cpu_inst.regfile_inst.registers\[24\]\[25\] _1384_ _0700_ _1718_ _0961_ VGND
+ VGND VPWR VPWR _1719_ sky130_fd_sc_hd__o221a_1
XFILLER_0_61_458 VPWR VGND VPWR VGND sky130_ef_sc_hd__decap_12
XFILLER_0_33_149 VPWR VGND VPWR VGND sky130_ef_sc_hd__decap_12
X_2809_ cpu_inst.regfile_inst.registers\[15\]\[4\] _0710_ _0720_ _0773_ _0571_ VGND
+ VGND VPWR VPWR _0774_ sky130_fd_sc_hd__a221o_1
XFILLER_0_131_335 VGND VGND VPWR VPWR sky130_fd_sc_hd__fill_1
XTAP_TAPCELL_ROW_76_1433 VGND VPWR sky130_fd_sc_hd__tapvpwrvgnd_1
XFILLER_0_14_363 VGND VGND VPWR VPWR sky130_fd_sc_hd__fill_1
XFILLER_0_42_672 VGND VGND VPWR VPWR sky130_fd_sc_hd__decap_3
X_5528_ clknet_leaf_37_clk _0448_ VGND VGND VPWR VPWR cpu_inst.regfile_inst.registers\[15\]\[0\]
+ sky130_fd_sc_hd__dfxtp_1
XTAP_TAPCELL_ROW_76_1444 VGND VPWR sky130_fd_sc_hd__tapvpwrvgnd_1
XFILLER_0_41_193 VPWR VGND VPWR VGND sky130_ef_sc_hd__decap_12
X_5459_ clknet_leaf_7_clk _0379_ VGND VGND VPWR VPWR cpu_inst.regfile_inst.registers\[0\]\[27\]
+ sky130_fd_sc_hd__dfxtp_1
XFILLER_0_97_801 VPWR VGND VPWR VGND sky130_ef_sc_hd__decap_12
XFILLER_0_96_333 VPWR VGND VPWR VGND sky130_ef_sc_hd__decap_12
XTAP_TAPCELL_ROW_38_870 VGND VPWR sky130_fd_sc_hd__tapvpwrvgnd_1
XFILLER_0_96_377 VPWR VGND VPWR VGND sky130_ef_sc_hd__decap_12
XFILLER_0_84_528 VGND VGND VPWR VPWR sky130_fd_sc_hd__decap_4
XFILLER_0_108_811 VGND VGND VPWR VPWR sky130_fd_sc_hd__fill_1
XFILLER_0_77_591 VGND VGND VPWR VPWR sky130_fd_sc_hd__decap_6
XFILLER_0_49_293 VPWR VGND VPWR VGND sky130_ef_sc_hd__decap_12
XFILLER_0_119_181 VPWR VGND VPWR VGND sky130_ef_sc_hd__decap_12
XFILLER_0_80_701 VGND VGND VPWR VPWR sky130_fd_sc_hd__fill_2
XFILLER_0_135_641 VPWR VGND VPWR VGND sky130_ef_sc_hd__decap_12
XFILLER_0_92_583 VGND VGND VPWR VPWR sky130_fd_sc_hd__decap_4
XFILLER_0_21_39 VPWR VGND VPWR VGND sky130_ef_sc_hd__decap_12
XFILLER_0_37_488 VGND VGND VPWR VPWR sky130_fd_sc_hd__fill_2
XFILLER_0_135_685 VPWR VGND VPWR VGND sky130_ef_sc_hd__decap_12
XTAP_TAPCELL_ROW_118_2072 VGND VPWR sky130_fd_sc_hd__tapvpwrvgnd_1
XFILLER_0_134_195 VGND VGND VPWR VPWR sky130_fd_sc_hd__fill_1
XFILLER_0_122_357 VGND VGND VPWR VPWR sky130_fd_sc_hd__decap_6
XFILLER_0_20_333 VPWR VGND VPWR VGND sky130_ef_sc_hd__decap_12
XTAP_TAPCELL_ROW_131_2272 VGND VPWR sky130_fd_sc_hd__tapvpwrvgnd_1
XTAP_TAPCELL_ROW_131_2261 VGND VPWR sky130_fd_sc_hd__tapvpwrvgnd_1
XFILLER_0_103_593 VPWR VGND VPWR VGND sky130_ef_sc_hd__decap_12
XFILLER_0_103_571 VGND VGND VPWR VPWR sky130_fd_sc_hd__fill_1
XFILLER_0_20_377 VPWR VGND VPWR VGND sky130_ef_sc_hd__decap_12
XFILLER_0_137_27 VPWR VGND VPWR VGND sky130_ef_sc_hd__decap_12
XFILLER_0_88_801 VGND VGND VPWR VPWR sky130_fd_sc_hd__decap_8
XFILLER_0_1_27 VPWR VGND VPWR VGND sky130_ef_sc_hd__decap_12
XFILLER_0_99_193 VPWR VGND VPWR VGND sky130_ef_sc_hd__decap_12
XTAP_TAPCELL_ROW_47_1001 VGND VPWR sky130_fd_sc_hd__tapvpwrvgnd_1
XTAP_TAPCELL_ROW_47_1012 VGND VPWR sky130_fd_sc_hd__tapvpwrvgnd_1
XTAP_TAPCELL_ROW_16_542 VGND VPWR sky130_fd_sc_hd__tapvpwrvgnd_1
X_4830_ cpu_inst.regfile_inst.registers\[9\]\[1\] VGND VGND VPWR VPWR _2400_ sky130_fd_sc_hd__clkbuf_1
XFILLER_0_134_3 VPWR VGND VPWR VGND sky130_ef_sc_hd__decap_12
XFILLER_0_75_539 VGND VGND VPWR VPWR sky130_fd_sc_hd__fill_1
XTAP_TAPCELL_ROW_60_1201 VGND VPWR sky130_fd_sc_hd__tapvpwrvgnd_1
XFILLER_0_7_305 VPWR VGND VPWR VGND sky130_ef_sc_hd__decap_12
XFILLER_0_28_433 VPWR VGND VPWR VGND sky130_ef_sc_hd__decap_12
XFILLER_0_90_509 VGND VGND VPWR VPWR sky130_fd_sc_hd__decap_8
X_4761_ _2292_ _2365_ cpu_inst.decoder_inst.current_pc\[30\] _2288_ VGND VGND VPWR
+ VPWR _0350_ sky130_fd_sc_hd__o2bb2a_1
X_3712_ _1636_ _1224_ _1643_ VGND VGND VPWR VPWR _1644_ sky130_fd_sc_hd__a21o_1
X_4692_ cpu_inst.decoder_inst.current_pc\[11\] _2313_ VGND VGND VPWR VPWR _2316_ sky130_fd_sc_hd__nor2_1
XFILLER_0_7_349 VPWR VGND VPWR VGND sky130_ef_sc_hd__decap_12
XFILLER_0_15_105 VGND VGND VPWR VPWR sky130_fd_sc_hd__decap_6
XFILLER_0_28_477 VPWR VGND VPWR VGND sky130_ef_sc_hd__decap_12
XFILLER_0_114_825 VPWR VGND VPWR VGND sky130_ef_sc_hd__decap_12
XFILLER_0_102_41 VPWR VGND VPWR VGND sky130_ef_sc_hd__decap_12
X_3643_ _1531_ _1529_ _1570_ _1526_ VGND VGND VPWR VPWR _1576_ sky130_fd_sc_hd__a211o_1
XFILLER_0_70_233 VPWR VGND VPWR VGND sky130_ef_sc_hd__decap_12
XFILLER_0_15_149 VPWR VGND VPWR VGND sky130_ef_sc_hd__decap_12
XFILLER_0_113_335 VGND VGND VPWR VPWR sky130_fd_sc_hd__fill_1
XFILLER_0_102_85 VPWR VGND VPWR VGND sky130_ef_sc_hd__decap_12
XFILLER_0_70_277 VPWR VGND VPWR VGND sky130_ef_sc_hd__decap_12
X_3574_ _1359_ _1508_ VGND VGND VPWR VPWR _1509_ sky130_fd_sc_hd__nand2_1
XFILLER_0_23_193 VPWR VGND VPWR VGND sky130_ef_sc_hd__decap_12
X_5313_ clknet_leaf_25_clk _0233_ VGND VGND VPWR VPWR cpu_inst.regfile_inst.registers\[7\]\[9\]
+ sky130_fd_sc_hd__dfxtp_1
XTAP_TAPCELL_ROW_58_1174 VGND VPWR sky130_fd_sc_hd__tapvpwrvgnd_1
XTAP_TAPCELL_ROW_58_1163 VGND VPWR sky130_fd_sc_hd__tapvpwrvgnd_1
X_5244_ clknet_leaf_38_clk _0164_ VGND VGND VPWR VPWR cpu_inst.regfile_inst.registers\[5\]\[4\]
+ sky130_fd_sc_hd__dfxtp_1
X_5175_ clknet_leaf_2_clk _0095_ VGND VGND VPWR VPWR cpu_inst.regfile_inst.registers\[25\]\[31\]
+ sky130_fd_sc_hd__dfxtp_1
XTAP_TAPCELL_ROW_71_1363 VGND VPWR sky130_fd_sc_hd__tapvpwrvgnd_1
X_4126_ _2002_ VGND VGND VPWR VPWR _0078_ sky130_fd_sc_hd__clkbuf_1
XFILLER_0_39_3 VPWR VGND VPWR VGND sky130_ef_sc_hd__decap_12
XFILLER_0_127_93 VPWR VGND VPWR VGND sky130_ef_sc_hd__decap_12
XFILLER_0_79_823 VPWR VGND VPWR VGND sky130_ef_sc_hd__decap_12
X_4057_ _1964_ VGND VGND VPWR VPWR _0047_ sky130_fd_sc_hd__clkbuf_1
XFILLER_0_78_333 VPWR VGND VPWR VGND sky130_ef_sc_hd__decap_12
X_3008_ cpu_inst.regfile_inst.registers\[25\]\[9\] _0692_ _0694_ _0972_ VGND VGND
+ VPWR VPWR _0973_ sky130_fd_sc_hd__o211a_1
XFILLER_0_94_837 VGND VGND VPWR VPWR sky130_fd_sc_hd__decap_4
XFILLER_0_78_377 VGND VGND VPWR VPWR sky130_fd_sc_hd__decap_4
X_4959_ _1948_ cpu_inst.regfile_inst.registers\[8\]\[31\] _2436_ VGND VGND VPWR VPWR
+ _2467_ sky130_fd_sc_hd__mux2_1
XFILLER_0_62_701 VGND VGND VPWR VPWR sky130_fd_sc_hd__fill_2
XFILLER_0_47_775 VGND VGND VPWR VPWR sky130_fd_sc_hd__fill_2
XFILLER_0_117_641 VPWR VGND VPWR VGND sky130_ef_sc_hd__decap_12
XFILLER_0_117_685 VPWR VGND VPWR VGND sky130_ef_sc_hd__decap_12
XFILLER_0_116_195 VGND VGND VPWR VPWR sky130_fd_sc_hd__fill_1
XFILLER_0_104_357 VGND VGND VPWR VPWR sky130_fd_sc_hd__decap_6
XFILLER_0_132_699 VGND VGND VPWR VPWR sky130_fd_sc_hd__fill_1
XFILLER_0_30_697 VGND VGND VPWR VPWR sky130_fd_sc_hd__decap_3
XTAP_TAPCELL_ROW_89_1635 VGND VPWR sky130_fd_sc_hd__tapvpwrvgnd_1
XFILLER_0_96_141 VPWR VGND VPWR VGND sky130_ef_sc_hd__decap_12
XFILLER_0_85_837 VGND VGND VPWR VPWR sky130_fd_sc_hd__decap_3
XFILLER_0_127_405 VPWR VGND VPWR VGND sky130_ef_sc_hd__decap_12
XTAP_TAPCELL_ROW_100_1802 VGND VPWR sky130_fd_sc_hd__tapvpwrvgnd_1
XFILLER_0_69_399 VPWR VGND VPWR VGND sky130_ef_sc_hd__decap_12
XFILLER_0_32_27 VGND VGND VPWR VPWR sky130_fd_sc_hd__fill_1
XTAP_TAPCELL_ROW_13_501 VGND VPWR sky130_fd_sc_hd__tapvpwrvgnd_1
XFILLER_0_127_449 VPWR VGND VPWR VGND sky130_ef_sc_hd__decap_12
XFILLER_0_108_630 VPWR VGND VPWR VGND sky130_ef_sc_hd__decap_12
XFILLER_0_5_809 VPWR VGND VPWR VGND sky130_ef_sc_hd__decap_12
XTAP_TAPCELL_ROW_133_2301 VGND VPWR sky130_fd_sc_hd__tapvpwrvgnd_1
XFILLER_0_25_447 VGND VGND VPWR VPWR sky130_fd_sc_hd__fill_1
XFILLER_0_52_233 VPWR VGND VPWR VGND sky130_ef_sc_hd__decap_12
XFILLER_0_122_121 VPWR VGND VPWR VGND sky130_ef_sc_hd__decap_12
XFILLER_0_80_586 VGND VGND VPWR VPWR sky130_fd_sc_hd__fill_2
XFILLER_0_52_277 VPWR VGND VPWR VGND sky130_ef_sc_hd__decap_12
XFILLER_0_13_609 VGND VGND VPWR VPWR sky130_fd_sc_hd__decap_6
XFILLER_0_122_165 VPWR VGND VPWR VGND sky130_ef_sc_hd__decap_12
XFILLER_0_111_839 VGND VGND VPWR VPWR sky130_fd_sc_hd__fill_1
XFILLER_0_20_141 VPWR VGND VPWR VGND sky130_ef_sc_hd__decap_12
XFILLER_0_21_653 VPWR VGND VPWR VGND sky130_ef_sc_hd__decap_12
X_3290_ _1062_ VGND VGND VPWR VPWR _1255_ sky130_fd_sc_hd__clkbuf_4
XFILLER_0_21_697 VPWR VGND VPWR VGND sky130_ef_sc_hd__decap_12
XTAP_TAPCELL_ROW_111_1964 VGND VPWR sky130_fd_sc_hd__tapvpwrvgnd_1
XFILLER_0_57_57 VPWR VGND VPWR VGND sky130_ef_sc_hd__decap_12
XTAP_TAPCELL_ROW_53_1093 VGND VPWR sky130_fd_sc_hd__tapvpwrvgnd_1
XFILLER_0_48_528 VGND VGND VPWR VPWR sky130_fd_sc_hd__fill_1
X_4813_ _2391_ VGND VGND VPWR VPWR _0376_ sky130_fd_sc_hd__clkbuf_1
XFILLER_0_8_625 VPWR VGND VPWR VGND sky130_ef_sc_hd__decap_12
XFILLER_0_7_113 VPWR VGND VPWR VGND sky130_ef_sc_hd__decap_12
XFILLER_0_29_753 VPWR VGND VPWR VGND sky130_ef_sc_hd__decap_12
XFILLER_0_113_51 VGND VGND VPWR VPWR sky130_fd_sc_hd__decap_4
X_4744_ _2353_ _0685_ _2284_ VGND VGND VPWR VPWR _2354_ sky130_fd_sc_hd__or3b_1
XFILLER_0_8_669 VPWR VGND VPWR VGND sky130_ef_sc_hd__decap_12
XFILLER_0_71_531 VGND VGND VPWR VPWR sky130_fd_sc_hd__fill_1
XFILLER_0_98_53 VPWR VGND VPWR VGND sky130_ef_sc_hd__decap_12
X_4675_ cpu_inst.decoder_inst.current_pc\[7\] cpu_inst.decoder_inst.current_pc\[6\]
+ _2299_ VGND VGND VPWR VPWR _2303_ sky130_fd_sc_hd__and3_1
XFILLER_0_16_469 VGND VGND VPWR VPWR sky130_fd_sc_hd__decap_6
XFILLER_0_31_417 VPWR VGND VPWR VGND sky130_ef_sc_hd__decap_12
X_3626_ _0853_ VGND VGND VPWR VPWR _1560_ sky130_fd_sc_hd__clkbuf_4
XFILLER_0_101_305 VPWR VGND VPWR VGND sky130_ef_sc_hd__decap_12
XPHY_EDGE_ROW_131_Right_131 VGND VGND VPWR VPWR sky130_fd_sc_hd__decap_3
XFILLER_0_114_699 VGND VGND VPWR VPWR sky130_fd_sc_hd__fill_1
XFILLER_0_98_97 VPWR VGND VPWR VGND sky130_ef_sc_hd__decap_12
X_3557_ _1224_ _1485_ _1486_ _1492_ _0683_ VGND VGND VPWR VPWR _1493_ sky130_fd_sc_hd__a32o_2
XFILLER_0_3_385 VGND VGND VPWR VPWR sky130_fd_sc_hd__decap_6
XFILLER_0_101_349 VPWR VGND VPWR VGND sky130_ef_sc_hd__decap_12
X_3488_ cpu_inst.regfile_inst.registers\[9\]\[18\] cpu_inst.regfile_inst.registers\[8\]\[18\]
+ _1386_ VGND VGND VPWR VPWR _1425_ sky130_fd_sc_hd__mux2_1
X_5227_ clknet_leaf_16_clk _0147_ VGND VGND VPWR VPWR cpu_inst.regfile_inst.registers\[24\]\[19\]
+ sky130_fd_sc_hd__dfxtp_1
XFILLER_0_138_81 VGND VGND VPWR VPWR sky130_fd_sc_hd__decap_3
X_5158_ clknet_leaf_23_clk _0078_ VGND VGND VPWR VPWR cpu_inst.regfile_inst.registers\[25\]\[14\]
+ sky130_fd_sc_hd__dfxtp_1
XFILLER_0_98_439 VGND VGND VPWR VPWR sky130_fd_sc_hd__decap_4
X_4109_ _1993_ VGND VGND VPWR VPWR _0070_ sky130_fd_sc_hd__clkbuf_1
X_5089_ clknet_leaf_32_clk _0009_ VGND VGND VPWR VPWR cpu_inst.regfile_inst.registers\[6\]\[9\]
+ sky130_fd_sc_hd__dfxtp_1
XFILLER_0_78_141 VPWR VGND VPWR VGND sky130_ef_sc_hd__decap_12
XFILLER_0_109_405 VPWR VGND VPWR VGND sky130_ef_sc_hd__decap_12
XFILLER_0_93_111 VGND VGND VPWR VPWR sky130_fd_sc_hd__fill_1
XTAP_TAPCELL_ROW_84_1565 VGND VPWR sky130_fd_sc_hd__tapvpwrvgnd_1
XTAP_TAPCELL_ROW_84_1554 VGND VPWR sky130_fd_sc_hd__tapvpwrvgnd_1
XFILLER_0_39_528 VGND VGND VPWR VPWR sky130_fd_sc_hd__fill_2
XFILLER_0_82_829 VGND VGND VPWR VPWR sky130_fd_sc_hd__decap_8
XFILLER_0_109_449 VPWR VGND VPWR VGND sky130_ef_sc_hd__decap_12
XFILLER_0_81_317 VPWR VGND VPWR VGND sky130_ef_sc_hd__decap_12
XFILLER_0_124_419 VGND VGND VPWR VPWR sky130_fd_sc_hd__fill_1
XFILLER_0_62_520 VGND VGND VPWR VPWR sky130_fd_sc_hd__fill_2
XFILLER_0_34_233 VPWR VGND VPWR VGND sky130_ef_sc_hd__decap_12
XFILLER_0_35_745 VPWR VGND VPWR VGND sky130_ef_sc_hd__decap_12
XTAP_TAPCELL_ROW_115_2020 VGND VPWR sky130_fd_sc_hd__tapvpwrvgnd_1
XFILLER_0_104_121 VPWR VGND VPWR VGND sky130_ef_sc_hd__decap_12
XFILLER_0_34_277 VPWR VGND VPWR VGND sky130_ef_sc_hd__decap_12
XFILLER_0_35_789 VGND VGND VPWR VPWR sky130_fd_sc_hd__fill_1
XFILLER_0_50_704 VGND VGND VPWR VPWR sky130_fd_sc_hd__fill_2
XFILLER_0_50_715 VGND VGND VPWR VPWR sky130_fd_sc_hd__decap_3
XTAP_TAPCELL_ROW_115_2031 VGND VPWR sky130_fd_sc_hd__tapvpwrvgnd_1
XFILLER_0_120_625 VPWR VGND VPWR VGND sky130_ef_sc_hd__decap_12
XFILLER_0_104_165 VPWR VGND VPWR VGND sky130_ef_sc_hd__decap_12
XFILLER_0_120_669 VPWR VGND VPWR VGND sky130_ef_sc_hd__decap_12
XFILLER_0_118_29 VPWR VGND VPWR VGND sky130_ef_sc_hd__decap_12
XFILLER_0_27_27 VPWR VGND VPWR VGND sky130_ef_sc_hd__decap_12
XTAP_TAPCELL_ROW_126_2193 VGND VPWR sky130_fd_sc_hd__tapvpwrvgnd_1
XFILLER_0_43_15 VPWR VGND VPWR VGND sky130_ef_sc_hd__decap_12
XFILLER_0_57_325 VGND VGND VPWR VPWR sky130_fd_sc_hd__fill_1
XFILLER_0_128_725 VPWR VGND VPWR VGND sky130_ef_sc_hd__decap_12
XFILLER_0_84_133 VGND VGND VPWR VPWR sky130_fd_sc_hd__decap_6
XTAP_TAPCELL_ROW_26_692 VGND VPWR sky130_fd_sc_hd__tapvpwrvgnd_1
XFILLER_0_128_769 VPWR VGND VPWR VGND sky130_ef_sc_hd__decap_12
XFILLER_0_84_177 VPWR VGND VPWR VGND sky130_ef_sc_hd__decap_12
XFILLER_0_26_701 VPWR VGND VPWR VGND sky130_ef_sc_hd__decap_12
XFILLER_0_127_279 VGND VGND VPWR VPWR sky130_fd_sc_hd__fill_1
X_2790_ _0714_ _0546_ VGND VGND VPWR VPWR _0755_ sky130_fd_sc_hd__or2b_1
XFILLER_0_5_617 VPWR VGND VPWR VGND sky130_ef_sc_hd__decap_12
XFILLER_0_13_417 VPWR VGND VPWR VGND sky130_ef_sc_hd__decap_12
XFILLER_0_123_441 VGND VGND VPWR VPWR sky130_fd_sc_hd__decap_6
X_4460_ _2177_ VGND VGND VPWR VPWR _0237_ sky130_fd_sc_hd__clkbuf_1
XFILLER_0_7_15 VPWR VGND VPWR VGND sky130_ef_sc_hd__decap_12
XFILLER_0_123_485 VPWR VGND VPWR VGND sky130_ef_sc_hd__decap_12
X_3411_ cpu_inst.regfile_inst.registers\[7\]\[16\] cpu_inst.regfile_inst.registers\[6\]\[16\]
+ _1348_ VGND VGND VPWR VPWR _1350_ sky130_fd_sc_hd__mux2_1
X_4391_ cpu_inst.regfile_inst.registers\[1\]\[13\] VGND VGND VPWR VPWR _2141_ sky130_fd_sc_hd__clkbuf_1
XTAP_TAPCELL_ROW_55_1122 VGND VPWR sky130_fd_sc_hd__tapvpwrvgnd_1
X_3342_ _0553_ _1293_ _1294_ _1296_ VGND VGND VPWR VPWR _1297_ sky130_fd_sc_hd__a31o_1
XFILLER_0_0_333 VGND VGND VPWR VPWR sky130_fd_sc_hd__decap_3
XFILLER_0_21_461 VPWR VGND VPWR VGND sky130_ef_sc_hd__decap_12
XFILLER_0_0_377 VPWR VGND VPWR VGND sky130_ef_sc_hd__decap_12
X_3273_ _1226_ _1237_ VGND VGND VPWR VPWR _1238_ sky130_fd_sc_hd__xnor2_1
X_5012_ _2495_ VGND VGND VPWR VPWR _0471_ sky130_fd_sc_hd__clkbuf_1
XFILLER_0_84_77 VGND VGND VPWR VPWR sky130_fd_sc_hd__decap_6
XFILLER_0_17_93 VPWR VGND VPWR VGND sky130_ef_sc_hd__decap_12
XFILLER_0_75_111 VGND VGND VPWR VPWR sky130_fd_sc_hd__fill_1
XFILLER_0_49_837 VGND VGND VPWR VPWR sky130_fd_sc_hd__decap_3
XFILLER_0_124_83 VGND VGND VPWR VPWR sky130_fd_sc_hd__fill_1
XTAP_TAPCELL_ROW_66_1295 VGND VPWR sky130_fd_sc_hd__tapvpwrvgnd_1
XTAP_TAPCELL_ROW_66_1284 VGND VPWR sky130_fd_sc_hd__tapvpwrvgnd_1
XFILLER_0_29_550 VGND VGND VPWR VPWR sky130_fd_sc_hd__decap_8
XFILLER_0_8_433 VPWR VGND VPWR VGND sky130_ef_sc_hd__decap_12
XFILLER_0_29_561 VGND VGND VPWR VPWR sky130_fd_sc_hd__decap_8
XFILLER_0_33_81 VPWR VGND VPWR VGND sky130_ef_sc_hd__decap_12
XFILLER_0_133_205 VPWR VGND VPWR VGND sky130_ef_sc_hd__decap_12
XFILLER_0_106_419 VGND VGND VPWR VPWR sky130_fd_sc_hd__fill_1
XFILLER_0_8_477 VPWR VGND VPWR VGND sky130_ef_sc_hd__decap_12
XFILLER_0_16_233 VPWR VGND VPWR VGND sky130_ef_sc_hd__decap_12
X_2988_ cpu_inst.regfile_inst.registers\[5\]\[7\] cpu_inst.regfile_inst.registers\[4\]\[7\]
+ _0866_ VGND VGND VPWR VPWR _0953_ sky130_fd_sc_hd__mux2_1
XFILLER_0_133_249 VPWR VGND VPWR VGND sky130_ef_sc_hd__decap_12
X_4727_ cpu_inst.decoder_inst.current_pc\[21\] _2338_ VGND VGND VPWR VPWR _2341_ sky130_fd_sc_hd__xnor2_1
X_4658_ _0521_ cpu_inst.decoder_inst.current_pc\[2\] VGND VGND VPWR VPWR _2290_ sky130_fd_sc_hd__xor2_1
XFILLER_0_16_277 VPWR VGND VPWR VGND sky130_ef_sc_hd__decap_12
XFILLER_0_31_225 VPWR VGND VPWR VGND sky130_ef_sc_hd__decap_12
XFILLER_0_32_726 VPWR VGND VPWR VGND sky130_ef_sc_hd__decap_12
XFILLER_0_101_113 VPWR VGND VPWR VGND sky130_ef_sc_hd__decap_12
X_3609_ _1536_ _1539_ _1542_ _0876_ VGND VGND VPWR VPWR _1543_ sky130_fd_sc_hd__o22a_1
X_4589_ cpu_inst.regfile_inst.registers\[10\]\[13\] _2241_ VGND VGND VPWR VPWR _2243_
+ sky130_fd_sc_hd__and2_1
XFILLER_0_3_193 VPWR VGND VPWR VGND sky130_ef_sc_hd__decap_12
XFILLER_0_40_770 VGND VGND VPWR VPWR sky130_fd_sc_hd__fill_1
XTAP_TAPCELL_ROW_4_365 VGND VPWR sky130_fd_sc_hd__tapvpwrvgnd_1
XTAP_TAPCELL_ROW_4_354 VGND VPWR sky130_fd_sc_hd__tapvpwrvgnd_1
XFILLER_0_67_634 VGND VGND VPWR VPWR sky130_fd_sc_hd__fill_2
XFILLER_0_66_133 VGND VGND VPWR VPWR sky130_fd_sc_hd__decap_6
XPHY_EDGE_ROW_11_Right_11 VGND VGND VPWR VPWR sky130_fd_sc_hd__decap_3
XTAP_TAPCELL_ROW_43_938 VGND VPWR sky130_fd_sc_hd__tapvpwrvgnd_1
XTAP_TAPCELL_ROW_43_949 VGND VPWR sky130_fd_sc_hd__tapvpwrvgnd_1
XFILLER_0_94_475 VGND VGND VPWR VPWR sky130_fd_sc_hd__fill_1
XFILLER_0_67_689 VGND VGND VPWR VPWR sky130_fd_sc_hd__fill_2
XFILLER_0_66_177 VPWR VGND VPWR VGND sky130_ef_sc_hd__decap_12
XTAP_TAPCELL_ROW_23_640 VGND VPWR sky130_fd_sc_hd__tapvpwrvgnd_1
XFILLER_0_109_279 VGND VGND VPWR VPWR sky130_fd_sc_hd__fill_1
XFILLER_0_81_125 VPWR VGND VPWR VGND sky130_ef_sc_hd__decap_12
XTAP_TAPCELL_ROW_23_651 VGND VPWR sky130_fd_sc_hd__tapvpwrvgnd_1
XFILLER_0_47_391 VGND VGND VPWR VPWR sky130_fd_sc_hd__fill_1
XFILLER_0_81_169 VPWR VGND VPWR VGND sky130_ef_sc_hd__decap_12
XTAP_TAPCELL_ROW_97_1756 VGND VPWR sky130_fd_sc_hd__tapvpwrvgnd_1
XFILLER_0_90_692 VGND VGND VPWR VPWR sky130_fd_sc_hd__fill_2
XFILLER_0_133_783 VGND VGND VPWR VPWR sky130_fd_sc_hd__fill_1
XFILLER_0_120_433 VPWR VGND VPWR VGND sky130_ef_sc_hd__decap_12
XFILLER_0_129_39 VPWR VGND VPWR VGND sky130_ef_sc_hd__decap_12
XFILLER_0_120_477 VPWR VGND VPWR VGND sky130_ef_sc_hd__decap_12
XPHY_EDGE_ROW_20_Right_20 VGND VGND VPWR VPWR sky130_fd_sc_hd__decap_3
XFILLER_0_38_15 VPWR VGND VPWR VGND sky130_ef_sc_hd__decap_12
XTAP_TAPCELL_ROW_128_2222 VGND VPWR sky130_fd_sc_hd__tapvpwrvgnd_1
XTAP_TAPCELL_ROW_50_1052 VGND VPWR sky130_fd_sc_hd__tapvpwrvgnd_1
XFILLER_0_89_225 VPWR VGND VPWR VGND sky130_ef_sc_hd__decap_12
X_3960_ cpu_inst.regfile_inst.registers\[1\]\[30\] _1804_ _1805_ cpu_inst.regfile_inst.registers\[5\]\[30\]
+ VGND VGND VPWR VPWR _1885_ sky130_fd_sc_hd__o22a_1
XFILLER_0_57_111 VGND VGND VPWR VPWR sky130_fd_sc_hd__fill_1
XTAP_TAPCELL_ROW_106_1896 VGND VPWR sky130_fd_sc_hd__tapvpwrvgnd_1
XTAP_TAPCELL_ROW_106_1885 VGND VPWR sky130_fd_sc_hd__tapvpwrvgnd_1
X_2911_ _0875_ VGND VGND VPWR VPWR _0876_ sky130_fd_sc_hd__buf_4
XFILLER_0_128_533 VPWR VGND VPWR VGND sky130_ef_sc_hd__decap_12
X_3891_ cpu_inst.regfile_inst.registers\[25\]\[28\] _1285_ _1449_ _1800_ _1816_ VGND
+ VGND VPWR VPWR _1818_ sky130_fd_sc_hd__o2111a_1
XFILLER_0_45_317 VPWR VGND VPWR VGND sky130_ef_sc_hd__decap_12
XFILLER_0_115_205 VPWR VGND VPWR VGND sky130_ef_sc_hd__decap_12
XFILLER_0_73_659 VPWR VGND VPWR VGND sky130_ef_sc_hd__decap_12
X_2842_ cpu_inst.regfile_inst.registers\[8\]\[6\] _0806_ _0598_ VGND VGND VPWR VPWR
+ _0807_ sky130_fd_sc_hd__mux2_1
XFILLER_0_60_309 VGND VGND VPWR VPWR sky130_fd_sc_hd__decap_4
XFILLER_0_5_447 VGND VGND VPWR VPWR sky130_fd_sc_hd__fill_1
X_5561_ clknet_leaf_31_clk _0481_ VGND VGND VPWR VPWR cpu_inst.display_inst.counter\[1\]
+ sky130_fd_sc_hd__dfxtp_1
X_2773_ _0724_ _0734_ _0737_ _0611_ VGND VGND VPWR VPWR _0738_ sky130_fd_sc_hd__a31o_1
XFILLER_0_131_709 VPWR VGND VPWR VGND sky130_ef_sc_hd__decap_12
XFILLER_0_115_249 VPWR VGND VPWR VGND sky130_ef_sc_hd__decap_12
X_5492_ clknet_leaf_6_clk _0412_ VGND VGND VPWR VPWR cpu_inst.regfile_inst.registers\[9\]\[28\]
+ sky130_fd_sc_hd__dfxtp_1
XFILLER_0_13_225 VPWR VGND VPWR VGND sky130_ef_sc_hd__decap_12
XFILLER_0_14_737 VPWR VGND VPWR VGND sky130_ef_sc_hd__decap_12
X_4512_ cpu_inst.regfile_inst.registers\[11\]\[7\] VGND VGND VPWR VPWR _2204_ sky130_fd_sc_hd__clkbuf_1
XFILLER_0_110_41 VPWR VGND VPWR VGND sky130_ef_sc_hd__decap_12
XFILLER_0_79_55 VGND VGND VPWR VPWR sky130_fd_sc_hd__fill_1
XFILLER_0_123_293 VPWR VGND VPWR VGND sky130_ef_sc_hd__decap_12
XFILLER_0_110_85 VPWR VGND VPWR VGND sky130_ef_sc_hd__decap_12
XFILLER_0_1_653 VPWR VGND VPWR VGND sky130_ef_sc_hd__decap_12
XFILLER_0_22_781 VPWR VGND VPWR VGND sky130_ef_sc_hd__decap_12
X_4443_ _2168_ VGND VGND VPWR VPWR _0229_ sky130_fd_sc_hd__clkbuf_1
XFILLER_0_0_141 VPWR VGND VPWR VGND sky130_ef_sc_hd__decap_12
X_4374_ _2132_ VGND VGND VPWR VPWR _0196_ sky130_fd_sc_hd__clkbuf_1
X_3325_ _1157_ VGND VGND VPWR VPWR net5 sky130_fd_sc_hd__inv_2
XFILLER_0_1_697 VPWR VGND VPWR VGND sky130_ef_sc_hd__decap_12
X_3256_ _1055_ _1202_ VGND VGND VPWR VPWR _1221_ sky130_fd_sc_hd__nand2_1
X_3187_ _0912_ _1151_ VGND VGND VPWR VPWR _1152_ sky130_fd_sc_hd__or2_1
XTAP_TAPCELL_ROW_68_1313 VGND VPWR sky130_fd_sc_hd__tapvpwrvgnd_1
XTAP_TAPCELL_ROW_1_313 VGND VPWR sky130_fd_sc_hd__tapvpwrvgnd_1
XFILLER_0_21_3 VPWR VGND VPWR VGND sky130_ef_sc_hd__decap_12
XTAP_TAPCELL_ROW_68_1324 VGND VPWR sky130_fd_sc_hd__tapvpwrvgnd_1
XFILLER_0_135_93 VPWR VGND VPWR VGND sky130_ef_sc_hd__decap_12
XFILLER_0_95_217 VGND VGND VPWR VPWR sky130_fd_sc_hd__decap_6
XTAP_TAPCELL_ROW_81_1513 VGND VPWR sky130_fd_sc_hd__tapvpwrvgnd_1
XFILLER_0_48_133 VGND VGND VPWR VPWR sky130_fd_sc_hd__decap_6
XFILLER_0_9_753 VPWR VGND VPWR VGND sky130_ef_sc_hd__decap_12
XFILLER_0_48_177 VPWR VGND VPWR VGND sky130_ef_sc_hd__decap_12
XFILLER_0_91_434 VGND VGND VPWR VPWR sky130_fd_sc_hd__decap_6
XFILLER_0_63_125 VPWR VGND VPWR VGND sky130_ef_sc_hd__decap_12
XFILLER_0_29_391 VGND VGND VPWR VPWR sky130_fd_sc_hd__fill_1
XFILLER_0_134_525 VGND VGND VPWR VPWR sky130_fd_sc_hd__decap_6
XFILLER_0_63_169 VPWR VGND VPWR VGND sky130_ef_sc_hd__decap_12
XFILLER_0_9_797 VPWR VGND VPWR VGND sky130_ef_sc_hd__decap_12
XFILLER_0_17_553 VGND VGND VPWR VPWR sky130_fd_sc_hd__decap_6
XFILLER_0_134_569 VPWR VGND VPWR VGND sky130_ef_sc_hd__decap_12
XFILLER_0_60_810 VGND VGND VPWR VPWR sky130_fd_sc_hd__fill_2
XFILLER_0_17_597 VPWR VGND VPWR VGND sky130_ef_sc_hd__decap_12
XFILLER_0_115_783 VGND VGND VPWR VPWR sky130_fd_sc_hd__fill_1
XTAP_TAPCELL_ROW_79_1486 VGND VPWR sky130_fd_sc_hd__tapvpwrvgnd_1
XTAP_TAPCELL_ROW_9_435 VGND VPWR sky130_fd_sc_hd__tapvpwrvgnd_1
XTAP_TAPCELL_ROW_92_1686 VGND VPWR sky130_fd_sc_hd__tapvpwrvgnd_1
XTAP_TAPCELL_ROW_92_1675 VGND VPWR sky130_fd_sc_hd__tapvpwrvgnd_1
XTAP_TAPCELL_ROW_123_2141 VGND VPWR sky130_fd_sc_hd__tapvpwrvgnd_1
XTAP_TAPCELL_ROW_28_721 VGND VPWR sky130_fd_sc_hd__tapvpwrvgnd_1
XTAP_TAPCELL_ROW_123_2152 VGND VPWR sky130_fd_sc_hd__tapvpwrvgnd_1
XFILLER_0_95_751 VGND VGND VPWR VPWR sky130_fd_sc_hd__fill_1
XFILLER_0_67_431 VGND VGND VPWR VPWR sky130_fd_sc_hd__decap_3
XFILLER_0_39_111 VGND VGND VPWR VPWR sky130_fd_sc_hd__fill_1
XFILLER_0_55_615 VGND VGND VPWR VPWR sky130_fd_sc_hd__fill_1
XFILLER_0_27_317 VPWR VGND VPWR VGND sky130_ef_sc_hd__decap_12
XFILLER_0_28_829 VPWR VGND VPWR VGND sky130_ef_sc_hd__decap_12
XFILLER_0_125_503 VGND VGND VPWR VPWR sky130_fd_sc_hd__fill_1
XFILLER_0_40_27 VGND VGND VPWR VPWR sky130_fd_sc_hd__fill_1
XFILLER_0_137_385 VGND VGND VPWR VPWR sky130_fd_sc_hd__decap_6
XFILLER_0_82_467 VGND VGND VPWR VPWR sky130_fd_sc_hd__decap_8
XFILLER_0_42_309 VPWR VGND VPWR VGND sky130_ef_sc_hd__decap_12
XFILLER_0_113_709 VPWR VGND VPWR VGND sky130_ef_sc_hd__decap_12
XFILLER_0_82_489 VGND VGND VPWR VPWR sky130_fd_sc_hd__decap_6
XFILLER_0_63_670 VGND VGND VPWR VPWR sky130_fd_sc_hd__fill_2
XFILLER_0_35_361 VPWR VGND VPWR VGND sky130_ef_sc_hd__decap_12
XFILLER_0_121_753 VPWR VGND VPWR VGND sky130_ef_sc_hd__decap_12
XFILLER_0_105_293 VPWR VGND VPWR VGND sky130_ef_sc_hd__decap_12
XFILLER_0_11_729 VPWR VGND VPWR VGND sky130_ef_sc_hd__decap_12
XFILLER_0_49_69 VPWR VGND VPWR VGND sky130_ef_sc_hd__decap_12
XFILLER_0_121_797 VPWR VGND VPWR VGND sky130_ef_sc_hd__decap_12
X_3110_ _1049_ _1048_ _1054_ _1074_ _0682_ VGND VGND VPWR VPWR _1075_ sky130_fd_sc_hd__a32o_2
XFILLER_0_4_27 VGND VGND VPWR VPWR sky130_fd_sc_hd__fill_1
XFILLER_0_65_57 VPWR VGND VPWR VGND sky130_ef_sc_hd__decap_12
X_4090_ _0510_ _0554_ _1292_ VGND VGND VPWR VPWR _1981_ sky130_fd_sc_hd__or3_2
XTAP_TAPCELL_ROW_108_1914 VGND VPWR sky130_fd_sc_hd__tapvpwrvgnd_1
X_3041_ _0990_ _1005_ VGND VGND VPWR VPWR _1006_ sky130_fd_sc_hd__xnor2_1
XTAP_TAPCELL_ROW_108_1925 VGND VPWR sky130_fd_sc_hd__tapvpwrvgnd_1
XFILLER_0_77_217 VGND VGND VPWR VPWR sky130_fd_sc_hd__decap_6
XFILLER_0_58_442 VGND VGND VPWR VPWR sky130_fd_sc_hd__fill_2
X_4992_ cpu_inst.regfile_inst.registers\[15\]\[14\] _2480_ VGND VGND VPWR VPWR _2485_
+ sky130_fd_sc_hd__and2_1
XFILLER_0_92_209 VPWR VGND VPWR VGND sky130_ef_sc_hd__decap_12
X_3943_ _1868_ VGND VGND VPWR VPWR _0029_ sky130_fd_sc_hd__clkbuf_1
XFILLER_0_85_261 VPWR VGND VPWR VGND sky130_ef_sc_hd__decap_12
XTAP_TAPCELL_ROW_63_1243 VGND VPWR sky130_fd_sc_hd__tapvpwrvgnd_1
XFILLER_0_128_363 VGND VGND VPWR VPWR sky130_fd_sc_hd__fill_1
X_3874_ cpu_inst.regfile_inst.registers\[25\]\[28\] _1310_ _1311_ _1800_ VGND VGND
+ VPWR VPWR _1801_ sky130_fd_sc_hd__o211a_1
XFILLER_0_73_445 VGND VGND VPWR VPWR sky130_fd_sc_hd__decap_3
XFILLER_0_14_83 VGND VGND VPWR VPWR sky130_fd_sc_hd__fill_1
XFILLER_0_6_701 VPWR VGND VPWR VGND sky130_ef_sc_hd__decap_12
XFILLER_0_45_125 VPWR VGND VPWR VGND sky130_ef_sc_hd__decap_12
XFILLER_0_116_525 VGND VGND VPWR VPWR sky130_fd_sc_hd__decap_6
X_2825_ cpu_inst.regfile_inst.registers\[4\]\[7\] _0622_ VGND VGND VPWR VPWR _0790_
+ sky130_fd_sc_hd__or2_1
XFILLER_0_45_169 VPWR VGND VPWR VGND sky130_ef_sc_hd__decap_12
XFILLER_0_121_51 VGND VGND VPWR VPWR sky130_fd_sc_hd__decap_4
XFILLER_0_116_569 VPWR VGND VPWR VGND sky130_ef_sc_hd__decap_12
XFILLER_0_61_629 VGND VGND VPWR VPWR sky130_fd_sc_hd__fill_2
XFILLER_0_14_501 VPWR VGND VPWR VGND sky130_ef_sc_hd__decap_12
XFILLER_0_131_517 VPWR VGND VPWR VGND sky130_ef_sc_hd__decap_12
X_5544_ clknet_leaf_21_clk _0464_ VGND VGND VPWR VPWR cpu_inst.regfile_inst.registers\[15\]\[16\]
+ sky130_fd_sc_hd__dfxtp_1
X_2756_ _0720_ VGND VGND VPWR VPWR _0721_ sky130_fd_sc_hd__clkbuf_4
XFILLER_0_60_139 VGND VGND VPWR VPWR sky130_fd_sc_hd__fill_1
XFILLER_0_14_545 VPWR VGND VPWR VGND sky130_ef_sc_hd__decap_12
X_2687_ _0577_ _0578_ _0651_ VGND VGND VPWR VPWR _0652_ sky130_fd_sc_hd__or3_1
XFILLER_0_14_589 VPWR VGND VPWR VGND sky130_ef_sc_hd__decap_12
X_5475_ clknet_leaf_29_clk _0395_ VGND VGND VPWR VPWR cpu_inst.regfile_inst.registers\[9\]\[11\]
+ sky130_fd_sc_hd__dfxtp_1
X_4426_ _2158_ VGND VGND VPWR VPWR _0222_ sky130_fd_sc_hd__clkbuf_1
XFILLER_0_1_461 VPWR VGND VPWR VGND sky130_ef_sc_hd__decap_12
X_4357_ _1833_ cpu_inst.regfile_inst.registers\[5\]\[28\] _2117_ VGND VGND VPWR VPWR
+ _2124_ sky130_fd_sc_hd__mux2_1
X_4288_ _2086_ VGND VGND VPWR VPWR _0156_ sky130_fd_sc_hd__clkbuf_1
X_3308_ _1262_ _1264_ _1268_ _1271_ VGND VGND VPWR VPWR net8 sky130_fd_sc_hd__a31o_1
X_3239_ _1088_ _1201_ _1203_ VGND VGND VPWR VPWR _1204_ sky130_fd_sc_hd__o21ai_1
XFILLER_0_96_515 VPWR VGND VPWR VGND sky130_ef_sc_hd__decap_12
XFILLER_0_69_729 VGND VGND VPWR VPWR sky130_fd_sc_hd__decap_8
XFILLER_0_49_420 VGND VGND VPWR VPWR sky130_fd_sc_hd__decap_4
XFILLER_0_37_615 VGND VGND VPWR VPWR sky130_fd_sc_hd__fill_1
XFILLER_0_9_561 VPWR VGND VPWR VGND sky130_ef_sc_hd__decap_12
XFILLER_0_119_385 VGND VGND VPWR VPWR sky130_fd_sc_hd__decap_6
XFILLER_0_24_309 VPWR VGND VPWR VGND sky130_ef_sc_hd__decap_12
XTAP_TAPCELL_ROW_33_790 VGND VPWR sky130_fd_sc_hd__tapvpwrvgnd_1
XFILLER_0_134_333 VPWR VGND VPWR VGND sky130_ef_sc_hd__decap_12
XFILLER_0_17_361 VPWR VGND VPWR VGND sky130_ef_sc_hd__decap_12
XFILLER_0_134_377 VPWR VGND VPWR VGND sky130_ef_sc_hd__decap_12
XTAP_TAPCELL_ROW_94_1715 VGND VPWR sky130_fd_sc_hd__tapvpwrvgnd_1
XTAP_TAPCELL_ROW_94_1704 VGND VPWR sky130_fd_sc_hd__tapvpwrvgnd_1
XFILLER_0_103_753 VPWR VGND VPWR VGND sky130_ef_sc_hd__decap_12
XFILLER_0_60_673 VGND VGND VPWR VPWR sky130_fd_sc_hd__decap_8
XFILLER_0_103_797 VPWR VGND VPWR VGND sky130_ef_sc_hd__decap_12
XFILLER_0_19_39 VPWR VGND VPWR VGND sky130_ef_sc_hd__decap_12
XFILLER_0_126_29 VPWR VGND VPWR VGND sky130_ef_sc_hd__decap_12
XFILLER_0_35_27 VPWR VGND VPWR VGND sky130_ef_sc_hd__decap_12
XFILLER_0_59_217 VGND VGND VPWR VPWR sky130_fd_sc_hd__decap_6
XFILLER_0_129_105 VGND VGND VPWR VPWR sky130_fd_sc_hd__decap_6
XFILLER_0_129_149 VPWR VGND VPWR VGND sky130_ef_sc_hd__decap_12
XTAP_TAPCELL_ROW_103_1844 VGND VPWR sky130_fd_sc_hd__tapvpwrvgnd_1
XFILLER_0_74_209 VPWR VGND VPWR VGND sky130_ef_sc_hd__decap_12
XFILLER_0_68_784 VGND VGND VPWR VPWR sky130_fd_sc_hd__fill_2
XFILLER_0_67_261 VPWR VGND VPWR VGND sky130_ef_sc_hd__decap_12
XFILLER_0_51_15 VPWR VGND VPWR VGND sky130_ef_sc_hd__decap_12
XFILLER_0_27_125 VPWR VGND VPWR VGND sky130_ef_sc_hd__decap_12
XFILLER_0_82_253 VPWR VGND VPWR VGND sky130_ef_sc_hd__decap_12
XFILLER_0_27_169 VPWR VGND VPWR VGND sky130_ef_sc_hd__decap_12
XFILLER_0_137_193 VPWR VGND VPWR VGND sky130_ef_sc_hd__decap_12
XTAP_TAPCELL_ROW_136_2343 VGND VPWR sky130_fd_sc_hd__tapvpwrvgnd_1
XFILLER_0_43_629 VGND VGND VPWR VPWR sky130_fd_sc_hd__fill_2
XFILLER_0_113_517 VPWR VGND VPWR VGND sky130_ef_sc_hd__decap_12
Xclkload35 clknet_leaf_16_clk VGND VGND VPWR VPWR clkload35/Y sky130_fd_sc_hd__clkinv_4
X_3590_ _1501_ _1523_ VGND VGND VPWR VPWR _1525_ sky130_fd_sc_hd__and2_1
Xclkload13 clknet_leaf_5_clk VGND VGND VPWR VPWR clkload13/Y sky130_fd_sc_hd__clkinv_8
X_2610_ cpu_inst.decoder_inst.current_pc\[6\] _0563_ VGND VGND VPWR VPWR _0575_ sky130_fd_sc_hd__nor2_1
XTAP_TAPCELL_ROW_11_462 VGND VPWR sky130_fd_sc_hd__tapvpwrvgnd_1
XFILLER_0_42_139 VGND VGND VPWR VPWR sky130_fd_sc_hd__fill_1
Xclkload24 clknet_leaf_29_clk VGND VGND VPWR VPWR clkload24/Y sky130_fd_sc_hd__inv_6
X_2541_ cpu_inst.decoder_inst.current_pc\[10\] cpu_inst.decoder_inst.current_pc\[13\]
+ cpu_inst.decoder_inst.current_pc\[15\] cpu_inst.decoder_inst.current_pc\[14\] VGND
+ VGND VPWR VPWR _0506_ sky130_fd_sc_hd__or4_4
XFILLER_0_51_673 VGND VGND VPWR VPWR sky130_fd_sc_hd__fill_1
XFILLER_0_121_561 VPWR VGND VPWR VGND sky130_ef_sc_hd__decap_12
X_5260_ clknet_leaf_23_clk _0180_ VGND VGND VPWR VPWR cpu_inst.regfile_inst.registers\[5\]\[20\]
+ sky130_fd_sc_hd__dfxtp_1
X_4211_ cpu_inst.regfile_inst.registers\[4\]\[22\] _2046_ VGND VGND VPWR VPWR _2048_
+ sky130_fd_sc_hd__and2_1
XFILLER_0_11_559 VGND VGND VPWR VPWR sky130_fd_sc_hd__fill_1
X_5191_ clknet_leaf_21_clk _0111_ VGND VGND VPWR VPWR cpu_inst.regfile_inst.registers\[4\]\[15\]
+ sky130_fd_sc_hd__dfxtp_1
X_4142_ _1608_ cpu_inst.regfile_inst.registers\[25\]\[22\] _2010_ VGND VGND VPWR VPWR
+ _2011_ sky130_fd_sc_hd__mux2_1
X_4073_ _1972_ VGND VGND VPWR VPWR _0055_ sky130_fd_sc_hd__clkbuf_1
X_3024_ _0976_ _0988_ VGND VGND VPWR VPWR _0989_ sky130_fd_sc_hd__or2_4
XFILLER_0_92_77 VGND VGND VPWR VPWR sky130_fd_sc_hd__decap_6
XTAP_TAPCELL_ROW_19_584 VGND VPWR sky130_fd_sc_hd__tapvpwrvgnd_1
XFILLER_0_74_710 VGND VGND VPWR VPWR sky130_fd_sc_hd__decap_8
XFILLER_0_19_615 VGND VGND VPWR VPWR sky130_fd_sc_hd__fill_1
XFILLER_0_25_93 VPWR VGND VPWR VGND sky130_ef_sc_hd__decap_12
X_4975_ cpu_inst.regfile_inst.registers\[15\]\[6\] _2469_ VGND VGND VPWR VPWR _2476_
+ sky130_fd_sc_hd__and2_1
XFILLER_0_46_401 VGND VGND VPWR VPWR sky130_fd_sc_hd__decap_6
XFILLER_0_86_581 VGND VGND VPWR VPWR sky130_fd_sc_hd__decap_6
X_3926_ _0843_ _1850_ _1851_ _0859_ VGND VGND VPWR VPWR _1852_ sky130_fd_sc_hd__o211a_1
XFILLER_0_132_83 VGND VGND VPWR VPWR sky130_fd_sc_hd__fill_1
XFILLER_0_116_333 VPWR VGND VPWR VGND sky130_ef_sc_hd__decap_12
X_3857_ _1782_ _1784_ VGND VGND VPWR VPWR _1785_ sky130_fd_sc_hd__xnor2_1
XFILLER_0_6_531 VGND VGND VPWR VPWR sky130_fd_sc_hd__fill_1
XFILLER_0_15_821 VPWR VGND VPWR VGND sky130_ef_sc_hd__decap_12
Xclkload7 clknet_leaf_40_clk VGND VGND VPWR VPWR clkload7/Y sky130_fd_sc_hd__clkinv_1
XFILLER_0_41_81 VPWR VGND VPWR VGND sky130_ef_sc_hd__decap_12
XFILLER_0_46_489 VPWR VGND VPWR VGND sky130_ef_sc_hd__decap_12
XFILLER_0_132_837 VGND VGND VPWR VPWR sky130_fd_sc_hd__decap_4
XFILLER_0_116_377 VPWR VGND VPWR VGND sky130_ef_sc_hd__decap_12
X_3788_ _1709_ _1710_ _1713_ _1717_ VGND VGND VPWR VPWR _1718_ sky130_fd_sc_hd__o211a_1
X_2808_ cpu_inst.regfile_inst.registers\[8\]\[4\] _0772_ _0598_ VGND VGND VPWR VPWR
+ _0773_ sky130_fd_sc_hd__mux2_2
XTAP_TAPCELL_ROW_76_1434 VGND VPWR sky130_fd_sc_hd__tapvpwrvgnd_1
X_5527_ clknet_leaf_4_clk _0447_ VGND VGND VPWR VPWR cpu_inst.regfile_inst.registers\[8\]\[31\]
+ sky130_fd_sc_hd__dfxtp_1
X_2739_ cpu_inst.regfile_inst.registers\[2\]\[10\] _0593_ _0703_ cpu_inst.regfile_inst.registers\[7\]\[10\]
+ VGND VGND VPWR VPWR _0704_ sky130_fd_sc_hd__o22a_1
XTAP_TAPCELL_ROW_76_1445 VGND VPWR sky130_fd_sc_hd__tapvpwrvgnd_1
XFILLER_0_41_161 VGND VGND VPWR VPWR sky130_fd_sc_hd__decap_6
X_5458_ clknet_leaf_8_clk _0378_ VGND VGND VPWR VPWR cpu_inst.regfile_inst.registers\[0\]\[26\]
+ sky130_fd_sc_hd__dfxtp_1
XFILLER_0_2_781 VPWR VGND VPWR VGND sky130_ef_sc_hd__decap_12
X_4409_ cpu_inst.regfile_inst.registers\[1\]\[22\] VGND VGND VPWR VPWR _2150_ sky130_fd_sc_hd__clkbuf_1
X_5389_ clknet_leaf_17_clk _0309_ VGND VGND VPWR VPWR cpu_inst.regfile_inst.registers\[10\]\[21\]
+ sky130_fd_sc_hd__dfxtp_1
XFILLER_0_10_581 VGND VGND VPWR VPWR sky130_fd_sc_hd__decap_6
XFILLER_0_5_81 VPWR VGND VPWR VGND sky130_ef_sc_hd__decap_12
XFILLER_0_97_813 VPWR VGND VPWR VGND sky130_ef_sc_hd__decap_12
XFILLER_0_96_301 VGND VGND VPWR VPWR sky130_fd_sc_hd__decap_6
XFILLER_0_69_526 VGND VGND VPWR VPWR sky130_fd_sc_hd__fill_1
XTAP_TAPCELL_ROW_120_2100 VGND VPWR sky130_fd_sc_hd__tapvpwrvgnd_1
XFILLER_0_96_345 VPWR VGND VPWR VGND sky130_ef_sc_hd__decap_12
XTAP_TAPCELL_ROW_38_871 VGND VPWR sky130_fd_sc_hd__tapvpwrvgnd_1
XFILLER_0_96_389 VGND VGND VPWR VPWR sky130_fd_sc_hd__decap_6
XFILLER_0_56_209 VPWR VGND VPWR VGND sky130_ef_sc_hd__decap_12
XFILLER_0_127_609 VGND VGND VPWR VPWR sky130_fd_sc_hd__decap_6
XFILLER_0_49_261 VPWR VGND VPWR VGND sky130_ef_sc_hd__decap_12
XFILLER_0_64_253 VPWR VGND VPWR VGND sky130_ef_sc_hd__decap_12
XFILLER_0_135_653 VPWR VGND VPWR VGND sky130_ef_sc_hd__decap_12
XFILLER_0_119_193 VPWR VGND VPWR VGND sky130_ef_sc_hd__decap_12
XFILLER_0_9_391 VGND VGND VPWR VPWR sky130_fd_sc_hd__fill_1
XFILLER_0_18_681 VPWR VGND VPWR VGND sky130_ef_sc_hd__decap_12
XFILLER_0_135_697 VPWR VGND VPWR VGND sky130_ef_sc_hd__decap_12
XFILLER_0_134_141 VPWR VGND VPWR VGND sky130_ef_sc_hd__decap_12
XTAP_TAPCELL_ROW_118_2073 VGND VPWR sky130_fd_sc_hd__tapvpwrvgnd_1
XFILLER_0_24_139 VGND VGND VPWR VPWR sky130_fd_sc_hd__fill_1
XFILLER_0_33_651 VGND VGND VPWR VPWR sky130_fd_sc_hd__decap_3
XFILLER_0_33_673 VGND VGND VPWR VPWR sky130_fd_sc_hd__fill_2
XFILLER_0_0_729 VPWR VGND VPWR VGND sky130_ef_sc_hd__decap_12
XFILLER_0_20_301 VGND VGND VPWR VPWR sky130_fd_sc_hd__decap_6
XTAP_TAPCELL_ROW_131_2262 VGND VPWR sky130_fd_sc_hd__tapvpwrvgnd_1
XFILLER_0_20_345 VPWR VGND VPWR VGND sky130_ef_sc_hd__decap_12
XFILLER_0_20_389 VPWR VGND VPWR VGND sky130_ef_sc_hd__decap_12
XFILLER_0_46_15 VPWR VGND VPWR VGND sky130_ef_sc_hd__decap_12
XFILLER_0_137_39 VPWR VGND VPWR VGND sky130_ef_sc_hd__decap_12
XFILLER_0_99_161 VGND VGND VPWR VPWR sky130_fd_sc_hd__decap_6
XFILLER_0_88_813 VPWR VGND VPWR VGND sky130_ef_sc_hd__decap_12
XFILLER_0_1_39 VPWR VGND VPWR VGND sky130_ef_sc_hd__decap_12
XTAP_TAPCELL_ROW_47_1002 VGND VPWR sky130_fd_sc_hd__tapvpwrvgnd_1
XFILLER_0_68_581 VGND VGND VPWR VPWR sky130_fd_sc_hd__fill_1
XTAP_TAPCELL_ROW_16_543 VGND VPWR sky130_fd_sc_hd__tapvpwrvgnd_1
XFILLER_0_28_401 VPWR VGND VPWR VGND sky130_ef_sc_hd__decap_12
XFILLER_0_127_3 VPWR VGND VPWR VGND sky130_ef_sc_hd__decap_12
XTAP_TAPCELL_ROW_60_1202 VGND VPWR sky130_fd_sc_hd__tapvpwrvgnd_1
X_4760_ _2363_ _2364_ VGND VGND VPWR VPWR _2365_ sky130_fd_sc_hd__or2b_1
XFILLER_0_7_317 VPWR VGND VPWR VGND sky130_ef_sc_hd__decap_12
XFILLER_0_28_445 VPWR VGND VPWR VGND sky130_ef_sc_hd__decap_12
XPHY_EDGE_ROW_112_Right_112 VGND VGND VPWR VPWR sky130_fd_sc_hd__decap_3
X_3711_ _1208_ _1637_ _1642_ _0683_ VGND VGND VPWR VPWR _1643_ sky130_fd_sc_hd__o31a_1
X_4691_ cpu_inst.decoder_inst.current_pc\[11\] _2313_ VGND VGND VPWR VPWR _2315_ sky130_fd_sc_hd__and2_1
XFILLER_0_56_787 VGND VGND VPWR VPWR sky130_fd_sc_hd__decap_3
XFILLER_0_28_489 VGND VGND VPWR VPWR sky130_fd_sc_hd__fill_2
XFILLER_0_114_837 VGND VGND VPWR VPWR sky130_fd_sc_hd__decap_4
XFILLER_0_102_53 VPWR VGND VPWR VGND sky130_ef_sc_hd__decap_12
X_3642_ _1575_ VGND VGND VPWR VPWR _0021_ sky130_fd_sc_hd__clkbuf_1
XFILLER_0_71_757 VGND VGND VPWR VPWR sky130_fd_sc_hd__decap_3
XFILLER_0_70_245 VGND VGND VPWR VPWR sky130_fd_sc_hd__decap_6
XFILLER_0_11_51 VGND VGND VPWR VPWR sky130_fd_sc_hd__decap_4
XFILLER_0_102_97 VPWR VGND VPWR VGND sky130_ef_sc_hd__decap_12
XFILLER_0_12_813 VPWR VGND VPWR VGND sky130_ef_sc_hd__decap_12
XFILLER_0_30_109 VPWR VGND VPWR VGND sky130_ef_sc_hd__decap_12
X_3573_ _1466_ _1480_ VGND VGND VPWR VPWR _1508_ sky130_fd_sc_hd__nor2_1
XFILLER_0_70_289 VGND VGND VPWR VPWR sky130_fd_sc_hd__decap_8
XFILLER_0_23_161 VGND VGND VPWR VPWR sky130_fd_sc_hd__decap_6
X_5312_ clknet_leaf_32_clk _0232_ VGND VGND VPWR VPWR cpu_inst.regfile_inst.registers\[7\]\[8\]
+ sky130_fd_sc_hd__dfxtp_1
XPHY_EDGE_ROW_49_Right_49 VGND VGND VPWR VPWR sky130_fd_sc_hd__decap_3
XFILLER_0_87_55 VGND VGND VPWR VPWR sky130_fd_sc_hd__fill_1
XTAP_TAPCELL_ROW_58_1175 VGND VPWR sky130_fd_sc_hd__tapvpwrvgnd_1
XTAP_TAPCELL_ROW_58_1164 VGND VPWR sky130_fd_sc_hd__tapvpwrvgnd_1
XFILLER_0_121_391 VGND VGND VPWR VPWR sky130_fd_sc_hd__fill_1
X_5243_ clknet_leaf_38_clk _0163_ VGND VGND VPWR VPWR cpu_inst.regfile_inst.registers\[5\]\[3\]
+ sky130_fd_sc_hd__dfxtp_1
X_5174_ clknet_leaf_1_clk _0094_ VGND VGND VPWR VPWR cpu_inst.regfile_inst.registers\[25\]\[30\]
+ sky130_fd_sc_hd__dfxtp_1
XTAP_TAPCELL_ROW_71_1364 VGND VPWR sky130_fd_sc_hd__tapvpwrvgnd_1
X_4125_ _1156_ cpu_inst.regfile_inst.registers\[25\]\[14\] _1998_ VGND VGND VPWR VPWR
+ _2002_ sky130_fd_sc_hd__mux2_1
XFILLER_0_79_835 VGND VGND VPWR VPWR sky130_fd_sc_hd__decap_4
XFILLER_0_78_301 VGND VGND VPWR VPWR sky130_fd_sc_hd__decap_6
X_4056_ cpu_inst.regfile_inst.registers\[2\]\[15\] VGND VGND VPWR VPWR _1964_ sky130_fd_sc_hd__clkbuf_1
XPHY_EDGE_ROW_58_Right_58 VGND VGND VPWR VPWR sky130_fd_sc_hd__decap_3
XFILLER_0_78_345 VPWR VGND VPWR VGND sky130_ef_sc_hd__decap_12
X_3007_ _0863_ _0969_ _0971_ _0875_ VGND VGND VPWR VPWR _0972_ sky130_fd_sc_hd__o22a_1
XTAP_TAPCELL_ROW_35_830 VGND VPWR sky130_fd_sc_hd__tapvpwrvgnd_1
XFILLER_0_38_209 VPWR VGND VPWR VGND sky130_ef_sc_hd__decap_12
XFILLER_0_109_609 VGND VGND VPWR VPWR sky130_fd_sc_hd__decap_6
XFILLER_0_93_337 VPWR VGND VPWR VGND sky130_ef_sc_hd__decap_12
XFILLER_0_59_570 VPWR VGND VPWR VGND sky130_ef_sc_hd__decap_12
X_4958_ _2466_ VGND VGND VPWR VPWR _0446_ sky130_fd_sc_hd__clkbuf_1
XFILLER_0_117_653 VPWR VGND VPWR VGND sky130_ef_sc_hd__decap_12
X_3909_ cpu_inst.regfile_inst.registers\[5\]\[29\] cpu_inst.regfile_inst.registers\[4\]\[29\]
+ _1797_ VGND VGND VPWR VPWR _1835_ sky130_fd_sc_hd__mux2_1
XFILLER_0_74_573 VGND VGND VPWR VPWR sky130_fd_sc_hd__fill_1
X_4889_ _2429_ VGND VGND VPWR VPWR _0414_ sky130_fd_sc_hd__clkbuf_1
XFILLER_0_46_253 VPWR VGND VPWR VGND sky130_ef_sc_hd__decap_12
XFILLER_0_132_601 VPWR VGND VPWR VGND sky130_ef_sc_hd__decap_12
XFILLER_0_116_141 VPWR VGND VPWR VGND sky130_ef_sc_hd__decap_12
XFILLER_0_61_223 VGND VGND VPWR VPWR sky130_fd_sc_hd__fill_1
XFILLER_0_132_645 VPWR VGND VPWR VGND sky130_ef_sc_hd__decap_12
XFILLER_0_131_111 VGND VGND VPWR VPWR sky130_fd_sc_hd__fill_1
XFILLER_0_117_697 VPWR VGND VPWR VGND sky130_ef_sc_hd__decap_12
XPHY_EDGE_ROW_67_Right_67 VGND VGND VPWR VPWR sky130_fd_sc_hd__decap_3
XFILLER_0_15_673 VPWR VGND VPWR VGND sky130_ef_sc_hd__decap_12
XFILLER_0_30_610 VGND VGND VPWR VPWR sky130_fd_sc_hd__fill_2
XFILLER_0_100_531 VGND VGND VPWR VPWR sky130_fd_sc_hd__fill_1
XFILLER_0_100_586 VGND VGND VPWR VPWR sky130_fd_sc_hd__fill_2
XTAP_TAPCELL_ROW_89_1636 VGND VPWR sky130_fd_sc_hd__tapvpwrvgnd_1
XPHY_EDGE_ROW_76_Right_76 VGND VGND VPWR VPWR sky130_fd_sc_hd__decap_3
XFILLER_0_88_109 VPWR VGND VPWR VGND sky130_ef_sc_hd__decap_12
XFILLER_0_69_301 VGND VGND VPWR VPWR sky130_fd_sc_hd__fill_2
XFILLER_0_16_29 VPWR VGND VPWR VGND sky130_ef_sc_hd__decap_12
XFILLER_0_96_153 VPWR VGND VPWR VGND sky130_ef_sc_hd__decap_12
XFILLER_0_96_197 VPWR VGND VPWR VGND sky130_ef_sc_hd__decap_12
XFILLER_0_127_417 VPWR VGND VPWR VGND sky130_ef_sc_hd__decap_12
XTAP_TAPCELL_ROW_100_1803 VGND VPWR sky130_fd_sc_hd__tapvpwrvgnd_1
XTAP_TAPCELL_ROW_13_502 VGND VPWR sky130_fd_sc_hd__tapvpwrvgnd_1
XFILLER_0_108_642 VGND VGND VPWR VPWR sky130_fd_sc_hd__fill_2
XFILLER_0_135_461 VPWR VGND VPWR VGND sky130_ef_sc_hd__decap_12
XTAP_TAPCELL_ROW_133_2302 VGND VPWR sky130_fd_sc_hd__tapvpwrvgnd_1
XPHY_EDGE_ROW_85_Right_85 VGND VGND VPWR VPWR sky130_fd_sc_hd__decap_3
XFILLER_0_4_309 VPWR VGND VPWR VGND sky130_ef_sc_hd__decap_12
XFILLER_0_12_109 VPWR VGND VPWR VGND sky130_ef_sc_hd__decap_12
XFILLER_0_52_245 VGND VGND VPWR VPWR sky130_fd_sc_hd__decap_6
XFILLER_0_122_133 VGND VGND VPWR VPWR sky130_fd_sc_hd__decap_6
XFILLER_0_80_598 VGND VGND VPWR VPWR sky130_fd_sc_hd__decap_4
XFILLER_0_52_289 VPWR VGND VPWR VGND sky130_ef_sc_hd__decap_12
XFILLER_0_122_177 VPWR VGND VPWR VGND sky130_ef_sc_hd__decap_12
XFILLER_0_21_665 VGND VGND VPWR VPWR sky130_fd_sc_hd__decap_6
XFILLER_0_103_391 VGND VGND VPWR VPWR sky130_fd_sc_hd__fill_1
XFILLER_0_20_153 VPWR VGND VPWR VGND sky130_ef_sc_hd__decap_12
XTAP_TAPCELL_ROW_111_1965 VGND VPWR sky130_fd_sc_hd__tapvpwrvgnd_1
XFILLER_0_20_197 VPWR VGND VPWR VGND sky130_ef_sc_hd__decap_12
XPHY_EDGE_ROW_94_Right_94 VGND VGND VPWR VPWR sky130_fd_sc_hd__decap_3
XFILLER_0_57_69 VPWR VGND VPWR VGND sky130_ef_sc_hd__decap_12
XPHY_EDGE_ROW_29_Left_168 VGND VGND VPWR VPWR sky130_fd_sc_hd__decap_3
XTAP_TAPCELL_ROW_53_1094 VGND VPWR sky130_fd_sc_hd__tapvpwrvgnd_1
XFILLER_0_88_632 VPWR VGND VPWR VGND sky130_ef_sc_hd__decap_12
XFILLER_0_73_57 VPWR VGND VPWR VGND sky130_ef_sc_hd__decap_12
XFILLER_0_76_816 VPWR VGND VPWR VGND sky130_ef_sc_hd__decap_12
XFILLER_0_88_698 VGND VGND VPWR VPWR sky130_fd_sc_hd__fill_2
XFILLER_0_75_337 VPWR VGND VPWR VGND sky130_ef_sc_hd__decap_12
XFILLER_0_29_710 VPWR VGND VPWR VGND sky130_ef_sc_hd__decap_12
X_4812_ cpu_inst.regfile_inst.registers\[0\]\[24\] VGND VGND VPWR VPWR _2391_ sky130_fd_sc_hd__clkbuf_1
XFILLER_0_8_637 VGND VGND VPWR VPWR sky130_fd_sc_hd__decap_6
XPHY_EDGE_ROW_1_Left_140 VGND VGND VPWR VPWR sky130_fd_sc_hd__decap_3
XFILLER_0_29_765 VPWR VGND VPWR VGND sky130_ef_sc_hd__decap_12
XPHY_EDGE_ROW_38_Left_177 VGND VGND VPWR VPWR sky130_fd_sc_hd__decap_3
XFILLER_0_90_307 VGND VGND VPWR VPWR sky130_fd_sc_hd__fill_1
X_4743_ _2351_ _2352_ VGND VGND VPWR VPWR _2353_ sky130_fd_sc_hd__nor2_1
XFILLER_0_7_125 VPWR VGND VPWR VGND sky130_ef_sc_hd__decap_12
XFILLER_0_28_253 VPWR VGND VPWR VGND sky130_ef_sc_hd__decap_12
XFILLER_0_114_601 VPWR VGND VPWR VGND sky130_ef_sc_hd__decap_12
XFILLER_0_71_543 VGND VGND VPWR VPWR sky130_fd_sc_hd__decap_3
XFILLER_0_7_169 VPWR VGND VPWR VGND sky130_ef_sc_hd__decap_12
XFILLER_0_22_83 VGND VGND VPWR VPWR sky130_fd_sc_hd__fill_1
XFILLER_0_43_223 VGND VGND VPWR VPWR sky130_fd_sc_hd__fill_1
XFILLER_0_44_757 VGND VGND VPWR VPWR sky130_fd_sc_hd__decap_4
XFILLER_0_114_645 VPWR VGND VPWR VGND sky130_ef_sc_hd__decap_12
XFILLER_0_113_111 VGND VGND VPWR VPWR sky130_fd_sc_hd__fill_1
X_4674_ cpu_inst.decoder_inst.current_pc\[6\] _1288_ _2285_ _2302_ VGND VGND VPWR
+ VPWR _0326_ sky130_fd_sc_hd__a22o_1
X_3625_ cpu_inst.regfile_inst.registers\[1\]\[21\] _0848_ _0849_ cpu_inst.regfile_inst.registers\[5\]\[21\]
+ VGND VGND VPWR VPWR _1559_ sky130_fd_sc_hd__o22a_1
XFILLER_0_98_65 VPWR VGND VPWR VGND sky130_ef_sc_hd__decap_12
XFILLER_0_31_429 VPWR VGND VPWR VGND sky130_ef_sc_hd__decap_12
XFILLER_0_101_317 VPWR VGND VPWR VGND sky130_ef_sc_hd__decap_12
X_3556_ _1487_ _1256_ _1491_ VGND VGND VPWR VPWR _1492_ sky130_fd_sc_hd__o21ai_1
XFILLER_0_12_643 VGND VGND VPWR VPWR sky130_fd_sc_hd__fill_1
X_3487_ _1422_ _1423_ _0871_ VGND VGND VPWR VPWR _1424_ sky130_fd_sc_hd__mux2_1
X_5226_ clknet_leaf_23_clk _0146_ VGND VGND VPWR VPWR cpu_inst.regfile_inst.registers\[24\]\[18\]
+ sky130_fd_sc_hd__dfxtp_1
XPHY_EDGE_ROW_47_Left_186 VGND VGND VPWR VPWR sky130_fd_sc_hd__decap_3
XFILLER_0_51_3 VPWR VGND VPWR VGND sky130_ef_sc_hd__decap_12
X_5157_ clknet_leaf_24_clk _0077_ VGND VGND VPWR VPWR cpu_inst.regfile_inst.registers\[25\]\[13\]
+ sky130_fd_sc_hd__dfxtp_1
XFILLER_0_98_429 VGND VGND VPWR VPWR sky130_fd_sc_hd__decap_6
X_4108_ _1168_ cpu_inst.regfile_inst.registers\[25\]\[6\] _1982_ VGND VGND VPWR VPWR
+ _1993_ sky130_fd_sc_hd__mux2_1
X_5088_ clknet_leaf_32_clk _0008_ VGND VGND VPWR VPWR cpu_inst.regfile_inst.registers\[6\]\[8\]
+ sky130_fd_sc_hd__dfxtp_1
X_4039_ _1955_ VGND VGND VPWR VPWR _0038_ sky130_fd_sc_hd__clkbuf_1
XFILLER_0_78_153 VPWR VGND VPWR VGND sky130_ef_sc_hd__decap_12
XTAP_TAPCELL_ROW_84_1566 VGND VPWR sky130_fd_sc_hd__tapvpwrvgnd_1
XTAP_TAPCELL_ROW_84_1555 VGND VPWR sky130_fd_sc_hd__tapvpwrvgnd_1
XFILLER_0_78_197 VPWR VGND VPWR VGND sky130_ef_sc_hd__decap_12
XPHY_EDGE_ROW_56_Left_195 VGND VGND VPWR VPWR sky130_fd_sc_hd__decap_3
XFILLER_0_109_417 VPWR VGND VPWR VGND sky130_ef_sc_hd__decap_12
XFILLER_0_66_359 VGND VGND VPWR VPWR sky130_fd_sc_hd__fill_2
XFILLER_0_93_167 VGND VGND VPWR VPWR sky130_fd_sc_hd__fill_1
XFILLER_0_81_329 VGND VGND VPWR VPWR sky130_fd_sc_hd__decap_6
XFILLER_0_117_461 VPWR VGND VPWR VGND sky130_ef_sc_hd__decap_12
XFILLER_0_90_841 VGND VGND VPWR VPWR sky130_fd_sc_hd__fill_1
XFILLER_0_74_381 VGND VGND VPWR VPWR sky130_fd_sc_hd__fill_1
XFILLER_0_35_757 VPWR VGND VPWR VGND sky130_ef_sc_hd__decap_12
XTAP_TAPCELL_ROW_115_2021 VGND VPWR sky130_fd_sc_hd__tapvpwrvgnd_1
XFILLER_0_62_565 VGND VGND VPWR VPWR sky130_fd_sc_hd__decap_8
XFILLER_0_34_245 VGND VGND VPWR VPWR sky130_fd_sc_hd__decap_6
XTAP_TAPCELL_ROW_115_2032 VGND VPWR sky130_fd_sc_hd__tapvpwrvgnd_1
XFILLER_0_104_133 VGND VGND VPWR VPWR sky130_fd_sc_hd__decap_6
XFILLER_0_34_289 VPWR VGND VPWR VGND sky130_ef_sc_hd__decap_12
XFILLER_0_132_475 VGND VGND VPWR VPWR sky130_fd_sc_hd__fill_1
XFILLER_0_120_637 VGND VGND VPWR VPWR sky130_fd_sc_hd__decap_6
XFILLER_0_104_177 VPWR VGND VPWR VGND sky130_ef_sc_hd__decap_12
XFILLER_0_118_19 VGND VGND VPWR VPWR sky130_fd_sc_hd__decap_8
XFILLER_0_27_39 VPWR VGND VPWR VGND sky130_ef_sc_hd__decap_12
XTAP_TAPCELL_ROW_126_2183 VGND VPWR sky130_fd_sc_hd__tapvpwrvgnd_1
XFILLER_0_134_29 VPWR VGND VPWR VGND sky130_ef_sc_hd__decap_12
XTAP_TAPCELL_ROW_126_2194 VGND VPWR sky130_fd_sc_hd__tapvpwrvgnd_1
XFILLER_0_43_27 VPWR VGND VPWR VGND sky130_ef_sc_hd__decap_12
XFILLER_0_128_737 VPWR VGND VPWR VGND sky130_ef_sc_hd__decap_12
XFILLER_0_127_225 VPWR VGND VPWR VGND sky130_ef_sc_hd__decap_12
XFILLER_0_84_189 VGND VGND VPWR VPWR sky130_fd_sc_hd__decap_6
XFILLER_0_72_307 VGND VGND VPWR VPWR sky130_fd_sc_hd__fill_1
XTAP_TAPCELL_ROW_26_693 VGND VPWR sky130_fd_sc_hd__tapvpwrvgnd_1
XFILLER_0_26_713 VPWR VGND VPWR VGND sky130_ef_sc_hd__decap_12
XFILLER_0_38_562 VGND VGND VPWR VPWR sky130_fd_sc_hd__fill_1
XFILLER_0_81_841 VGND VGND VPWR VPWR sky130_fd_sc_hd__fill_1
XFILLER_0_5_629 VPWR VGND VPWR VGND sky130_ef_sc_hd__decap_12
XFILLER_0_25_223 VGND VGND VPWR VPWR sky130_fd_sc_hd__fill_1
XFILLER_0_26_757 VPWR VGND VPWR VGND sky130_ef_sc_hd__decap_12
XFILLER_0_136_781 VPWR VGND VPWR VGND sky130_ef_sc_hd__decap_12
XFILLER_0_4_139 VGND VGND VPWR VPWR sky130_fd_sc_hd__fill_1
XFILLER_0_13_429 VPWR VGND VPWR VGND sky130_ef_sc_hd__decap_12
XFILLER_0_7_27 VPWR VGND VPWR VGND sky130_ef_sc_hd__decap_12
XFILLER_0_41_738 VGND VGND VPWR VPWR sky130_fd_sc_hd__decap_3
XFILLER_0_123_497 VGND VGND VPWR VPWR sky130_fd_sc_hd__decap_6
XFILLER_0_111_615 VGND VGND VPWR VPWR sky130_fd_sc_hd__fill_1
X_3410_ cpu_inst.regfile_inst.registers\[5\]\[16\] cpu_inst.regfile_inst.registers\[4\]\[16\]
+ _1348_ VGND VGND VPWR VPWR _1349_ sky130_fd_sc_hd__mux2_1
X_4390_ _2140_ VGND VGND VPWR VPWR _0204_ sky130_fd_sc_hd__clkbuf_1
XTAP_TAPCELL_ROW_55_1123 VGND VPWR sky130_fd_sc_hd__tapvpwrvgnd_1
X_3341_ _0574_ _0579_ _1295_ VGND VGND VPWR VPWR _1296_ sky130_fd_sc_hd__or3_1
XFILLER_0_21_473 VPWR VGND VPWR VGND sky130_ef_sc_hd__decap_12
XFILLER_0_0_389 VGND VGND VPWR VPWR sky130_fd_sc_hd__decap_3
X_3272_ _0639_ _1236_ VGND VGND VPWR VPWR _1237_ sky130_fd_sc_hd__nor2_1
X_5011_ cpu_inst.regfile_inst.registers\[15\]\[23\] _2491_ VGND VGND VPWR VPWR _2495_
+ sky130_fd_sc_hd__and2_1
XFILLER_0_108_41 VPWR VGND VPWR VGND sky130_ef_sc_hd__decap_12
XFILLER_0_108_85 VPWR VGND VPWR VGND sky130_ef_sc_hd__decap_12
XFILLER_0_88_440 VGND VGND VPWR VPWR sky130_fd_sc_hd__decap_8
XFILLER_0_88_473 VGND VGND VPWR VPWR sky130_fd_sc_hd__decap_3
XFILLER_0_76_657 VGND VGND VPWR VPWR sky130_fd_sc_hd__fill_2
XTAP_TAPCELL_ROW_66_1296 VGND VPWR sky130_fd_sc_hd__tapvpwrvgnd_1
XTAP_TAPCELL_ROW_66_1285 VGND VPWR sky130_fd_sc_hd__tapvpwrvgnd_1
XFILLER_0_64_819 VPWR VGND VPWR VGND sky130_ef_sc_hd__decap_12
XFILLER_0_8_401 VPWR VGND VPWR VGND sky130_ef_sc_hd__decap_12
XTAP_TAPCELL_ROW_45_980 VGND VPWR sky130_fd_sc_hd__tapvpwrvgnd_1
XFILLER_0_75_167 VGND VGND VPWR VPWR sky130_fd_sc_hd__fill_1
XFILLER_0_8_445 VPWR VGND VPWR VGND sky130_ef_sc_hd__decap_12
XFILLER_0_33_93 VPWR VGND VPWR VGND sky130_ef_sc_hd__decap_12
XFILLER_0_99_3 VPWR VGND VPWR VGND sky130_ef_sc_hd__decap_12
X_2987_ _0795_ _0951_ VGND VGND VPWR VPWR _0952_ sky130_fd_sc_hd__xnor2_1
XFILLER_0_8_489 VPWR VGND VPWR VGND sky130_ef_sc_hd__decap_12
XFILLER_0_133_217 VGND VGND VPWR VPWR sky130_fd_sc_hd__decap_6
X_4726_ _2293_ _2340_ cpu_inst.decoder_inst.current_pc\[20\] _2289_ VGND VGND VPWR
+ VPWR _0340_ sky130_fd_sc_hd__o2bb2a_1
XFILLER_0_16_245 VGND VGND VPWR VPWR sky130_fd_sc_hd__decap_6
X_4657_ _2288_ VGND VGND VPWR VPWR _2289_ sky130_fd_sc_hd__clkbuf_2
XFILLER_0_16_289 VPWR VGND VPWR VGND sky130_ef_sc_hd__decap_12
XFILLER_0_32_738 VPWR VGND VPWR VGND sky130_ef_sc_hd__decap_12
XFILLER_0_114_475 VGND VGND VPWR VPWR sky130_fd_sc_hd__fill_1
XFILLER_0_102_637 VGND VGND VPWR VPWR sky130_fd_sc_hd__fill_1
XFILLER_0_102_604 VGND VGND VPWR VPWR sky130_fd_sc_hd__decap_8
X_3608_ _1541_ cpu_inst.regfile_inst.registers\[10\]\[21\] _1351_ VGND VGND VPWR VPWR
+ _1542_ sky130_fd_sc_hd__mux2_1
XFILLER_0_3_161 VGND VGND VPWR VPWR sky130_fd_sc_hd__decap_6
XFILLER_0_31_237 VPWR VGND VPWR VGND sky130_ef_sc_hd__decap_12
XFILLER_0_101_125 VPWR VGND VPWR VGND sky130_ef_sc_hd__decap_12
X_4588_ _2242_ VGND VGND VPWR VPWR _0300_ sky130_fd_sc_hd__clkbuf_1
XFILLER_0_101_169 VPWR VGND VPWR VGND sky130_ef_sc_hd__decap_12
X_3539_ cpu_inst.regfile_inst.registers\[11\]\[19\] cpu_inst.regfile_inst.registers\[10\]\[19\]
+ _0731_ VGND VGND VPWR VPWR _1475_ sky130_fd_sc_hd__mux2_1
XFILLER_0_110_681 VPWR VGND VPWR VGND sky130_ef_sc_hd__decap_12
X_5209_ clknet_leaf_37_clk _0129_ VGND VGND VPWR VPWR cpu_inst.regfile_inst.registers\[24\]\[1\]
+ sky130_fd_sc_hd__dfxtp_1
XTAP_TAPCELL_ROW_4_366 VGND VPWR sky130_fd_sc_hd__tapvpwrvgnd_1
XTAP_TAPCELL_ROW_4_355 VGND VPWR sky130_fd_sc_hd__tapvpwrvgnd_1
XFILLER_0_79_440 VGND VGND VPWR VPWR sky130_fd_sc_hd__decap_8
XPHY_EDGE_ROW_64_Left_203 VGND VGND VPWR VPWR sky130_fd_sc_hd__decap_3
XFILLER_0_94_410 VGND VGND VPWR VPWR sky130_fd_sc_hd__fill_1
XFILLER_0_39_337 VPWR VGND VPWR VGND sky130_ef_sc_hd__decap_12
XTAP_TAPCELL_ROW_43_939 VGND VPWR sky130_fd_sc_hd__tapvpwrvgnd_1
XFILLER_0_109_225 VPWR VGND VPWR VGND sky130_ef_sc_hd__decap_12
XFILLER_0_82_616 VGND VGND VPWR VPWR sky130_fd_sc_hd__decap_6
XFILLER_0_54_307 VGND VGND VPWR VPWR sky130_fd_sc_hd__fill_1
XTAP_TAPCELL_ROW_23_641 VGND VPWR sky130_fd_sc_hd__tapvpwrvgnd_1
XFILLER_0_125_729 VPWR VGND VPWR VGND sky130_ef_sc_hd__decap_12
XFILLER_0_81_137 VPWR VGND VPWR VGND sky130_ef_sc_hd__decap_12
XFILLER_0_66_189 VGND VGND VPWR VPWR sky130_fd_sc_hd__decap_6
XFILLER_0_63_841 VGND VGND VPWR VPWR sky130_fd_sc_hd__fill_1
XTAP_TAPCELL_ROW_23_652 VGND VPWR sky130_fd_sc_hd__tapvpwrvgnd_1
XFILLER_0_118_781 VPWR VGND VPWR VGND sky130_ef_sc_hd__decap_12
XTAP_TAPCELL_ROW_97_1757 VGND VPWR sky130_fd_sc_hd__tapvpwrvgnd_1
XPHY_EDGE_ROW_73_Left_212 VGND VGND VPWR VPWR sky130_fd_sc_hd__decap_3
XFILLER_0_23_727 VGND VGND VPWR VPWR sky130_fd_sc_hd__fill_1
XFILLER_0_50_513 VGND VGND VPWR VPWR sky130_fd_sc_hd__decap_3
XFILLER_0_120_401 VPWR VGND VPWR VGND sky130_ef_sc_hd__decap_12
XFILLER_0_120_445 VPWR VGND VPWR VGND sky130_ef_sc_hd__decap_12
XFILLER_0_120_489 VPWR VGND VPWR VGND sky130_ef_sc_hd__decap_12
XFILLER_0_38_27 VGND VGND VPWR VPWR sky130_fd_sc_hd__fill_1
XTAP_TAPCELL_ROW_128_2223 VGND VPWR sky130_fd_sc_hd__tapvpwrvgnd_1
XTAP_TAPCELL_ROW_50_1053 VGND VPWR sky130_fd_sc_hd__tapvpwrvgnd_1
XFILLER_0_89_237 VPWR VGND VPWR VGND sky130_ef_sc_hd__decap_12
XPHY_EDGE_ROW_82_Left_221 VGND VGND VPWR VPWR sky130_fd_sc_hd__decap_3
XFILLER_0_54_15 VPWR VGND VPWR VGND sky130_ef_sc_hd__decap_12
XFILLER_0_58_613 VPWR VGND VPWR VGND sky130_ef_sc_hd__decap_12
XFILLER_0_128_501 VPWR VGND VPWR VGND sky130_ef_sc_hd__decap_12
XTAP_TAPCELL_ROW_106_1897 VGND VPWR sky130_fd_sc_hd__tapvpwrvgnd_1
XTAP_TAPCELL_ROW_106_1886 VGND VPWR sky130_fd_sc_hd__tapvpwrvgnd_1
XFILLER_0_97_281 VPWR VGND VPWR VGND sky130_ef_sc_hd__decap_12
X_2910_ _0657_ VGND VGND VPWR VPWR _0875_ sky130_fd_sc_hd__clkbuf_4
XFILLER_0_128_545 VPWR VGND VPWR VGND sky130_ef_sc_hd__decap_12
X_3890_ _1801_ _1816_ VGND VGND VPWR VPWR _1817_ sky130_fd_sc_hd__nor2_1
XFILLER_0_57_167 VGND VGND VPWR VPWR sky130_fd_sc_hd__fill_1
XFILLER_0_128_589 VPWR VGND VPWR VGND sky130_ef_sc_hd__decap_12
XFILLER_0_26_510 VGND VGND VPWR VPWR sky130_fd_sc_hd__decap_6
X_2841_ cpu_inst.regfile_inst.registers\[11\]\[6\] cpu_inst.regfile_inst.registers\[10\]\[6\]
+ _0595_ VGND VGND VPWR VPWR _0806_ sky130_fd_sc_hd__mux2_4
XFILLER_0_45_329 VGND VGND VPWR VPWR sky130_fd_sc_hd__decap_6
XFILLER_0_115_217 VGND VGND VPWR VPWR sky130_fd_sc_hd__decap_6
XPHY_EDGE_ROW_91_Left_230 VGND VGND VPWR VPWR sky130_fd_sc_hd__decap_3
X_5560_ clknet_leaf_31_clk _0480_ VGND VGND VPWR VPWR cpu_inst.display_inst.counter\[0\]
+ sky130_fd_sc_hd__dfxtp_1
X_2772_ _0735_ _0736_ VGND VGND VPWR VPWR _0737_ sky130_fd_sc_hd__or2_1
X_5491_ clknet_leaf_7_clk _0411_ VGND VGND VPWR VPWR cpu_inst.regfile_inst.registers\[9\]\[27\]
+ sky130_fd_sc_hd__dfxtp_1
XFILLER_0_81_682 VGND VGND VPWR VPWR sky130_fd_sc_hd__decap_4
XFILLER_0_53_384 VGND VGND VPWR VPWR sky130_fd_sc_hd__fill_1
XFILLER_0_14_749 VGND VGND VPWR VPWR sky130_fd_sc_hd__decap_6
XFILLER_0_26_587 VGND VGND VPWR VPWR sky130_fd_sc_hd__fill_1
X_4511_ _2203_ VGND VGND VPWR VPWR _0262_ sky130_fd_sc_hd__clkbuf_1
XFILLER_0_130_209 VPWR VGND VPWR VGND sky130_ef_sc_hd__decap_12
XFILLER_0_123_261 VPWR VGND VPWR VGND sky130_ef_sc_hd__decap_12
XFILLER_0_110_53 VPWR VGND VPWR VGND sky130_ef_sc_hd__decap_12
X_4442_ _1325_ cpu_inst.regfile_inst.registers\[7\]\[5\] _2167_ VGND VGND VPWR VPWR
+ _2168_ sky130_fd_sc_hd__mux2_1
XFILLER_0_13_237 VPWR VGND VPWR VGND sky130_ef_sc_hd__decap_12
XFILLER_0_110_97 VPWR VGND VPWR VGND sky130_ef_sc_hd__decap_12
XFILLER_0_0_153 VPWR VGND VPWR VGND sky130_ef_sc_hd__decap_12
XFILLER_0_1_665 VGND VGND VPWR VPWR sky130_fd_sc_hd__decap_6
XFILLER_0_21_281 VPWR VGND VPWR VGND sky130_ef_sc_hd__decap_12
XFILLER_0_22_793 VPWR VGND VPWR VGND sky130_ef_sc_hd__decap_12
X_4373_ cpu_inst.regfile_inst.registers\[1\]\[4\] VGND VGND VPWR VPWR _2132_ sky130_fd_sc_hd__clkbuf_1
XFILLER_0_95_55 VGND VGND VPWR VPWR sky130_fd_sc_hd__fill_1
X_3324_ cpu_inst.display_inst.digit_select\[0\] _0690_ VGND VGND VPWR VPWR net4 sky130_fd_sc_hd__nand2_1
XFILLER_0_0_197 VPWR VGND VPWR VGND sky130_ef_sc_hd__decap_12
XFILLER_0_119_51 VGND VGND VPWR VPWR sky130_fd_sc_hd__decap_4
X_3255_ _0948_ _0950_ _1218_ VGND VGND VPWR VPWR _1220_ sky130_fd_sc_hd__a21o_1
X_3186_ _1149_ _1150_ _1062_ VGND VGND VPWR VPWR _1151_ sky130_fd_sc_hd__mux2_1
XTAP_TAPCELL_ROW_68_1314 VGND VPWR sky130_fd_sc_hd__tapvpwrvgnd_1
XTAP_TAPCELL_ROW_1_314 VGND VPWR sky130_fd_sc_hd__tapvpwrvgnd_1
XTAP_TAPCELL_ROW_68_1325 VGND VPWR sky130_fd_sc_hd__tapvpwrvgnd_1
XFILLER_0_14_3 VPWR VGND VPWR VGND sky130_ef_sc_hd__decap_12
XFILLER_0_138_309 VPWR VGND VPWR VGND sky130_ef_sc_hd__decap_12
XTAP_TAPCELL_ROW_81_1514 VGND VPWR sky130_fd_sc_hd__tapvpwrvgnd_1
XFILLER_0_49_635 VGND VGND VPWR VPWR sky130_fd_sc_hd__decap_3
XFILLER_0_9_721 VGND VGND VPWR VPWR sky130_fd_sc_hd__decap_6
XFILLER_0_36_307 VGND VGND VPWR VPWR sky130_fd_sc_hd__fill_1
XFILLER_0_107_729 VPWR VGND VPWR VGND sky130_ef_sc_hd__decap_12
XFILLER_0_91_424 VGND VGND VPWR VPWR sky130_fd_sc_hd__fill_1
XFILLER_0_63_137 VPWR VGND VPWR VGND sky130_ef_sc_hd__decap_12
XFILLER_0_9_765 VPWR VGND VPWR VGND sky130_ef_sc_hd__decap_12
XFILLER_0_8_253 VPWR VGND VPWR VGND sky130_ef_sc_hd__decap_12
XFILLER_0_45_841 VGND VGND VPWR VPWR sky130_fd_sc_hd__fill_1
XFILLER_0_48_189 VGND VGND VPWR VPWR sky130_fd_sc_hd__decap_6
XTAP_TAPCELL_ROW_20_600 VGND VPWR sky130_fd_sc_hd__tapvpwrvgnd_1
X_4709_ cpu_inst.decoder_inst.current_pc\[15\] cpu_inst.decoder_inst.current_pc\[16\]
+ _2323_ VGND VGND VPWR VPWR _2328_ sky130_fd_sc_hd__and3_1
XFILLER_0_32_513 VGND VGND VPWR VPWR sky130_fd_sc_hd__fill_2
XFILLER_0_32_524 VGND VGND VPWR VPWR sky130_fd_sc_hd__decap_8
XFILLER_0_102_401 VPWR VGND VPWR VGND sky130_ef_sc_hd__decap_12
XFILLER_0_71_181 VPWR VGND VPWR VGND sky130_ef_sc_hd__decap_12
XTAP_TAPCELL_ROW_79_1487 VGND VPWR sky130_fd_sc_hd__tapvpwrvgnd_1
XTAP_TAPCELL_ROW_9_436 VGND VPWR sky130_fd_sc_hd__tapvpwrvgnd_1
XTAP_TAPCELL_ROW_92_1687 VGND VPWR sky130_fd_sc_hd__tapvpwrvgnd_1
XTAP_TAPCELL_ROW_92_1676 VGND VPWR sky130_fd_sc_hd__tapvpwrvgnd_1
XFILLER_0_99_513 VGND VGND VPWR VPWR sky130_fd_sc_hd__decap_4
XTAP_TAPCELL_ROW_28_722 VGND VPWR sky130_fd_sc_hd__tapvpwrvgnd_1
XTAP_TAPCELL_ROW_123_2142 VGND VPWR sky130_fd_sc_hd__tapvpwrvgnd_1
XFILLER_0_24_29 VPWR VGND VPWR VGND sky130_ef_sc_hd__decap_12
XFILLER_0_95_741 VGND VGND VPWR VPWR sky130_fd_sc_hd__fill_1
XFILLER_0_79_281 VPWR VGND VPWR VGND sky130_ef_sc_hd__decap_12
XFILLER_0_95_785 VGND VGND VPWR VPWR sky130_fd_sc_hd__fill_1
XFILLER_0_94_251 VGND VGND VPWR VPWR sky130_fd_sc_hd__fill_1
XFILLER_0_67_465 VGND VGND VPWR VPWR sky130_fd_sc_hd__fill_1
XFILLER_0_39_167 VGND VGND VPWR VPWR sky130_fd_sc_hd__fill_1
XFILLER_0_55_649 VGND VGND VPWR VPWR sky130_fd_sc_hd__decap_4
XFILLER_0_27_329 VGND VGND VPWR VPWR sky130_fd_sc_hd__decap_6
XFILLER_0_70_608 VGND VGND VPWR VPWR sky130_fd_sc_hd__fill_1
XFILLER_0_125_559 VGND VGND VPWR VPWR sky130_fd_sc_hd__fill_1
XFILLER_0_35_373 VPWR VGND VPWR VGND sky130_ef_sc_hd__decap_12
XFILLER_0_112_209 VPWR VGND VPWR VGND sky130_ef_sc_hd__decap_12
XFILLER_0_105_261 VPWR VGND VPWR VGND sky130_ef_sc_hd__decap_12
XFILLER_0_50_321 VPWR VGND VPWR VGND sky130_ef_sc_hd__decap_12
XFILLER_0_121_721 VGND VGND VPWR VPWR sky130_fd_sc_hd__decap_6
XFILLER_0_49_15 VPWR VGND VPWR VGND sky130_ef_sc_hd__decap_12
XFILLER_0_50_365 VPWR VGND VPWR VGND sky130_ef_sc_hd__decap_12
XFILLER_0_121_765 VPWR VGND VPWR VGND sky130_ef_sc_hd__decap_12
XFILLER_0_120_253 VPWR VGND VPWR VGND sky130_ef_sc_hd__decap_12
XTAP_TAPCELL_ROW_108_1915 VGND VPWR sky130_fd_sc_hd__tapvpwrvgnd_1
XFILLER_0_65_69 VPWR VGND VPWR VGND sky130_ef_sc_hd__decap_12
X_3040_ _0816_ _0840_ _0696_ VGND VGND VPWR VPWR _1005_ sky130_fd_sc_hd__a21oi_1
XTAP_TAPCELL_ROW_108_1926 VGND VPWR sky130_fd_sc_hd__tapvpwrvgnd_1
XFILLER_0_86_730 VGND VGND VPWR VPWR sky130_fd_sc_hd__fill_1
XFILLER_0_81_57 VPWR VGND VPWR VGND sky130_ef_sc_hd__decap_12
X_4991_ _2484_ VGND VGND VPWR VPWR _0461_ sky130_fd_sc_hd__clkbuf_1
XFILLER_0_58_421 VGND VGND VPWR VPWR sky130_fd_sc_hd__decap_4
XFILLER_0_129_821 VPWR VGND VPWR VGND sky130_ef_sc_hd__decap_12
X_3942_ _1867_ cpu_inst.regfile_inst.registers\[6\]\[29\] _1609_ VGND VGND VPWR VPWR
+ _1868_ sky130_fd_sc_hd__mux2_1
XTAP_TAPCELL_ROW_63_1244 VGND VPWR sky130_fd_sc_hd__tapvpwrvgnd_1
XFILLER_0_18_307 VGND VGND VPWR VPWR sky130_fd_sc_hd__fill_1
XFILLER_0_46_605 VGND VGND VPWR VPWR sky130_fd_sc_hd__decap_6
X_3873_ _1536_ _1796_ _1799_ _1314_ VGND VGND VPWR VPWR _1800_ sky130_fd_sc_hd__o22a_1
XFILLER_0_85_273 VGND VGND VPWR VPWR sky130_fd_sc_hd__decap_6
XFILLER_0_46_638 VGND VGND VPWR VPWR sky130_fd_sc_hd__decap_3
XFILLER_0_6_713 VPWR VGND VPWR VGND sky130_ef_sc_hd__decap_12
XFILLER_0_27_841 VGND VGND VPWR VPWR sky130_fd_sc_hd__fill_1
XFILLER_0_45_137 VPWR VGND VPWR VGND sky130_ef_sc_hd__decap_12
X_2824_ _0720_ _0787_ _0788_ VGND VGND VPWR VPWR _0789_ sky130_fd_sc_hd__a21o_1
X_5543_ clknet_leaf_22_clk _0463_ VGND VGND VPWR VPWR cpu_inst.regfile_inst.registers\[15\]\[15\]
+ sky130_fd_sc_hd__dfxtp_1
XFILLER_0_6_757 VPWR VGND VPWR VGND sky130_ef_sc_hd__decap_12
XFILLER_0_5_223 VGND VGND VPWR VPWR sky130_fd_sc_hd__fill_1
XFILLER_0_14_513 VPWR VGND VPWR VGND sky130_ef_sc_hd__decap_12
XFILLER_0_42_800 VPWR VGND VPWR VGND sky130_ef_sc_hd__decap_12
XFILLER_0_131_529 VPWR VGND VPWR VGND sky130_ef_sc_hd__decap_12
XFILLER_0_14_557 VPWR VGND VPWR VGND sky130_ef_sc_hd__decap_12
XFILLER_0_30_83 VGND VGND VPWR VPWR sky130_fd_sc_hd__fill_1
X_2755_ _0719_ VGND VGND VPWR VPWR _0720_ sky130_fd_sc_hd__clkbuf_4
XFILLER_0_53_181 VPWR VGND VPWR VGND sky130_ef_sc_hd__decap_12
XFILLER_0_124_581 VGND VGND VPWR VPWR sky130_fd_sc_hd__decap_6
X_2686_ _0529_ _0510_ _0531_ _0573_ VGND VGND VPWR VPWR _0651_ sky130_fd_sc_hd__o31ai_1
X_5474_ clknet_leaf_32_clk _0394_ VGND VGND VPWR VPWR cpu_inst.regfile_inst.registers\[9\]\[10\]
+ sky130_fd_sc_hd__dfxtp_1
X_4425_ cpu_inst.regfile_inst.registers\[1\]\[30\] VGND VGND VPWR VPWR _2158_ sky130_fd_sc_hd__clkbuf_1
X_4356_ _2123_ VGND VGND VPWR VPWR _0187_ sky130_fd_sc_hd__clkbuf_1
XFILLER_0_1_473 VPWR VGND VPWR VGND sky130_ef_sc_hd__decap_12
X_3307_ _1262_ _1269_ _1270_ VGND VGND VPWR VPWR _1271_ sky130_fd_sc_hd__nor3_1
XFILLER_0_39_81 VPWR VGND VPWR VGND sky130_ef_sc_hd__decap_12
X_4287_ cpu_inst.regfile_inst.registers\[24\]\[28\] VGND VGND VPWR VPWR _2086_ sky130_fd_sc_hd__clkbuf_1
X_3238_ _1092_ _1055_ _1202_ VGND VGND VPWR VPWR _1203_ sky130_fd_sc_hd__or3_1
X_3169_ cpu_inst.regfile_inst.registers\[25\]\[14\] _0692_ _0695_ _1125_ _1131_ VGND
+ VGND VPWR VPWR _1134_ sky130_fd_sc_hd__o2111ai_4
XPHY_EDGE_ROW_126_Right_126 VGND VGND VPWR VPWR sky130_fd_sc_hd__decap_3
XFILLER_0_96_527 VGND VGND VPWR VPWR sky130_fd_sc_hd__decap_4
XFILLER_0_76_251 VGND VGND VPWR VPWR sky130_fd_sc_hd__fill_1
XFILLER_0_37_638 VGND VGND VPWR VPWR sky130_fd_sc_hd__fill_2
XFILLER_0_134_301 VGND VGND VPWR VPWR sky130_fd_sc_hd__decap_6
XFILLER_0_92_755 VGND VGND VPWR VPWR sky130_fd_sc_hd__fill_1
XFILLER_0_9_573 VPWR VGND VPWR VGND sky130_ef_sc_hd__decap_12
XFILLER_0_18_841 VGND VGND VPWR VPWR sky130_fd_sc_hd__fill_1
XTAP_TAPCELL_ROW_33_791 VGND VPWR sky130_fd_sc_hd__tapvpwrvgnd_1
XFILLER_0_134_345 VPWR VGND VPWR VGND sky130_ef_sc_hd__decap_12
XFILLER_0_107_559 VGND VGND VPWR VPWR sky130_fd_sc_hd__fill_1
XFILLER_0_17_373 VPWR VGND VPWR VGND sky130_ef_sc_hd__decap_12
XFILLER_0_45_671 VGND VGND VPWR VPWR sky130_fd_sc_hd__fill_1
XFILLER_0_134_389 VPWR VGND VPWR VGND sky130_ef_sc_hd__decap_12
XTAP_TAPCELL_ROW_94_1705 VGND VPWR sky130_fd_sc_hd__tapvpwrvgnd_1
XFILLER_0_32_321 VPWR VGND VPWR VGND sky130_ef_sc_hd__decap_12
XFILLER_0_103_721 VGND VGND VPWR VPWR sky130_fd_sc_hd__decap_6
XTAP_TAPCELL_ROW_94_1716 VGND VPWR sky130_fd_sc_hd__tapvpwrvgnd_1
XFILLER_0_32_365 VPWR VGND VPWR VGND sky130_ef_sc_hd__decap_12
XFILLER_0_103_765 VPWR VGND VPWR VGND sky130_ef_sc_hd__decap_12
XFILLER_0_102_253 VPWR VGND VPWR VGND sky130_ef_sc_hd__decap_12
XFILLER_0_3_3 VPWR VGND VPWR VGND sky130_ef_sc_hd__decap_12
XFILLER_0_35_39 VPWR VGND VPWR VGND sky130_ef_sc_hd__decap_12
XTAP_TAPCELL_ROW_103_1845 VGND VPWR sky130_fd_sc_hd__tapvpwrvgnd_1
XFILLER_0_68_774 VGND VGND VPWR VPWR sky130_fd_sc_hd__fill_1
XFILLER_0_28_605 VGND VGND VPWR VPWR sky130_fd_sc_hd__decap_6
XFILLER_0_51_27 VPWR VGND VPWR VGND sky130_ef_sc_hd__decap_12
XFILLER_0_82_221 VPWR VGND VPWR VGND sky130_ef_sc_hd__decap_12
XFILLER_0_67_273 VGND VGND VPWR VPWR sky130_fd_sc_hd__decap_6
XFILLER_0_138_673 VPWR VGND VPWR VGND sky130_ef_sc_hd__decap_12
XFILLER_0_137_161 VGND VGND VPWR VPWR sky130_fd_sc_hd__decap_6
XFILLER_0_126_813 VPWR VGND VPWR VGND sky130_ef_sc_hd__decap_12
XFILLER_0_27_137 VPWR VGND VPWR VGND sky130_ef_sc_hd__decap_12
XTAP_TAPCELL_ROW_136_2344 VGND VPWR sky130_fd_sc_hd__tapvpwrvgnd_1
XTAP_TAPCELL_ROW_136_2333 VGND VPWR sky130_fd_sc_hd__tapvpwrvgnd_1
XFILLER_0_82_265 VPWR VGND VPWR VGND sky130_ef_sc_hd__decap_12
XFILLER_0_24_811 VGND VGND VPWR VPWR sky130_fd_sc_hd__fill_1
XFILLER_0_113_529 VPWR VGND VPWR VGND sky130_ef_sc_hd__decap_12
Xclkload14 clknet_leaf_6_clk VGND VGND VPWR VPWR clkload14/Y sky130_fd_sc_hd__bufinv_16
XTAP_TAPCELL_ROW_11_463 VGND VPWR sky130_fd_sc_hd__tapvpwrvgnd_1
XFILLER_0_3_727 VGND VGND VPWR VPWR sky130_fd_sc_hd__fill_1
XFILLER_0_35_181 VPWR VGND VPWR VGND sky130_ef_sc_hd__decap_12
Xclkload25 clknet_leaf_30_clk VGND VGND VPWR VPWR clkload25/Y sky130_fd_sc_hd__inv_6
Xclkload36 clknet_leaf_17_clk VGND VGND VPWR VPWR clkload36/Y sky130_fd_sc_hd__inv_8
X_2540_ _0501_ _0502_ _0503_ net25 VGND VGND VPWR VPWR _0505_ sky130_fd_sc_hd__nor4_2
XFILLER_0_11_505 VPWR VGND VPWR VGND sky130_ef_sc_hd__decap_12
XFILLER_0_121_573 VPWR VGND VPWR VGND sky130_ef_sc_hd__decap_12
X_4210_ _2047_ VGND VGND VPWR VPWR _0117_ sky130_fd_sc_hd__clkbuf_1
XFILLER_0_50_195 VGND VGND VPWR VPWR sky130_fd_sc_hd__fill_1
XPHY_EDGE_ROW_10_Left_149 VGND VGND VPWR VPWR sky130_fd_sc_hd__decap_3
X_5190_ clknet_leaf_27_clk _0110_ VGND VGND VPWR VPWR cpu_inst.regfile_inst.registers\[4\]\[14\]
+ sky130_fd_sc_hd__dfxtp_1
X_4141_ _1981_ VGND VGND VPWR VPWR _2010_ sky130_fd_sc_hd__clkbuf_4
X_4072_ cpu_inst.regfile_inst.registers\[2\]\[23\] VGND VGND VPWR VPWR _1972_ sky130_fd_sc_hd__clkbuf_1
X_3023_ _0986_ _0987_ VGND VGND VPWR VPWR _0988_ sky130_fd_sc_hd__nand2_1
XFILLER_0_116_41 VPWR VGND VPWR VGND sky130_ef_sc_hd__decap_12
XFILLER_0_116_85 VPWR VGND VPWR VGND sky130_ef_sc_hd__decap_12
XFILLER_0_93_519 VGND VGND VPWR VPWR sky130_fd_sc_hd__decap_3
XFILLER_0_58_251 VGND VGND VPWR VPWR sky130_fd_sc_hd__fill_1
XTAP_TAPCELL_ROW_19_585 VGND VPWR sky130_fd_sc_hd__tapvpwrvgnd_1
X_4974_ _2475_ VGND VGND VPWR VPWR _0453_ sky130_fd_sc_hd__clkbuf_1
X_3925_ cpu_inst.regfile_inst.registers\[24\]\[29\] _1384_ VGND VGND VPWR VPWR _1851_
+ sky130_fd_sc_hd__or2_1
XFILLER_0_129_673 VPWR VGND VPWR VGND sky130_ef_sc_hd__decap_12
XFILLER_0_116_301 VGND VGND VPWR VPWR sky130_fd_sc_hd__decap_6
XFILLER_0_116_345 VPWR VGND VPWR VGND sky130_ef_sc_hd__decap_12
X_3856_ _1783_ _1751_ VGND VGND VPWR VPWR _1784_ sky130_fd_sc_hd__or2_1
XFILLER_0_61_405 VGND VGND VPWR VPWR sky130_fd_sc_hd__decap_3
XFILLER_0_27_671 VGND VGND VPWR VPWR sky130_fd_sc_hd__fill_1
XFILLER_0_41_93 VPWR VGND VPWR VGND sky130_ef_sc_hd__decap_12
Xclkload8 clknet_leaf_41_clk VGND VGND VPWR VPWR clkload8/Y sky130_fd_sc_hd__clkinvlp_2
XFILLER_0_132_805 VGND VGND VPWR VPWR sky130_fd_sc_hd__decap_6
XFILLER_0_116_389 VPWR VGND VPWR VGND sky130_ef_sc_hd__decap_12
X_3787_ cpu_inst.regfile_inst.registers\[15\]\[25\] _0729_ _1716_ _1552_ VGND VGND
+ VPWR VPWR _1717_ sky130_fd_sc_hd__a211o_1
XFILLER_0_81_3 VPWR VGND VPWR VGND sky130_ef_sc_hd__decap_12
XFILLER_0_54_490 VPWR VGND VPWR VGND sky130_ef_sc_hd__decap_12
XFILLER_0_14_321 VPWR VGND VPWR VGND sky130_ef_sc_hd__decap_12
XFILLER_0_6_587 VGND VGND VPWR VPWR sky130_fd_sc_hd__fill_1
XFILLER_0_15_833 VGND VGND VPWR VPWR sky130_fd_sc_hd__decap_6
XTAP_TAPCELL_ROW_30_750 VGND VPWR sky130_fd_sc_hd__tapvpwrvgnd_1
X_2807_ cpu_inst.regfile_inst.registers\[11\]\[4\] cpu_inst.regfile_inst.registers\[10\]\[4\]
+ _0595_ VGND VGND VPWR VPWR _0772_ sky130_fd_sc_hd__mux2_2
XFILLER_0_131_337 VPWR VGND VPWR VGND sky130_ef_sc_hd__decap_12
X_5526_ clknet_leaf_4_clk _0446_ VGND VGND VPWR VPWR cpu_inst.regfile_inst.registers\[8\]\[30\]
+ sky130_fd_sc_hd__dfxtp_1
XFILLER_0_14_365 VPWR VGND VPWR VGND sky130_ef_sc_hd__decap_12
X_2738_ _0702_ VGND VGND VPWR VPWR _0703_ sky130_fd_sc_hd__buf_2
X_5457_ clknet_leaf_9_clk _0377_ VGND VGND VPWR VPWR cpu_inst.regfile_inst.registers\[0\]\[25\]
+ sky130_fd_sc_hd__dfxtp_1
XTAP_TAPCELL_ROW_76_1446 VGND VPWR sky130_fd_sc_hd__tapvpwrvgnd_1
XTAP_TAPCELL_ROW_76_1435 VGND VPWR sky130_fd_sc_hd__tapvpwrvgnd_1
X_4408_ _2149_ VGND VGND VPWR VPWR _0213_ sky130_fd_sc_hd__clkbuf_1
XFILLER_0_100_735 VGND VGND VPWR VPWR sky130_fd_sc_hd__decap_3
X_2669_ _0578_ _0514_ VGND VGND VPWR VPWR _0634_ sky130_fd_sc_hd__nor2_1
XFILLER_0_2_793 VPWR VGND VPWR VGND sky130_ef_sc_hd__decap_12
XFILLER_0_100_757 VGND VGND VPWR VPWR sky130_fd_sc_hd__fill_2
X_5388_ clknet_leaf_17_clk _0308_ VGND VGND VPWR VPWR cpu_inst.regfile_inst.registers\[10\]\[20\]
+ sky130_fd_sc_hd__dfxtp_1
XFILLER_0_1_281 VPWR VGND VPWR VGND sky130_ef_sc_hd__decap_12
X_4339_ _2114_ VGND VGND VPWR VPWR _0179_ sky130_fd_sc_hd__clkbuf_1
XFILLER_0_5_93 VPWR VGND VPWR VGND sky130_ef_sc_hd__decap_12
XFILLER_0_97_825 VPWR VGND VPWR VGND sky130_ef_sc_hd__decap_12
XTAP_TAPCELL_ROW_120_2101 VGND VPWR sky130_fd_sc_hd__tapvpwrvgnd_1
XTAP_TAPCELL_ROW_38_872 VGND VPWR sky130_fd_sc_hd__tapvpwrvgnd_1
XFILLER_0_96_357 VGND VGND VPWR VPWR sky130_fd_sc_hd__decap_6
XFILLER_0_65_722 VGND VGND VPWR VPWR sky130_fd_sc_hd__decap_6
XFILLER_0_49_273 VGND VGND VPWR VPWR sky130_fd_sc_hd__decap_6
XFILLER_0_126_109 VPWR VGND VPWR VGND sky130_ef_sc_hd__decap_12
XFILLER_0_119_161 VGND VGND VPWR VPWR sky130_fd_sc_hd__decap_6
XFILLER_0_108_813 VPWR VGND VPWR VGND sky130_ef_sc_hd__decap_12
XFILLER_0_64_221 VPWR VGND VPWR VGND sky130_ef_sc_hd__decap_12
XFILLER_0_92_596 VGND VGND VPWR VPWR sky130_fd_sc_hd__fill_2
XFILLER_0_64_265 VPWR VGND VPWR VGND sky130_ef_sc_hd__decap_12
XFILLER_0_135_665 VGND VGND VPWR VPWR sky130_fd_sc_hd__decap_6
XFILLER_0_134_153 VPWR VGND VPWR VGND sky130_ef_sc_hd__decap_12
XTAP_TAPCELL_ROW_118_2074 VGND VPWR sky130_fd_sc_hd__tapvpwrvgnd_1
XTAP_TAPCELL_ROW_118_2063 VGND VPWR sky130_fd_sc_hd__tapvpwrvgnd_1
XFILLER_0_17_181 VPWR VGND VPWR VGND sky130_ef_sc_hd__decap_12
XFILLER_0_18_693 VGND VGND VPWR VPWR sky130_fd_sc_hd__decap_6
XFILLER_0_134_197 VPWR VGND VPWR VGND sky130_ef_sc_hd__decap_12
XFILLER_0_60_493 VGND VGND VPWR VPWR sky130_fd_sc_hd__decap_6
XTAP_TAPCELL_ROW_131_2263 VGND VPWR sky130_fd_sc_hd__tapvpwrvgnd_1
XFILLER_0_20_357 VGND VGND VPWR VPWR sky130_fd_sc_hd__decap_6
XFILLER_0_32_195 VGND VGND VPWR VPWR sky130_fd_sc_hd__fill_1
XFILLER_0_46_27 VGND VGND VPWR VPWR sky130_fd_sc_hd__fill_1
XFILLER_0_88_825 VPWR VGND VPWR VGND sky130_ef_sc_hd__decap_12
XFILLER_0_87_335 VGND VGND VPWR VPWR sky130_fd_sc_hd__fill_1
XFILLER_0_62_15 VPWR VGND VPWR VGND sky130_ef_sc_hd__decap_12
XTAP_TAPCELL_ROW_47_1003 VGND VPWR sky130_fd_sc_hd__tapvpwrvgnd_1
XTAP_TAPCELL_ROW_16_533 VGND VPWR sky130_fd_sc_hd__tapvpwrvgnd_1
XTAP_TAPCELL_ROW_16_544 VGND VPWR sky130_fd_sc_hd__tapvpwrvgnd_1
XFILLER_0_28_413 VGND VGND VPWR VPWR sky130_fd_sc_hd__decap_6
X_3710_ _1448_ _1641_ VGND VGND VPWR VPWR _1642_ sky130_fd_sc_hd__nor2_1
XTAP_TAPCELL_ROW_60_1203 VGND VPWR sky130_fd_sc_hd__tapvpwrvgnd_1
XFILLER_0_7_329 VGND VGND VPWR VPWR sky130_fd_sc_hd__decap_6
XFILLER_0_28_457 VPWR VGND VPWR VGND sky130_ef_sc_hd__decap_12
XFILLER_0_126_643 VGND VGND VPWR VPWR sky130_fd_sc_hd__fill_1
X_4690_ _2285_ _2311_ _2314_ _2286_ VGND VGND VPWR VPWR _0330_ sky130_fd_sc_hd__o22ai_1
XFILLER_0_43_405 VGND VGND VPWR VPWR sky130_fd_sc_hd__decap_8
XFILLER_0_114_805 VGND VGND VPWR VPWR sky130_fd_sc_hd__decap_6
X_3641_ _1574_ cpu_inst.regfile_inst.registers\[6\]\[21\] _1339_ VGND VGND VPWR VPWR
+ _1575_ sky130_fd_sc_hd__mux2_1
XFILLER_0_113_337 VPWR VGND VPWR VGND sky130_ef_sc_hd__decap_12
XFILLER_0_102_65 VPWR VGND VPWR VGND sky130_ef_sc_hd__decap_12
X_3572_ cpu_inst.regfile_inst.registers\[25\]\[20\] _0693_ _0695_ _1500_ VGND VGND
+ VPWR VPWR _1507_ sky130_fd_sc_hd__o211a_1
XFILLER_0_12_825 VPWR VGND VPWR VGND sky130_ef_sc_hd__decap_12
X_5311_ clknet_leaf_32_clk _0231_ VGND VGND VPWR VPWR cpu_inst.regfile_inst.registers\[7\]\[7\]
+ sky130_fd_sc_hd__dfxtp_1
XTAP_TAPCELL_ROW_58_1176 VGND VPWR sky130_fd_sc_hd__tapvpwrvgnd_1
XTAP_TAPCELL_ROW_58_1165 VGND VPWR sky130_fd_sc_hd__tapvpwrvgnd_1
XFILLER_0_11_335 VGND VGND VPWR VPWR sky130_fd_sc_hd__fill_1
X_5242_ clknet_leaf_38_clk _0162_ VGND VGND VPWR VPWR cpu_inst.regfile_inst.registers\[5\]\[2\]
+ sky130_fd_sc_hd__dfxtp_1
X_5173_ clknet_leaf_11_clk _0093_ VGND VGND VPWR VPWR cpu_inst.regfile_inst.registers\[25\]\[29\]
+ sky130_fd_sc_hd__dfxtp_1
XTAP_TAPCELL_ROW_71_1365 VGND VPWR sky130_fd_sc_hd__tapvpwrvgnd_1
X_4124_ _2001_ VGND VGND VPWR VPWR _0077_ sky130_fd_sc_hd__clkbuf_1
XFILLER_0_127_51 VGND VGND VPWR VPWR sky130_fd_sc_hd__decap_4
Xinput1 control VGND VGND VPWR VPWR net1 sky130_fd_sc_hd__buf_2
X_4055_ _1963_ VGND VGND VPWR VPWR _0046_ sky130_fd_sc_hd__clkbuf_1
X_3006_ _0970_ cpu_inst.regfile_inst.registers\[10\]\[9\] _0883_ VGND VGND VPWR VPWR
+ _0971_ sky130_fd_sc_hd__mux2_1
XFILLER_0_93_305 VPWR VGND VPWR VGND sky130_ef_sc_hd__decap_12
XFILLER_0_78_357 VGND VGND VPWR VPWR sky130_fd_sc_hd__decap_6
XTAP_TAPCELL_ROW_35_820 VGND VPWR sky130_fd_sc_hd__tapvpwrvgnd_1
XTAP_TAPCELL_ROW_35_831 VGND VPWR sky130_fd_sc_hd__tapvpwrvgnd_1
XFILLER_0_59_582 VGND VGND VPWR VPWR sky130_fd_sc_hd__decap_6
XFILLER_0_108_109 VPWR VGND VPWR VGND sky130_ef_sc_hd__decap_12
XFILLER_0_93_349 VPWR VGND VPWR VGND sky130_ef_sc_hd__decap_12
X_4957_ _1899_ cpu_inst.regfile_inst.registers\[8\]\[30\] _2431_ VGND VGND VPWR VPWR
+ _2466_ sky130_fd_sc_hd__mux2_1
XFILLER_0_46_221 VPWR VGND VPWR VGND sky130_ef_sc_hd__decap_12
XFILLER_0_47_766 VGND VGND VPWR VPWR sky130_fd_sc_hd__decap_4
X_3908_ _1834_ VGND VGND VPWR VPWR _0028_ sky130_fd_sc_hd__clkbuf_1
X_4888_ cpu_inst.regfile_inst.registers\[9\]\[30\] VGND VGND VPWR VPWR _2429_ sky130_fd_sc_hd__clkbuf_1
XFILLER_0_7_841 VGND VGND VPWR VPWR sky130_fd_sc_hd__fill_1
XFILLER_0_46_265 VPWR VGND VPWR VGND sky130_ef_sc_hd__decap_12
XFILLER_0_47_799 VPWR VGND VPWR VGND sky130_ef_sc_hd__decap_12
XFILLER_0_132_613 VPWR VGND VPWR VGND sky130_ef_sc_hd__decap_12
XFILLER_0_117_665 VGND VGND VPWR VPWR sky130_fd_sc_hd__decap_6
XFILLER_0_116_153 VPWR VGND VPWR VGND sky130_ef_sc_hd__decap_12
X_3839_ _1536_ _1764_ _1766_ _1314_ VGND VGND VPWR VPWR _1767_ sky130_fd_sc_hd__o22a_1
XFILLER_0_116_197 VPWR VGND VPWR VGND sky130_ef_sc_hd__decap_12
XFILLER_0_61_279 VGND VGND VPWR VPWR sky130_fd_sc_hd__fill_1
XFILLER_0_15_641 VPWR VGND VPWR VGND sky130_ef_sc_hd__decap_12
XFILLER_0_132_657 VPWR VGND VPWR VGND sky130_ef_sc_hd__decap_12
XFILLER_0_15_685 VPWR VGND VPWR VGND sky130_ef_sc_hd__decap_12
XFILLER_0_131_167 VGND VGND VPWR VPWR sky130_fd_sc_hd__fill_1
X_5509_ clknet_leaf_27_clk _0429_ VGND VGND VPWR VPWR cpu_inst.regfile_inst.registers\[8\]\[13\]
+ sky130_fd_sc_hd__dfxtp_1
XFILLER_0_14_195 VGND VGND VPWR VPWR sky130_fd_sc_hd__fill_1
XTAP_TAPCELL_ROW_89_1637 VGND VPWR sky130_fd_sc_hd__tapvpwrvgnd_1
Xclkbuf_leaf_39_clk clknet_2_0__leaf_clk VGND VGND VPWR VPWR clknet_leaf_39_clk sky130_fd_sc_hd__clkbuf_8
XFILLER_0_96_121 VPWR VGND VPWR VGND sky130_ef_sc_hd__decap_12
XFILLER_0_69_357 VGND VGND VPWR VPWR sky130_fd_sc_hd__decap_3
XFILLER_0_96_165 VPWR VGND VPWR VGND sky130_ef_sc_hd__decap_12
XFILLER_0_32_29 VPWR VGND VPWR VGND sky130_ef_sc_hd__decap_12
XFILLER_0_127_429 VPWR VGND VPWR VGND sky130_ef_sc_hd__decap_12
XTAP_TAPCELL_ROW_100_1804 VGND VPWR sky130_fd_sc_hd__tapvpwrvgnd_1
XFILLER_0_38_755 VGND VGND VPWR VPWR sky130_fd_sc_hd__fill_1
XFILLER_0_108_621 VGND VGND VPWR VPWR sky130_fd_sc_hd__fill_1
XFILLER_0_25_405 VPWR VGND VPWR VGND sky130_ef_sc_hd__decap_12
XFILLER_0_38_799 VGND VGND VPWR VPWR sky130_fd_sc_hd__fill_2
XFILLER_0_92_393 VGND VGND VPWR VPWR sky130_fd_sc_hd__decap_4
XFILLER_0_25_449 VPWR VGND VPWR VGND sky130_ef_sc_hd__decap_12
XFILLER_0_135_473 VPWR VGND VPWR VGND sky130_ef_sc_hd__decap_12
XFILLER_0_122_189 VGND VGND VPWR VPWR sky130_fd_sc_hd__decap_6
XFILLER_0_110_307 VGND VGND VPWR VPWR sky130_fd_sc_hd__fill_1
XFILLER_0_0_505 VPWR VGND VPWR VGND sky130_ef_sc_hd__decap_12
XFILLER_0_20_121 VPWR VGND VPWR VGND sky130_ef_sc_hd__decap_12
XFILLER_0_57_15 VPWR VGND VPWR VGND sky130_ef_sc_hd__decap_12
XFILLER_0_20_165 VPWR VGND VPWR VGND sky130_ef_sc_hd__decap_12
XTAP_TAPCELL_ROW_111_1966 VGND VPWR sky130_fd_sc_hd__tapvpwrvgnd_1
XTAP_TAPCELL_ROW_53_1095 VGND VPWR sky130_fd_sc_hd__tapvpwrvgnd_1
XFILLER_0_73_69 VPWR VGND VPWR VGND sky130_ef_sc_hd__decap_12
XFILLER_0_76_828 VPWR VGND VPWR VGND sky130_ef_sc_hd__decap_12
X_4811_ _2390_ VGND VGND VPWR VPWR _0375_ sky130_fd_sc_hd__clkbuf_1
XFILLER_0_75_305 VPWR VGND VPWR VGND sky130_ef_sc_hd__decap_12
XFILLER_0_29_722 VGND VGND VPWR VPWR sky130_fd_sc_hd__decap_6
XFILLER_0_75_349 VPWR VGND VPWR VGND sky130_ef_sc_hd__decap_12
XFILLER_0_28_221 VPWR VGND VPWR VGND sky130_ef_sc_hd__decap_12
XFILLER_0_71_500 VGND VGND VPWR VPWR sky130_fd_sc_hd__decap_4
X_4742_ cpu_inst.decoder_inst.current_pc\[24\] _2345_ cpu_inst.decoder_inst.current_pc\[25\]
+ VGND VGND VPWR VPWR _2352_ sky130_fd_sc_hd__a21oi_1
XFILLER_0_7_137 VPWR VGND VPWR VGND sky130_ef_sc_hd__decap_12
XFILLER_0_28_265 VPWR VGND VPWR VGND sky130_ef_sc_hd__decap_12
XFILLER_0_29_777 VGND VGND VPWR VPWR sky130_fd_sc_hd__decap_6
XFILLER_0_83_393 VGND VGND VPWR VPWR sky130_fd_sc_hd__decap_4
XFILLER_0_71_511 VPWR VGND VPWR VGND sky130_ef_sc_hd__decap_12
X_4673_ cpu_inst.decoder_inst.current_pc\[6\] _2299_ VGND VGND VPWR VPWR _2302_ sky130_fd_sc_hd__xor2_1
XFILLER_0_4_811 VGND VGND VPWR VPWR sky130_fd_sc_hd__fill_1
XFILLER_0_114_613 VPWR VGND VPWR VGND sky130_ef_sc_hd__decap_12
X_3624_ cpu_inst.regfile_inst.registers\[2\]\[21\] _1469_ _1470_ cpu_inst.regfile_inst.registers\[7\]\[21\]
+ _1557_ VGND VGND VPWR VPWR _1558_ sky130_fd_sc_hd__o221a_1
XFILLER_0_114_657 VPWR VGND VPWR VGND sky130_ef_sc_hd__decap_12
XFILLER_0_98_77 VGND VGND VPWR VPWR sky130_fd_sc_hd__decap_6
XFILLER_0_43_279 VGND VGND VPWR VPWR sky130_fd_sc_hd__fill_1
XFILLER_0_113_167 VGND VGND VPWR VPWR sky130_fd_sc_hd__fill_1
XFILLER_0_101_329 VGND VGND VPWR VPWR sky130_fd_sc_hd__decap_6
X_3555_ _1448_ _1490_ _1153_ VGND VGND VPWR VPWR _1491_ sky130_fd_sc_hd__o21a_1
XFILLER_0_110_841 VGND VGND VPWR VPWR sky130_fd_sc_hd__fill_1
X_3486_ cpu_inst.regfile_inst.registers\[7\]\[18\] cpu_inst.regfile_inst.registers\[6\]\[18\]
+ _1386_ VGND VGND VPWR VPWR _1423_ sky130_fd_sc_hd__mux2_1
XFILLER_0_12_699 VGND VGND VPWR VPWR sky130_fd_sc_hd__fill_1
XPHY_EDGE_ROW_102_Left_241 VGND VGND VPWR VPWR sky130_fd_sc_hd__decap_3
X_5225_ clknet_leaf_22_clk _0145_ VGND VGND VPWR VPWR cpu_inst.regfile_inst.registers\[24\]\[17\]
+ sky130_fd_sc_hd__dfxtp_1
XFILLER_0_44_3 VPWR VGND VPWR VGND sky130_ef_sc_hd__decap_12
X_5156_ clknet_leaf_23_clk _0076_ VGND VGND VPWR VPWR cpu_inst.regfile_inst.registers\[25\]\[12\]
+ sky130_fd_sc_hd__dfxtp_1
XFILLER_0_47_81 VPWR VGND VPWR VGND sky130_ef_sc_hd__decap_12
XFILLER_0_98_419 VGND VGND VPWR VPWR sky130_fd_sc_hd__fill_1
X_4107_ _1992_ VGND VGND VPWR VPWR _0069_ sky130_fd_sc_hd__clkbuf_1
X_5087_ clknet_leaf_32_clk _0007_ VGND VGND VPWR VPWR cpu_inst.regfile_inst.registers\[6\]\[7\]
+ sky130_fd_sc_hd__dfxtp_1
XFILLER_0_79_633 VGND VGND VPWR VPWR sky130_fd_sc_hd__fill_2
X_4038_ cpu_inst.regfile_inst.registers\[2\]\[6\] VGND VGND VPWR VPWR _1955_ sky130_fd_sc_hd__clkbuf_1
XFILLER_0_78_121 VPWR VGND VPWR VGND sky130_ef_sc_hd__decap_12
XFILLER_0_2_83 VGND VGND VPWR VPWR sky130_fd_sc_hd__fill_1
XFILLER_0_93_113 VPWR VGND VPWR VGND sky130_ef_sc_hd__decap_12
XTAP_TAPCELL_ROW_84_1567 VGND VPWR sky130_fd_sc_hd__tapvpwrvgnd_1
XTAP_TAPCELL_ROW_84_1556 VGND VPWR sky130_fd_sc_hd__tapvpwrvgnd_1
XFILLER_0_78_165 VPWR VGND VPWR VGND sky130_ef_sc_hd__decap_12
XFILLER_0_137_727 VGND VGND VPWR VPWR sky130_fd_sc_hd__fill_1
XPHY_EDGE_ROW_111_Left_250 VGND VGND VPWR VPWR sky130_fd_sc_hd__decap_3
XFILLER_0_109_429 VPWR VGND VPWR VGND sky130_ef_sc_hd__decap_12
XFILLER_0_132_421 VPWR VGND VPWR VGND sky130_ef_sc_hd__decap_12
XFILLER_0_117_473 VPWR VGND VPWR VGND sky130_ef_sc_hd__decap_12
XFILLER_0_7_671 VGND VGND VPWR VPWR sky130_fd_sc_hd__fill_1
XFILLER_0_35_769 VPWR VGND VPWR VGND sky130_ef_sc_hd__decap_12
XTAP_TAPCELL_ROW_115_2022 VGND VPWR sky130_fd_sc_hd__tapvpwrvgnd_1
XFILLER_0_105_668 VGND VGND VPWR VPWR sky130_fd_sc_hd__decap_4
XFILLER_0_22_419 VGND VGND VPWR VPWR sky130_fd_sc_hd__fill_1
XFILLER_0_43_791 VGND VGND VPWR VPWR sky130_fd_sc_hd__decap_8
XFILLER_0_104_189 VGND VGND VPWR VPWR sky130_fd_sc_hd__decap_6
XFILLER_0_101_841 VGND VGND VPWR VPWR sky130_fd_sc_hd__fill_1
XFILLER_0_89_419 VGND VGND VPWR VPWR sky130_fd_sc_hd__decap_8
XTAP_TAPCELL_ROW_126_2184 VGND VPWR sky130_fd_sc_hd__tapvpwrvgnd_1
XTAP_TAPCELL_ROW_126_2195 VGND VPWR sky130_fd_sc_hd__tapvpwrvgnd_1
XFILLER_0_85_614 VGND VGND VPWR VPWR sky130_fd_sc_hd__fill_2
XFILLER_0_43_39 VPWR VGND VPWR VGND sky130_ef_sc_hd__decap_12
XFILLER_0_85_658 VGND VGND VPWR VPWR sky130_fd_sc_hd__decap_8
XTAP_TAPCELL_ROW_26_683 VGND VPWR sky130_fd_sc_hd__tapvpwrvgnd_1
XFILLER_0_128_749 VGND VGND VPWR VPWR sky130_fd_sc_hd__decap_6
XFILLER_0_127_237 VPWR VGND VPWR VGND sky130_ef_sc_hd__decap_12
XTAP_TAPCELL_ROW_26_694 VGND VPWR sky130_fd_sc_hd__tapvpwrvgnd_1
XFILLER_0_65_393 VGND VGND VPWR VPWR sky130_fd_sc_hd__decap_6
XFILLER_0_26_725 VPWR VGND VPWR VGND sky130_ef_sc_hd__decap_12
XFILLER_0_136_793 VPWR VGND VPWR VGND sky130_ef_sc_hd__decap_12
XFILLER_0_26_769 VPWR VGND VPWR VGND sky130_ef_sc_hd__decap_12
XFILLER_0_135_281 VPWR VGND VPWR VGND sky130_ef_sc_hd__decap_12
XFILLER_0_80_363 VGND VGND VPWR VPWR sky130_fd_sc_hd__fill_1
XFILLER_0_53_588 VGND VGND VPWR VPWR sky130_fd_sc_hd__decap_8
XFILLER_0_25_279 VGND VGND VPWR VPWR sky130_fd_sc_hd__fill_1
XFILLER_0_7_39 VPWR VGND VPWR VGND sky130_ef_sc_hd__decap_12
XFILLER_0_104_690 VGND VGND VPWR VPWR sky130_fd_sc_hd__fill_1
X_3340_ _0696_ VGND VGND VPWR VPWR _1295_ sky130_fd_sc_hd__buf_4
XTAP_TAPCELL_ROW_55_1124 VGND VPWR sky130_fd_sc_hd__tapvpwrvgnd_1
XFILLER_0_21_441 VGND VGND VPWR VPWR sky130_fd_sc_hd__decap_6
XFILLER_0_21_485 VPWR VGND VPWR VGND sky130_ef_sc_hd__decap_12
X_5010_ _2494_ VGND VGND VPWR VPWR _0470_ sky130_fd_sc_hd__clkbuf_1
X_3271_ _0843_ _1234_ _1235_ _0637_ VGND VGND VPWR VPWR _1236_ sky130_fd_sc_hd__o211a_1
XFILLER_0_108_53 VPWR VGND VPWR VGND sky130_ef_sc_hd__decap_12
XFILLER_0_17_51 VGND VGND VPWR VPWR sky130_fd_sc_hd__decap_4
XFILLER_0_108_97 VPWR VGND VPWR VGND sky130_ef_sc_hd__decap_12
XFILLER_0_124_41 VPWR VGND VPWR VGND sky130_ef_sc_hd__decap_12
XFILLER_0_119_727 VGND VGND VPWR VPWR sky130_fd_sc_hd__fill_1
XFILLER_0_75_113 VPWR VGND VPWR VGND sky130_ef_sc_hd__decap_12
XTAP_TAPCELL_ROW_66_1297 VGND VPWR sky130_fd_sc_hd__tapvpwrvgnd_1
XTAP_TAPCELL_ROW_66_1286 VGND VPWR sky130_fd_sc_hd__tapvpwrvgnd_1
XFILLER_0_64_809 VGND VGND VPWR VPWR sky130_fd_sc_hd__decap_3
XFILLER_0_8_413 VGND VGND VPWR VPWR sky130_fd_sc_hd__decap_6
XTAP_TAPCELL_ROW_45_970 VGND VPWR sky130_fd_sc_hd__tapvpwrvgnd_1
XTAP_TAPCELL_ROW_45_981 VGND VPWR sky130_fd_sc_hd__tapvpwrvgnd_1
XFILLER_0_124_85 VPWR VGND VPWR VGND sky130_ef_sc_hd__decap_12
XFILLER_0_91_617 VPWR VGND VPWR VGND sky130_ef_sc_hd__decap_12
XFILLER_0_56_393 VGND VGND VPWR VPWR sky130_fd_sc_hd__fill_1
X_2986_ _0696_ _0814_ _0937_ VGND VGND VPWR VPWR _0951_ sky130_fd_sc_hd__o21a_1
XFILLER_0_8_457 VPWR VGND VPWR VGND sky130_ef_sc_hd__decap_12
X_4725_ _2338_ _2339_ VGND VGND VPWR VPWR _2340_ sky130_fd_sc_hd__or2b_1
XFILLER_0_114_421 VPWR VGND VPWR VGND sky130_ef_sc_hd__decap_12
X_4656_ _1988_ VGND VGND VPWR VPWR _2288_ sky130_fd_sc_hd__buf_2
XFILLER_0_31_205 VPWR VGND VPWR VGND sky130_ef_sc_hd__decap_12
X_3607_ cpu_inst.regfile_inst.registers\[9\]\[21\] cpu_inst.regfile_inst.registers\[8\]\[21\]
+ _1540_ VGND VGND VPWR VPWR _1541_ sky130_fd_sc_hd__mux2_1
X_4587_ cpu_inst.regfile_inst.registers\[10\]\[12\] _2241_ VGND VGND VPWR VPWR _2242_
+ sky130_fd_sc_hd__and2_1
XFILLER_0_31_249 VPWR VGND VPWR VGND sky130_ef_sc_hd__decap_12
XFILLER_0_101_137 VPWR VGND VPWR VGND sky130_ef_sc_hd__decap_12
X_3538_ _0850_ _1472_ _1473_ VGND VGND VPWR VPWR _1474_ sky130_fd_sc_hd__or3_1
XFILLER_0_110_693 VGND VGND VPWR VPWR sky130_fd_sc_hd__decap_6
X_3469_ _1393_ _1406_ VGND VGND VPWR VPWR _1407_ sky130_fd_sc_hd__xor2_2
X_5208_ clknet_leaf_37_clk _0128_ VGND VGND VPWR VPWR cpu_inst.regfile_inst.registers\[24\]\[0\]
+ sky130_fd_sc_hd__dfxtp_1
X_5139_ clknet_leaf_8_clk _0059_ VGND VGND VPWR VPWR cpu_inst.regfile_inst.registers\[2\]\[27\]
+ sky130_fd_sc_hd__dfxtp_1
XTAP_TAPCELL_ROW_4_367 VGND VPWR sky130_fd_sc_hd__tapvpwrvgnd_1
XTAP_TAPCELL_ROW_4_356 VGND VPWR sky130_fd_sc_hd__tapvpwrvgnd_1
XFILLER_0_39_305 VPWR VGND VPWR VGND sky130_ef_sc_hd__decap_12
XFILLER_0_39_349 VPWR VGND VPWR VGND sky130_ef_sc_hd__decap_12
XFILLER_0_109_237 VPWR VGND VPWR VGND sky130_ef_sc_hd__decap_12
XFILLER_0_94_477 VGND VGND VPWR VPWR sky130_fd_sc_hd__decap_8
XFILLER_0_81_105 VGND VGND VPWR VPWR sky130_fd_sc_hd__decap_6
XTAP_TAPCELL_ROW_23_642 VGND VPWR sky130_fd_sc_hd__tapvpwrvgnd_1
XFILLER_0_47_393 VPWR VGND VPWR VGND sky130_ef_sc_hd__decap_12
XFILLER_0_118_793 VPWR VGND VPWR VGND sky130_ef_sc_hd__decap_12
XFILLER_0_81_149 VPWR VGND VPWR VGND sky130_ef_sc_hd__decap_12
XFILLER_0_133_741 VPWR VGND VPWR VGND sky130_ef_sc_hd__decap_12
XFILLER_0_117_281 VPWR VGND VPWR VGND sky130_ef_sc_hd__decap_12
XTAP_TAPCELL_ROW_97_1758 VGND VPWR sky130_fd_sc_hd__tapvpwrvgnd_1
XFILLER_0_35_577 VGND VGND VPWR VPWR sky130_fd_sc_hd__fill_1
XFILLER_0_50_503 VGND VGND VPWR VPWR sky130_fd_sc_hd__fill_1
XFILLER_0_133_785 VPWR VGND VPWR VGND sky130_ef_sc_hd__decap_12
XFILLER_0_132_251 VGND VGND VPWR VPWR sky130_fd_sc_hd__fill_1
XFILLER_0_120_413 VGND VGND VPWR VPWR sky130_fd_sc_hd__decap_6
XFILLER_0_50_547 VGND VGND VPWR VPWR sky130_fd_sc_hd__fill_1
XFILLER_0_50_569 VGND VGND VPWR VPWR sky130_fd_sc_hd__fill_1
XFILLER_0_120_457 VPWR VGND VPWR VGND sky130_ef_sc_hd__decap_12
XFILLER_0_31_783 VGND VGND VPWR VPWR sky130_fd_sc_hd__fill_1
XFILLER_0_101_671 VGND VGND VPWR VPWR sky130_fd_sc_hd__fill_1
XTAP_TAPCELL_ROW_128_2224 VGND VPWR sky130_fd_sc_hd__tapvpwrvgnd_1
XTAP_TAPCELL_ROW_128_2213 VGND VPWR sky130_fd_sc_hd__tapvpwrvgnd_1
XFILLER_0_89_205 VPWR VGND VPWR VGND sky130_ef_sc_hd__decap_12
XTAP_TAPCELL_ROW_50_1043 VGND VPWR sky130_fd_sc_hd__tapvpwrvgnd_1
XTAP_TAPCELL_ROW_50_1054 VGND VPWR sky130_fd_sc_hd__tapvpwrvgnd_1
XFILLER_0_54_27 VGND VGND VPWR VPWR sky130_fd_sc_hd__fill_1
XFILLER_0_89_249 VPWR VGND VPWR VGND sky130_ef_sc_hd__decap_12
XFILLER_0_128_513 VPWR VGND VPWR VGND sky130_ef_sc_hd__decap_12
XTAP_TAPCELL_ROW_106_1887 VGND VPWR sky130_fd_sc_hd__tapvpwrvgnd_1
XFILLER_0_97_293 VPWR VGND VPWR VGND sky130_ef_sc_hd__decap_12
XFILLER_0_70_15 VPWR VGND VPWR VGND sky130_ef_sc_hd__decap_12
XFILLER_0_57_113 VPWR VGND VPWR VGND sky130_ef_sc_hd__decap_12
X_2840_ cpu_inst.regfile_inst.registers\[24\]\[5\] _0640_ _0799_ _0804_ _0637_ VGND
+ VGND VPWR VPWR _0805_ sky130_fd_sc_hd__o221a_1
XFILLER_0_128_557 VPWR VGND VPWR VGND sky130_ef_sc_hd__decap_12
XFILLER_0_5_405 VPWR VGND VPWR VGND sky130_ef_sc_hd__decap_12
X_2771_ cpu_inst.regfile_inst.registers\[2\]\[11\] _0726_ _0703_ cpu_inst.regfile_inst.registers\[7\]\[11\]
+ VGND VGND VPWR VPWR _0736_ sky130_fd_sc_hd__o22a_1
X_5490_ clknet_leaf_10_clk _0410_ VGND VGND VPWR VPWR cpu_inst.regfile_inst.registers\[9\]\[26\]
+ sky130_fd_sc_hd__dfxtp_1
XFILLER_0_13_205 VPWR VGND VPWR VGND sky130_ef_sc_hd__decap_12
XFILLER_0_5_449 VPWR VGND VPWR VGND sky130_ef_sc_hd__decap_12
X_4510_ cpu_inst.regfile_inst.registers\[11\]\[6\] VGND VGND VPWR VPWR _2203_ sky130_fd_sc_hd__clkbuf_1
XFILLER_0_102_3 VPWR VGND VPWR VGND sky130_ef_sc_hd__decap_12
XFILLER_0_79_57 VPWR VGND VPWR VGND sky130_ef_sc_hd__decap_12
XFILLER_0_13_249 VPWR VGND VPWR VGND sky130_ef_sc_hd__decap_12
X_4441_ _1330_ _1331_ _1290_ VGND VGND VPWR VPWR _2167_ sky130_fd_sc_hd__or3b_2
XFILLER_0_123_273 VGND VGND VPWR VPWR sky130_fd_sc_hd__decap_6
XFILLER_0_110_65 VPWR VGND VPWR VGND sky130_ef_sc_hd__decap_12
XPHY_EDGE_ROW_9_Right_9 VGND VGND VPWR VPWR sky130_fd_sc_hd__decap_3
X_4372_ _2131_ VGND VGND VPWR VPWR _0195_ sky130_fd_sc_hd__clkbuf_1
X_3323_ _1269_ _1272_ _1281_ _1263_ VGND VGND VPWR VPWR net13 sky130_fd_sc_hd__a22o_1
XFILLER_0_0_165 VGND VGND VPWR VPWR sky130_fd_sc_hd__decap_3
XFILLER_0_21_293 VPWR VGND VPWR VGND sky130_ef_sc_hd__decap_12
XPHY_EDGE_ROW_107_Right_107 VGND VGND VPWR VPWR sky130_fd_sc_hd__decap_3
X_3254_ _0948_ _0950_ _1218_ VGND VGND VPWR VPWR _1219_ sky130_fd_sc_hd__nand3_1
XFILLER_0_28_83 VGND VGND VPWR VPWR sky130_fd_sc_hd__fill_1
X_3185_ _1059_ _1064_ _1060_ VGND VGND VPWR VPWR _1150_ sky130_fd_sc_hd__mux2_1
XTAP_TAPCELL_ROW_1_315 VGND VPWR sky130_fd_sc_hd__tapvpwrvgnd_1
XTAP_TAPCELL_ROW_68_1326 VGND VPWR sky130_fd_sc_hd__tapvpwrvgnd_1
XTAP_TAPCELL_ROW_68_1315 VGND VPWR sky130_fd_sc_hd__tapvpwrvgnd_1
XFILLER_0_135_51 VGND VGND VPWR VPWR sky130_fd_sc_hd__decap_4
XFILLER_0_89_783 VGND VGND VPWR VPWR sky130_fd_sc_hd__fill_1
XFILLER_0_49_603 VGND VGND VPWR VPWR sky130_fd_sc_hd__fill_1
XTAP_TAPCELL_ROW_81_1515 VGND VPWR sky130_fd_sc_hd__tapvpwrvgnd_1
XFILLER_0_8_221 VPWR VGND VPWR VGND sky130_ef_sc_hd__decap_12
XFILLER_0_49_669 VGND VGND VPWR VPWR sky130_fd_sc_hd__decap_3
XFILLER_0_63_105 VGND VGND VPWR VPWR sky130_fd_sc_hd__decap_6
XFILLER_0_9_777 VGND VGND VPWR VPWR sky130_fd_sc_hd__decap_6
XFILLER_0_45_831 VGND VGND VPWR VPWR sky130_fd_sc_hd__decap_8
XFILLER_0_63_149 VPWR VGND VPWR VGND sky130_ef_sc_hd__decap_12
X_2969_ _0929_ _0933_ VGND VGND VPWR VPWR _0934_ sky130_fd_sc_hd__or2b_4
XFILLER_0_8_265 VPWR VGND VPWR VGND sky130_ef_sc_hd__decap_12
XTAP_TAPCELL_ROW_20_601 VGND VPWR sky130_fd_sc_hd__tapvpwrvgnd_1
XFILLER_0_29_393 VPWR VGND VPWR VGND sky130_ef_sc_hd__decap_12
XFILLER_0_115_741 VPWR VGND VPWR VGND sky130_ef_sc_hd__decap_12
X_4708_ cpu_inst.decoder_inst.current_pc\[15\] _1288_ _2285_ _2327_ VGND VGND VPWR
+ VPWR _0335_ sky130_fd_sc_hd__a22o_1
XFILLER_0_44_363 VGND VGND VPWR VPWR sky130_fd_sc_hd__fill_1
XFILLER_0_115_785 VPWR VGND VPWR VGND sky130_ef_sc_hd__decap_12
XFILLER_0_114_251 VGND VGND VPWR VPWR sky130_fd_sc_hd__fill_1
XFILLER_0_71_193 VPWR VGND VPWR VGND sky130_ef_sc_hd__decap_12
XFILLER_0_102_413 VGND VGND VPWR VPWR sky130_fd_sc_hd__decap_6
XTAP_TAPCELL_ROW_79_1488 VGND VPWR sky130_fd_sc_hd__tapvpwrvgnd_1
X_4639_ _1156_ _1215_ _1382_ VGND VGND VPWR VPWR _2272_ sky130_fd_sc_hd__or3_1
XFILLER_0_130_755 VGND VGND VPWR VPWR sky130_fd_sc_hd__fill_1
XTAP_TAPCELL_ROW_9_437 VGND VPWR sky130_fd_sc_hd__tapvpwrvgnd_1
XFILLER_0_13_783 VGND VGND VPWR VPWR sky130_fd_sc_hd__fill_1
XTAP_TAPCELL_ROW_92_1677 VGND VPWR sky130_fd_sc_hd__tapvpwrvgnd_1
XTAP_TAPCELL_ROW_28_723 VGND VPWR sky130_fd_sc_hd__tapvpwrvgnd_1
XTAP_TAPCELL_ROW_123_2143 VGND VPWR sky130_fd_sc_hd__tapvpwrvgnd_1
XFILLER_0_79_293 VPWR VGND VPWR VGND sky130_ef_sc_hd__decap_12
XFILLER_0_39_113 VPWR VGND VPWR VGND sky130_ef_sc_hd__decap_12
XFILLER_0_55_617 VGND VGND VPWR VPWR sky130_fd_sc_hd__decap_3
XFILLER_0_125_505 VPWR VGND VPWR VGND sky130_ef_sc_hd__decap_12
XFILLER_0_40_29 VPWR VGND VPWR VGND sky130_ef_sc_hd__decap_12
XFILLER_0_23_503 VGND VGND VPWR VPWR sky130_fd_sc_hd__fill_1
XFILLER_0_51_801 VGND VGND VPWR VPWR sky130_fd_sc_hd__fill_1
XFILLER_0_2_419 VGND VGND VPWR VPWR sky130_fd_sc_hd__fill_1
XFILLER_0_35_385 VGND VGND VPWR VPWR sky130_fd_sc_hd__decap_6
XFILLER_0_50_333 VPWR VGND VPWR VGND sky130_ef_sc_hd__decap_12
XFILLER_0_120_221 VPWR VGND VPWR VGND sky130_ef_sc_hd__decap_12
XFILLER_0_105_273 VGND VGND VPWR VPWR sky130_fd_sc_hd__decap_6
XFILLER_0_11_709 VPWR VGND VPWR VGND sky130_ef_sc_hd__decap_12
XFILLER_0_49_27 VPWR VGND VPWR VGND sky130_ef_sc_hd__decap_12
XFILLER_0_50_377 VPWR VGND VPWR VGND sky130_ef_sc_hd__decap_12
XFILLER_0_121_777 VGND VGND VPWR VPWR sky130_fd_sc_hd__decap_6
XFILLER_0_120_265 VPWR VGND VPWR VGND sky130_ef_sc_hd__decap_12
XFILLER_0_65_15 VPWR VGND VPWR VGND sky130_ef_sc_hd__decap_12
XFILLER_0_4_29 VPWR VGND VPWR VGND sky130_ef_sc_hd__decap_12
XTAP_TAPCELL_ROW_108_1927 VGND VPWR sky130_fd_sc_hd__tapvpwrvgnd_1
XTAP_TAPCELL_ROW_108_1916 VGND VPWR sky130_fd_sc_hd__tapvpwrvgnd_1
XFILLER_0_81_69 VPWR VGND VPWR VGND sky130_ef_sc_hd__decap_12
X_4990_ cpu_inst.regfile_inst.registers\[15\]\[13\] _2480_ VGND VGND VPWR VPWR _2484_
+ sky130_fd_sc_hd__and2_1
XFILLER_0_129_833 VGND VGND VPWR VPWR sky130_fd_sc_hd__decap_6
XFILLER_0_128_321 VPWR VGND VPWR VGND sky130_ef_sc_hd__decap_12
X_3941_ _1859_ _1862_ _0684_ _1866_ VGND VGND VPWR VPWR _1867_ sky130_fd_sc_hd__a2bb2o_1
XFILLER_0_14_41 VPWR VGND VPWR VGND sky130_ef_sc_hd__decap_12
XFILLER_0_19_809 VPWR VGND VPWR VGND sky130_ef_sc_hd__decap_12
X_3872_ _1798_ cpu_inst.regfile_inst.registers\[10\]\[28\] _1313_ VGND VGND VPWR VPWR
+ _1799_ sky130_fd_sc_hd__mux2_1
XTAP_TAPCELL_ROW_63_1245 VGND VPWR sky130_fd_sc_hd__tapvpwrvgnd_1
XFILLER_0_14_85 VPWR VGND VPWR VGND sky130_ef_sc_hd__decap_12
XFILLER_0_45_105 VGND VGND VPWR VPWR sky130_fd_sc_hd__decap_6
XFILLER_0_128_365 VPWR VGND VPWR VGND sky130_ef_sc_hd__decap_12
XFILLER_0_6_725 VPWR VGND VPWR VGND sky130_ef_sc_hd__decap_12
XFILLER_0_45_149 VPWR VGND VPWR VGND sky130_ef_sc_hd__decap_12
X_2823_ cpu_inst.regfile_inst.registers\[15\]\[7\] _0566_ _0571_ VGND VGND VPWR VPWR
+ _0788_ sky130_fd_sc_hd__a21o_1
XFILLER_0_6_769 VPWR VGND VPWR VGND sky130_ef_sc_hd__decap_12
XFILLER_0_26_363 VGND VGND VPWR VPWR sky130_fd_sc_hd__fill_1
X_5542_ clknet_leaf_28_clk _0462_ VGND VGND VPWR VPWR cpu_inst.regfile_inst.registers\[15\]\[14\]
+ sky130_fd_sc_hd__dfxtp_1
X_2754_ _0709_ _0634_ _0565_ VGND VGND VPWR VPWR _0719_ sky130_fd_sc_hd__and3_1
XFILLER_0_5_279 VGND VGND VPWR VPWR sky130_fd_sc_hd__fill_1
XFILLER_0_14_525 VGND VGND VPWR VPWR sky130_fd_sc_hd__decap_6
XFILLER_0_53_193 VPWR VGND VPWR VGND sky130_ef_sc_hd__decap_12
XFILLER_0_14_569 VPWR VGND VPWR VGND sky130_ef_sc_hd__decap_12
X_2685_ cpu_inst.regfile_inst.registers\[7\]\[1\] cpu_inst.regfile_inst.registers\[6\]\[1\]
+ _0648_ VGND VGND VPWR VPWR _0650_ sky130_fd_sc_hd__mux2_1
X_5473_ clknet_leaf_32_clk _0393_ VGND VGND VPWR VPWR cpu_inst.regfile_inst.registers\[9\]\[9\]
+ sky130_fd_sc_hd__dfxtp_1
XFILLER_0_112_755 VGND VGND VPWR VPWR sky130_fd_sc_hd__fill_1
X_4424_ _2157_ VGND VGND VPWR VPWR _0221_ sky130_fd_sc_hd__clkbuf_1
XFILLER_0_1_441 VGND VGND VPWR VPWR sky130_fd_sc_hd__decap_6
X_4355_ _1792_ cpu_inst.regfile_inst.registers\[5\]\[27\] _2117_ VGND VGND VPWR VPWR
+ _2123_ sky130_fd_sc_hd__mux2_1
XFILLER_0_1_485 VPWR VGND VPWR VGND sky130_ef_sc_hd__decap_12
X_3306_ _1102_ _1199_ _1171_ VGND VGND VPWR VPWR _1270_ sky130_fd_sc_hd__o21ai_1
XFILLER_0_39_93 VPWR VGND VPWR VGND sky130_ef_sc_hd__decap_12
X_4286_ _2085_ VGND VGND VPWR VPWR _0155_ sky130_fd_sc_hd__clkbuf_1
X_3237_ _1077_ _1080_ _1062_ VGND VGND VPWR VPWR _1202_ sky130_fd_sc_hd__mux2_1
X_3168_ _1125_ _1132_ VGND VGND VPWR VPWR _1133_ sky130_fd_sc_hd__or2b_1
XFILLER_0_55_81 VPWR VGND VPWR VGND sky130_ef_sc_hd__decap_12
X_3099_ cpu_inst.regfile_inst.registers\[25\]\[10\] _1022_ _0921_ _1012_ VGND VGND
+ VPWR VPWR _1064_ sky130_fd_sc_hd__o211a_1
XFILLER_0_49_433 VPWR VGND VPWR VGND sky130_ef_sc_hd__decap_12
XFILLER_0_92_701 VGND VGND VPWR VPWR sky130_fd_sc_hd__fill_1
XFILLER_0_64_403 VPWR VGND VPWR VGND sky130_ef_sc_hd__decap_12
XFILLER_0_9_541 VPWR VGND VPWR VGND sky130_ef_sc_hd__decap_12
XFILLER_0_37_628 VGND VGND VPWR VPWR sky130_fd_sc_hd__fill_1
XFILLER_0_107_505 VGND VGND VPWR VPWR sky130_fd_sc_hd__decap_8
XFILLER_0_92_778 VGND VGND VPWR VPWR sky130_fd_sc_hd__fill_1
XFILLER_0_9_585 VPWR VGND VPWR VGND sky130_ef_sc_hd__decap_12
XTAP_TAPCELL_ROW_33_792 VGND VPWR sky130_fd_sc_hd__tapvpwrvgnd_1
XFILLER_0_45_683 VGND VGND VPWR VPWR sky130_fd_sc_hd__decap_8
XFILLER_0_134_357 VGND VGND VPWR VPWR sky130_fd_sc_hd__decap_6
XTAP_TAPCELL_ROW_94_1706 VGND VPWR sky130_fd_sc_hd__tapvpwrvgnd_1
XFILLER_0_17_385 VGND VGND VPWR VPWR sky130_fd_sc_hd__decap_6
XFILLER_0_32_333 VPWR VGND VPWR VGND sky130_ef_sc_hd__decap_12
XTAP_TAPCELL_ROW_94_1717 VGND VPWR sky130_fd_sc_hd__tapvpwrvgnd_1
XFILLER_0_60_664 VGND VGND VPWR VPWR sky130_fd_sc_hd__fill_1
XFILLER_0_103_777 VGND VGND VPWR VPWR sky130_fd_sc_hd__decap_6
XFILLER_0_102_221 VPWR VGND VPWR VGND sky130_ef_sc_hd__decap_12
XFILLER_0_32_377 VPWR VGND VPWR VGND sky130_ef_sc_hd__decap_12
XFILLER_0_102_265 VPWR VGND VPWR VGND sky130_ef_sc_hd__decap_12
XFILLER_0_68_764 VGND VGND VPWR VPWR sky130_fd_sc_hd__decap_6
XFILLER_0_138_641 VGND VGND VPWR VPWR sky130_fd_sc_hd__decap_3
XTAP_TAPCELL_ROW_103_1846 VGND VPWR sky130_fd_sc_hd__tapvpwrvgnd_1
XFILLER_0_27_105 VGND VGND VPWR VPWR sky130_fd_sc_hd__decap_6
XFILLER_0_51_39 VPWR VGND VPWR VGND sky130_ef_sc_hd__decap_12
XFILLER_0_138_685 VPWR VGND VPWR VGND sky130_ef_sc_hd__decap_12
XFILLER_0_126_825 VPWR VGND VPWR VGND sky130_ef_sc_hd__decap_12
XFILLER_0_82_233 VPWR VGND VPWR VGND sky130_ef_sc_hd__decap_12
XFILLER_0_55_447 VGND VGND VPWR VPWR sky130_fd_sc_hd__fill_1
XFILLER_0_27_149 VPWR VGND VPWR VGND sky130_ef_sc_hd__decap_12
XTAP_TAPCELL_ROW_136_2345 VGND VPWR sky130_fd_sc_hd__tapvpwrvgnd_1
XTAP_TAPCELL_ROW_136_2334 VGND VPWR sky130_fd_sc_hd__tapvpwrvgnd_1
XFILLER_0_125_335 VGND VGND VPWR VPWR sky130_fd_sc_hd__fill_1
XFILLER_0_82_277 VPWR VGND VPWR VGND sky130_ef_sc_hd__decap_12
XFILLER_0_36_661 VGND VGND VPWR VPWR sky130_fd_sc_hd__decap_4
Xclkload15 clknet_leaf_8_clk VGND VGND VPWR VPWR clkload15/X sky130_fd_sc_hd__clkbuf_4
XTAP_TAPCELL_ROW_11_464 VGND VPWR sky130_fd_sc_hd__tapvpwrvgnd_1
Xclkload26 clknet_leaf_31_clk VGND VGND VPWR VPWR clkload26/Y sky130_fd_sc_hd__inv_16
Xclkload37 clknet_leaf_18_clk VGND VGND VPWR VPWR clkload37/Y sky130_fd_sc_hd__clkinvlp_4
XFILLER_0_35_193 VPWR VGND VPWR VGND sky130_ef_sc_hd__decap_12
XFILLER_0_50_141 VPWR VGND VPWR VGND sky130_ef_sc_hd__decap_12
XFILLER_0_121_541 VPWR VGND VPWR VGND sky130_ef_sc_hd__decap_12
XFILLER_0_11_517 VPWR VGND VPWR VGND sky130_ef_sc_hd__decap_12
XFILLER_0_121_585 VPWR VGND VPWR VGND sky130_ef_sc_hd__decap_12
X_4140_ _2009_ VGND VGND VPWR VPWR _0085_ sky130_fd_sc_hd__clkbuf_1
X_4071_ _1971_ VGND VGND VPWR VPWR _0054_ sky130_fd_sc_hd__clkbuf_1
X_3022_ cpu_inst.regfile_inst.registers\[25\]\[8\] _0692_ _0694_ _0978_ _0984_ VGND
+ VGND VPWR VPWR _0987_ sky130_fd_sc_hd__o2111ai_2
XFILLER_0_116_53 VPWR VGND VPWR VGND sky130_ef_sc_hd__decap_12
XFILLER_0_25_51 VGND VGND VPWR VPWR sky130_fd_sc_hd__decap_4
XFILLER_0_116_97 VPWR VGND VPWR VGND sky130_ef_sc_hd__decap_12
XFILLER_0_59_775 VGND VGND VPWR VPWR sky130_fd_sc_hd__decap_4
XTAP_TAPCELL_ROW_19_586 VGND VPWR sky130_fd_sc_hd__tapvpwrvgnd_1
X_4973_ cpu_inst.regfile_inst.registers\[15\]\[5\] _2469_ VGND VGND VPWR VPWR _2475_
+ sky130_fd_sc_hd__and2_1
XFILLER_0_129_641 VPWR VGND VPWR VGND sky130_ef_sc_hd__decap_12
X_3924_ _1552_ _1845_ _1846_ _1849_ VGND VGND VPWR VPWR _1850_ sky130_fd_sc_hd__o22a_1
XFILLER_0_19_617 VPWR VGND VPWR VGND sky130_ef_sc_hd__decap_12
XFILLER_0_132_41 VPWR VGND VPWR VGND sky130_ef_sc_hd__decap_12
XFILLER_0_129_685 VPWR VGND VPWR VGND sky130_ef_sc_hd__decap_12
XFILLER_0_132_85 VPWR VGND VPWR VGND sky130_ef_sc_hd__decap_12
XFILLER_0_128_195 VGND VGND VPWR VPWR sky130_fd_sc_hd__fill_1
X_3855_ _1735_ _1749_ VGND VGND VPWR VPWR _1783_ sky130_fd_sc_hd__nor2_1
Xclkload9 clknet_leaf_42_clk VGND VGND VPWR VPWR clkload9/Y sky130_fd_sc_hd__bufinv_16
XFILLER_0_6_533 VPWR VGND VPWR VGND sky130_ef_sc_hd__decap_12
XFILLER_0_46_469 VGND VGND VPWR VPWR sky130_fd_sc_hd__decap_6
XFILLER_0_131_305 VPWR VGND VPWR VGND sky130_ef_sc_hd__decap_12
XFILLER_0_116_357 VGND VGND VPWR VPWR sky130_fd_sc_hd__decap_6
X_3786_ _1028_ _1714_ _1715_ _1555_ VGND VGND VPWR VPWR _1716_ sky130_fd_sc_hd__o211a_1
X_2806_ _0770_ _0742_ _0756_ _0740_ VGND VGND VPWR VPWR _0771_ sky130_fd_sc_hd__or4_4
XTAP_TAPCELL_ROW_30_751 VGND VPWR sky130_fd_sc_hd__tapvpwrvgnd_1
X_5525_ clknet_leaf_3_clk _0445_ VGND VGND VPWR VPWR cpu_inst.regfile_inst.registers\[8\]\[29\]
+ sky130_fd_sc_hd__dfxtp_1
XFILLER_0_14_333 VPWR VGND VPWR VGND sky130_ef_sc_hd__decap_12
X_2737_ _0602_ VGND VGND VPWR VPWR _0702_ sky130_fd_sc_hd__clkbuf_4
XFILLER_0_42_664 VGND VGND VPWR VPWR sky130_fd_sc_hd__decap_8
XFILLER_0_131_349 VPWR VGND VPWR VGND sky130_ef_sc_hd__decap_12
X_5456_ clknet_leaf_9_clk _0376_ VGND VGND VPWR VPWR cpu_inst.regfile_inst.registers\[0\]\[24\]
+ sky130_fd_sc_hd__dfxtp_1
XTAP_TAPCELL_ROW_76_1447 VGND VPWR sky130_fd_sc_hd__tapvpwrvgnd_1
XTAP_TAPCELL_ROW_76_1436 VGND VPWR sky130_fd_sc_hd__tapvpwrvgnd_1
XFILLER_0_74_3 VPWR VGND VPWR VGND sky130_ef_sc_hd__decap_12
XFILLER_0_14_377 VPWR VGND VPWR VGND sky130_ef_sc_hd__decap_12
X_2668_ _0632_ _0626_ _0606_ VGND VGND VPWR VPWR _0633_ sky130_fd_sc_hd__a21o_1
X_4407_ cpu_inst.regfile_inst.registers\[1\]\[21\] VGND VGND VPWR VPWR _2149_ sky130_fd_sc_hd__clkbuf_1
XFILLER_0_100_725 VGND VGND VPWR VPWR sky130_fd_sc_hd__decap_3
X_5387_ clknet_leaf_19_clk _0307_ VGND VGND VPWR VPWR cpu_inst.regfile_inst.registers\[10\]\[19\]
+ sky130_fd_sc_hd__dfxtp_1
XFILLER_0_1_293 VPWR VGND VPWR VGND sky130_ef_sc_hd__decap_12
X_2599_ net17 _0518_ _0523_ VGND VGND VPWR VPWR _0564_ sky130_fd_sc_hd__or3_4
X_4338_ _1493_ cpu_inst.regfile_inst.registers\[5\]\[19\] _2105_ VGND VGND VPWR VPWR
+ _2114_ sky130_fd_sc_hd__mux2_1
X_4269_ cpu_inst.regfile_inst.registers\[24\]\[19\] VGND VGND VPWR VPWR _2077_ sky130_fd_sc_hd__clkbuf_1
XFILLER_0_97_837 VGND VGND VPWR VPWR sky130_fd_sc_hd__decap_3
XTAP_TAPCELL_ROW_120_2102 VGND VPWR sky130_fd_sc_hd__tapvpwrvgnd_1
XTAP_TAPCELL_ROW_38_873 VGND VPWR sky130_fd_sc_hd__tapvpwrvgnd_1
XTAP_TAPCELL_ROW_87_1598 VGND VPWR sky130_fd_sc_hd__tapvpwrvgnd_1
XFILLER_0_108_825 VPWR VGND VPWR VGND sky130_ef_sc_hd__decap_12
XFILLER_0_92_531 VGND VGND VPWR VPWR sky130_fd_sc_hd__fill_1
XFILLER_0_64_233 VPWR VGND VPWR VGND sky130_ef_sc_hd__decap_12
XFILLER_0_37_458 VGND VGND VPWR VPWR sky130_fd_sc_hd__decap_4
XFILLER_0_134_121 VPWR VGND VPWR VGND sky130_ef_sc_hd__decap_12
XFILLER_0_107_335 VGND VGND VPWR VPWR sky130_fd_sc_hd__fill_1
XFILLER_0_64_277 VPWR VGND VPWR VGND sky130_ef_sc_hd__decap_12
XFILLER_0_9_393 VPWR VGND VPWR VGND sky130_ef_sc_hd__decap_12
XFILLER_0_134_165 VPWR VGND VPWR VGND sky130_ef_sc_hd__decap_12
XTAP_TAPCELL_ROW_118_2064 VGND VPWR sky130_fd_sc_hd__tapvpwrvgnd_1
XFILLER_0_123_839 VGND VGND VPWR VPWR sky130_fd_sc_hd__fill_1
XTAP_TAPCELL_ROW_118_2075 VGND VPWR sky130_fd_sc_hd__tapvpwrvgnd_1
XFILLER_0_60_450 VGND VGND VPWR VPWR sky130_fd_sc_hd__decap_8
XFILLER_0_17_193 VPWR VGND VPWR VGND sky130_ef_sc_hd__decap_12
XFILLER_0_32_141 VPWR VGND VPWR VGND sky130_ef_sc_hd__decap_12
XTAP_TAPCELL_ROW_131_2264 VGND VPWR sky130_fd_sc_hd__tapvpwrvgnd_1
XFILLER_0_88_837 VGND VGND VPWR VPWR sky130_fd_sc_hd__decap_4
XFILLER_0_62_27 VGND VGND VPWR VPWR sky130_fd_sc_hd__fill_1
XTAP_TAPCELL_ROW_47_1004 VGND VPWR sky130_fd_sc_hd__tapvpwrvgnd_1
XTAP_TAPCELL_ROW_16_534 VGND VPWR sky130_fd_sc_hd__tapvpwrvgnd_1
XTAP_TAPCELL_ROW_16_545 VGND VPWR sky130_fd_sc_hd__tapvpwrvgnd_1
XFILLER_0_95_391 VGND VGND VPWR VPWR sky130_fd_sc_hd__fill_1
XTAP_TAPCELL_ROW_60_1204 VGND VPWR sky130_fd_sc_hd__tapvpwrvgnd_1
XFILLER_0_83_564 VPWR VGND VPWR VGND sky130_ef_sc_hd__decap_12
XFILLER_0_71_726 VGND VGND VPWR VPWR sky130_fd_sc_hd__fill_2
XFILLER_0_28_469 VGND VGND VPWR VPWR sky130_fd_sc_hd__decap_6
X_3640_ _1092_ _1548_ _1573_ _1224_ VGND VGND VPWR VPWR _1574_ sky130_fd_sc_hd__a2bb2o_1
XFILLER_0_3_503 VGND VGND VPWR VPWR sky130_fd_sc_hd__fill_1
XFILLER_0_43_428 VGND VGND VPWR VPWR sky130_fd_sc_hd__decap_4
XFILLER_0_126_699 VGND VGND VPWR VPWR sky130_fd_sc_hd__fill_1
XFILLER_0_113_305 VPWR VGND VPWR VGND sky130_ef_sc_hd__decap_12
XFILLER_0_102_77 VGND VGND VPWR VPWR sky130_fd_sc_hd__decap_6
X_3571_ _1251_ _1379_ _1505_ _1153_ VGND VGND VPWR VPWR _1506_ sky130_fd_sc_hd__o211a_1
XFILLER_0_24_642 VGND VGND VPWR VPWR sky130_fd_sc_hd__fill_2
XFILLER_0_113_349 VPWR VGND VPWR VGND sky130_ef_sc_hd__decap_12
XFILLER_0_12_837 VGND VGND VPWR VPWR sky130_fd_sc_hd__decap_4
X_5310_ clknet_leaf_33_clk _0230_ VGND VGND VPWR VPWR cpu_inst.regfile_inst.registers\[7\]\[6\]
+ sky130_fd_sc_hd__dfxtp_1
XFILLER_0_51_461 VPWR VGND VPWR VGND sky130_ef_sc_hd__decap_12
XFILLER_0_87_57 VPWR VGND VPWR VGND sky130_ef_sc_hd__decap_12
XTAP_TAPCELL_ROW_58_1177 VGND VPWR sky130_fd_sc_hd__tapvpwrvgnd_1
XTAP_TAPCELL_ROW_58_1166 VGND VPWR sky130_fd_sc_hd__tapvpwrvgnd_1
XFILLER_0_121_393 VPWR VGND VPWR VGND sky130_ef_sc_hd__decap_12
X_5241_ clknet_leaf_40_clk _0161_ VGND VGND VPWR VPWR cpu_inst.regfile_inst.registers\[5\]\[1\]
+ sky130_fd_sc_hd__dfxtp_1
X_5172_ clknet_leaf_11_clk _0092_ VGND VGND VPWR VPWR cpu_inst.regfile_inst.registers\[25\]\[28\]
+ sky130_fd_sc_hd__dfxtp_1
XTAP_TAPCELL_ROW_71_1366 VGND VPWR sky130_fd_sc_hd__tapvpwrvgnd_1
X_4123_ net16 cpu_inst.regfile_inst.registers\[25\]\[13\] _1998_ VGND VGND VPWR VPWR
+ _2001_ sky130_fd_sc_hd__mux2_1
Xinput2 res VGND VGND VPWR VPWR net2 sky130_fd_sc_hd__buf_12
X_4054_ cpu_inst.regfile_inst.registers\[2\]\[14\] VGND VGND VPWR VPWR _1963_ sky130_fd_sc_hd__clkbuf_1
X_3005_ cpu_inst.regfile_inst.registers\[9\]\[9\] cpu_inst.regfile_inst.registers\[8\]\[9\]
+ _0922_ VGND VGND VPWR VPWR _0970_ sky130_fd_sc_hd__mux2_1
XFILLER_0_36_83 VGND VGND VPWR VPWR sky130_fd_sc_hd__fill_1
XTAP_TAPCELL_ROW_35_821 VGND VPWR sky130_fd_sc_hd__tapvpwrvgnd_1
XTAP_TAPCELL_ROW_35_832 VGND VPWR sky130_fd_sc_hd__tapvpwrvgnd_1
XFILLER_0_93_317 VPWR VGND VPWR VGND sky130_ef_sc_hd__decap_12
XFILLER_0_136_419 VGND VGND VPWR VPWR sky130_fd_sc_hd__fill_1
X_4956_ _2465_ VGND VGND VPWR VPWR _0445_ sky130_fd_sc_hd__clkbuf_1
XFILLER_0_74_531 VGND VGND VPWR VPWR sky130_fd_sc_hd__fill_1
XFILLER_0_19_447 VGND VGND VPWR VPWR sky130_fd_sc_hd__fill_1
XFILLER_0_46_233 VPWR VGND VPWR VGND sky130_ef_sc_hd__decap_12
XFILLER_0_116_121 VPWR VGND VPWR VGND sky130_ef_sc_hd__decap_12
X_3907_ _1833_ cpu_inst.regfile_inst.registers\[6\]\[28\] _1609_ VGND VGND VPWR VPWR
+ _1834_ sky130_fd_sc_hd__mux2_1
X_4887_ _2428_ VGND VGND VPWR VPWR _0413_ sky130_fd_sc_hd__clkbuf_1
XFILLER_0_46_277 VPWR VGND VPWR VGND sky130_ef_sc_hd__decap_12
X_3838_ _1765_ cpu_inst.regfile_inst.registers\[10\]\[27\] _1312_ VGND VGND VPWR VPWR
+ _1766_ sky130_fd_sc_hd__mux2_1
XFILLER_0_61_225 VPWR VGND VPWR VGND sky130_ef_sc_hd__decap_12
XFILLER_0_132_625 VPWR VGND VPWR VGND sky130_ef_sc_hd__decap_12
XFILLER_0_131_113 VPWR VGND VPWR VGND sky130_ef_sc_hd__decap_12
XFILLER_0_116_165 VPWR VGND VPWR VGND sky130_ef_sc_hd__decap_12
XFILLER_0_105_839 VGND VGND VPWR VPWR sky130_fd_sc_hd__fill_1
XFILLER_0_14_141 VPWR VGND VPWR VGND sky130_ef_sc_hd__decap_12
XFILLER_0_6_363 VGND VGND VPWR VPWR sky130_fd_sc_hd__fill_1
XFILLER_0_15_653 VPWR VGND VPWR VGND sky130_ef_sc_hd__decap_12
XFILLER_0_132_669 VPWR VGND VPWR VGND sky130_ef_sc_hd__decap_12
X_3769_ _0864_ _1696_ _1698_ _0876_ VGND VGND VPWR VPWR _1699_ sky130_fd_sc_hd__o22a_1
X_5508_ clknet_leaf_21_clk _0428_ VGND VGND VPWR VPWR cpu_inst.regfile_inst.registers\[8\]\[12\]
+ sky130_fd_sc_hd__dfxtp_1
XFILLER_0_15_697 VPWR VGND VPWR VGND sky130_ef_sc_hd__decap_12
XFILLER_0_30_645 VPWR VGND VPWR VGND sky130_ef_sc_hd__decap_12
XFILLER_0_100_533 VGND VGND VPWR VPWR sky130_fd_sc_hd__fill_1
XFILLER_0_30_689 VGND VGND VPWR VPWR sky130_fd_sc_hd__decap_8
X_5439_ clknet_leaf_33_clk _0359_ VGND VGND VPWR VPWR cpu_inst.regfile_inst.registers\[0\]\[7\]
+ sky130_fd_sc_hd__dfxtp_1
XTAP_TAPCELL_ROW_89_1638 VGND VPWR sky130_fd_sc_hd__tapvpwrvgnd_1
XFILLER_0_96_133 VGND VGND VPWR VPWR sky130_fd_sc_hd__decap_6
XFILLER_0_96_177 VPWR VGND VPWR VGND sky130_ef_sc_hd__decap_12
XTAP_TAPCELL_ROW_100_1805 VGND VPWR sky130_fd_sc_hd__tapvpwrvgnd_1
XFILLER_0_135_441 VGND VGND VPWR VPWR sky130_fd_sc_hd__decap_6
XFILLER_0_25_417 VPWR VGND VPWR VGND sky130_ef_sc_hd__decap_12
XFILLER_0_135_485 VPWR VGND VPWR VGND sky130_ef_sc_hd__decap_12
XFILLER_0_108_699 VGND VGND VPWR VPWR sky130_fd_sc_hd__fill_1
XFILLER_0_80_567 VGND VGND VPWR VPWR sky130_fd_sc_hd__fill_2
XFILLER_0_111_809 VPWR VGND VPWR VGND sky130_ef_sc_hd__decap_12
XFILLER_0_0_517 VPWR VGND VPWR VGND sky130_ef_sc_hd__decap_12
XFILLER_0_20_133 VGND VGND VPWR VPWR sky130_fd_sc_hd__decap_6
XFILLER_0_103_393 VPWR VGND VPWR VGND sky130_ef_sc_hd__decap_12
XFILLER_0_57_27 VPWR VGND VPWR VGND sky130_ef_sc_hd__decap_12
XFILLER_0_20_177 VPWR VGND VPWR VGND sky130_ef_sc_hd__decap_12
XTAP_TAPCELL_ROW_111_1967 VGND VPWR sky130_fd_sc_hd__tapvpwrvgnd_1
XTAP_TAPCELL_ROW_53_1096 VGND VPWR sky130_fd_sc_hd__tapvpwrvgnd_1
XFILLER_0_73_15 VPWR VGND VPWR VGND sky130_ef_sc_hd__decap_12
XFILLER_0_88_645 VGND VGND VPWR VPWR sky130_fd_sc_hd__decap_3
XFILLER_0_87_111 VGND VGND VPWR VPWR sky130_fd_sc_hd__fill_1
X_4810_ cpu_inst.regfile_inst.registers\[0\]\[23\] VGND VGND VPWR VPWR _2390_ sky130_fd_sc_hd__clkbuf_1
XFILLER_0_75_317 VPWR VGND VPWR VGND sky130_ef_sc_hd__decap_12
XFILLER_0_132_3 VPWR VGND VPWR VGND sky130_ef_sc_hd__decap_12
XFILLER_0_118_419 VGND VGND VPWR VPWR sky130_fd_sc_hd__fill_1
XFILLER_0_7_105 VGND VGND VPWR VPWR sky130_fd_sc_hd__decap_6
XFILLER_0_28_233 VPWR VGND VPWR VGND sky130_ef_sc_hd__decap_12
XFILLER_0_90_309 VPWR VGND VPWR VGND sky130_ef_sc_hd__decap_12
XFILLER_0_83_361 VPWR VGND VPWR VGND sky130_ef_sc_hd__decap_12
X_4741_ cpu_inst.decoder_inst.current_pc\[25\] cpu_inst.decoder_inst.current_pc\[24\]
+ _2345_ VGND VGND VPWR VPWR _2351_ sky130_fd_sc_hd__and3_1
XFILLER_0_22_41 VPWR VGND VPWR VGND sky130_ef_sc_hd__decap_12
XFILLER_0_44_704 VGND VGND VPWR VPWR sky130_fd_sc_hd__fill_2
XFILLER_0_44_715 VGND VGND VPWR VPWR sky130_fd_sc_hd__fill_2
XFILLER_0_71_523 VGND VGND VPWR VPWR sky130_fd_sc_hd__fill_1
X_4672_ _2297_ _2298_ _2301_ _2293_ VGND VGND VPWR VPWR _0325_ sky130_fd_sc_hd__a2bb2o_1
XFILLER_0_7_149 VPWR VGND VPWR VGND sky130_ef_sc_hd__decap_12
XFILLER_0_22_85 VPWR VGND VPWR VGND sky130_ef_sc_hd__decap_12
XFILLER_0_28_277 VPWR VGND VPWR VGND sky130_ef_sc_hd__decap_12
XFILLER_0_43_225 VPWR VGND VPWR VGND sky130_ef_sc_hd__decap_12
XFILLER_0_114_625 VPWR VGND VPWR VGND sky130_ef_sc_hd__decap_12
XFILLER_0_113_113 VPWR VGND VPWR VGND sky130_ef_sc_hd__decap_12
X_3623_ _0850_ VGND VGND VPWR VPWR _1557_ sky130_fd_sc_hd__buf_2
XFILLER_0_114_669 VPWR VGND VPWR VGND sky130_ef_sc_hd__decap_12
XFILLER_0_12_601 VPWR VGND VPWR VGND sky130_ef_sc_hd__decap_12
X_3554_ _1413_ _1489_ _1255_ VGND VGND VPWR VPWR _1490_ sky130_fd_sc_hd__mux2_1
XFILLER_0_12_645 VPWR VGND VPWR VGND sky130_ef_sc_hd__decap_12
XFILLER_0_11_111 VGND VGND VPWR VPWR sky130_fd_sc_hd__fill_1
X_3485_ cpu_inst.regfile_inst.registers\[5\]\[18\] cpu_inst.regfile_inst.registers\[4\]\[18\]
+ _1386_ VGND VGND VPWR VPWR _1422_ sky130_fd_sc_hd__mux2_1
X_5224_ clknet_leaf_23_clk _0144_ VGND VGND VPWR VPWR cpu_inst.regfile_inst.registers\[24\]\[16\]
+ sky130_fd_sc_hd__dfxtp_1
X_5155_ clknet_leaf_24_clk _0075_ VGND VGND VPWR VPWR cpu_inst.regfile_inst.registers\[25\]\[11\]
+ sky130_fd_sc_hd__dfxtp_1
XFILLER_0_37_3 VPWR VGND VPWR VGND sky130_ef_sc_hd__decap_12
X_4106_ _1325_ cpu_inst.regfile_inst.registers\[25\]\[5\] _1991_ VGND VGND VPWR VPWR
+ _1992_ sky130_fd_sc_hd__mux2_1
X_5086_ clknet_leaf_33_clk _0006_ VGND VGND VPWR VPWR cpu_inst.regfile_inst.registers\[6\]\[6\]
+ sky130_fd_sc_hd__dfxtp_1
XFILLER_0_47_93 VPWR VGND VPWR VGND sky130_ef_sc_hd__decap_12
X_4037_ _1954_ VGND VGND VPWR VPWR _0037_ sky130_fd_sc_hd__clkbuf_1
XFILLER_0_78_133 VGND VGND VPWR VPWR sky130_fd_sc_hd__decap_6
XTAP_TAPCELL_ROW_84_1557 VGND VPWR sky130_fd_sc_hd__tapvpwrvgnd_1
XFILLER_0_78_177 VPWR VGND VPWR VGND sky130_ef_sc_hd__decap_12
XFILLER_0_63_81 VPWR VGND VPWR VGND sky130_ef_sc_hd__decap_12
XFILLER_0_93_125 VPWR VGND VPWR VGND sky130_ef_sc_hd__decap_12
XFILLER_0_59_380 VGND VGND VPWR VPWR sky130_fd_sc_hd__fill_1
X_4939_ _1574_ cpu_inst.regfile_inst.registers\[8\]\[21\] _2449_ VGND VGND VPWR VPWR
+ _2457_ sky130_fd_sc_hd__mux2_1
XFILLER_0_93_169 VPWR VGND VPWR VGND sky130_ef_sc_hd__decap_12
XFILLER_0_117_441 VGND VGND VPWR VPWR sky130_fd_sc_hd__decap_6
XFILLER_0_117_485 VPWR VGND VPWR VGND sky130_ef_sc_hd__decap_12
XFILLER_0_132_433 VPWR VGND VPWR VGND sky130_ef_sc_hd__decap_12
XTAP_TAPCELL_ROW_115_2023 VGND VPWR sky130_fd_sc_hd__tapvpwrvgnd_1
XFILLER_0_62_589 VPWR VGND VPWR VGND sky130_ef_sc_hd__decap_12
XFILLER_0_15_461 VPWR VGND VPWR VGND sky130_ef_sc_hd__decap_12
XFILLER_0_132_477 VPWR VGND VPWR VGND sky130_ef_sc_hd__decap_12
XFILLER_0_30_475 VGND VGND VPWR VPWR sky130_fd_sc_hd__fill_1
XFILLER_0_100_363 VGND VGND VPWR VPWR sky130_fd_sc_hd__fill_1
XTAP_TAPCELL_ROW_7_398 VGND VPWR sky130_fd_sc_hd__tapvpwrvgnd_1
XFILLER_0_69_111 VGND VGND VPWR VPWR sky130_fd_sc_hd__fill_1
XTAP_TAPCELL_ROW_126_2196 VGND VPWR sky130_fd_sc_hd__tapvpwrvgnd_1
XTAP_TAPCELL_ROW_126_2185 VGND VPWR sky130_fd_sc_hd__tapvpwrvgnd_1
XFILLER_0_127_205 VPWR VGND VPWR VGND sky130_ef_sc_hd__decap_12
XFILLER_0_72_309 VPWR VGND VPWR VGND sky130_ef_sc_hd__decap_12
XTAP_TAPCELL_ROW_26_684 VGND VPWR sky130_fd_sc_hd__tapvpwrvgnd_1
XTAP_TAPCELL_ROW_26_695 VGND VPWR sky130_fd_sc_hd__tapvpwrvgnd_1
XFILLER_0_38_542 VGND VGND VPWR VPWR sky130_fd_sc_hd__fill_2
XFILLER_0_127_249 VPWR VGND VPWR VGND sky130_ef_sc_hd__decap_12
XFILLER_0_65_361 VGND VGND VPWR VPWR sky130_fd_sc_hd__decap_4
XFILLER_0_53_523 VGND VGND VPWR VPWR sky130_fd_sc_hd__fill_2
XFILLER_0_5_609 VGND VGND VPWR VPWR sky130_fd_sc_hd__decap_6
XFILLER_0_25_225 VPWR VGND VPWR VGND sky130_ef_sc_hd__decap_12
XFILLER_0_26_737 VPWR VGND VPWR VGND sky130_ef_sc_hd__decap_12
XFILLER_0_53_556 VGND VGND VPWR VPWR sky130_fd_sc_hd__fill_1
XFILLER_0_135_293 VPWR VGND VPWR VGND sky130_ef_sc_hd__decap_12
XFILLER_0_34_781 VGND VGND VPWR VPWR sky130_fd_sc_hd__decap_8
XFILLER_0_111_617 VPWR VGND VPWR VGND sky130_ef_sc_hd__decap_12
XFILLER_0_68_15 VPWR VGND VPWR VGND sky130_ef_sc_hd__decap_12
XTAP_TAPCELL_ROW_55_1125 VGND VPWR sky130_fd_sc_hd__tapvpwrvgnd_1
X_3270_ cpu_inst.regfile_inst.registers\[24\]\[15\] _0697_ VGND VGND VPWR VPWR _1235_
+ sky130_fd_sc_hd__or2_1
XFILLER_0_21_497 VGND VGND VPWR VPWR sky130_fd_sc_hd__decap_6
XFILLER_0_108_65 VPWR VGND VPWR VGND sky130_ef_sc_hd__decap_12
XFILLER_0_124_53 VPWR VGND VPWR VGND sky130_ef_sc_hd__decap_12
XFILLER_0_75_125 VPWR VGND VPWR VGND sky130_ef_sc_hd__decap_12
XTAP_TAPCELL_ROW_66_1287 VGND VPWR sky130_fd_sc_hd__tapvpwrvgnd_1
XFILLER_0_33_51 VGND VGND VPWR VPWR sky130_fd_sc_hd__decap_4
XTAP_TAPCELL_ROW_45_971 VGND VPWR sky130_fd_sc_hd__tapvpwrvgnd_1
XTAP_TAPCELL_ROW_45_982 VGND VPWR sky130_fd_sc_hd__tapvpwrvgnd_1
XFILLER_0_124_97 VPWR VGND VPWR VGND sky130_ef_sc_hd__decap_12
XFILLER_0_91_629 VGND VGND VPWR VPWR sky130_fd_sc_hd__decap_3
XFILLER_0_75_169 VPWR VGND VPWR VGND sky130_ef_sc_hd__decap_12
XFILLER_0_90_139 VGND VGND VPWR VPWR sky130_fd_sc_hd__fill_1
XFILLER_0_84_681 VGND VGND VPWR VPWR sky130_fd_sc_hd__fill_1
X_4724_ cpu_inst.decoder_inst.current_pc\[19\] _2334_ cpu_inst.decoder_inst.current_pc\[20\]
+ VGND VGND VPWR VPWR _2339_ sky130_fd_sc_hd__a21o_1
X_2985_ _0920_ _0934_ _0936_ _0949_ VGND VGND VPWR VPWR _0950_ sky130_fd_sc_hd__a211o_4
XFILLER_0_8_469 VGND VGND VPWR VPWR sky130_fd_sc_hd__decap_6
XFILLER_0_127_783 VGND VGND VPWR VPWR sky130_fd_sc_hd__fill_1
XFILLER_0_44_556 VGND VGND VPWR VPWR sky130_fd_sc_hd__decap_4
XFILLER_0_114_433 VPWR VGND VPWR VGND sky130_ef_sc_hd__decap_12
X_4655_ _2287_ VGND VGND VPWR VPWR _0322_ sky130_fd_sc_hd__clkbuf_1
XFILLER_0_31_217 VGND VGND VPWR VPWR sky130_fd_sc_hd__decap_6
XFILLER_0_44_589 VGND VGND VPWR VPWR sky130_fd_sc_hd__fill_2
XFILLER_0_114_477 VPWR VGND VPWR VGND sky130_ef_sc_hd__decap_12
X_3606_ _1386_ VGND VGND VPWR VPWR _1540_ sky130_fd_sc_hd__clkbuf_4
X_4586_ _2229_ VGND VGND VPWR VPWR _2241_ sky130_fd_sc_hd__buf_2
XFILLER_0_101_105 VGND VGND VPWR VPWR sky130_fd_sc_hd__decap_6
X_3537_ cpu_inst.regfile_inst.registers\[1\]\[19\] _0848_ _0849_ cpu_inst.regfile_inst.registers\[5\]\[19\]
+ _0562_ VGND VGND VPWR VPWR _1473_ sky130_fd_sc_hd__o221a_1
XFILLER_0_101_149 VPWR VGND VPWR VGND sky130_ef_sc_hd__decap_12
XFILLER_0_12_475 VGND VGND VPWR VPWR sky130_fd_sc_hd__fill_1
X_3468_ _1394_ _1405_ VGND VGND VPWR VPWR _1406_ sky130_fd_sc_hd__xnor2_2
X_5207_ clknet_leaf_11_clk _0127_ VGND VGND VPWR VPWR cpu_inst.regfile_inst.registers\[4\]\[31\]
+ sky130_fd_sc_hd__dfxtp_1
X_3399_ _1341_ VGND VGND VPWR VPWR _0012_ sky130_fd_sc_hd__clkbuf_1
X_5138_ clknet_leaf_8_clk _0058_ VGND VGND VPWR VPWR cpu_inst.regfile_inst.registers\[2\]\[26\]
+ sky130_fd_sc_hd__dfxtp_1
XFILLER_0_99_729 VGND VGND VPWR VPWR sky130_fd_sc_hd__decap_6
XTAP_TAPCELL_ROW_4_357 VGND VPWR sky130_fd_sc_hd__tapvpwrvgnd_1
X_5069_ _2528_ VGND VGND VPWR VPWR _2529_ sky130_fd_sc_hd__inv_2
XFILLER_0_67_626 VGND VGND VPWR VPWR sky130_fd_sc_hd__decap_8
XFILLER_0_39_317 VPWR VGND VPWR VGND sky130_ef_sc_hd__decap_12
XFILLER_0_137_503 VGND VGND VPWR VPWR sky130_fd_sc_hd__fill_1
XFILLER_0_79_497 VGND VGND VPWR VPWR sky130_fd_sc_hd__fill_1
XFILLER_0_109_205 VPWR VGND VPWR VGND sky130_ef_sc_hd__decap_12
XFILLER_0_54_309 VGND VGND VPWR VPWR sky130_fd_sc_hd__fill_1
XFILLER_0_125_709 VPWR VGND VPWR VGND sky130_ef_sc_hd__decap_12
XFILLER_0_109_249 VPWR VGND VPWR VGND sky130_ef_sc_hd__decap_12
XFILLER_0_63_821 VGND VGND VPWR VPWR sky130_fd_sc_hd__fill_1
XTAP_TAPCELL_ROW_23_643 VGND VPWR sky130_fd_sc_hd__tapvpwrvgnd_1
XFILLER_0_47_361 VPWR VGND VPWR VGND sky130_ef_sc_hd__decap_12
XFILLER_0_133_753 VPWR VGND VPWR VGND sky130_ef_sc_hd__decap_12
XFILLER_0_117_293 VPWR VGND VPWR VGND sky130_ef_sc_hd__decap_12
XTAP_TAPCELL_ROW_97_1748 VGND VPWR sky130_fd_sc_hd__tapvpwrvgnd_1
XFILLER_0_90_684 VGND VGND VPWR VPWR sky130_fd_sc_hd__decap_8
XFILLER_0_23_729 VPWR VGND VPWR VGND sky130_ef_sc_hd__decap_12
XTAP_TAPCELL_ROW_97_1759 VGND VPWR sky130_fd_sc_hd__tapvpwrvgnd_1
XFILLER_0_16_781 VPWR VGND VPWR VGND sky130_ef_sc_hd__decap_12
XFILLER_0_133_797 VPWR VGND VPWR VGND sky130_ef_sc_hd__decap_12
XFILLER_0_120_469 VGND VGND VPWR VPWR sky130_fd_sc_hd__decap_6
XFILLER_0_38_29 VPWR VGND VPWR VGND sky130_ef_sc_hd__decap_12
XTAP_TAPCELL_ROW_128_2225 VGND VPWR sky130_fd_sc_hd__tapvpwrvgnd_1
XTAP_TAPCELL_ROW_128_2214 VGND VPWR sky130_fd_sc_hd__tapvpwrvgnd_1
XTAP_TAPCELL_ROW_50_1044 VGND VPWR sky130_fd_sc_hd__tapvpwrvgnd_1
XTAP_TAPCELL_ROW_50_1055 VGND VPWR sky130_fd_sc_hd__tapvpwrvgnd_1
XFILLER_0_89_217 VGND VGND VPWR VPWR sky130_fd_sc_hd__decap_6
XFILLER_0_98_795 VPWR VGND VPWR VGND sky130_ef_sc_hd__decap_12
XFILLER_0_97_261 VPWR VGND VPWR VGND sky130_ef_sc_hd__decap_12
XTAP_TAPCELL_ROW_106_1888 VGND VPWR sky130_fd_sc_hd__tapvpwrvgnd_1
XFILLER_0_57_125 VPWR VGND VPWR VGND sky130_ef_sc_hd__decap_12
XFILLER_0_128_525 VGND VGND VPWR VPWR sky130_fd_sc_hd__decap_6
XFILLER_0_70_27 VGND VGND VPWR VPWR sky130_fd_sc_hd__fill_1
XFILLER_0_57_169 VPWR VGND VPWR VGND sky130_ef_sc_hd__decap_12
XTAP_TAPCELL_ROW_42_930 VGND VPWR sky130_fd_sc_hd__tapvpwrvgnd_1
XFILLER_0_128_569 VPWR VGND VPWR VGND sky130_ef_sc_hd__decap_12
XFILLER_0_26_501 VGND VGND VPWR VPWR sky130_fd_sc_hd__decap_6
XFILLER_0_109_783 VGND VGND VPWR VPWR sky130_fd_sc_hd__fill_1
X_2770_ _0701_ VGND VGND VPWR VPWR _0735_ sky130_fd_sc_hd__clkbuf_4
XFILLER_0_72_139 VGND VGND VPWR VPWR sky130_fd_sc_hd__fill_1
XFILLER_0_5_417 VPWR VGND VPWR VGND sky130_ef_sc_hd__decap_12
XPHY_EDGE_ROW_130_Left_269 VGND VGND VPWR VPWR sky130_fd_sc_hd__decap_3
XFILLER_0_79_69 VPWR VGND VPWR VGND sky130_ef_sc_hd__decap_12
XFILLER_0_13_217 VGND VGND VPWR VPWR sky130_fd_sc_hd__decap_6
X_4440_ _2166_ VGND VGND VPWR VPWR _0228_ sky130_fd_sc_hd__clkbuf_1
XFILLER_0_110_77 VGND VGND VPWR VPWR sky130_fd_sc_hd__decap_6
XFILLER_0_111_447 VGND VGND VPWR VPWR sky130_fd_sc_hd__fill_1
XFILLER_0_21_261 VPWR VGND VPWR VGND sky130_ef_sc_hd__decap_12
X_4371_ cpu_inst.regfile_inst.registers\[1\]\[3\] VGND VGND VPWR VPWR _2131_ sky130_fd_sc_hd__clkbuf_1
XFILLER_0_95_57 VPWR VGND VPWR VGND sky130_ef_sc_hd__decap_12
X_3322_ _1199_ _1267_ _1278_ VGND VGND VPWR VPWR _1281_ sky130_fd_sc_hd__o21ai_1
X_3253_ _1018_ _1217_ VGND VGND VPWR VPWR _1218_ sky130_fd_sc_hd__or2_1
X_3184_ _1056_ _0985_ _1060_ VGND VGND VPWR VPWR _1149_ sky130_fd_sc_hd__mux2_1
XTAP_TAPCELL_ROW_1_316 VGND VPWR sky130_fd_sc_hd__tapvpwrvgnd_1
XTAP_TAPCELL_ROW_68_1327 VGND VPWR sky130_fd_sc_hd__tapvpwrvgnd_1
XTAP_TAPCELL_ROW_68_1316 VGND VPWR sky130_fd_sc_hd__tapvpwrvgnd_1
XFILLER_0_89_762 VGND VGND VPWR VPWR sky130_fd_sc_hd__decap_3
XFILLER_0_49_615 VGND VGND VPWR VPWR sky130_fd_sc_hd__fill_1
XFILLER_0_119_503 VGND VGND VPWR VPWR sky130_fd_sc_hd__fill_1
XTAP_TAPCELL_ROW_81_1516 VGND VPWR sky130_fd_sc_hd__tapvpwrvgnd_1
XFILLER_0_44_83 VGND VGND VPWR VPWR sky130_fd_sc_hd__fill_1
XFILLER_0_36_309 VPWR VGND VPWR VGND sky130_ef_sc_hd__decap_12
XFILLER_0_107_709 VPWR VGND VPWR VGND sky130_ef_sc_hd__decap_12
XFILLER_0_64_629 VPWR VGND VPWR VGND sky130_ef_sc_hd__decap_12
XFILLER_0_8_233 VPWR VGND VPWR VGND sky130_ef_sc_hd__decap_12
XFILLER_0_29_361 VPWR VGND VPWR VGND sky130_ef_sc_hd__decap_12
X_2968_ _0930_ _0931_ _0932_ VGND VGND VPWR VPWR _0933_ sky130_fd_sc_hd__mux2_1
XFILLER_0_8_277 VPWR VGND VPWR VGND sky130_ef_sc_hd__decap_12
XTAP_TAPCELL_ROW_20_602 VGND VPWR sky130_fd_sc_hd__tapvpwrvgnd_1
X_4707_ _2326_ _0685_ _2284_ VGND VGND VPWR VPWR _2327_ sky130_fd_sc_hd__or3b_1
XFILLER_0_71_161 VGND VGND VPWR VPWR sky130_fd_sc_hd__decap_6
XFILLER_0_130_701 VPWR VGND VPWR VGND sky130_ef_sc_hd__decap_12
XFILLER_0_115_753 VPWR VGND VPWR VGND sky130_ef_sc_hd__decap_12
X_2899_ _0863_ VGND VGND VPWR VPWR _0864_ sky130_fd_sc_hd__clkbuf_4
X_4638_ net4 _2270_ _2271_ VGND VGND VPWR VPWR _0321_ sky130_fd_sc_hd__o21ai_1
XFILLER_0_115_797 VPWR VGND VPWR VGND sky130_ef_sc_hd__decap_12
XFILLER_0_102_425 VGND VGND VPWR VPWR sky130_fd_sc_hd__fill_1
XTAP_TAPCELL_ROW_79_1489 VGND VPWR sky130_fd_sc_hd__tapvpwrvgnd_1
XTAP_TAPCELL_ROW_79_1478 VGND VPWR sky130_fd_sc_hd__tapvpwrvgnd_1
XFILLER_0_8_83 VGND VGND VPWR VPWR sky130_fd_sc_hd__fill_1
XFILLER_0_32_559 VGND VGND VPWR VPWR sky130_fd_sc_hd__decap_4
XTAP_TAPCELL_ROW_9_438 VGND VPWR sky130_fd_sc_hd__tapvpwrvgnd_1
X_4569_ _0575_ _2021_ _1990_ cpu_inst.regfile_inst.registers\[10\]\[3\] VGND VGND
+ VPWR VPWR _0291_ sky130_fd_sc_hd__a31o_1
XTAP_TAPCELL_ROW_92_1678 VGND VPWR sky130_fd_sc_hd__tapvpwrvgnd_1
XFILLER_0_99_548 VGND VGND VPWR VPWR sky130_fd_sc_hd__fill_2
XTAP_TAPCELL_ROW_28_713 VGND VPWR sky130_fd_sc_hd__tapvpwrvgnd_1
XTAP_TAPCELL_ROW_28_724 VGND VPWR sky130_fd_sc_hd__tapvpwrvgnd_1
XTAP_TAPCELL_ROW_123_2144 VGND VPWR sky130_fd_sc_hd__tapvpwrvgnd_1
XFILLER_0_86_209 VPWR VGND VPWR VGND sky130_ef_sc_hd__decap_12
XFILLER_0_79_261 VPWR VGND VPWR VGND sky130_ef_sc_hd__decap_12
XFILLER_0_67_423 VGND VGND VPWR VPWR sky130_fd_sc_hd__decap_8
XFILLER_0_39_125 VPWR VGND VPWR VGND sky130_ef_sc_hd__decap_12
XFILLER_0_94_253 VPWR VGND VPWR VGND sky130_ef_sc_hd__decap_12
XFILLER_0_55_629 VGND VGND VPWR VPWR sky130_fd_sc_hd__fill_1
XFILLER_0_36_810 VGND VGND VPWR VPWR sky130_fd_sc_hd__fill_2
XFILLER_0_39_169 VPWR VGND VPWR VGND sky130_ef_sc_hd__decap_12
XFILLER_0_125_517 VPWR VGND VPWR VGND sky130_ef_sc_hd__decap_12
XFILLER_0_82_448 VGND VGND VPWR VPWR sky130_fd_sc_hd__fill_1
XFILLER_0_54_139 VGND VGND VPWR VPWR sky130_fd_sc_hd__fill_1
XFILLER_0_63_651 VGND VGND VPWR VPWR sky130_fd_sc_hd__decap_4
XFILLER_0_50_301 VGND VGND VPWR VPWR sky130_fd_sc_hd__decap_6
XFILLER_0_133_561 VPWR VGND VPWR VGND sky130_ef_sc_hd__decap_12
XFILLER_0_23_559 VGND VGND VPWR VPWR sky130_fd_sc_hd__fill_1
XFILLER_0_50_345 VPWR VGND VPWR VGND sky130_ef_sc_hd__decap_12
XFILLER_0_120_233 VPWR VGND VPWR VGND sky130_ef_sc_hd__decap_12
XFILLER_0_10_209 VPWR VGND VPWR VGND sky130_ef_sc_hd__decap_12
XFILLER_0_49_39 VPWR VGND VPWR VGND sky130_ef_sc_hd__decap_12
XFILLER_0_120_277 VPWR VGND VPWR VGND sky130_ef_sc_hd__decap_12
XFILLER_0_65_27 VPWR VGND VPWR VGND sky130_ef_sc_hd__decap_12
XTAP_TAPCELL_ROW_108_1917 VGND VPWR sky130_fd_sc_hd__tapvpwrvgnd_1
XFILLER_0_81_15 VPWR VGND VPWR VGND sky130_ef_sc_hd__decap_12
X_3940_ _1448_ _1703_ _1865_ _1208_ VGND VGND VPWR VPWR _1866_ sky130_fd_sc_hd__a211o_1
XFILLER_0_105_55 VGND VGND VPWR VPWR sky130_fd_sc_hd__fill_1
XFILLER_0_14_53 VPWR VGND VPWR VGND sky130_ef_sc_hd__decap_12
XFILLER_0_128_333 VPWR VGND VPWR VGND sky130_ef_sc_hd__decap_12
X_3871_ cpu_inst.regfile_inst.registers\[9\]\[28\] cpu_inst.regfile_inst.registers\[8\]\[28\]
+ _1797_ VGND VGND VPWR VPWR _1798_ sky130_fd_sc_hd__mux2_1
XTAP_TAPCELL_ROW_63_1246 VGND VPWR sky130_fd_sc_hd__tapvpwrvgnd_1
XFILLER_0_18_309 VPWR VGND VPWR VGND sky130_ef_sc_hd__decap_12
XFILLER_0_27_810 VGND VGND VPWR VPWR sky130_fd_sc_hd__decap_4
XFILLER_0_46_618 VGND VGND VPWR VPWR sky130_fd_sc_hd__fill_1
XFILLER_0_128_377 VPWR VGND VPWR VGND sky130_ef_sc_hd__decap_12
XFILLER_0_14_97 VPWR VGND VPWR VGND sky130_ef_sc_hd__decap_12
X_2822_ cpu_inst.regfile_inst.registers\[8\]\[7\] _0786_ _0598_ VGND VGND VPWR VPWR
+ _0787_ sky130_fd_sc_hd__mux2_1
X_5541_ clknet_leaf_22_clk _0461_ VGND VGND VPWR VPWR cpu_inst.regfile_inst.registers\[15\]\[13\]
+ sky130_fd_sc_hd__dfxtp_1
XFILLER_0_60_109 VPWR VGND VPWR VGND sky130_ef_sc_hd__decap_12
X_2753_ cpu_inst.regfile_inst.registers\[24\]\[10\] _0698_ _0699_ _0717_ VGND VGND
+ VPWR VPWR _0718_ sky130_fd_sc_hd__o211a_1
XFILLER_0_6_737 VPWR VGND VPWR VGND sky130_ef_sc_hd__decap_12
XFILLER_0_5_225 VPWR VGND VPWR VGND sky130_ef_sc_hd__decap_12
XFILLER_0_30_41 VPWR VGND VPWR VGND sky130_ef_sc_hd__decap_12
XFILLER_0_112_701 VPWR VGND VPWR VGND sky130_ef_sc_hd__decap_12
XFILLER_0_54_684 VPWR VGND VPWR VGND sky130_ef_sc_hd__decap_12
XFILLER_0_53_161 VGND VGND VPWR VPWR sky130_fd_sc_hd__decap_6
XFILLER_0_30_85 VPWR VGND VPWR VGND sky130_ef_sc_hd__decap_12
X_2684_ cpu_inst.regfile_inst.registers\[5\]\[1\] cpu_inst.regfile_inst.registers\[4\]\[1\]
+ _0648_ VGND VGND VPWR VPWR _0649_ sky130_fd_sc_hd__mux2_1
X_5472_ clknet_leaf_35_clk _0392_ VGND VGND VPWR VPWR cpu_inst.regfile_inst.registers\[9\]\[8\]
+ sky130_fd_sc_hd__dfxtp_1
X_4423_ cpu_inst.regfile_inst.registers\[1\]\[29\] VGND VGND VPWR VPWR _2157_ sky130_fd_sc_hd__clkbuf_1
XFILLER_0_22_581 VGND VGND VPWR VPWR sky130_fd_sc_hd__decap_6
X_4354_ _2122_ VGND VGND VPWR VPWR _0186_ sky130_fd_sc_hd__clkbuf_1
X_3305_ _1102_ _1199_ VGND VGND VPWR VPWR _1269_ sky130_fd_sc_hd__and2_1
XFILLER_0_1_497 VGND VGND VPWR VPWR sky130_fd_sc_hd__decap_6
X_4285_ cpu_inst.regfile_inst.registers\[24\]\[27\] VGND VGND VPWR VPWR _2085_ sky130_fd_sc_hd__clkbuf_1
X_3236_ _0902_ _0917_ VGND VGND VPWR VPWR _1201_ sky130_fd_sc_hd__xnor2_1
X_3167_ cpu_inst.regfile_inst.registers\[25\]\[14\] _1022_ _0921_ _1131_ VGND VGND
+ VPWR VPWR _1132_ sky130_fd_sc_hd__o211ai_2
XFILLER_0_96_507 VGND VGND VPWR VPWR sky130_fd_sc_hd__decap_4
X_3098_ _1058_ _1061_ _1062_ VGND VGND VPWR VPWR _1063_ sky130_fd_sc_hd__mux2_1
XFILLER_0_68_209 VPWR VGND VPWR VGND sky130_ef_sc_hd__decap_12
XFILLER_0_55_93 VPWR VGND VPWR VGND sky130_ef_sc_hd__decap_12
XFILLER_0_49_401 VGND VGND VPWR VPWR sky130_fd_sc_hd__decap_3
XFILLER_0_76_253 VPWR VGND VPWR VGND sky130_ef_sc_hd__decap_12
XFILLER_0_49_445 VGND VGND VPWR VPWR sky130_fd_sc_hd__decap_3
XFILLER_0_71_81 VPWR VGND VPWR VGND sky130_ef_sc_hd__decap_12
XFILLER_0_64_415 VGND VGND VPWR VPWR sky130_fd_sc_hd__fill_2
XFILLER_0_9_553 VGND VGND VPWR VPWR sky130_fd_sc_hd__decap_6
XFILLER_0_92_768 VGND VGND VPWR VPWR sky130_fd_sc_hd__fill_1
XFILLER_0_91_223 VGND VGND VPWR VPWR sky130_fd_sc_hd__fill_1
XFILLER_0_36_139 VGND VGND VPWR VPWR sky130_fd_sc_hd__fill_1
XFILLER_0_9_597 VPWR VGND VPWR VGND sky130_ef_sc_hd__decap_12
XTAP_TAPCELL_ROW_33_793 VGND VPWR sky130_fd_sc_hd__tapvpwrvgnd_1
XFILLER_0_45_651 VPWR VGND VPWR VGND sky130_ef_sc_hd__decap_12
XFILLER_0_115_561 VPWR VGND VPWR VGND sky130_ef_sc_hd__decap_12
XFILLER_0_32_301 VGND VGND VPWR VPWR sky130_fd_sc_hd__decap_6
XTAP_TAPCELL_ROW_94_1707 VGND VPWR sky130_fd_sc_hd__tapvpwrvgnd_1
XFILLER_0_60_643 VGND VGND VPWR VPWR sky130_fd_sc_hd__fill_1
XFILLER_0_32_345 VPWR VGND VPWR VGND sky130_ef_sc_hd__decap_12
XFILLER_0_130_531 VGND VGND VPWR VPWR sky130_fd_sc_hd__fill_1
XFILLER_0_102_233 VPWR VGND VPWR VGND sky130_ef_sc_hd__decap_12
XFILLER_0_32_389 VPWR VGND VPWR VGND sky130_ef_sc_hd__decap_12
XFILLER_0_102_277 VPWR VGND VPWR VGND sky130_ef_sc_hd__decap_12
XFILLER_0_68_710 VGND VGND VPWR VPWR sky130_fd_sc_hd__fill_1
XFILLER_0_68_754 VGND VGND VPWR VPWR sky130_fd_sc_hd__fill_2
XTAP_TAPCELL_ROW_103_1847 VGND VPWR sky130_fd_sc_hd__tapvpwrvgnd_1
XFILLER_0_83_724 VGND VGND VPWR VPWR sky130_fd_sc_hd__decap_4
XFILLER_0_126_837 VGND VGND VPWR VPWR sky130_fd_sc_hd__decap_4
XFILLER_0_82_245 VGND VGND VPWR VPWR sky130_fd_sc_hd__decap_6
XFILLER_0_138_697 VGND VGND VPWR VPWR sky130_fd_sc_hd__decap_3
XTAP_TAPCELL_ROW_136_2346 VGND VPWR sky130_fd_sc_hd__tapvpwrvgnd_1
XTAP_TAPCELL_ROW_136_2335 VGND VPWR sky130_fd_sc_hd__tapvpwrvgnd_1
XFILLER_0_24_813 VPWR VGND VPWR VGND sky130_ef_sc_hd__decap_12
XFILLER_0_42_109 VPWR VGND VPWR VGND sky130_ef_sc_hd__decap_12
Xclkload16 clknet_leaf_9_clk VGND VGND VPWR VPWR clkload16/Y sky130_fd_sc_hd__bufinv_16
XFILLER_0_82_289 VPWR VGND VPWR VGND sky130_ef_sc_hd__decap_12
XTAP_TAPCELL_ROW_11_465 VGND VPWR sky130_fd_sc_hd__tapvpwrvgnd_1
XFILLER_0_35_161 VGND VGND VPWR VPWR sky130_fd_sc_hd__decap_6
XFILLER_0_51_621 VGND VGND VPWR VPWR sky130_fd_sc_hd__fill_1
Xclkload38 clknet_leaf_19_clk VGND VGND VPWR VPWR clkload38/Y sky130_fd_sc_hd__clkinvlp_4
XFILLER_0_3_729 VPWR VGND VPWR VGND sky130_ef_sc_hd__decap_12
Xclkload27 clknet_leaf_33_clk VGND VGND VPWR VPWR clkload27/Y sky130_fd_sc_hd__clkinv_4
XFILLER_0_51_665 VGND VGND VPWR VPWR sky130_fd_sc_hd__fill_1
XFILLER_0_133_391 VGND VGND VPWR VPWR sky130_fd_sc_hd__fill_1
XFILLER_0_121_553 VGND VGND VPWR VPWR sky130_fd_sc_hd__decap_6
XFILLER_0_11_529 VPWR VGND VPWR VGND sky130_ef_sc_hd__decap_12
XFILLER_0_50_153 VPWR VGND VPWR VGND sky130_ef_sc_hd__decap_12
XFILLER_0_76_15 VPWR VGND VPWR VGND sky130_ef_sc_hd__decap_12
XFILLER_0_50_197 VPWR VGND VPWR VGND sky130_ef_sc_hd__decap_12
XFILLER_0_121_597 VPWR VGND VPWR VGND sky130_ef_sc_hd__decap_12
X_4070_ cpu_inst.regfile_inst.registers\[2\]\[22\] VGND VGND VPWR VPWR _1971_ sky130_fd_sc_hd__clkbuf_1
X_3021_ _0978_ _0985_ VGND VGND VPWR VPWR _0986_ sky130_fd_sc_hd__or2_1
XFILLER_0_116_65 VPWR VGND VPWR VGND sky130_ef_sc_hd__decap_12
XTAP_TAPCELL_ROW_19_587 VGND VPWR sky130_fd_sc_hd__tapvpwrvgnd_1
X_4972_ _2474_ VGND VGND VPWR VPWR _0452_ sky130_fd_sc_hd__clkbuf_1
XFILLER_0_129_653 VPWR VGND VPWR VGND sky130_ef_sc_hd__decap_12
X_3923_ cpu_inst.regfile_inst.registers\[0\]\[29\] _0615_ _1847_ _1560_ _1848_ VGND
+ VGND VPWR VPWR _1849_ sky130_fd_sc_hd__o221a_1
XFILLER_0_58_253 VPWR VGND VPWR VGND sky130_ef_sc_hd__decap_12
XFILLER_0_19_629 VPWR VGND VPWR VGND sky130_ef_sc_hd__decap_12
XFILLER_0_46_426 VGND VGND VPWR VPWR sky130_fd_sc_hd__decap_4
XFILLER_0_132_53 VPWR VGND VPWR VGND sky130_ef_sc_hd__decap_12
XFILLER_0_128_141 VPWR VGND VPWR VGND sky130_ef_sc_hd__decap_12
X_3854_ _1768_ _1781_ VGND VGND VPWR VPWR _1782_ sky130_fd_sc_hd__xor2_1
XFILLER_0_73_223 VGND VGND VPWR VPWR sky130_fd_sc_hd__fill_1
XFILLER_0_58_297 VGND VGND VPWR VPWR sky130_fd_sc_hd__decap_3
XFILLER_0_6_501 VPWR VGND VPWR VGND sky130_ef_sc_hd__decap_12
XFILLER_0_18_139 VGND VGND VPWR VPWR sky130_fd_sc_hd__fill_1
XFILLER_0_132_97 VPWR VGND VPWR VGND sky130_ef_sc_hd__decap_12
XFILLER_0_129_697 VPWR VGND VPWR VGND sky130_ef_sc_hd__decap_12
X_2805_ _0768_ _0757_ _0617_ _0769_ VGND VGND VPWR VPWR _0770_ sky130_fd_sc_hd__a31o_4
XFILLER_0_6_545 VPWR VGND VPWR VGND sky130_ef_sc_hd__decap_12
XFILLER_0_27_673 VPWR VGND VPWR VGND sky130_ef_sc_hd__decap_12
XFILLER_0_41_51 VGND VGND VPWR VPWR sky130_fd_sc_hd__decap_4
X_3785_ cpu_inst.regfile_inst.registers\[8\]\[25\] _1557_ VGND VGND VPWR VPWR _1715_
+ sky130_fd_sc_hd__or2_1
XFILLER_0_54_470 VGND VGND VPWR VPWR sky130_fd_sc_hd__fill_1
XFILLER_0_14_301 VGND VGND VPWR VPWR sky130_fd_sc_hd__decap_6
XTAP_TAPCELL_ROW_30_752 VGND VPWR sky130_fd_sc_hd__tapvpwrvgnd_1
XFILLER_0_131_317 VPWR VGND VPWR VGND sky130_ef_sc_hd__decap_12
X_5524_ clknet_leaf_10_clk _0444_ VGND VGND VPWR VPWR cpu_inst.regfile_inst.registers\[8\]\[28\]
+ sky130_fd_sc_hd__dfxtp_1
XFILLER_0_14_345 VPWR VGND VPWR VGND sky130_ef_sc_hd__decap_12
XFILLER_0_6_589 VPWR VGND VPWR VGND sky130_ef_sc_hd__decap_12
X_2736_ _0584_ VGND VGND VPWR VPWR _0701_ sky130_fd_sc_hd__clkbuf_4
XFILLER_0_112_531 VGND VGND VPWR VPWR sky130_fd_sc_hd__fill_1
X_5455_ clknet_leaf_15_clk _0375_ VGND VGND VPWR VPWR cpu_inst.regfile_inst.registers\[0\]\[23\]
+ sky130_fd_sc_hd__dfxtp_1
XTAP_TAPCELL_ROW_76_1437 VGND VPWR sky130_fd_sc_hd__tapvpwrvgnd_1
XFILLER_0_14_389 VPWR VGND VPWR VGND sky130_ef_sc_hd__decap_12
X_2667_ _0613_ _0628_ _0631_ VGND VGND VPWR VPWR _0632_ sky130_fd_sc_hd__a21o_1
X_4406_ _2148_ VGND VGND VPWR VPWR _0212_ sky130_fd_sc_hd__clkbuf_1
XFILLER_0_67_3 VPWR VGND VPWR VGND sky130_ef_sc_hd__decap_12
XFILLER_0_1_261 VPWR VGND VPWR VGND sky130_ef_sc_hd__decap_12
X_5386_ clknet_leaf_19_clk _0306_ VGND VGND VPWR VPWR cpu_inst.regfile_inst.registers\[10\]\[18\]
+ sky130_fd_sc_hd__dfxtp_1
X_2598_ cpu_inst.decoder_inst.current_pc\[5\] cpu_inst.decoder_inst.current_pc\[4\]
+ cpu_inst.decoder_inst.current_pc\[7\] VGND VGND VPWR VPWR _0563_ sky130_fd_sc_hd__or3_2
X_4337_ _2113_ VGND VGND VPWR VPWR _0178_ sky130_fd_sc_hd__clkbuf_1
XFILLER_0_5_51 VGND VGND VPWR VPWR sky130_fd_sc_hd__decap_4
X_4268_ _2076_ VGND VGND VPWR VPWR _0146_ sky130_fd_sc_hd__clkbuf_1
X_3219_ _0689_ _1183_ VGND VGND VPWR VPWR _1184_ sky130_fd_sc_hd__nand2_1
X_4199_ _2041_ VGND VGND VPWR VPWR _0112_ sky130_fd_sc_hd__clkbuf_1
XTAP_TAPCELL_ROW_120_2103 VGND VPWR sky130_fd_sc_hd__tapvpwrvgnd_1
XTAP_TAPCELL_ROW_38_863 VGND VPWR sky130_fd_sc_hd__tapvpwrvgnd_1
XTAP_TAPCELL_ROW_38_874 VGND VPWR sky130_fd_sc_hd__tapvpwrvgnd_1
XTAP_TAPCELL_ROW_87_1599 VGND VPWR sky130_fd_sc_hd__tapvpwrvgnd_1
XFILLER_0_9_361 VPWR VGND VPWR VGND sky130_ef_sc_hd__decap_12
XFILLER_0_37_437 VGND VGND VPWR VPWR sky130_fd_sc_hd__fill_2
XFILLER_0_108_837 VGND VGND VPWR VPWR sky130_fd_sc_hd__fill_2
XFILLER_0_92_587 VGND VGND VPWR VPWR sky130_fd_sc_hd__fill_1
XFILLER_0_64_245 VGND VGND VPWR VPWR sky130_fd_sc_hd__decap_6
XFILLER_0_24_109 VPWR VGND VPWR VGND sky130_ef_sc_hd__decap_12
XFILLER_0_134_133 VGND VGND VPWR VPWR sky130_fd_sc_hd__decap_6
XFILLER_0_64_289 VPWR VGND VPWR VGND sky130_ef_sc_hd__decap_12
XFILLER_0_17_161 VGND VGND VPWR VPWR sky130_fd_sc_hd__decap_6
XFILLER_0_134_177 VPWR VGND VPWR VGND sky130_ef_sc_hd__decap_12
XTAP_TAPCELL_ROW_118_2076 VGND VPWR sky130_fd_sc_hd__tapvpwrvgnd_1
XTAP_TAPCELL_ROW_118_2065 VGND VPWR sky130_fd_sc_hd__tapvpwrvgnd_1
XFILLER_0_115_391 VGND VGND VPWR VPWR sky130_fd_sc_hd__fill_1
XFILLER_0_60_473 VGND VGND VPWR VPWR sky130_fd_sc_hd__decap_3
XFILLER_0_32_153 VPWR VGND VPWR VGND sky130_ef_sc_hd__decap_12
XTAP_TAPCELL_ROW_131_2265 VGND VPWR sky130_fd_sc_hd__tapvpwrvgnd_1
XFILLER_0_32_197 VPWR VGND VPWR VGND sky130_ef_sc_hd__decap_12
XFILLER_0_46_29 VPWR VGND VPWR VGND sky130_ef_sc_hd__decap_12
XFILLER_0_87_337 VPWR VGND VPWR VGND sky130_ef_sc_hd__decap_12
XTAP_TAPCELL_ROW_47_1005 VGND VPWR sky130_fd_sc_hd__tapvpwrvgnd_1
XFILLER_0_68_551 VGND VGND VPWR VPWR sky130_fd_sc_hd__fill_1
XTAP_TAPCELL_ROW_16_535 VGND VPWR sky130_fd_sc_hd__tapvpwrvgnd_1
XTAP_TAPCELL_ROW_16_546 VGND VPWR sky130_fd_sc_hd__tapvpwrvgnd_1
XFILLER_0_138_461 VPWR VGND VPWR VGND sky130_ef_sc_hd__decap_12
XFILLER_0_126_601 VPWR VGND VPWR VGND sky130_ef_sc_hd__decap_12
XTAP_TAPCELL_ROW_60_1205 VGND VPWR sky130_fd_sc_hd__tapvpwrvgnd_1
XFILLER_0_56_757 VGND VGND VPWR VPWR sky130_fd_sc_hd__decap_4
XFILLER_0_55_223 VGND VGND VPWR VPWR sky130_fd_sc_hd__fill_1
XFILLER_0_126_645 VPWR VGND VPWR VGND sky130_ef_sc_hd__decap_12
XFILLER_0_125_111 VGND VGND VPWR VPWR sky130_fd_sc_hd__fill_1
XFILLER_0_83_576 VPWR VGND VPWR VGND sky130_ef_sc_hd__decap_12
XFILLER_0_83_554 VGND VGND VPWR VPWR sky130_fd_sc_hd__decap_6
XFILLER_0_24_610 VPWR VGND VPWR VGND sky130_ef_sc_hd__decap_12
XFILLER_0_113_317 VPWR VGND VPWR VGND sky130_ef_sc_hd__decap_12
X_3570_ _1448_ _1504_ VGND VGND VPWR VPWR _1505_ sky130_fd_sc_hd__or2_1
XFILLER_0_12_805 VGND VGND VPWR VPWR sky130_fd_sc_hd__decap_6
XFILLER_0_3_559 VGND VGND VPWR VPWR sky130_fd_sc_hd__fill_1
XFILLER_0_51_473 VPWR VGND VPWR VGND sky130_ef_sc_hd__decap_12
XFILLER_0_121_361 VPWR VGND VPWR VGND sky130_ef_sc_hd__decap_12
XTAP_TAPCELL_ROW_58_1167 VGND VPWR sky130_fd_sc_hd__tapvpwrvgnd_1
XFILLER_0_11_337 VPWR VGND VPWR VGND sky130_ef_sc_hd__decap_12
X_5240_ clknet_leaf_40_clk _0160_ VGND VGND VPWR VPWR cpu_inst.regfile_inst.registers\[5\]\[0\]
+ sky130_fd_sc_hd__dfxtp_1
XFILLER_0_87_69 VPWR VGND VPWR VGND sky130_ef_sc_hd__decap_12
X_5171_ clknet_leaf_10_clk _0091_ VGND VGND VPWR VPWR cpu_inst.regfile_inst.registers\[25\]\[27\]
+ sky130_fd_sc_hd__dfxtp_1
XPHY_EDGE_ROW_18_Right_18 VGND VGND VPWR VPWR sky130_fd_sc_hd__decap_3
X_4122_ _2000_ VGND VGND VPWR VPWR _0076_ sky130_fd_sc_hd__clkbuf_1
XTAP_TAPCELL_ROW_71_1367 VGND VPWR sky130_fd_sc_hd__tapvpwrvgnd_1
X_4053_ _1962_ VGND VGND VPWR VPWR _0045_ sky130_fd_sc_hd__clkbuf_1
X_3004_ _0967_ _0968_ _0883_ VGND VGND VPWR VPWR _0969_ sky130_fd_sc_hd__mux2_1
XTAP_TAPCELL_ROW_35_822 VGND VPWR sky130_fd_sc_hd__tapvpwrvgnd_1
XFILLER_0_93_329 VGND VGND VPWR VPWR sky130_fd_sc_hd__decap_6
X_4955_ _1867_ cpu_inst.regfile_inst.registers\[8\]\[29\] _2431_ VGND VGND VPWR VPWR
+ _2465_ sky130_fd_sc_hd__mux2_1
XPHY_EDGE_ROW_27_Right_27 VGND VGND VPWR VPWR sky130_fd_sc_hd__decap_3
XFILLER_0_129_461 VPWR VGND VPWR VGND sky130_ef_sc_hd__decap_12
X_3906_ _1088_ _1827_ _1832_ VGND VGND VPWR VPWR _1833_ sky130_fd_sc_hd__o21ai_2
XFILLER_0_52_83 VGND VGND VPWR VPWR sky130_fd_sc_hd__fill_1
X_4886_ cpu_inst.regfile_inst.registers\[9\]\[29\] VGND VGND VPWR VPWR _2428_ sky130_fd_sc_hd__clkbuf_1
XFILLER_0_7_821 VPWR VGND VPWR VGND sky130_ef_sc_hd__decap_12
XFILLER_0_46_245 VGND VGND VPWR VPWR sky130_fd_sc_hd__decap_6
XFILLER_0_116_133 VGND VGND VPWR VPWR sky130_fd_sc_hd__decap_6
X_3837_ cpu_inst.regfile_inst.registers\[9\]\[27\] cpu_inst.regfile_inst.registers\[8\]\[27\]
+ _1657_ VGND VGND VPWR VPWR _1765_ sky130_fd_sc_hd__mux2_1
XFILLER_0_46_289 VPWR VGND VPWR VGND sky130_ef_sc_hd__decap_12
XFILLER_0_132_637 VGND VGND VPWR VPWR sky130_fd_sc_hd__decap_6
XFILLER_0_116_177 VPWR VGND VPWR VGND sky130_ef_sc_hd__decap_12
X_3768_ _1697_ cpu_inst.regfile_inst.registers\[10\]\[25\] _1351_ VGND VGND VPWR VPWR
+ _1698_ sky130_fd_sc_hd__mux2_1
XFILLER_0_61_237 VPWR VGND VPWR VGND sky130_ef_sc_hd__decap_12
XFILLER_0_131_125 VPWR VGND VPWR VGND sky130_ef_sc_hd__decap_12
X_2719_ _0683_ VGND VGND VPWR VPWR _0684_ sky130_fd_sc_hd__clkbuf_4
XFILLER_0_70_782 VGND VGND VPWR VPWR sky130_fd_sc_hd__decap_6
XFILLER_0_14_153 VPWR VGND VPWR VGND sky130_ef_sc_hd__decap_12
XFILLER_0_15_665 VGND VGND VPWR VPWR sky130_fd_sc_hd__decap_6
X_5507_ clknet_leaf_29_clk _0427_ VGND VGND VPWR VPWR cpu_inst.regfile_inst.registers\[8\]\[11\]
+ sky130_fd_sc_hd__dfxtp_1
XFILLER_0_42_473 VGND VGND VPWR VPWR sky130_fd_sc_hd__decap_3
XFILLER_0_131_169 VPWR VGND VPWR VGND sky130_ef_sc_hd__decap_12
X_3699_ _0639_ _1630_ VGND VGND VPWR VPWR _1631_ sky130_fd_sc_hd__nor2_1
XFILLER_0_14_197 VPWR VGND VPWR VGND sky130_ef_sc_hd__decap_12
XFILLER_0_30_657 VGND VGND VPWR VPWR sky130_fd_sc_hd__decap_4
XFILLER_0_100_523 VGND VGND VPWR VPWR sky130_fd_sc_hd__decap_8
XFILLER_0_2_581 VGND VGND VPWR VPWR sky130_fd_sc_hd__decap_6
X_5438_ clknet_leaf_33_clk _0358_ VGND VGND VPWR VPWR cpu_inst.regfile_inst.registers\[0\]\[6\]
+ sky130_fd_sc_hd__dfxtp_1
XFILLER_0_30_668 VGND VGND VPWR VPWR sky130_fd_sc_hd__decap_4
XPHY_EDGE_ROW_36_Right_36 VGND VGND VPWR VPWR sky130_fd_sc_hd__decap_3
X_5369_ clknet_leaf_41_clk _0289_ VGND VGND VPWR VPWR cpu_inst.regfile_inst.registers\[10\]\[1\]
+ sky130_fd_sc_hd__dfxtp_1
XTAP_TAPCELL_ROW_89_1639 VGND VPWR sky130_fd_sc_hd__tapvpwrvgnd_1
XTAP_TAPCELL_ROW_89_1628 VGND VPWR sky130_fd_sc_hd__tapvpwrvgnd_1
XPHY_EDGE_ROW_45_Right_45 VGND VGND VPWR VPWR sky130_fd_sc_hd__decap_3
XFILLER_0_96_189 VGND VGND VPWR VPWR sky130_fd_sc_hd__decap_6
XFILLER_0_84_307 VGND VGND VPWR VPWR sky130_fd_sc_hd__fill_1
XFILLER_0_108_601 VPWR VGND VPWR VGND sky130_ef_sc_hd__decap_12
XTAP_TAPCELL_ROW_100_1806 VGND VPWR sky130_fd_sc_hd__tapvpwrvgnd_1
XFILLER_0_93_841 VGND VGND VPWR VPWR sky130_fd_sc_hd__fill_1
XFILLER_0_77_381 VGND VGND VPWR VPWR sky130_fd_sc_hd__fill_1
XFILLER_0_65_543 VGND VGND VPWR VPWR sky130_fd_sc_hd__fill_1
XFILLER_0_37_223 VGND VGND VPWR VPWR sky130_fd_sc_hd__fill_1
XFILLER_0_38_757 VPWR VGND VPWR VGND sky130_ef_sc_hd__decap_12
XFILLER_0_107_111 VGND VGND VPWR VPWR sky130_fd_sc_hd__fill_1
XFILLER_0_108_645 VPWR VGND VPWR VGND sky130_ef_sc_hd__decap_12
XFILLER_0_53_738 VGND VGND VPWR VPWR sky130_fd_sc_hd__decap_3
XFILLER_0_53_727 VGND VGND VPWR VPWR sky130_fd_sc_hd__fill_1
XFILLER_0_25_429 VPWR VGND VPWR VGND sky130_ef_sc_hd__decap_12
XFILLER_0_135_497 VGND VGND VPWR VPWR sky130_fd_sc_hd__decap_6
XFILLER_0_123_615 VGND VGND VPWR VPWR sky130_fd_sc_hd__fill_1
XFILLER_0_110_309 VPWR VGND VPWR VGND sky130_ef_sc_hd__decap_12
XPHY_EDGE_ROW_54_Right_54 VGND VGND VPWR VPWR sky130_fd_sc_hd__decap_3
XFILLER_0_0_529 VGND VGND VPWR VPWR sky130_fd_sc_hd__decap_3
XFILLER_0_103_361 VPWR VGND VPWR VGND sky130_ef_sc_hd__decap_12
XFILLER_0_57_39 VPWR VGND VPWR VGND sky130_ef_sc_hd__decap_12
XFILLER_0_20_189 VGND VGND VPWR VPWR sky130_fd_sc_hd__decap_6
XTAP_TAPCELL_ROW_111_1968 VGND VPWR sky130_fd_sc_hd__tapvpwrvgnd_1
XTAP_TAPCELL_ROW_53_1097 VGND VPWR sky130_fd_sc_hd__tapvpwrvgnd_1
XFILLER_0_73_27 VPWR VGND VPWR VGND sky130_ef_sc_hd__decap_12
XPHY_EDGE_ROW_63_Right_63 VGND VGND VPWR VPWR sky130_fd_sc_hd__decap_3
XFILLER_0_76_808 VGND VGND VPWR VPWR sky130_fd_sc_hd__fill_1
XFILLER_0_87_167 VGND VGND VPWR VPWR sky130_fd_sc_hd__fill_1
XFILLER_0_84_841 VGND VGND VPWR VPWR sky130_fd_sc_hd__fill_1
XFILLER_0_75_329 VGND VGND VPWR VPWR sky130_fd_sc_hd__decap_6
XFILLER_0_113_55 VGND VGND VPWR VPWR sky130_fd_sc_hd__fill_1
X_4740_ cpu_inst.decoder_inst.current_pc\[24\] _1288_ _2297_ _2350_ VGND VGND VPWR
+ VPWR _0344_ sky130_fd_sc_hd__a22o_1
XFILLER_0_28_245 VGND VGND VPWR VPWR sky130_fd_sc_hd__decap_6
XFILLER_0_125_3 VPWR VGND VPWR VGND sky130_ef_sc_hd__decap_12
XFILLER_0_83_373 VGND VGND VPWR VPWR sky130_fd_sc_hd__fill_1
X_4671_ _2299_ _2300_ VGND VGND VPWR VPWR _2301_ sky130_fd_sc_hd__nor2_1
XFILLER_0_22_53 VPWR VGND VPWR VGND sky130_ef_sc_hd__decap_12
XFILLER_0_28_289 VPWR VGND VPWR VGND sky130_ef_sc_hd__decap_12
XFILLER_0_126_475 VGND VGND VPWR VPWR sky130_fd_sc_hd__fill_1
X_3622_ cpu_inst.regfile_inst.registers\[15\]\[21\] _1554_ _1555_ VGND VGND VPWR VPWR
+ _1556_ sky130_fd_sc_hd__mux2_1
XFILLER_0_4_813 VPWR VGND VPWR VGND sky130_ef_sc_hd__decap_12
XFILLER_0_22_97 VPWR VGND VPWR VGND sky130_ef_sc_hd__decap_12
XFILLER_0_43_237 VPWR VGND VPWR VGND sky130_ef_sc_hd__decap_12
XFILLER_0_114_637 VGND VGND VPWR VPWR sky130_fd_sc_hd__decap_6
XFILLER_0_113_125 VPWR VGND VPWR VGND sky130_ef_sc_hd__decap_12
XPHY_EDGE_ROW_72_Right_72 VGND VGND VPWR VPWR sky130_fd_sc_hd__decap_3
XFILLER_0_12_613 VPWR VGND VPWR VGND sky130_ef_sc_hd__decap_12
XFILLER_0_113_169 VPWR VGND VPWR VGND sky130_ef_sc_hd__decap_12
X_3553_ _1450_ _1488_ _1451_ VGND VGND VPWR VPWR _1489_ sky130_fd_sc_hd__mux2_1
XFILLER_0_51_281 VPWR VGND VPWR VGND sky130_ef_sc_hd__decap_12
XFILLER_0_122_681 VPWR VGND VPWR VGND sky130_ef_sc_hd__decap_12
X_3484_ _1412_ _1406_ _1420_ VGND VGND VPWR VPWR _1421_ sky130_fd_sc_hd__o21a_1
XFILLER_0_12_657 VPWR VGND VPWR VGND sky130_ef_sc_hd__decap_12
X_5223_ clknet_leaf_22_clk _0143_ VGND VGND VPWR VPWR cpu_inst.regfile_inst.registers\[24\]\[15\]
+ sky130_fd_sc_hd__dfxtp_1
XFILLER_0_11_167 VGND VGND VPWR VPWR sky130_fd_sc_hd__fill_1
XFILLER_0_138_41 VPWR VGND VPWR VGND sky130_ef_sc_hd__decap_12
X_5154_ clknet_leaf_25_clk _0074_ VGND VGND VPWR VPWR cpu_inst.regfile_inst.registers\[25\]\[10\]
+ sky130_fd_sc_hd__dfxtp_1
XFILLER_0_138_85 VPWR VGND VPWR VGND sky130_ef_sc_hd__decap_12
X_4105_ _0576_ _1990_ VGND VGND VPWR VPWR _1991_ sky130_fd_sc_hd__nand2_1
XPHY_EDGE_ROW_81_Right_81 VGND VGND VPWR VPWR sky130_fd_sc_hd__decap_3
XPHY_EDGE_ROW_16_Left_155 VGND VGND VPWR VPWR sky130_fd_sc_hd__decap_3
X_5085_ clknet_leaf_35_clk _0005_ VGND VGND VPWR VPWR cpu_inst.regfile_inst.registers\[6\]\[5\]
+ sky130_fd_sc_hd__dfxtp_1
XFILLER_0_79_602 VGND VGND VPWR VPWR sky130_fd_sc_hd__decap_4
XFILLER_0_2_41 VPWR VGND VPWR VGND sky130_ef_sc_hd__decap_12
X_4036_ cpu_inst.regfile_inst.registers\[2\]\[5\] VGND VGND VPWR VPWR _1954_ sky130_fd_sc_hd__clkbuf_1
XFILLER_0_79_657 VPWR VGND VPWR VGND sky130_ef_sc_hd__decap_12
XFILLER_0_2_85 VPWR VGND VPWR VGND sky130_ef_sc_hd__decap_12
XTAP_TAPCELL_ROW_84_1558 VGND VPWR sky130_fd_sc_hd__tapvpwrvgnd_1
XFILLER_0_66_307 VGND VGND VPWR VPWR sky130_fd_sc_hd__fill_1
XFILLER_0_63_93 VPWR VGND VPWR VGND sky130_ef_sc_hd__decap_12
XFILLER_0_137_729 VPWR VGND VPWR VGND sky130_ef_sc_hd__decap_12
XFILLER_0_93_137 VPWR VGND VPWR VGND sky130_ef_sc_hd__decap_12
XFILLER_0_78_189 VGND VGND VPWR VPWR sky130_fd_sc_hd__decap_6
XFILLER_0_75_841 VGND VGND VPWR VPWR sky130_fd_sc_hd__fill_1
XFILLER_0_19_223 VGND VGND VPWR VPWR sky130_fd_sc_hd__fill_1
XFILLER_0_47_510 VGND VGND VPWR VPWR sky130_fd_sc_hd__decap_6
X_4938_ _2456_ VGND VGND VPWR VPWR _0436_ sky130_fd_sc_hd__clkbuf_1
X_4869_ _2419_ VGND VGND VPWR VPWR _0404_ sky130_fd_sc_hd__clkbuf_1
XFILLER_0_90_811 VGND VGND VPWR VPWR sky130_fd_sc_hd__fill_1
XPHY_EDGE_ROW_25_Left_164 VGND VGND VPWR VPWR sky130_fd_sc_hd__decap_3
XFILLER_0_132_401 VPWR VGND VPWR VGND sky130_ef_sc_hd__decap_12
XPHY_EDGE_ROW_90_Right_90 VGND VGND VPWR VPWR sky130_fd_sc_hd__decap_3
XFILLER_0_62_546 VGND VGND VPWR VPWR sky130_fd_sc_hd__fill_1
XFILLER_0_7_673 VPWR VGND VPWR VGND sky130_ef_sc_hd__decap_12
XFILLER_0_132_445 VPWR VGND VPWR VGND sky130_ef_sc_hd__decap_12
XFILLER_0_117_497 VGND VGND VPWR VPWR sky130_fd_sc_hd__decap_6
XTAP_TAPCELL_ROW_115_2024 VGND VPWR sky130_fd_sc_hd__tapvpwrvgnd_1
XTAP_TAPCELL_ROW_99_1790 VGND VPWR sky130_fd_sc_hd__tapvpwrvgnd_1
XFILLER_0_15_473 VPWR VGND VPWR VGND sky130_ef_sc_hd__decap_12
XFILLER_0_30_421 VPWR VGND VPWR VGND sky130_ef_sc_hd__decap_12
XFILLER_0_132_489 VPWR VGND VPWR VGND sky130_ef_sc_hd__decap_12
XFILLER_0_101_821 VPWR VGND VPWR VGND sky130_ef_sc_hd__decap_12
XTAP_TAPCELL_ROW_7_399 VGND VPWR sky130_fd_sc_hd__tapvpwrvgnd_1
XPHY_EDGE_ROW_34_Left_173 VGND VGND VPWR VPWR sky130_fd_sc_hd__decap_3
XTAP_TAPCELL_ROW_126_2197 VGND VPWR sky130_fd_sc_hd__tapvpwrvgnd_1
XTAP_TAPCELL_ROW_126_2186 VGND VPWR sky130_fd_sc_hd__tapvpwrvgnd_1
XFILLER_0_85_627 VGND VGND VPWR VPWR sky130_fd_sc_hd__decap_6
XFILLER_0_69_167 VGND VGND VPWR VPWR sky130_fd_sc_hd__fill_1
XFILLER_0_97_498 VGND VGND VPWR VPWR sky130_fd_sc_hd__fill_1
XFILLER_0_66_830 VPWR VGND VPWR VGND sky130_ef_sc_hd__decap_12
XFILLER_0_127_217 VGND VGND VPWR VPWR sky130_fd_sc_hd__decap_6
XTAP_TAPCELL_ROW_26_685 VGND VPWR sky130_fd_sc_hd__tapvpwrvgnd_1
XTAP_TAPCELL_ROW_26_696 VGND VPWR sky130_fd_sc_hd__tapvpwrvgnd_1
XPHY_EDGE_ROW_43_Left_182 VGND VGND VPWR VPWR sky130_fd_sc_hd__decap_3
XFILLER_0_26_749 VGND VGND VPWR VPWR sky130_fd_sc_hd__decap_6
XFILLER_0_38_598 VGND VGND VPWR VPWR sky130_fd_sc_hd__decap_3
XFILLER_0_135_261 VPWR VGND VPWR VGND sky130_ef_sc_hd__decap_12
XFILLER_0_108_475 VGND VGND VPWR VPWR sky130_fd_sc_hd__fill_1
XFILLER_0_80_321 VPWR VGND VPWR VGND sky130_ef_sc_hd__decap_12
XFILLER_0_4_109 VPWR VGND VPWR VGND sky130_ef_sc_hd__decap_12
XFILLER_0_25_237 VPWR VGND VPWR VGND sky130_ef_sc_hd__decap_12
XFILLER_0_80_365 VGND VGND VPWR VPWR sky130_fd_sc_hd__decap_6
XFILLER_0_61_590 VGND VGND VPWR VPWR sky130_fd_sc_hd__fill_1
XFILLER_0_33_281 VPWR VGND VPWR VGND sky130_ef_sc_hd__decap_12
XFILLER_0_111_629 VPWR VGND VPWR VGND sky130_ef_sc_hd__decap_12
XFILLER_0_68_27 VGND VGND VPWR VPWR sky130_fd_sc_hd__fill_1
XFILLER_0_0_337 VPWR VGND VPWR VGND sky130_ef_sc_hd__decap_12
XFILLER_0_110_139 VGND VGND VPWR VPWR sky130_fd_sc_hd__fill_1
XTAP_TAPCELL_ROW_55_1126 VGND VPWR sky130_fd_sc_hd__tapvpwrvgnd_1
XPHY_EDGE_ROW_52_Left_191 VGND VGND VPWR VPWR sky130_fd_sc_hd__decap_3
XFILLER_0_84_15 VPWR VGND VPWR VGND sky130_ef_sc_hd__decap_12
XFILLER_0_108_77 VGND VGND VPWR VPWR sky130_fd_sc_hd__decap_6
XFILLER_0_48_307 VGND VGND VPWR VPWR sky130_fd_sc_hd__fill_1
XFILLER_0_124_65 VPWR VGND VPWR VGND sky130_ef_sc_hd__decap_12
XFILLER_0_75_137 VPWR VGND VPWR VGND sky130_ef_sc_hd__decap_12
XTAP_TAPCELL_ROW_66_1288 VGND VPWR sky130_fd_sc_hd__tapvpwrvgnd_1
XTAP_TAPCELL_ROW_45_972 VGND VPWR sky130_fd_sc_hd__tapvpwrvgnd_1
XFILLER_0_119_729 VPWR VGND VPWR VGND sky130_ef_sc_hd__decap_12
XFILLER_0_72_800 VPWR VGND VPWR VGND sky130_ef_sc_hd__decap_12
X_2984_ _0946_ _0948_ VGND VGND VPWR VPWR _0949_ sky130_fd_sc_hd__nand2_1
XFILLER_0_57_841 VGND VGND VPWR VPWR sky130_fd_sc_hd__fill_1
X_4723_ cpu_inst.decoder_inst.current_pc\[19\] cpu_inst.decoder_inst.current_pc\[20\]
+ _2334_ VGND VGND VPWR VPWR _2338_ sky130_fd_sc_hd__and3_1
XFILLER_0_17_727 VGND VGND VPWR VPWR sky130_fd_sc_hd__fill_1
XFILLER_0_114_401 VPWR VGND VPWR VGND sky130_ef_sc_hd__decap_12
XFILLER_0_83_181 VPWR VGND VPWR VGND sky130_ef_sc_hd__decap_12
XFILLER_0_44_546 VGND VGND VPWR VPWR sky130_fd_sc_hd__decap_4
XFILLER_0_114_445 VPWR VGND VPWR VGND sky130_ef_sc_hd__decap_12
X_4654_ _1988_ _2286_ cpu_inst.decoder_inst.current_pc\[2\] VGND VGND VPWR VPWR _2287_
+ sky130_fd_sc_hd__mux2_1
XFILLER_0_4_643 VGND VGND VPWR VPWR sky130_fd_sc_hd__fill_1
X_3605_ _1537_ _1538_ _1351_ VGND VGND VPWR VPWR _1539_ sky130_fd_sc_hd__mux2_1
XFILLER_0_12_421 VPWR VGND VPWR VGND sky130_ef_sc_hd__decap_12
X_4585_ _2240_ VGND VGND VPWR VPWR _0299_ sky130_fd_sc_hd__clkbuf_1
XFILLER_0_114_489 VPWR VGND VPWR VGND sky130_ef_sc_hd__decap_12
X_3536_ cpu_inst.regfile_inst.registers\[0\]\[19\] _0848_ _0849_ cpu_inst.regfile_inst.registers\[4\]\[19\]
+ _0853_ VGND VGND VPWR VPWR _1472_ sky130_fd_sc_hd__o221a_1
X_5206_ clknet_leaf_3_clk _0126_ VGND VGND VPWR VPWR cpu_inst.regfile_inst.registers\[4\]\[30\]
+ sky130_fd_sc_hd__dfxtp_1
X_3467_ _0859_ _1403_ _1404_ _0610_ VGND VGND VPWR VPWR _1405_ sky130_fd_sc_hd__a31o_1
X_3398_ _1192_ cpu_inst.regfile_inst.registers\[6\]\[12\] _1339_ VGND VGND VPWR VPWR
+ _1341_ sky130_fd_sc_hd__mux2_1
X_5137_ clknet_leaf_9_clk _0057_ VGND VGND VPWR VPWR cpu_inst.regfile_inst.registers\[2\]\[25\]
+ sky130_fd_sc_hd__dfxtp_1
XTAP_TAPCELL_ROW_4_358 VGND VPWR sky130_fd_sc_hd__tapvpwrvgnd_1
X_5068_ cpu_inst.display_inst.counter\[14\] cpu_inst.display_inst.counter\[15\] _2524_
+ VGND VGND VPWR VPWR _2528_ sky130_fd_sc_hd__and3_1
X_4019_ _1385_ _1175_ _1182_ VGND VGND VPWR VPWR _1942_ sky130_fd_sc_hd__a21o_1
XPHY_EDGE_ROW_0_Right_0 VGND VGND VPWR VPWR sky130_fd_sc_hd__decap_3
XFILLER_0_39_329 VGND VGND VPWR VPWR sky130_fd_sc_hd__decap_6
XFILLER_0_109_217 VGND VGND VPWR VPWR sky130_fd_sc_hd__decap_6
XFILLER_0_48_841 VGND VGND VPWR VPWR sky130_fd_sc_hd__fill_1
XFILLER_0_137_559 VGND VGND VPWR VPWR sky130_fd_sc_hd__fill_1
XTAP_TAPCELL_ROW_23_644 VGND VPWR sky130_fd_sc_hd__tapvpwrvgnd_1
XFILLER_0_35_513 VGND VGND VPWR VPWR sky130_fd_sc_hd__fill_2
XFILLER_0_47_373 VPWR VGND VPWR VGND sky130_ef_sc_hd__decap_12
XFILLER_0_124_209 VPWR VGND VPWR VGND sky130_ef_sc_hd__decap_12
XFILLER_0_117_261 VPWR VGND VPWR VGND sky130_ef_sc_hd__decap_12
XFILLER_0_133_721 VGND VGND VPWR VPWR sky130_fd_sc_hd__decap_6
XTAP_TAPCELL_ROW_97_1749 VGND VPWR sky130_fd_sc_hd__tapvpwrvgnd_1
XFILLER_0_133_765 VPWR VGND VPWR VGND sky130_ef_sc_hd__decap_12
XFILLER_0_132_253 VPWR VGND VPWR VGND sky130_ef_sc_hd__decap_12
XFILLER_0_15_281 VPWR VGND VPWR VGND sky130_ef_sc_hd__decap_12
XFILLER_0_16_793 VPWR VGND VPWR VGND sky130_ef_sc_hd__decap_12
XFILLER_0_31_741 VPWR VGND VPWR VGND sky130_ef_sc_hd__decap_12
XFILLER_0_30_251 VGND VGND VPWR VPWR sky130_fd_sc_hd__fill_1
XFILLER_0_31_785 VGND VGND VPWR VPWR sky130_fd_sc_hd__decap_6
XTAP_TAPCELL_ROW_128_2226 VGND VPWR sky130_fd_sc_hd__tapvpwrvgnd_1
XTAP_TAPCELL_ROW_128_2215 VGND VPWR sky130_fd_sc_hd__tapvpwrvgnd_1
XTAP_TAPCELL_ROW_50_1045 VGND VPWR sky130_fd_sc_hd__tapvpwrvgnd_1
XFILLER_0_54_29 VPWR VGND VPWR VGND sky130_ef_sc_hd__decap_12
XTAP_TAPCELL_ROW_50_1056 VGND VPWR sky130_fd_sc_hd__tapvpwrvgnd_1
XPHY_EDGE_ROW_121_Right_121 VGND VGND VPWR VPWR sky130_fd_sc_hd__decap_3
XTAP_TAPCELL_ROW_106_1889 VGND VPWR sky130_fd_sc_hd__tapvpwrvgnd_1
XFILLER_0_97_273 VGND VGND VPWR VPWR sky130_fd_sc_hd__decap_6
XFILLER_0_85_446 VGND VGND VPWR VPWR sky130_fd_sc_hd__fill_2
XFILLER_0_57_137 VPWR VGND VPWR VGND sky130_ef_sc_hd__decap_12
XFILLER_0_39_841 VGND VGND VPWR VPWR sky130_fd_sc_hd__fill_1
XTAP_TAPCELL_ROW_42_931 VGND VPWR sky130_fd_sc_hd__tapvpwrvgnd_1
XFILLER_0_54_822 VPWR VGND VPWR VGND sky130_ef_sc_hd__decap_12
XFILLER_0_54_811 VGND VGND VPWR VPWR sky130_fd_sc_hd__fill_1
XFILLER_0_65_181 VPWR VGND VPWR VGND sky130_ef_sc_hd__decap_12
XFILLER_0_53_321 VGND VGND VPWR VPWR sky130_fd_sc_hd__fill_1
XFILLER_0_5_429 VPWR VGND VPWR VGND sky130_ef_sc_hd__decap_12
XFILLER_0_136_581 VGND VGND VPWR VPWR sky130_fd_sc_hd__decap_6
XFILLER_0_81_652 VGND VGND VPWR VPWR sky130_fd_sc_hd__fill_1
XFILLER_0_79_15 VPWR VGND VPWR VGND sky130_ef_sc_hd__decap_12
XFILLER_0_81_696 VGND VGND VPWR VPWR sky130_fd_sc_hd__fill_1
XFILLER_0_80_195 VGND VGND VPWR VPWR sky130_fd_sc_hd__fill_1
X_4370_ _2130_ VGND VGND VPWR VPWR _0194_ sky130_fd_sc_hd__clkbuf_1
X_3321_ _1279_ _1270_ _1280_ _1272_ VGND VGND VPWR VPWR net12 sky130_fd_sc_hd__a22o_1
XFILLER_0_21_273 VGND VGND VPWR VPWR sky130_fd_sc_hd__decap_6
XFILLER_0_95_69 VPWR VGND VPWR VGND sky130_ef_sc_hd__decap_12
X_3252_ _0952_ _0959_ VGND VGND VPWR VPWR _1217_ sky130_fd_sc_hd__nor2_1
XFILLER_0_28_41 VPWR VGND VPWR VGND sky130_ef_sc_hd__decap_12
X_3183_ _1145_ _1147_ _1062_ VGND VGND VPWR VPWR _1148_ sky130_fd_sc_hd__mux2_1
XFILLER_0_28_85 VPWR VGND VPWR VGND sky130_ef_sc_hd__decap_12
XTAP_TAPCELL_ROW_68_1317 VGND VPWR sky130_fd_sc_hd__tapvpwrvgnd_1
XTAP_TAPCELL_ROW_1_317 VGND VPWR sky130_fd_sc_hd__tapvpwrvgnd_1
XFILLER_0_88_251 VGND VGND VPWR VPWR sky130_fd_sc_hd__fill_1
XTAP_TAPCELL_ROW_81_1517 VGND VPWR sky130_fd_sc_hd__tapvpwrvgnd_1
XFILLER_0_119_559 VGND VGND VPWR VPWR sky130_fd_sc_hd__fill_1
XFILLER_0_8_245 VGND VGND VPWR VPWR sky130_fd_sc_hd__decap_6
XFILLER_0_29_373 VPWR VGND VPWR VGND sky130_ef_sc_hd__decap_12
XFILLER_0_106_209 VPWR VGND VPWR VGND sky130_ef_sc_hd__decap_12
XFILLER_0_60_83 VGND VGND VPWR VPWR sky130_fd_sc_hd__fill_1
X_2967_ _0782_ _0771_ _0548_ VGND VGND VPWR VPWR _0932_ sky130_fd_sc_hd__o21a_1
XTAP_TAPCELL_ROW_20_603 VGND VPWR sky130_fd_sc_hd__tapvpwrvgnd_1
XFILLER_0_44_321 VPWR VGND VPWR VGND sky130_ef_sc_hd__decap_12
XFILLER_0_115_721 VGND VGND VPWR VPWR sky130_fd_sc_hd__decap_6
XFILLER_0_97_3 VPWR VGND VPWR VGND sky130_ef_sc_hd__decap_12
XFILLER_0_72_663 VGND VGND VPWR VPWR sky130_fd_sc_hd__fill_1
X_4706_ cpu_inst.decoder_inst.current_pc\[15\] _2323_ VGND VGND VPWR VPWR _2326_ sky130_fd_sc_hd__xor2_1
XFILLER_0_8_289 VPWR VGND VPWR VGND sky130_ef_sc_hd__decap_12
XFILLER_0_44_365 VPWR VGND VPWR VGND sky130_ef_sc_hd__decap_12
X_2898_ _0658_ VGND VGND VPWR VPWR _0863_ sky130_fd_sc_hd__clkbuf_4
XFILLER_0_115_765 VPWR VGND VPWR VGND sky130_ef_sc_hd__decap_12
XFILLER_0_114_253 VPWR VGND VPWR VGND sky130_ef_sc_hd__decap_12
X_4637_ _0689_ _2270_ cpu_inst.display_inst.digit_select\[1\] VGND VGND VPWR VPWR
+ _2271_ sky130_fd_sc_hd__o21ai_1
XFILLER_0_130_713 VPWR VGND VPWR VGND sky130_ef_sc_hd__decap_12
XTAP_TAPCELL_ROW_79_1479 VGND VPWR sky130_fd_sc_hd__tapvpwrvgnd_1
XFILLER_0_13_741 VPWR VGND VPWR VGND sky130_ef_sc_hd__decap_12
XFILLER_0_130_757 VPWR VGND VPWR VGND sky130_ef_sc_hd__decap_12
XFILLER_0_69_81 VPWR VGND VPWR VGND sky130_ef_sc_hd__decap_12
XFILLER_0_12_251 VGND VGND VPWR VPWR sky130_fd_sc_hd__fill_1
XTAP_TAPCELL_ROW_9_439 VGND VPWR sky130_fd_sc_hd__tapvpwrvgnd_1
XTAP_TAPCELL_ROW_9_428 VGND VPWR sky130_fd_sc_hd__tapvpwrvgnd_1
XFILLER_0_13_785 VPWR VGND VPWR VGND sky130_ef_sc_hd__decap_12
X_4568_ _2232_ VGND VGND VPWR VPWR _0290_ sky130_fd_sc_hd__clkbuf_1
XTAP_TAPCELL_ROW_92_1679 VGND VPWR sky130_fd_sc_hd__tapvpwrvgnd_1
X_3519_ _1053_ _1446_ _1447_ _1455_ _0683_ VGND VGND VPWR VPWR _1456_ sky130_fd_sc_hd__a32o_2
X_4499_ _2197_ VGND VGND VPWR VPWR _0256_ sky130_fd_sc_hd__clkbuf_1
XTAP_TAPCELL_ROW_28_714 VGND VPWR sky130_fd_sc_hd__tapvpwrvgnd_1
XTAP_TAPCELL_ROW_123_2145 VGND VPWR sky130_fd_sc_hd__tapvpwrvgnd_1
XTAP_TAPCELL_ROW_28_725 VGND VPWR sky130_fd_sc_hd__tapvpwrvgnd_1
XFILLER_0_79_273 VGND VGND VPWR VPWR sky130_fd_sc_hd__decap_6
XFILLER_0_67_402 VGND VGND VPWR VPWR sky130_fd_sc_hd__fill_1
XFILLER_0_138_813 VPWR VGND VPWR VGND sky130_ef_sc_hd__decap_12
XFILLER_0_95_777 VGND VGND VPWR VPWR sky130_fd_sc_hd__decap_6
XFILLER_0_94_221 VPWR VGND VPWR VGND sky130_ef_sc_hd__decap_12
XFILLER_0_39_137 VPWR VGND VPWR VGND sky130_ef_sc_hd__decap_12
XFILLER_0_94_265 VPWR VGND VPWR VGND sky130_ef_sc_hd__decap_12
XFILLER_0_125_529 VPWR VGND VPWR VGND sky130_ef_sc_hd__decap_12
XFILLER_0_75_490 VPWR VGND VPWR VGND sky130_ef_sc_hd__decap_12
XFILLER_0_47_181 VPWR VGND VPWR VGND sky130_ef_sc_hd__decap_12
XFILLER_0_118_581 VGND VGND VPWR VPWR sky130_fd_sc_hd__decap_6
Xclkbuf_leaf_20_clk clknet_2_3__leaf_clk VGND VGND VPWR VPWR clknet_leaf_20_clk sky130_fd_sc_hd__clkbuf_8
XFILLER_0_23_505 VPWR VGND VPWR VGND sky130_ef_sc_hd__decap_12
XFILLER_0_90_493 VGND VGND VPWR VPWR sky130_fd_sc_hd__decap_3
XFILLER_0_90_471 VGND VGND VPWR VPWR sky130_fd_sc_hd__fill_1
XFILLER_0_133_573 VPWR VGND VPWR VGND sky130_ef_sc_hd__decap_12
XFILLER_0_62_195 VGND VGND VPWR VPWR sky130_fd_sc_hd__fill_1
XFILLER_0_50_357 VGND VGND VPWR VPWR sky130_fd_sc_hd__decap_6
XFILLER_0_120_245 VGND VGND VPWR VPWR sky130_fd_sc_hd__decap_6
XFILLER_0_120_289 VPWR VGND VPWR VGND sky130_ef_sc_hd__decap_12
XFILLER_0_65_39 VPWR VGND VPWR VGND sky130_ef_sc_hd__decap_12
XTAP_TAPCELL_ROW_108_1918 VGND VPWR sky130_fd_sc_hd__tapvpwrvgnd_1
XFILLER_0_81_27 VPWR VGND VPWR VGND sky130_ef_sc_hd__decap_12
XFILLER_0_128_301 VGND VGND VPWR VPWR sky130_fd_sc_hd__decap_6
XFILLER_0_86_755 VGND VGND VPWR VPWR sky130_fd_sc_hd__fill_1
XFILLER_0_128_345 VPWR VGND VPWR VGND sky130_ef_sc_hd__decap_12
X_3870_ _1657_ VGND VGND VPWR VPWR _1797_ sky130_fd_sc_hd__clkbuf_4
XTAP_TAPCELL_ROW_63_1247 VGND VPWR sky130_fd_sc_hd__tapvpwrvgnd_1
XFILLER_0_14_65 VPWR VGND VPWR VGND sky130_ef_sc_hd__decap_12
XFILLER_0_39_660 VGND VGND VPWR VPWR sky130_fd_sc_hd__decap_4
XFILLER_0_26_321 VPWR VGND VPWR VGND sky130_ef_sc_hd__decap_12
XFILLER_0_27_833 VGND VGND VPWR VPWR sky130_fd_sc_hd__decap_6
X_2821_ cpu_inst.regfile_inst.registers\[10\]\[7\] cpu_inst.regfile_inst.registers\[11\]\[7\]
+ _0560_ VGND VGND VPWR VPWR _0786_ sky130_fd_sc_hd__mux2_2
XFILLER_0_128_389 VPWR VGND VPWR VGND sky130_ef_sc_hd__decap_12
Xclkbuf_leaf_11_clk clknet_2_1__leaf_clk VGND VGND VPWR VPWR clknet_leaf_11_clk sky130_fd_sc_hd__clkbuf_8
X_5540_ clknet_leaf_21_clk _0460_ VGND VGND VPWR VPWR cpu_inst.regfile_inst.registers\[15\]\[12\]
+ sky130_fd_sc_hd__dfxtp_1
X_2752_ _0700_ _0716_ VGND VGND VPWR VPWR _0717_ sky130_fd_sc_hd__or2_1
XFILLER_0_6_749 VGND VGND VPWR VPWR sky130_fd_sc_hd__decap_6
XFILLER_0_5_237 VPWR VGND VPWR VGND sky130_ef_sc_hd__decap_12
XFILLER_0_26_365 VPWR VGND VPWR VGND sky130_ef_sc_hd__decap_12
XFILLER_0_121_55 VGND VGND VPWR VPWR sky130_fd_sc_hd__fill_1
XFILLER_0_54_696 VGND VGND VPWR VPWR sky130_fd_sc_hd__decap_4
XFILLER_0_30_53 VPWR VGND VPWR VGND sky130_ef_sc_hd__decap_12
X_5471_ clknet_leaf_34_clk _0391_ VGND VGND VPWR VPWR cpu_inst.regfile_inst.registers\[9\]\[7\]
+ sky130_fd_sc_hd__dfxtp_1
XFILLER_0_42_836 VGND VGND VPWR VPWR sky130_fd_sc_hd__decap_3
XFILLER_0_112_713 VPWR VGND VPWR VGND sky130_ef_sc_hd__decap_12
X_4422_ _2156_ VGND VGND VPWR VPWR _0220_ sky130_fd_sc_hd__clkbuf_1
XFILLER_0_30_97 VPWR VGND VPWR VGND sky130_ef_sc_hd__decap_12
XFILLER_0_41_335 VGND VGND VPWR VPWR sky130_fd_sc_hd__fill_1
X_2683_ _0569_ net20 _0647_ VGND VGND VPWR VPWR _0648_ sky130_fd_sc_hd__and3_2
XFILLER_0_112_757 VPWR VGND VPWR VGND sky130_ef_sc_hd__decap_12
XFILLER_0_111_223 VGND VGND VPWR VPWR sky130_fd_sc_hd__fill_1
X_4353_ _1760_ cpu_inst.regfile_inst.registers\[5\]\[26\] _2117_ VGND VGND VPWR VPWR
+ _2122_ sky130_fd_sc_hd__mux2_1
XFILLER_0_10_755 VGND VGND VPWR VPWR sky130_fd_sc_hd__fill_1
XFILLER_0_39_51 VGND VGND VPWR VPWR sky130_fd_sc_hd__decap_4
X_4284_ _2084_ VGND VGND VPWR VPWR _0154_ sky130_fd_sc_hd__clkbuf_1
X_3304_ _1199_ _1102_ VGND VGND VPWR VPWR _1268_ sky130_fd_sc_hd__or2b_1
X_3235_ _1102_ _1172_ _1199_ VGND VGND VPWR VPWR _1200_ sky130_fd_sc_hd__a21o_1
X_3166_ _0864_ _1128_ _1130_ _0876_ VGND VGND VPWR VPWR _1131_ sky130_fd_sc_hd__o22a_2
X_3097_ _0644_ VGND VGND VPWR VPWR _1062_ sky130_fd_sc_hd__clkbuf_4
XFILLER_0_12_3 VPWR VGND VPWR VGND sky130_ef_sc_hd__decap_12
XFILLER_0_138_109 VGND VGND VPWR VPWR sky130_fd_sc_hd__decap_3
XFILLER_0_76_221 VPWR VGND VPWR VGND sky130_ef_sc_hd__decap_12
XFILLER_0_76_265 VPWR VGND VPWR VGND sky130_ef_sc_hd__decap_12
XFILLER_0_18_811 VGND VGND VPWR VPWR sky130_fd_sc_hd__fill_1
X_3999_ _1448_ _1788_ VGND VGND VPWR VPWR _1923_ sky130_fd_sc_hd__and2_1
XFILLER_0_71_93 VPWR VGND VPWR VGND sky130_ef_sc_hd__decap_12
XFILLER_0_29_181 VPWR VGND VPWR VGND sky130_ef_sc_hd__decap_12
XFILLER_0_91_279 VGND VGND VPWR VPWR sky130_fd_sc_hd__fill_1
XTAP_TAPCELL_ROW_33_794 VGND VPWR sky130_fd_sc_hd__tapvpwrvgnd_1
XFILLER_0_33_814 VGND VGND VPWR VPWR sky130_fd_sc_hd__decap_4
XFILLER_0_45_663 VGND VGND VPWR VPWR sky130_fd_sc_hd__decap_8
XFILLER_0_115_573 VPWR VGND VPWR VGND sky130_ef_sc_hd__decap_12
XTAP_TAPCELL_ROW_94_1708 VGND VPWR sky130_fd_sc_hd__tapvpwrvgnd_1
XFILLER_0_32_357 VGND VGND VPWR VPWR sky130_fd_sc_hd__decap_6
XFILLER_0_44_195 VGND VGND VPWR VPWR sky130_fd_sc_hd__fill_1
XFILLER_0_102_245 VGND VGND VPWR VPWR sky130_fd_sc_hd__decap_6
XFILLER_0_130_587 VGND VGND VPWR VPWR sky130_fd_sc_hd__fill_1
XFILLER_0_102_289 VPWR VGND VPWR VGND sky130_ef_sc_hd__decap_12
XPHY_EDGE_ROW_8_Left_147 VGND VGND VPWR VPWR sky130_fd_sc_hd__decap_3
XFILLER_0_99_335 VGND VGND VPWR VPWR sky130_fd_sc_hd__fill_1
XFILLER_0_95_552 VGND VGND VPWR VPWR sky130_fd_sc_hd__decap_4
XTAP_TAPCELL_ROW_103_1848 VGND VPWR sky130_fd_sc_hd__tapvpwrvgnd_1
XFILLER_0_126_805 VGND VGND VPWR VPWR sky130_fd_sc_hd__decap_6
XTAP_TAPCELL_ROW_136_2336 VGND VPWR sky130_fd_sc_hd__tapvpwrvgnd_1
XFILLER_0_125_337 VPWR VGND VPWR VGND sky130_ef_sc_hd__decap_12
XTAP_TAPCELL_ROW_136_2347 VGND VPWR sky130_fd_sc_hd__tapvpwrvgnd_1
Xclkload17 clknet_leaf_10_clk VGND VGND VPWR VPWR clkload17/Y sky130_fd_sc_hd__inv_6
XFILLER_0_24_825 VPWR VGND VPWR VGND sky130_ef_sc_hd__decap_12
Xclkload39 clknet_leaf_20_clk VGND VGND VPWR VPWR clkload39/Y sky130_fd_sc_hd__bufinv_16
XTAP_TAPCELL_ROW_11_466 VGND VPWR sky130_fd_sc_hd__tapvpwrvgnd_1
XFILLER_0_23_335 VGND VGND VPWR VPWR sky130_fd_sc_hd__fill_1
Xclkload28 clknet_leaf_34_clk VGND VGND VPWR VPWR clkload28/Y sky130_fd_sc_hd__inv_6
XFILLER_0_50_121 VPWR VGND VPWR VGND sky130_ef_sc_hd__decap_12
XFILLER_0_50_165 VPWR VGND VPWR VGND sky130_ef_sc_hd__decap_12
XFILLER_0_102_790 VPWR VGND VPWR VGND sky130_ef_sc_hd__decap_12
XFILLER_0_76_27 VGND VGND VPWR VPWR sky130_fd_sc_hd__fill_1
XFILLER_0_92_15 VPWR VGND VPWR VGND sky130_ef_sc_hd__decap_12
Xclkbuf_leaf_0_clk clknet_2_0__leaf_clk VGND VGND VPWR VPWR clknet_leaf_0_clk sky130_fd_sc_hd__clkbuf_8
X_3020_ cpu_inst.regfile_inst.registers\[25\]\[8\] _0903_ _0669_ _0984_ VGND VGND
+ VPWR VPWR _0985_ sky130_fd_sc_hd__o211a_1
XFILLER_0_59_722 VGND VGND VPWR VPWR sky130_fd_sc_hd__decap_6
XFILLER_0_116_77 VGND VGND VPWR VPWR sky130_fd_sc_hd__decap_6
XFILLER_0_58_221 VPWR VGND VPWR VGND sky130_ef_sc_hd__decap_12
XTAP_TAPCELL_ROW_19_588 VGND VPWR sky130_fd_sc_hd__tapvpwrvgnd_1
X_4971_ cpu_inst.regfile_inst.registers\[15\]\[4\] _2469_ VGND VGND VPWR VPWR _2474_
+ sky130_fd_sc_hd__and2_1
X_3922_ cpu_inst.regfile_inst.registers\[4\]\[29\] _0854_ _1709_ VGND VGND VPWR VPWR
+ _1848_ sky130_fd_sc_hd__o21a_1
XFILLER_0_58_265 VPWR VGND VPWR VGND sky130_ef_sc_hd__decap_12
XFILLER_0_129_665 VGND VGND VPWR VPWR sky130_fd_sc_hd__decap_6
XFILLER_0_128_153 VPWR VGND VPWR VGND sky130_ef_sc_hd__decap_12
X_3853_ _1769_ _1780_ VGND VGND VPWR VPWR _1781_ sky130_fd_sc_hd__xor2_1
XFILLER_0_132_65 VPWR VGND VPWR VGND sky130_ef_sc_hd__decap_12
XFILLER_0_128_197 VPWR VGND VPWR VGND sky130_ef_sc_hd__decap_12
X_2804_ _0555_ _0622_ VGND VGND VPWR VPWR _0769_ sky130_fd_sc_hd__nand2_2
XFILLER_0_6_513 VPWR VGND VPWR VGND sky130_ef_sc_hd__decap_12
XFILLER_0_27_663 VGND VGND VPWR VPWR sky130_fd_sc_hd__decap_8
X_3784_ cpu_inst.regfile_inst.registers\[11\]\[25\] cpu_inst.regfile_inst.registers\[10\]\[25\]
+ _1592_ VGND VGND VPWR VPWR _1714_ sky130_fd_sc_hd__mux2_1
XFILLER_0_73_279 VGND VGND VPWR VPWR sky130_fd_sc_hd__fill_1
XFILLER_0_6_557 VPWR VGND VPWR VGND sky130_ef_sc_hd__decap_12
XFILLER_0_27_685 VPWR VGND VPWR VGND sky130_ef_sc_hd__decap_12
XTAP_TAPCELL_ROW_30_753 VGND VPWR sky130_fd_sc_hd__tapvpwrvgnd_1
XFILLER_0_131_329 VGND VGND VPWR VPWR sky130_fd_sc_hd__decap_6
X_5523_ clknet_leaf_7_clk _0443_ VGND VGND VPWR VPWR cpu_inst.regfile_inst.registers\[8\]\[27\]
+ sky130_fd_sc_hd__dfxtp_1
X_2735_ _0606_ VGND VGND VPWR VPWR _0700_ sky130_fd_sc_hd__buf_4
XFILLER_0_14_357 VGND VGND VPWR VPWR sky130_fd_sc_hd__decap_6
XFILLER_0_26_195 VGND VGND VPWR VPWR sky130_fd_sc_hd__fill_1
X_5454_ clknet_leaf_15_clk _0374_ VGND VGND VPWR VPWR cpu_inst.regfile_inst.registers\[0\]\[22\]
+ sky130_fd_sc_hd__dfxtp_1
XTAP_TAPCELL_ROW_76_1438 VGND VPWR sky130_fd_sc_hd__tapvpwrvgnd_1
X_2666_ _0600_ _0629_ _0614_ cpu_inst.regfile_inst.registers\[0\]\[1\] _0630_ VGND
+ VGND VPWR VPWR _0631_ sky130_fd_sc_hd__o221a_1
X_4405_ cpu_inst.regfile_inst.registers\[1\]\[20\] VGND VGND VPWR VPWR _2148_ sky130_fd_sc_hd__clkbuf_1
X_5385_ clknet_leaf_26_clk _0305_ VGND VGND VPWR VPWR cpu_inst.regfile_inst.registers\[10\]\[17\]
+ sky130_fd_sc_hd__dfxtp_1
XFILLER_0_112_587 VGND VGND VPWR VPWR sky130_fd_sc_hd__fill_1
X_4336_ _1456_ cpu_inst.regfile_inst.registers\[5\]\[18\] _2105_ VGND VGND VPWR VPWR
+ _2113_ sky130_fd_sc_hd__mux2_1
X_2597_ _0561_ VGND VGND VPWR VPWR _0562_ sky130_fd_sc_hd__clkbuf_8
XFILLER_0_1_273 VGND VGND VPWR VPWR sky130_fd_sc_hd__decap_6
X_4267_ cpu_inst.regfile_inst.registers\[24\]\[18\] VGND VGND VPWR VPWR _2076_ sky130_fd_sc_hd__clkbuf_1
X_4198_ cpu_inst.regfile_inst.registers\[4\]\[16\] _2035_ VGND VGND VPWR VPWR _2041_
+ sky130_fd_sc_hd__and2_1
X_3218_ _1175_ _1053_ _1182_ VGND VGND VPWR VPWR _1183_ sky130_fd_sc_hd__a21o_2
X_3149_ cpu_inst.regfile_inst.registers\[2\]\[14\] _0820_ _0821_ cpu_inst.regfile_inst.registers\[7\]\[14\]
+ VGND VGND VPWR VPWR _1114_ sky130_fd_sc_hd__o22a_1
XTAP_TAPCELL_ROW_120_2104 VGND VPWR sky130_fd_sc_hd__tapvpwrvgnd_1
XTAP_TAPCELL_ROW_38_864 VGND VPWR sky130_fd_sc_hd__tapvpwrvgnd_1
XTAP_TAPCELL_ROW_38_875 VGND VPWR sky130_fd_sc_hd__tapvpwrvgnd_1
XFILLER_0_37_405 VPWR VGND VPWR VGND sky130_ef_sc_hd__decap_12
XFILLER_0_108_805 VGND VGND VPWR VPWR sky130_fd_sc_hd__decap_6
XFILLER_0_107_337 VPWR VGND VPWR VGND sky130_ef_sc_hd__decap_12
XFILLER_0_9_373 VPWR VGND VPWR VGND sky130_ef_sc_hd__decap_12
XFILLER_0_52_419 VGND VGND VPWR VPWR sky130_fd_sc_hd__fill_1
XFILLER_0_134_189 VGND VGND VPWR VPWR sky130_fd_sc_hd__decap_6
XFILLER_0_122_307 VGND VGND VPWR VPWR sky130_fd_sc_hd__fill_1
XTAP_TAPCELL_ROW_118_2077 VGND VPWR sky130_fd_sc_hd__tapvpwrvgnd_1
XTAP_TAPCELL_ROW_118_2066 VGND VPWR sky130_fd_sc_hd__tapvpwrvgnd_1
XFILLER_0_32_121 VPWR VGND VPWR VGND sky130_ef_sc_hd__decap_12
XFILLER_0_45_493 VGND VGND VPWR VPWR sky130_fd_sc_hd__fill_2
XFILLER_0_131_841 VGND VGND VPWR VPWR sky130_fd_sc_hd__fill_1
XFILLER_0_21_839 VGND VGND VPWR VPWR sky130_fd_sc_hd__fill_1
XFILLER_0_32_165 VPWR VGND VPWR VGND sky130_ef_sc_hd__decap_12
XTAP_TAPCELL_ROW_131_2266 VGND VPWR sky130_fd_sc_hd__tapvpwrvgnd_1
XFILLER_0_1_3 VPWR VGND VPWR VGND sky130_ef_sc_hd__decap_12
XFILLER_0_87_305 VPWR VGND VPWR VGND sky130_ef_sc_hd__decap_12
XTAP_TAPCELL_ROW_47_1006 VGND VPWR sky130_fd_sc_hd__tapvpwrvgnd_1
XFILLER_0_87_349 VPWR VGND VPWR VGND sky130_ef_sc_hd__decap_12
XFILLER_0_62_29 VPWR VGND VPWR VGND sky130_ef_sc_hd__decap_12
XTAP_TAPCELL_ROW_16_536 VGND VPWR sky130_fd_sc_hd__tapvpwrvgnd_1
XTAP_TAPCELL_ROW_16_547 VGND VPWR sky130_fd_sc_hd__tapvpwrvgnd_1
XFILLER_0_95_393 VGND VGND VPWR VPWR sky130_fd_sc_hd__decap_8
XFILLER_0_68_585 VGND VGND VPWR VPWR sky130_fd_sc_hd__decap_3
XTAP_TAPCELL_ROW_60_1206 VGND VPWR sky130_fd_sc_hd__tapvpwrvgnd_1
XFILLER_0_138_473 VGND VGND VPWR VPWR sky130_fd_sc_hd__decap_3
XFILLER_0_126_613 VPWR VGND VPWR VGND sky130_ef_sc_hd__decap_12
XFILLER_0_126_657 VPWR VGND VPWR VGND sky130_ef_sc_hd__decap_12
XFILLER_0_83_599 VGND VGND VPWR VPWR sky130_fd_sc_hd__fill_2
XFILLER_0_83_588 VGND VGND VPWR VPWR sky130_fd_sc_hd__fill_2
XFILLER_0_55_279 VGND VGND VPWR VPWR sky130_fd_sc_hd__fill_1
XFILLER_0_24_622 VPWR VGND VPWR VGND sky130_ef_sc_hd__decap_12
XFILLER_0_125_167 VGND VGND VPWR VPWR sky130_fd_sc_hd__fill_1
XFILLER_0_113_329 VGND VGND VPWR VPWR sky130_fd_sc_hd__decap_6
XFILLER_0_11_55 VGND VGND VPWR VPWR sky130_fd_sc_hd__fill_1
XFILLER_0_3_505 VPWR VGND VPWR VGND sky130_ef_sc_hd__decap_12
XFILLER_0_122_841 VGND VGND VPWR VPWR sky130_fd_sc_hd__fill_1
XFILLER_0_87_15 VPWR VGND VPWR VGND sky130_ef_sc_hd__decap_12
XFILLER_0_11_305 VPWR VGND VPWR VGND sky130_ef_sc_hd__decap_12
XTAP_TAPCELL_ROW_58_1168 VGND VPWR sky130_fd_sc_hd__tapvpwrvgnd_1
XFILLER_0_11_349 VPWR VGND VPWR VGND sky130_ef_sc_hd__decap_12
XFILLER_0_24_699 VGND VGND VPWR VPWR sky130_fd_sc_hd__fill_1
XFILLER_0_51_485 VPWR VGND VPWR VGND sky130_ef_sc_hd__decap_12
XFILLER_0_121_373 VPWR VGND VPWR VGND sky130_ef_sc_hd__decap_12
X_5170_ clknet_leaf_10_clk _0090_ VGND VGND VPWR VPWR cpu_inst.regfile_inst.registers\[25\]\[26\]
+ sky130_fd_sc_hd__dfxtp_1
X_4121_ _1192_ cpu_inst.regfile_inst.registers\[25\]\[12\] _1998_ VGND VGND VPWR VPWR
+ _2000_ sky130_fd_sc_hd__mux2_1
XTAP_TAPCELL_ROW_71_1368 VGND VPWR sky130_fd_sc_hd__tapvpwrvgnd_1
X_4052_ cpu_inst.regfile_inst.registers\[2\]\[13\] VGND VGND VPWR VPWR _1962_ sky130_fd_sc_hd__clkbuf_1
XFILLER_0_36_41 VPWR VGND VPWR VGND sky130_ef_sc_hd__decap_12
X_3003_ cpu_inst.regfile_inst.registers\[7\]\[9\] cpu_inst.regfile_inst.registers\[6\]\[9\]
+ _0865_ VGND VGND VPWR VPWR _0968_ sky130_fd_sc_hd__mux2_1
XFILLER_0_79_839 VGND VGND VPWR VPWR sky130_fd_sc_hd__fill_1
XFILLER_0_36_85 VPWR VGND VPWR VGND sky130_ef_sc_hd__decap_12
Xclkbuf_2_1__f_clk clknet_0_clk VGND VGND VPWR VPWR clknet_2_1__leaf_clk sky130_fd_sc_hd__clkbuf_16
XTAP_TAPCELL_ROW_35_823 VGND VPWR sky130_fd_sc_hd__tapvpwrvgnd_1
X_4954_ _2464_ VGND VGND VPWR VPWR _0444_ sky130_fd_sc_hd__clkbuf_1
XFILLER_0_19_405 VPWR VGND VPWR VGND sky130_ef_sc_hd__decap_12
X_3905_ _0683_ _1831_ VGND VGND VPWR VPWR _1832_ sky130_fd_sc_hd__nand2_1
XFILLER_0_74_533 VPWR VGND VPWR VGND sky130_ef_sc_hd__decap_12
XFILLER_0_19_449 VPWR VGND VPWR VGND sky130_ef_sc_hd__decap_12
XFILLER_0_129_473 VPWR VGND VPWR VGND sky130_ef_sc_hd__decap_12
X_4885_ _2427_ VGND VGND VPWR VPWR _0412_ sky130_fd_sc_hd__clkbuf_1
XFILLER_0_7_833 VGND VGND VPWR VPWR sky130_fd_sc_hd__decap_6
X_3836_ _1762_ _1763_ _1312_ VGND VGND VPWR VPWR _1764_ sky130_fd_sc_hd__mux2_1
XFILLER_0_61_205 VPWR VGND VPWR VGND sky130_ef_sc_hd__decap_12
XFILLER_0_6_321 VPWR VGND VPWR VGND sky130_ef_sc_hd__decap_12
XFILLER_0_34_419 VGND VGND VPWR VPWR sky130_fd_sc_hd__fill_1
XFILLER_0_104_307 VGND VGND VPWR VPWR sky130_fd_sc_hd__fill_1
X_3767_ cpu_inst.regfile_inst.registers\[9\]\[25\] cpu_inst.regfile_inst.registers\[8\]\[25\]
+ _1348_ VGND VGND VPWR VPWR _1697_ sky130_fd_sc_hd__mux2_1
XFILLER_0_61_249 VPWR VGND VPWR VGND sky130_ef_sc_hd__decap_12
XFILLER_0_14_121 VPWR VGND VPWR VGND sky130_ef_sc_hd__decap_12
XFILLER_0_6_365 VPWR VGND VPWR VGND sky130_ef_sc_hd__decap_12
XFILLER_0_131_137 VPWR VGND VPWR VGND sky130_ef_sc_hd__decap_12
XFILLER_0_116_189 VGND VGND VPWR VPWR sky130_fd_sc_hd__decap_6
XFILLER_0_113_841 VGND VGND VPWR VPWR sky130_fd_sc_hd__fill_1
XPHY_EDGE_ROW_89_Left_228 VGND VGND VPWR VPWR sky130_fd_sc_hd__decap_3
X_2718_ _0682_ VGND VGND VPWR VPWR _0683_ sky130_fd_sc_hd__clkbuf_4
XFILLER_0_14_165 VPWR VGND VPWR VGND sky130_ef_sc_hd__decap_12
X_5506_ clknet_leaf_32_clk _0426_ VGND VGND VPWR VPWR cpu_inst.regfile_inst.registers\[8\]\[10\]
+ sky130_fd_sc_hd__dfxtp_1
XFILLER_0_42_463 VGND VGND VPWR VPWR sky130_fd_sc_hd__decap_4
X_3698_ _0843_ _1628_ _1629_ net42 VGND VGND VPWR VPWR _1630_ sky130_fd_sc_hd__o211a_1
X_5437_ clknet_leaf_39_clk _0357_ VGND VGND VPWR VPWR cpu_inst.regfile_inst.registers\[0\]\[4\]
+ sky130_fd_sc_hd__dfxtp_1
X_2649_ _0560_ _0592_ VGND VGND VPWR VPWR _0614_ sky130_fd_sc_hd__or2_2
XFILLER_0_77_81 VPWR VGND VPWR VGND sky130_ef_sc_hd__decap_12
X_5368_ clknet_leaf_37_clk _0288_ VGND VGND VPWR VPWR cpu_inst.regfile_inst.registers\[10\]\[0\]
+ sky130_fd_sc_hd__dfxtp_1
X_5299_ clknet_leaf_7_clk _0219_ VGND VGND VPWR VPWR cpu_inst.regfile_inst.registers\[1\]\[27\]
+ sky130_fd_sc_hd__dfxtp_1
X_4319_ _1164_ cpu_inst.regfile_inst.registers\[5\]\[10\] _2092_ VGND VGND VPWR VPWR
+ _2104_ sky130_fd_sc_hd__mux2_1
XTAP_TAPCELL_ROW_89_1629 VGND VPWR sky130_fd_sc_hd__tapvpwrvgnd_1
XPHY_EDGE_ROW_98_Left_237 VGND VGND VPWR VPWR sky130_fd_sc_hd__decap_3
XTAP_TAPCELL_ROW_100_1807 VGND VPWR sky130_fd_sc_hd__tapvpwrvgnd_1
XFILLER_0_77_393 VPWR VGND VPWR VGND sky130_ef_sc_hd__decap_12
XFILLER_0_108_613 VGND VGND VPWR VPWR sky130_fd_sc_hd__decap_8
XFILLER_0_38_769 VPWR VGND VPWR VGND sky130_ef_sc_hd__decap_12
XFILLER_0_108_657 VPWR VGND VPWR VGND sky130_ef_sc_hd__decap_12
XFILLER_0_92_363 VGND VGND VPWR VPWR sky130_fd_sc_hd__fill_1
XFILLER_0_80_525 VGND VGND VPWR VPWR sky130_fd_sc_hd__decap_4
XFILLER_0_9_181 VPWR VGND VPWR VGND sky130_ef_sc_hd__decap_12
XFILLER_0_37_279 VGND VGND VPWR VPWR sky130_fd_sc_hd__fill_1
XFILLER_0_107_167 VGND VGND VPWR VPWR sky130_fd_sc_hd__fill_1
XFILLER_0_104_841 VGND VGND VPWR VPWR sky130_fd_sc_hd__fill_1
XFILLER_0_33_441 VGND VGND VPWR VPWR sky130_fd_sc_hd__decap_6
XFILLER_0_61_794 VGND VGND VPWR VPWR sky130_fd_sc_hd__decap_3
XFILLER_0_131_671 VGND VGND VPWR VPWR sky130_fd_sc_hd__fill_1
XFILLER_0_103_373 VPWR VGND VPWR VGND sky130_ef_sc_hd__decap_12
XTAP_TAPCELL_ROW_111_1969 VGND VPWR sky130_fd_sc_hd__tapvpwrvgnd_1
XTAP_TAPCELL_ROW_111_1958 VGND VPWR sky130_fd_sc_hd__tapvpwrvgnd_1
XTAP_TAPCELL_ROW_53_1098 VGND VPWR sky130_fd_sc_hd__tapvpwrvgnd_1
XFILLER_0_73_39 VPWR VGND VPWR VGND sky130_ef_sc_hd__decap_12
XFILLER_0_88_658 VGND VGND VPWR VPWR sky130_fd_sc_hd__fill_2
XFILLER_0_87_113 VPWR VGND VPWR VGND sky130_ef_sc_hd__decap_12
XFILLER_0_96_680 VGND VGND VPWR VPWR sky130_fd_sc_hd__fill_1
XFILLER_0_56_522 VGND VGND VPWR VPWR sky130_fd_sc_hd__decap_6
XFILLER_0_138_281 VPWR VGND VPWR VGND sky130_ef_sc_hd__decap_12
XFILLER_0_126_421 VPWR VGND VPWR VGND sky130_ef_sc_hd__decap_12
X_4670_ cpu_inst.decoder_inst.current_pc\[5\] _2295_ VGND VGND VPWR VPWR _2300_ sky130_fd_sc_hd__nor2_1
XFILLER_0_16_419 VGND VGND VPWR VPWR sky130_fd_sc_hd__fill_1
XFILLER_0_22_65 VPWR VGND VPWR VGND sky130_ef_sc_hd__decap_12
XFILLER_0_43_205 VPWR VGND VPWR VGND sky130_ef_sc_hd__decap_12
X_3621_ _0721_ VGND VGND VPWR VPWR _1555_ sky130_fd_sc_hd__buf_4
XFILLER_0_4_825 VPWR VGND VPWR VGND sky130_ef_sc_hd__decap_12
XFILLER_0_43_249 VPWR VGND VPWR VGND sky130_ef_sc_hd__decap_12
XFILLER_0_113_137 VPWR VGND VPWR VGND sky130_ef_sc_hd__decap_12
X_3552_ cpu_inst.regfile_inst.registers\[25\]\[19\] _1285_ _1449_ _1464_ VGND VGND
+ VPWR VPWR _1488_ sky130_fd_sc_hd__o211ai_1
XFILLER_0_3_335 VGND VGND VPWR VPWR sky130_fd_sc_hd__fill_1
XFILLER_0_12_625 VPWR VGND VPWR VGND sky130_ef_sc_hd__decap_12
XFILLER_0_11_113 VPWR VGND VPWR VGND sky130_ef_sc_hd__decap_12
XFILLER_0_122_693 VGND VGND VPWR VPWR sky130_fd_sc_hd__decap_6
XFILLER_0_110_811 VGND VGND VPWR VPWR sky130_fd_sc_hd__fill_1
X_3483_ _1374_ _1407_ VGND VGND VPWR VPWR _1420_ sky130_fd_sc_hd__nand2_1
XFILLER_0_12_669 VPWR VGND VPWR VGND sky130_ef_sc_hd__decap_12
XFILLER_0_51_293 VPWR VGND VPWR VGND sky130_ef_sc_hd__decap_12
XFILLER_0_121_181 VPWR VGND VPWR VGND sky130_ef_sc_hd__decap_12
X_5222_ clknet_leaf_22_clk _0142_ VGND VGND VPWR VPWR cpu_inst.regfile_inst.registers\[24\]\[14\]
+ sky130_fd_sc_hd__dfxtp_1
XFILLER_0_138_53 VGND VGND VPWR VPWR sky130_fd_sc_hd__decap_3
XPHY_EDGE_ROW_135_Right_135 VGND VGND VPWR VPWR sky130_fd_sc_hd__decap_3
X_5153_ clknet_leaf_25_clk _0073_ VGND VGND VPWR VPWR cpu_inst.regfile_inst.registers\[25\]\[9\]
+ sky130_fd_sc_hd__dfxtp_1
X_4104_ _1989_ VGND VGND VPWR VPWR _1990_ sky130_fd_sc_hd__dlymetal6s2s_1
XFILLER_0_47_51 VGND VGND VPWR VPWR sky130_fd_sc_hd__decap_4
XFILLER_0_138_97 VPWR VGND VPWR VGND sky130_ef_sc_hd__decap_12
X_5084_ clknet_leaf_33_clk _0004_ VGND VGND VPWR VPWR cpu_inst.regfile_inst.registers\[6\]\[4\]
+ sky130_fd_sc_hd__dfxtp_1
XFILLER_0_79_625 VGND VGND VPWR VPWR sky130_fd_sc_hd__decap_8
X_4035_ _1953_ VGND VGND VPWR VPWR _0036_ sky130_fd_sc_hd__clkbuf_1
XFILLER_0_79_669 VGND VGND VPWR VPWR sky130_fd_sc_hd__decap_3
XFILLER_0_2_53 VPWR VGND VPWR VGND sky130_ef_sc_hd__decap_12
XFILLER_0_94_606 VGND VGND VPWR VPWR sky130_fd_sc_hd__fill_2
XTAP_TAPCELL_ROW_84_1559 VGND VPWR sky130_fd_sc_hd__tapvpwrvgnd_1
XFILLER_0_2_97 VPWR VGND VPWR VGND sky130_ef_sc_hd__decap_12
XFILLER_0_93_105 VGND VGND VPWR VPWR sky130_fd_sc_hd__decap_6
XFILLER_0_93_149 VPWR VGND VPWR VGND sky130_ef_sc_hd__decap_12
X_4937_ _1534_ cpu_inst.regfile_inst.registers\[8\]\[20\] _2449_ VGND VGND VPWR VPWR
+ _2456_ sky130_fd_sc_hd__mux2_1
XFILLER_0_59_393 VGND VGND VPWR VPWR sky130_fd_sc_hd__fill_2
XFILLER_0_47_555 VGND VGND VPWR VPWR sky130_fd_sc_hd__fill_2
XFILLER_0_129_281 VPWR VGND VPWR VGND sky130_ef_sc_hd__decap_12
X_4868_ cpu_inst.regfile_inst.registers\[9\]\[20\] VGND VGND VPWR VPWR _2419_ sky130_fd_sc_hd__clkbuf_1
XFILLER_0_74_363 VGND VGND VPWR VPWR sky130_fd_sc_hd__fill_1
XFILLER_0_62_525 VGND VGND VPWR VPWR sky130_fd_sc_hd__decap_4
XFILLER_0_7_641 VPWR VGND VPWR VGND sky130_ef_sc_hd__decap_12
XFILLER_0_19_279 VGND VGND VPWR VPWR sky130_fd_sc_hd__fill_1
XFILLER_0_47_577 VGND VGND VPWR VPWR sky130_fd_sc_hd__fill_1
X_3819_ cpu_inst.regfile_inst.registers\[24\]\[26\] _1384_ _0700_ _1747_ _0699_ VGND
+ VGND VPWR VPWR _1748_ sky130_fd_sc_hd__o221ai_4
XFILLER_0_7_685 VPWR VGND VPWR VGND sky130_ef_sc_hd__decap_12
XFILLER_0_132_413 VGND VGND VPWR VPWR sky130_fd_sc_hd__decap_6
XTAP_TAPCELL_ROW_115_2025 VGND VPWR sky130_fd_sc_hd__tapvpwrvgnd_1
XFILLER_0_105_649 VGND VGND VPWR VPWR sky130_fd_sc_hd__decap_3
XTAP_TAPCELL_ROW_99_1791 VGND VPWR sky130_fd_sc_hd__tapvpwrvgnd_1
XTAP_TAPCELL_ROW_99_1780 VGND VPWR sky130_fd_sc_hd__tapvpwrvgnd_1
X_4799_ _2384_ VGND VGND VPWR VPWR _0369_ sky130_fd_sc_hd__clkbuf_1
XFILLER_0_6_195 VGND VGND VPWR VPWR sky130_fd_sc_hd__fill_1
XFILLER_0_15_441 VGND VGND VPWR VPWR sky130_fd_sc_hd__decap_6
XFILLER_0_132_457 VPWR VGND VPWR VGND sky130_ef_sc_hd__decap_12
XFILLER_0_15_485 VPWR VGND VPWR VGND sky130_ef_sc_hd__decap_12
XFILLER_0_113_671 VGND VGND VPWR VPWR sky130_fd_sc_hd__fill_1
XFILLER_0_101_833 VGND VGND VPWR VPWR sky130_fd_sc_hd__decap_6
XFILLER_0_30_433 VPWR VGND VPWR VGND sky130_ef_sc_hd__decap_12
XFILLER_0_100_321 VPWR VGND VPWR VGND sky130_ef_sc_hd__decap_12
XFILLER_0_100_365 VPWR VGND VPWR VGND sky130_ef_sc_hd__decap_12
XPHY_EDGE_ROW_102_Right_102 VGND VGND VPWR VPWR sky130_fd_sc_hd__decap_3
XTAP_TAPCELL_ROW_126_2187 VGND VPWR sky130_fd_sc_hd__tapvpwrvgnd_1
XFILLER_0_69_113 VPWR VGND VPWR VGND sky130_ef_sc_hd__decap_12
XFILLER_0_97_488 VGND VGND VPWR VPWR sky130_fd_sc_hd__fill_1
XFILLER_0_65_330 VGND VGND VPWR VPWR sky130_fd_sc_hd__decap_6
XTAP_TAPCELL_ROW_26_686 VGND VPWR sky130_fd_sc_hd__tapvpwrvgnd_1
XTAP_TAPCELL_ROW_26_697 VGND VPWR sky130_fd_sc_hd__tapvpwrvgnd_1
XFILLER_0_108_421 VPWR VGND VPWR VGND sky130_ef_sc_hd__decap_12
XFILLER_0_53_503 VGND VGND VPWR VPWR sky130_fd_sc_hd__fill_1
XFILLER_0_25_205 VPWR VGND VPWR VGND sky130_ef_sc_hd__decap_12
XFILLER_0_80_333 VPWR VGND VPWR VGND sky130_ef_sc_hd__decap_12
XFILLER_0_25_249 VPWR VGND VPWR VGND sky130_ef_sc_hd__decap_12
XFILLER_0_135_273 VGND VGND VPWR VPWR sky130_fd_sc_hd__decap_6
XFILLER_0_0_305 VGND VGND VPWR VPWR sky130_fd_sc_hd__decap_3
XFILLER_0_1_839 VGND VGND VPWR VPWR sky130_fd_sc_hd__fill_1
XFILLER_0_33_293 VPWR VGND VPWR VGND sky130_ef_sc_hd__decap_12
XFILLER_0_103_181 VPWR VGND VPWR VGND sky130_ef_sc_hd__decap_12
XTAP_TAPCELL_ROW_55_1127 VGND VPWR sky130_fd_sc_hd__tapvpwrvgnd_1
XFILLER_0_0_349 VPWR VGND VPWR VGND sky130_ef_sc_hd__decap_12
XFILLER_0_84_27 VGND VGND VPWR VPWR sky130_fd_sc_hd__fill_1
XFILLER_0_88_400 VGND VGND VPWR VPWR sky130_fd_sc_hd__decap_4
XFILLER_0_75_105 VGND VGND VPWR VPWR sky130_fd_sc_hd__decap_6
XFILLER_0_29_511 VGND VGND VPWR VPWR sky130_fd_sc_hd__fill_1
XTAP_TAPCELL_ROW_45_973 VGND VPWR sky130_fd_sc_hd__tapvpwrvgnd_1
XFILLER_0_124_77 VGND VGND VPWR VPWR sky130_fd_sc_hd__decap_6
XFILLER_0_75_149 VPWR VGND VPWR VGND sky130_ef_sc_hd__decap_12
XTAP_TAPCELL_ROW_66_1289 VGND VPWR sky130_fd_sc_hd__tapvpwrvgnd_1
X_2983_ _0938_ _0947_ VGND VGND VPWR VPWR _0948_ sky130_fd_sc_hd__nand2_1
XFILLER_0_29_544 VGND VGND VPWR VPWR sky130_fd_sc_hd__fill_1
XFILLER_0_127_741 VPWR VGND VPWR VGND sky130_ef_sc_hd__decap_12
XFILLER_0_72_823 VGND VGND VPWR VPWR sky130_fd_sc_hd__fill_2
X_4722_ cpu_inst.decoder_inst.current_pc\[19\] _2288_ _2318_ _2337_ VGND VGND VPWR
+ VPWR _0339_ sky130_fd_sc_hd__o22a_1
XFILLER_0_127_785 VPWR VGND VPWR VGND sky130_ef_sc_hd__decap_12
XFILLER_0_126_251 VGND VGND VPWR VPWR sky130_fd_sc_hd__fill_1
XFILLER_0_83_193 VPWR VGND VPWR VGND sky130_ef_sc_hd__decap_12
XFILLER_0_72_834 VGND VGND VPWR VPWR sky130_fd_sc_hd__decap_8
XFILLER_0_114_413 VGND VGND VPWR VPWR sky130_fd_sc_hd__decap_6
XFILLER_0_71_344 VGND VGND VPWR VPWR sky130_fd_sc_hd__fill_1
X_4653_ _2284_ _2285_ VGND VGND VPWR VPWR _2286_ sky130_fd_sc_hd__nand2_1
XFILLER_0_114_457 VPWR VGND VPWR VGND sky130_ef_sc_hd__decap_12
X_3604_ cpu_inst.regfile_inst.registers\[7\]\[21\] cpu_inst.regfile_inst.registers\[6\]\[21\]
+ _1348_ VGND VGND VPWR VPWR _1538_ sky130_fd_sc_hd__mux2_1
XFILLER_0_25_783 VGND VGND VPWR VPWR sky130_fd_sc_hd__fill_1
X_4584_ cpu_inst.regfile_inst.registers\[10\]\[11\] _2230_ VGND VGND VPWR VPWR _2240_
+ sky130_fd_sc_hd__and2_1
X_3535_ cpu_inst.regfile_inst.registers\[2\]\[19\] _1469_ _1470_ cpu_inst.regfile_inst.registers\[7\]\[19\]
+ VGND VGND VPWR VPWR _1471_ sky130_fd_sc_hd__o22a_1
XFILLER_0_12_433 VPWR VGND VPWR VGND sky130_ef_sc_hd__decap_12
XFILLER_0_4_699 VGND VGND VPWR VPWR sky130_fd_sc_hd__fill_1
X_3466_ cpu_inst.regfile_inst.registers\[24\]\[17\] _0697_ VGND VGND VPWR VPWR _1404_
+ sky130_fd_sc_hd__or2_1
XFILLER_0_12_477 VPWR VGND VPWR VGND sky130_ef_sc_hd__decap_12
X_5205_ clknet_leaf_6_clk _0125_ VGND VGND VPWR VPWR cpu_inst.regfile_inst.registers\[4\]\[29\]
+ sky130_fd_sc_hd__dfxtp_1
XFILLER_0_58_83 VGND VGND VPWR VPWR sky130_fd_sc_hd__fill_1
XFILLER_0_42_3 VPWR VGND VPWR VGND sky130_ef_sc_hd__decap_12
X_3397_ _1340_ VGND VGND VPWR VPWR _0011_ sky130_fd_sc_hd__clkbuf_1
X_5136_ clknet_leaf_8_clk _0056_ VGND VGND VPWR VPWR cpu_inst.regfile_inst.registers\[2\]\[24\]
+ sky130_fd_sc_hd__dfxtp_1
XTAP_TAPCELL_ROW_4_359 VGND VPWR sky130_fd_sc_hd__tapvpwrvgnd_1
X_5067_ cpu_inst.display_inst.counter\[15\] _2526_ VGND VGND VPWR VPWR _2527_ sky130_fd_sc_hd__or2_1
X_4018_ _1940_ _0527_ VGND VGND VPWR VPWR _1941_ sky130_fd_sc_hd__or2b_1
XFILLER_0_79_477 VGND VGND VPWR VPWR sky130_fd_sc_hd__fill_2
XFILLER_0_137_505 VPWR VGND VPWR VGND sky130_ef_sc_hd__decap_12
XFILLER_0_94_469 VGND VGND VPWR VPWR sky130_fd_sc_hd__decap_6
XTAP_TAPCELL_ROW_23_645 VGND VPWR sky130_fd_sc_hd__tapvpwrvgnd_1
XFILLER_0_47_385 VGND VGND VPWR VPWR sky130_fd_sc_hd__decap_6
XFILLER_0_132_221 VPWR VGND VPWR VGND sky130_ef_sc_hd__decap_12
XFILLER_0_117_273 VGND VGND VPWR VPWR sky130_fd_sc_hd__decap_6
XFILLER_0_105_435 VGND VGND VPWR VPWR sky130_fd_sc_hd__fill_1
XFILLER_0_90_664 VGND VGND VPWR VPWR sky130_fd_sc_hd__decap_4
XFILLER_0_23_709 VPWR VGND VPWR VGND sky130_ef_sc_hd__decap_12
XFILLER_0_35_558 VGND VGND VPWR VPWR sky130_fd_sc_hd__fill_2
XFILLER_0_133_777 VGND VGND VPWR VPWR sky130_fd_sc_hd__decap_6
XFILLER_0_62_388 VGND VGND VPWR VPWR sky130_fd_sc_hd__fill_1
XFILLER_0_132_265 VPWR VGND VPWR VGND sky130_ef_sc_hd__decap_12
XFILLER_0_15_293 VPWR VGND VPWR VGND sky130_ef_sc_hd__decap_12
XFILLER_0_31_753 VPWR VGND VPWR VGND sky130_ef_sc_hd__decap_12
XTAP_TAPCELL_ROW_128_2216 VGND VPWR sky130_fd_sc_hd__tapvpwrvgnd_1
XTAP_TAPCELL_ROW_128_2227 VGND VPWR sky130_fd_sc_hd__tapvpwrvgnd_1
XFILLER_0_100_195 VGND VGND VPWR VPWR sky130_fd_sc_hd__fill_1
XTAP_TAPCELL_ROW_50_1046 VGND VPWR sky130_fd_sc_hd__tapvpwrvgnd_1
XTAP_TAPCELL_ROW_50_1057 VGND VPWR sky130_fd_sc_hd__tapvpwrvgnd_1
XFILLER_0_57_105 VGND VGND VPWR VPWR sky130_fd_sc_hd__decap_6
XFILLER_0_70_29 VPWR VGND VPWR VGND sky130_ef_sc_hd__decap_12
XFILLER_0_57_149 VPWR VGND VPWR VGND sky130_ef_sc_hd__decap_12
XTAP_TAPCELL_ROW_42_932 VGND VPWR sky130_fd_sc_hd__tapvpwrvgnd_1
XFILLER_0_109_741 VPWR VGND VPWR VGND sky130_ef_sc_hd__decap_12
XFILLER_0_38_363 VGND VGND VPWR VPWR sky130_fd_sc_hd__fill_1
XFILLER_0_108_251 VGND VGND VPWR VPWR sky130_fd_sc_hd__fill_1
XFILLER_0_65_193 VPWR VGND VPWR VGND sky130_ef_sc_hd__decap_12
XFILLER_0_54_834 VGND VGND VPWR VPWR sky130_fd_sc_hd__decap_8
XFILLER_0_109_785 VPWR VGND VPWR VGND sky130_ef_sc_hd__decap_12
XFILLER_0_80_141 VPWR VGND VPWR VGND sky130_ef_sc_hd__decap_12
XFILLER_0_79_27 VPWR VGND VPWR VGND sky130_ef_sc_hd__decap_12
XFILLER_0_53_344 VPWR VGND VPWR VGND sky130_ef_sc_hd__decap_12
XFILLER_0_124_755 VGND VGND VPWR VPWR sky130_fd_sc_hd__fill_1
XFILLER_0_111_405 VPWR VGND VPWR VGND sky130_ef_sc_hd__decap_12
XFILLER_0_111_449 VPWR VGND VPWR VGND sky130_ef_sc_hd__decap_12
XFILLER_0_104_490 VGND VGND VPWR VPWR sky130_fd_sc_hd__fill_1
X_3320_ _1268_ VGND VGND VPWR VPWR _1280_ sky130_fd_sc_hd__inv_2
XFILLER_0_0_113 VPWR VGND VPWR VGND sky130_ef_sc_hd__decap_12
XFILLER_0_95_15 VPWR VGND VPWR VGND sky130_ef_sc_hd__decap_12
X_3251_ _0689_ _1215_ VGND VGND VPWR VPWR _1216_ sky130_fd_sc_hd__and2_1
XFILLER_0_119_55 VGND VGND VPWR VPWR sky130_fd_sc_hd__fill_1
X_3182_ _1146_ VGND VGND VPWR VPWR _1147_ sky130_fd_sc_hd__inv_2
XFILLER_0_28_53 VPWR VGND VPWR VGND sky130_ef_sc_hd__decap_12
XFILLER_0_28_97 VPWR VGND VPWR VGND sky130_ef_sc_hd__decap_12
XTAP_TAPCELL_ROW_68_1318 VGND VPWR sky130_fd_sc_hd__tapvpwrvgnd_1
XTAP_TAPCELL_ROW_1_318 VGND VPWR sky130_fd_sc_hd__tapvpwrvgnd_1
XFILLER_0_44_41 VPWR VGND VPWR VGND sky130_ef_sc_hd__decap_12
XFILLER_0_44_85 VPWR VGND VPWR VGND sky130_ef_sc_hd__decap_12
XFILLER_0_119_505 VPWR VGND VPWR VGND sky130_ef_sc_hd__decap_12
XTAP_TAPCELL_ROW_81_1518 VGND VPWR sky130_fd_sc_hd__tapvpwrvgnd_1
XFILLER_0_91_417 VGND VGND VPWR VPWR sky130_fd_sc_hd__decap_4
XFILLER_0_57_661 VGND VGND VPWR VPWR sky130_fd_sc_hd__decap_8
XFILLER_0_17_503 VGND VGND VPWR VPWR sky130_fd_sc_hd__fill_1
XFILLER_0_45_823 VGND VGND VPWR VPWR sky130_fd_sc_hd__fill_1
X_2966_ _0639_ _0805_ VGND VGND VPWR VPWR _0931_ sky130_fd_sc_hd__or2_1
XTAP_TAPCELL_ROW_20_604 VGND VPWR sky130_fd_sc_hd__tapvpwrvgnd_1
XFILLER_0_29_385 VGND VGND VPWR VPWR sky130_fd_sc_hd__decap_6
XFILLER_0_44_333 VPWR VGND VPWR VGND sky130_ef_sc_hd__decap_12
X_4705_ cpu_inst.decoder_inst.current_pc\[14\] _2285_ _2286_ _2325_ VGND VGND VPWR
+ VPWR _0334_ sky130_fd_sc_hd__o22a_1
X_2897_ _0842_ _0861_ VGND VGND VPWR VPWR _0862_ sky130_fd_sc_hd__xnor2_2
XFILLER_0_115_777 VGND VGND VPWR VPWR sky130_fd_sc_hd__decap_6
XFILLER_0_114_221 VPWR VGND VPWR VGND sky130_ef_sc_hd__decap_12
X_4636_ cpu_inst.display_inst.digit_select\[0\] _2270_ VGND VGND VPWR VPWR _0320_
+ sky130_fd_sc_hd__xnor2_1
XFILLER_0_8_41 VPWR VGND VPWR VGND sky130_ef_sc_hd__decap_12
XFILLER_0_44_377 VPWR VGND VPWR VGND sky130_ef_sc_hd__decap_12
XFILLER_0_130_725 VPWR VGND VPWR VGND sky130_ef_sc_hd__decap_12
XFILLER_0_114_265 VPWR VGND VPWR VGND sky130_ef_sc_hd__decap_12
XFILLER_0_13_753 VPWR VGND VPWR VGND sky130_ef_sc_hd__decap_12
XFILLER_0_130_769 VPWR VGND VPWR VGND sky130_ef_sc_hd__decap_12
XFILLER_0_69_93 VPWR VGND VPWR VGND sky130_ef_sc_hd__decap_12
XTAP_TAPCELL_ROW_9_429 VGND VPWR sky130_fd_sc_hd__tapvpwrvgnd_1
XFILLER_0_8_85 VPWR VGND VPWR VGND sky130_ef_sc_hd__decap_12
X_4567_ cpu_inst.regfile_inst.registers\[10\]\[2\] _2230_ VGND VGND VPWR VPWR _2232_
+ sky130_fd_sc_hd__and2_1
X_3518_ _1448_ _1148_ _1454_ _1208_ VGND VGND VPWR VPWR _1455_ sky130_fd_sc_hd__a211o_1
XFILLER_0_13_797 VPWR VGND VPWR VGND sky130_ef_sc_hd__decap_12
X_4498_ cpu_inst.regfile_inst.registers\[11\]\[0\] VGND VGND VPWR VPWR _2197_ sky130_fd_sc_hd__clkbuf_1
X_3449_ cpu_inst.regfile_inst.registers\[5\]\[17\] cpu_inst.regfile_inst.registers\[4\]\[17\]
+ _1386_ VGND VGND VPWR VPWR _1387_ sky130_fd_sc_hd__mux2_1
XFILLER_0_99_528 VGND VGND VPWR VPWR sky130_fd_sc_hd__fill_2
XFILLER_0_85_81 VPWR VGND VPWR VGND sky130_ef_sc_hd__decap_12
X_5119_ clknet_leaf_33_clk _0039_ VGND VGND VPWR VPWR cpu_inst.regfile_inst.registers\[2\]\[7\]
+ sky130_fd_sc_hd__dfxtp_1
XTAP_TAPCELL_ROW_28_715 VGND VPWR sky130_fd_sc_hd__tapvpwrvgnd_1
XTAP_TAPCELL_ROW_123_2146 VGND VPWR sky130_fd_sc_hd__tapvpwrvgnd_1
XTAP_TAPCELL_ROW_28_726 VGND VPWR sky130_fd_sc_hd__tapvpwrvgnd_1
XFILLER_0_39_105 VGND VGND VPWR VPWR sky130_fd_sc_hd__decap_6
XFILLER_0_138_825 VPWR VGND VPWR VGND sky130_ef_sc_hd__decap_12
XFILLER_0_94_233 VPWR VGND VPWR VGND sky130_ef_sc_hd__decap_12
XFILLER_0_39_149 VPWR VGND VPWR VGND sky130_ef_sc_hd__decap_12
XFILLER_0_137_335 VGND VGND VPWR VPWR sky130_fd_sc_hd__fill_1
XFILLER_0_94_277 VPWR VGND VPWR VGND sky130_ef_sc_hd__decap_12
XFILLER_0_82_406 VPWR VGND VPWR VGND sky130_ef_sc_hd__decap_12
XFILLER_0_63_631 VGND VGND VPWR VPWR sky130_fd_sc_hd__decap_8
XFILLER_0_62_141 VPWR VGND VPWR VGND sky130_ef_sc_hd__decap_12
XFILLER_0_47_193 VPWR VGND VPWR VGND sky130_ef_sc_hd__decap_12
XFILLER_0_133_541 VPWR VGND VPWR VGND sky130_ef_sc_hd__decap_12
XFILLER_0_106_755 VGND VGND VPWR VPWR sky130_fd_sc_hd__fill_1
XFILLER_0_23_517 VPWR VGND VPWR VGND sky130_ef_sc_hd__decap_12
XFILLER_0_133_585 VPWR VGND VPWR VGND sky130_ef_sc_hd__decap_12
XTAP_TAPCELL_ROW_108_1919 VGND VPWR sky130_fd_sc_hd__tapvpwrvgnd_1
XFILLER_0_86_701 VGND VGND VPWR VPWR sky130_fd_sc_hd__decap_8
XFILLER_0_81_39 VPWR VGND VPWR VGND sky130_ef_sc_hd__decap_12
XFILLER_0_105_57 VPWR VGND VPWR VGND sky130_ef_sc_hd__decap_12
XTAP_TAPCELL_ROW_63_1248 VGND VPWR sky130_fd_sc_hd__tapvpwrvgnd_1
XFILLER_0_14_77 VGND VGND VPWR VPWR sky130_fd_sc_hd__decap_6
XFILLER_0_128_357 VGND VGND VPWR VPWR sky130_fd_sc_hd__decap_6
XFILLER_0_73_428 VGND VGND VPWR VPWR sky130_fd_sc_hd__fill_1
XFILLER_0_54_631 VGND VGND VPWR VPWR sky130_fd_sc_hd__fill_2
X_2820_ _0701_ _0784_ VGND VGND VPWR VPWR _0785_ sky130_fd_sc_hd__or2_1
XFILLER_0_54_642 VGND VGND VPWR VPWR sky130_fd_sc_hd__fill_2
XFILLER_0_5_205 VPWR VGND VPWR VGND sky130_ef_sc_hd__decap_12
XFILLER_0_26_333 VPWR VGND VPWR VGND sky130_ef_sc_hd__decap_12
X_2751_ _0701_ _0704_ _0708_ _0715_ VGND VGND VPWR VPWR _0716_ sky130_fd_sc_hd__o211a_1
X_2682_ _0529_ _0510_ _0531_ _0573_ VGND VGND VPWR VPWR _0647_ sky130_fd_sc_hd__o31a_2
XFILLER_0_5_249 VPWR VGND VPWR VGND sky130_ef_sc_hd__decap_12
XFILLER_0_26_377 VPWR VGND VPWR VGND sky130_ef_sc_hd__decap_12
XFILLER_0_30_65 VPWR VGND VPWR VGND sky130_ef_sc_hd__decap_12
X_5470_ clknet_leaf_34_clk _0390_ VGND VGND VPWR VPWR cpu_inst.regfile_inst.registers\[9\]\[6\]
+ sky130_fd_sc_hd__dfxtp_1
XFILLER_0_112_725 VPWR VGND VPWR VGND sky130_ef_sc_hd__decap_12
XFILLER_0_100_3 VPWR VGND VPWR VGND sky130_ef_sc_hd__decap_12
X_4421_ cpu_inst.regfile_inst.registers\[1\]\[28\] VGND VGND VPWR VPWR _2156_ sky130_fd_sc_hd__clkbuf_1
XFILLER_0_81_494 VGND VGND VPWR VPWR sky130_fd_sc_hd__decap_4
XFILLER_0_112_769 VPWR VGND VPWR VGND sky130_ef_sc_hd__decap_12
XFILLER_0_10_701 VPWR VGND VPWR VGND sky130_ef_sc_hd__decap_12
XFILLER_0_111_279 VGND VGND VPWR VPWR sky130_fd_sc_hd__fill_1
X_4352_ _2121_ VGND VGND VPWR VPWR _0185_ sky130_fd_sc_hd__clkbuf_1
X_4283_ cpu_inst.regfile_inst.registers\[24\]\[26\] VGND VGND VPWR VPWR _2084_ sky130_fd_sc_hd__clkbuf_1
X_3303_ _1200_ _1262_ _1266_ _1267_ VGND VGND VPWR VPWR net7 sky130_fd_sc_hd__o211a_1
X_3234_ net3 _1174_ _1184_ _1198_ VGND VGND VPWR VPWR _1199_ sky130_fd_sc_hd__a2bb2o_2
X_3165_ _1129_ cpu_inst.regfile_inst.registers\[10\]\[14\] _0871_ VGND VGND VPWR VPWR
+ _1130_ sky130_fd_sc_hd__mux2_1
XFILLER_0_55_51 VGND VGND VPWR VPWR sky130_fd_sc_hd__decap_4
X_3096_ _0985_ _1059_ _1060_ VGND VGND VPWR VPWR _1061_ sky130_fd_sc_hd__mux2_1
XFILLER_0_89_583 VGND VGND VPWR VPWR sky130_fd_sc_hd__decap_4
XFILLER_0_77_723 VGND VGND VPWR VPWR sky130_fd_sc_hd__fill_2
XFILLER_0_77_756 VGND VGND VPWR VPWR sky130_fd_sc_hd__fill_1
XFILLER_0_76_233 VPWR VGND VPWR VGND sky130_ef_sc_hd__decap_12
XFILLER_0_119_335 VGND VGND VPWR VPWR sky130_fd_sc_hd__fill_1
XFILLER_0_76_277 VPWR VGND VPWR VGND sky130_ef_sc_hd__decap_12
XFILLER_0_91_225 VPWR VGND VPWR VGND sky130_ef_sc_hd__decap_12
X_3998_ _1894_ _1896_ _1920_ VGND VGND VPWR VPWR _1922_ sky130_fd_sc_hd__o21ai_1
XFILLER_0_135_839 VGND VGND VPWR VPWR sky130_fd_sc_hd__fill_1
X_2949_ _0911_ _0913_ VGND VGND VPWR VPWR _0914_ sky130_fd_sc_hd__xnor2_1
XFILLER_0_29_193 VPWR VGND VPWR VGND sky130_ef_sc_hd__decap_12
XTAP_TAPCELL_ROW_33_795 VGND VPWR sky130_fd_sc_hd__tapvpwrvgnd_1
XFILLER_0_44_141 VPWR VGND VPWR VGND sky130_ef_sc_hd__decap_12
XFILLER_0_115_541 VPWR VGND VPWR VGND sky130_ef_sc_hd__decap_12
XPHY_EDGE_ROW_70_Left_209 VGND VGND VPWR VPWR sky130_fd_sc_hd__decap_3
XFILLER_0_60_612 VGND VGND VPWR VPWR sky130_fd_sc_hd__decap_3
XFILLER_0_115_585 VPWR VGND VPWR VGND sky130_ef_sc_hd__decap_12
XTAP_TAPCELL_ROW_94_1709 VGND VPWR sky130_fd_sc_hd__tapvpwrvgnd_1
XFILLER_0_5_783 VGND VGND VPWR VPWR sky130_fd_sc_hd__fill_1
XFILLER_0_130_533 VPWR VGND VPWR VGND sky130_ef_sc_hd__decap_12
X_4619_ _2258_ VGND VGND VPWR VPWR _0315_ sky130_fd_sc_hd__clkbuf_1
XFILLER_0_13_561 VPWR VGND VPWR VGND sky130_ef_sc_hd__decap_12
XTAP_TAPCELL_ROW_103_1849 VGND VPWR sky130_fd_sc_hd__tapvpwrvgnd_1
XTAP_TAPCELL_ROW_103_1838 VGND VPWR sky130_fd_sc_hd__tapvpwrvgnd_1
XFILLER_0_95_586 VGND VGND VPWR VPWR sky130_fd_sc_hd__fill_1
XPHY_EDGE_ROW_109_Left_248 VGND VGND VPWR VPWR sky130_fd_sc_hd__decap_3
XTAP_TAPCELL_ROW_136_2337 VGND VPWR sky130_fd_sc_hd__tapvpwrvgnd_1
XFILLER_0_125_305 VPWR VGND VPWR VGND sky130_ef_sc_hd__decap_12
XFILLER_0_125_349 VPWR VGND VPWR VGND sky130_ef_sc_hd__decap_12
XFILLER_0_63_472 VPWR VGND VPWR VGND sky130_ef_sc_hd__decap_12
XFILLER_0_3_709 VPWR VGND VPWR VGND sky130_ef_sc_hd__decap_12
XFILLER_0_24_837 VGND VGND VPWR VPWR sky130_fd_sc_hd__decap_4
XFILLER_0_51_612 VGND VGND VPWR VPWR sky130_fd_sc_hd__decap_4
XFILLER_0_106_563 VGND VGND VPWR VPWR sky130_fd_sc_hd__fill_1
Xclkload18 clknet_leaf_11_clk VGND VGND VPWR VPWR clkload18/Y sky130_fd_sc_hd__clkinv_8
XTAP_TAPCELL_ROW_11_467 VGND VPWR sky130_fd_sc_hd__tapvpwrvgnd_1
Xclkload29 clknet_leaf_35_clk VGND VGND VPWR VPWR clkload29/Y sky130_fd_sc_hd__clkinvlp_4
XFILLER_0_50_133 VGND VGND VPWR VPWR sky130_fd_sc_hd__decap_6
XFILLER_0_133_393 VPWR VGND VPWR VGND sky130_ef_sc_hd__decap_12
XFILLER_0_51_678 VGND VGND VPWR VPWR sky130_fd_sc_hd__fill_2
XFILLER_0_50_177 VPWR VGND VPWR VGND sky130_ef_sc_hd__decap_12
XFILLER_0_31_391 VGND VGND VPWR VPWR sky130_fd_sc_hd__fill_1
XPHY_EDGE_ROW_118_Left_257 VGND VGND VPWR VPWR sky130_fd_sc_hd__decap_3
XFILLER_0_92_27 VGND VGND VPWR VPWR sky130_fd_sc_hd__fill_1
XFILLER_0_58_233 VPWR VGND VPWR VGND sky130_ef_sc_hd__decap_12
XTAP_TAPCELL_ROW_19_578 VGND VPWR sky130_fd_sc_hd__tapvpwrvgnd_1
XTAP_TAPCELL_ROW_19_589 VGND VPWR sky130_fd_sc_hd__tapvpwrvgnd_1
X_4970_ _2473_ VGND VGND VPWR VPWR _0451_ sky130_fd_sc_hd__clkbuf_1
XFILLER_0_128_121 VPWR VGND VPWR VGND sky130_ef_sc_hd__decap_12
XPHY_EDGE_ROW_127_Left_266 VGND VGND VPWR VPWR sky130_fd_sc_hd__decap_3
X_3921_ cpu_inst.regfile_inst.registers\[1\]\[29\] _1804_ _1805_ cpu_inst.regfile_inst.registers\[5\]\[29\]
+ VGND VGND VPWR VPWR _1847_ sky130_fd_sc_hd__o22a_1
XFILLER_0_86_553 VGND VGND VPWR VPWR sky130_fd_sc_hd__fill_2
XFILLER_0_19_609 VGND VGND VPWR VPWR sky130_fd_sc_hd__decap_6
XFILLER_0_46_417 VGND VGND VPWR VPWR sky130_fd_sc_hd__decap_3
X_3852_ _0859_ _1778_ _1779_ _0610_ VGND VGND VPWR VPWR _1780_ sky130_fd_sc_hd__a31o_1
XFILLER_0_73_225 VPWR VGND VPWR VGND sky130_ef_sc_hd__decap_12
XFILLER_0_58_277 VPWR VGND VPWR VGND sky130_ef_sc_hd__decap_12
XFILLER_0_132_77 VGND VGND VPWR VPWR sky130_fd_sc_hd__decap_6
XFILLER_0_128_165 VPWR VGND VPWR VGND sky130_ef_sc_hd__decap_12
XFILLER_0_117_839 VGND VGND VPWR VPWR sky130_fd_sc_hd__fill_1
XFILLER_0_6_525 VGND VGND VPWR VPWR sky130_fd_sc_hd__decap_6
X_2803_ _0759_ _0767_ _0763_ _0612_ VGND VGND VPWR VPWR _0768_ sky130_fd_sc_hd__o31ai_4
X_3783_ _1557_ _1711_ _1712_ VGND VGND VPWR VPWR _1713_ sky130_fd_sc_hd__or3_1
X_5522_ clknet_leaf_10_clk _0442_ VGND VGND VPWR VPWR cpu_inst.regfile_inst.registers\[8\]\[26\]
+ sky130_fd_sc_hd__dfxtp_1
XFILLER_0_6_569 VPWR VGND VPWR VGND sky130_ef_sc_hd__decap_12
XFILLER_0_26_141 VPWR VGND VPWR VGND sky130_ef_sc_hd__decap_12
XFILLER_0_27_697 VPWR VGND VPWR VGND sky130_ef_sc_hd__decap_12
XTAP_TAPCELL_ROW_30_743 VGND VPWR sky130_fd_sc_hd__tapvpwrvgnd_1
XTAP_TAPCELL_ROW_30_754 VGND VPWR sky130_fd_sc_hd__tapvpwrvgnd_1
X_2734_ _0639_ _0636_ VGND VGND VPWR VPWR _0699_ sky130_fd_sc_hd__or2_4
XFILLER_0_41_111 VGND VGND VPWR VPWR sky130_fd_sc_hd__fill_1
XFILLER_0_42_645 VGND VGND VPWR VPWR sky130_fd_sc_hd__fill_2
XFILLER_0_112_533 VPWR VGND VPWR VGND sky130_ef_sc_hd__decap_12
X_5453_ clknet_leaf_18_clk _0373_ VGND VGND VPWR VPWR cpu_inst.regfile_inst.registers\[0\]\[21\]
+ sky130_fd_sc_hd__dfxtp_1
XTAP_TAPCELL_ROW_76_1439 VGND VPWR sky130_fd_sc_hd__tapvpwrvgnd_1
X_2665_ cpu_inst.regfile_inst.registers\[4\]\[1\] _0622_ _0584_ VGND VGND VPWR VPWR
+ _0630_ sky130_fd_sc_hd__o21a_1
XPHY_EDGE_ROW_136_Left_275 VGND VGND VPWR VPWR sky130_fd_sc_hd__decap_3
X_4404_ _2147_ VGND VGND VPWR VPWR _0211_ sky130_fd_sc_hd__clkbuf_1
X_5384_ clknet_leaf_22_clk _0304_ VGND VGND VPWR VPWR cpu_inst.regfile_inst.registers\[10\]\[16\]
+ sky130_fd_sc_hd__dfxtp_1
X_2596_ _0560_ VGND VGND VPWR VPWR _0561_ sky130_fd_sc_hd__clkbuf_4
XFILLER_0_10_531 VGND VGND VPWR VPWR sky130_fd_sc_hd__fill_1
X_4335_ _2112_ VGND VGND VPWR VPWR _0177_ sky130_fd_sc_hd__clkbuf_1
X_4266_ _2075_ VGND VGND VPWR VPWR _0145_ sky130_fd_sc_hd__clkbuf_1
X_4197_ _2040_ VGND VGND VPWR VPWR _0111_ sky130_fd_sc_hd__clkbuf_1
XFILLER_0_66_83 VGND VGND VPWR VPWR sky130_fd_sc_hd__fill_1
X_3217_ _1092_ _1181_ VGND VGND VPWR VPWR _1182_ sky130_fd_sc_hd__nor2_1
X_3148_ _0841_ _1112_ _0696_ VGND VGND VPWR VPWR _1113_ sky130_fd_sc_hd__a21oi_1
XTAP_TAPCELL_ROW_38_865 VGND VPWR sky130_fd_sc_hd__tapvpwrvgnd_1
XTAP_TAPCELL_ROW_120_2105 VGND VPWR sky130_fd_sc_hd__tapvpwrvgnd_1
XFILLER_0_89_391 VGND VGND VPWR VPWR sky130_fd_sc_hd__fill_1
X_3079_ _1043_ cpu_inst.regfile_inst.registers\[10\]\[13\] _0870_ VGND VGND VPWR VPWR
+ _1044_ sky130_fd_sc_hd__mux2_1
XTAP_TAPCELL_ROW_38_876 VGND VPWR sky130_fd_sc_hd__tapvpwrvgnd_1
XFILLER_0_77_553 VGND VGND VPWR VPWR sky130_fd_sc_hd__decap_6
XFILLER_0_65_715 VGND VGND VPWR VPWR sky130_fd_sc_hd__fill_2
XFILLER_0_92_523 VGND VGND VPWR VPWR sky130_fd_sc_hd__decap_4
XFILLER_0_37_417 VPWR VGND VPWR VGND sky130_ef_sc_hd__decap_12
XFILLER_0_107_305 VPWR VGND VPWR VGND sky130_ef_sc_hd__decap_12
XFILLER_0_9_385 VGND VGND VPWR VPWR sky130_fd_sc_hd__decap_6
XFILLER_0_123_809 VPWR VGND VPWR VGND sky130_ef_sc_hd__decap_12
XFILLER_0_107_349 VPWR VGND VPWR VGND sky130_ef_sc_hd__decap_12
XFILLER_0_73_770 VGND VGND VPWR VPWR sky130_fd_sc_hd__decap_4
XFILLER_0_33_601 VGND VGND VPWR VPWR sky130_fd_sc_hd__decap_6
XTAP_TAPCELL_ROW_118_2067 VGND VPWR sky130_fd_sc_hd__tapvpwrvgnd_1
XFILLER_0_60_431 VGND VGND VPWR VPWR sky130_fd_sc_hd__fill_2
XFILLER_0_32_133 VGND VGND VPWR VPWR sky130_fd_sc_hd__decap_6
XFILLER_0_33_634 VGND VGND VPWR VPWR sky130_fd_sc_hd__fill_1
XFILLER_0_115_393 VPWR VGND VPWR VGND sky130_ef_sc_hd__decap_12
XTAP_TAPCELL_ROW_131_2267 VGND VPWR sky130_fd_sc_hd__tapvpwrvgnd_1
XFILLER_0_32_177 VPWR VGND VPWR VGND sky130_ef_sc_hd__decap_12
XFILLER_0_130_363 VGND VGND VPWR VPWR sky130_fd_sc_hd__fill_1
XFILLER_0_13_391 VGND VGND VPWR VPWR sky130_fd_sc_hd__fill_1
XFILLER_0_99_111 VGND VGND VPWR VPWR sky130_fd_sc_hd__fill_1
XFILLER_0_87_317 VPWR VGND VPWR VGND sky130_ef_sc_hd__decap_12
XFILLER_0_68_531 VGND VGND VPWR VPWR sky130_fd_sc_hd__fill_1
XTAP_TAPCELL_ROW_47_1007 VGND VPWR sky130_fd_sc_hd__tapvpwrvgnd_1
XFILLER_0_95_361 VPWR VGND VPWR VGND sky130_ef_sc_hd__decap_12
XTAP_TAPCELL_ROW_16_537 VGND VPWR sky130_fd_sc_hd__tapvpwrvgnd_1
XTAP_TAPCELL_ROW_60_1207 VGND VPWR sky130_fd_sc_hd__tapvpwrvgnd_1
XFILLER_0_55_225 VPWR VGND VPWR VGND sky130_ef_sc_hd__decap_12
XFILLER_0_126_625 VPWR VGND VPWR VGND sky130_ef_sc_hd__decap_12
XFILLER_0_126_669 VPWR VGND VPWR VGND sky130_ef_sc_hd__decap_12
XFILLER_0_125_113 VPWR VGND VPWR VGND sky130_ef_sc_hd__decap_12
XFILLER_0_71_729 VGND VGND VPWR VPWR sky130_fd_sc_hd__decap_4
XFILLER_0_24_601 VGND VGND VPWR VPWR sky130_fd_sc_hd__decap_6
XFILLER_0_3_517 VPWR VGND VPWR VGND sky130_ef_sc_hd__decap_12
XFILLER_0_23_111 VGND VGND VPWR VPWR sky130_fd_sc_hd__fill_1
XFILLER_0_24_634 VGND VGND VPWR VPWR sky130_fd_sc_hd__decap_8
XFILLER_0_24_645 VPWR VGND VPWR VGND sky130_ef_sc_hd__decap_12
XFILLER_0_51_420 VGND VGND VPWR VPWR sky130_fd_sc_hd__fill_1
XPHY_EDGE_ROW_116_Right_116 VGND VGND VPWR VPWR sky130_fd_sc_hd__decap_3
XFILLER_0_87_27 VPWR VGND VPWR VGND sky130_ef_sc_hd__decap_12
XFILLER_0_11_317 VPWR VGND VPWR VGND sky130_ef_sc_hd__decap_12
XFILLER_0_51_497 VGND VGND VPWR VPWR sky130_fd_sc_hd__decap_6
XFILLER_0_121_385 VGND VGND VPWR VPWR sky130_fd_sc_hd__decap_6
XTAP_TAPCELL_ROW_58_1169 VGND VPWR sky130_fd_sc_hd__tapvpwrvgnd_1
XTAP_TAPCELL_ROW_71_1369 VGND VPWR sky130_fd_sc_hd__tapvpwrvgnd_1
XTAP_TAPCELL_ROW_71_1358 VGND VPWR sky130_fd_sc_hd__tapvpwrvgnd_1
X_4120_ _1999_ VGND VGND VPWR VPWR _0075_ sky130_fd_sc_hd__clkbuf_1
X_4051_ _1961_ VGND VGND VPWR VPWR _0044_ sky130_fd_sc_hd__clkbuf_1
XFILLER_0_127_55 VGND VGND VPWR VPWR sky130_fd_sc_hd__fill_1
XFILLER_0_36_53 VPWR VGND VPWR VGND sky130_ef_sc_hd__decap_12
X_3002_ cpu_inst.regfile_inst.registers\[5\]\[9\] cpu_inst.regfile_inst.registers\[4\]\[9\]
+ _0922_ VGND VGND VPWR VPWR _0967_ sky130_fd_sc_hd__mux2_1
XFILLER_0_36_97 VPWR VGND VPWR VGND sky130_ef_sc_hd__decap_12
X_4953_ _1947_ cpu_inst.regfile_inst.registers\[8\]\[28\] _2436_ VGND VGND VPWR VPWR
+ _2464_ sky130_fd_sc_hd__mux2_1
XTAP_TAPCELL_ROW_86_1590 VGND VPWR sky130_fd_sc_hd__tapvpwrvgnd_1
XFILLER_0_59_553 VGND VGND VPWR VPWR sky130_fd_sc_hd__decap_4
XTAP_TAPCELL_ROW_35_824 VGND VPWR sky130_fd_sc_hd__tapvpwrvgnd_1
XFILLER_0_52_41 VPWR VGND VPWR VGND sky130_ef_sc_hd__decap_12
XFILLER_0_129_441 VGND VGND VPWR VPWR sky130_fd_sc_hd__decap_6
X_3904_ _1448_ _1688_ _1830_ _1208_ VGND VGND VPWR VPWR _1831_ sky130_fd_sc_hd__a211o_1
XFILLER_0_19_417 VPWR VGND VPWR VGND sky130_ef_sc_hd__decap_12
XFILLER_0_129_485 VPWR VGND VPWR VGND sky130_ef_sc_hd__decap_12
X_4884_ cpu_inst.regfile_inst.registers\[9\]\[28\] VGND VGND VPWR VPWR _2427_ sky130_fd_sc_hd__clkbuf_1
XFILLER_0_74_545 VPWR VGND VPWR VGND sky130_ef_sc_hd__decap_12
XFILLER_0_52_85 VPWR VGND VPWR VGND sky130_ef_sc_hd__decap_12
XFILLER_0_105_809 VPWR VGND VPWR VGND sky130_ef_sc_hd__decap_12
X_3835_ cpu_inst.regfile_inst.registers\[7\]\[27\] cpu_inst.regfile_inst.registers\[6\]\[27\]
+ _1657_ VGND VGND VPWR VPWR _1763_ sky130_fd_sc_hd__mux2_1
XFILLER_0_74_589 VPWR VGND VPWR VGND sky130_ef_sc_hd__decap_12
XFILLER_0_61_217 VGND VGND VPWR VPWR sky130_fd_sc_hd__decap_6
XFILLER_0_6_333 VPWR VGND VPWR VGND sky130_ef_sc_hd__decap_12
XFILLER_0_27_461 VPWR VGND VPWR VGND sky130_ef_sc_hd__decap_12
XFILLER_0_131_105 VGND VGND VPWR VPWR sky130_fd_sc_hd__decap_6
X_3766_ _1694_ _1695_ _1351_ VGND VGND VPWR VPWR _1696_ sky130_fd_sc_hd__mux2_1
XFILLER_0_6_377 VPWR VGND VPWR VGND sky130_ef_sc_hd__decap_12
X_2717_ _0529_ _0572_ VGND VGND VPWR VPWR _0682_ sky130_fd_sc_hd__nor2_4
XFILLER_0_14_133 VGND VGND VPWR VPWR sky130_fd_sc_hd__decap_6
X_5505_ clknet_leaf_32_clk _0425_ VGND VGND VPWR VPWR cpu_inst.regfile_inst.registers\[8\]\[9\]
+ sky130_fd_sc_hd__dfxtp_1
XFILLER_0_131_149 VPWR VGND VPWR VGND sky130_ef_sc_hd__decap_12
X_3697_ cpu_inst.regfile_inst.registers\[24\]\[23\] _0698_ VGND VGND VPWR VPWR _1629_
+ sky130_fd_sc_hd__or2_1
XFILLER_0_72_3 VPWR VGND VPWR VGND sky130_ef_sc_hd__decap_12
XFILLER_0_14_177 VPWR VGND VPWR VGND sky130_ef_sc_hd__decap_12
X_5436_ clknet_leaf_39_clk _0356_ VGND VGND VPWR VPWR cpu_inst.regfile_inst.registers\[0\]\[3\]
+ sky130_fd_sc_hd__dfxtp_1
XFILLER_0_112_363 VGND VGND VPWR VPWR sky130_fd_sc_hd__fill_1
X_2648_ _0598_ VGND VGND VPWR VPWR _0613_ sky130_fd_sc_hd__clkbuf_4
X_5367_ clknet_leaf_4_clk _0287_ VGND VGND VPWR VPWR cpu_inst.regfile_inst.registers\[11\]\[31\]
+ sky130_fd_sc_hd__dfxtp_1
X_2579_ _0510_ _0511_ VGND VGND VPWR VPWR _0544_ sky130_fd_sc_hd__or2_1
X_5298_ clknet_leaf_8_clk _0218_ VGND VGND VPWR VPWR cpu_inst.regfile_inst.registers\[1\]\[26\]
+ sky130_fd_sc_hd__dfxtp_1
XFILLER_0_77_93 VPWR VGND VPWR VGND sky130_ef_sc_hd__decap_12
X_4318_ _2103_ VGND VGND VPWR VPWR _0169_ sky130_fd_sc_hd__clkbuf_1
X_4249_ cpu_inst.regfile_inst.registers\[24\]\[9\] VGND VGND VPWR VPWR _2067_ sky130_fd_sc_hd__clkbuf_1
XFILLER_0_97_626 VPWR VGND VPWR VGND sky130_ef_sc_hd__decap_12
XFILLER_0_93_81 VPWR VGND VPWR VGND sky130_ef_sc_hd__decap_12
XFILLER_0_78_840 VGND VGND VPWR VPWR sky130_fd_sc_hd__fill_2
XFILLER_0_84_309 VPWR VGND VPWR VGND sky130_ef_sc_hd__decap_12
XFILLER_0_77_361 VPWR VGND VPWR VGND sky130_ef_sc_hd__decap_12
XFILLER_0_37_225 VPWR VGND VPWR VGND sky130_ef_sc_hd__decap_12
XFILLER_0_38_737 VPWR VGND VPWR VGND sky130_ef_sc_hd__decap_12
XFILLER_0_108_669 VPWR VGND VPWR VGND sky130_ef_sc_hd__decap_12
XFILLER_0_107_113 VPWR VGND VPWR VGND sky130_ef_sc_hd__decap_12
XFILLER_0_9_193 VPWR VGND VPWR VGND sky130_ef_sc_hd__decap_12
XFILLER_0_123_617 VPWR VGND VPWR VGND sky130_ef_sc_hd__decap_12
XFILLER_0_61_773 VGND VGND VPWR VPWR sky130_fd_sc_hd__fill_2
XFILLER_0_21_615 VGND VGND VPWR VPWR sky130_fd_sc_hd__fill_1
XFILLER_0_33_475 VGND VGND VPWR VPWR sky130_fd_sc_hd__fill_1
XFILLER_0_103_385 VGND VGND VPWR VPWR sky130_fd_sc_hd__decap_6
XTAP_TAPCELL_ROW_111_1959 VGND VPWR sky130_fd_sc_hd__tapvpwrvgnd_1
XTAP_TAPCELL_ROW_53_1088 VGND VPWR sky130_fd_sc_hd__tapvpwrvgnd_1
XTAP_TAPCELL_ROW_53_1099 VGND VPWR sky130_fd_sc_hd__tapvpwrvgnd_1
XFILLER_0_88_615 VGND VGND VPWR VPWR sky130_fd_sc_hd__decap_4
XFILLER_0_87_125 VPWR VGND VPWR VGND sky130_ef_sc_hd__decap_12
XFILLER_0_87_169 VPWR VGND VPWR VGND sky130_ef_sc_hd__decap_12
XFILLER_0_68_350 VPWR VGND VPWR VGND sky130_ef_sc_hd__decap_12
XFILLER_0_84_821 VPWR VGND VPWR VGND sky130_ef_sc_hd__decap_12
XFILLER_0_138_293 VPWR VGND VPWR VGND sky130_ef_sc_hd__decap_12
XFILLER_0_126_433 VPWR VGND VPWR VGND sky130_ef_sc_hd__decap_12
XFILLER_0_113_57 VPWR VGND VPWR VGND sky130_ef_sc_hd__decap_12
XFILLER_0_43_217 VGND VGND VPWR VPWR sky130_fd_sc_hd__decap_6
XFILLER_0_126_477 VPWR VGND VPWR VGND sky130_ef_sc_hd__decap_12
X_3620_ cpu_inst.regfile_inst.registers\[8\]\[21\] _1553_ _0850_ VGND VGND VPWR VPWR
+ _1554_ sky130_fd_sc_hd__mux2_1
XFILLER_0_98_15 VPWR VGND VPWR VGND sky130_ef_sc_hd__decap_12
XFILLER_0_83_397 VGND VGND VPWR VPWR sky130_fd_sc_hd__fill_1
XFILLER_0_71_559 VGND VGND VPWR VPWR sky130_fd_sc_hd__fill_1
XFILLER_0_22_77 VGND VGND VPWR VPWR sky130_fd_sc_hd__decap_6
XFILLER_0_113_105 VGND VGND VPWR VPWR sky130_fd_sc_hd__decap_6
X_3551_ _1251_ VGND VGND VPWR VPWR _1487_ sky130_fd_sc_hd__buf_2
XFILLER_0_4_837 VGND VGND VPWR VPWR sky130_fd_sc_hd__fill_2
XTAP_TAPCELL_ROW_40_893 VGND VPWR sky130_fd_sc_hd__tapvpwrvgnd_1
XFILLER_0_113_149 VPWR VGND VPWR VGND sky130_ef_sc_hd__decap_12
XFILLER_0_12_637 VGND VGND VPWR VPWR sky130_fd_sc_hd__decap_6
XFILLER_0_24_475 VGND VGND VPWR VPWR sky130_fd_sc_hd__fill_1
XFILLER_0_51_261 VPWR VGND VPWR VGND sky130_ef_sc_hd__decap_12
X_3482_ _1419_ VGND VGND VPWR VPWR _0017_ sky130_fd_sc_hd__clkbuf_1
XFILLER_0_11_125 VPWR VGND VPWR VGND sky130_ef_sc_hd__decap_12
XFILLER_0_121_193 VPWR VGND VPWR VGND sky130_ef_sc_hd__decap_12
X_5221_ clknet_leaf_22_clk _0141_ VGND VGND VPWR VPWR cpu_inst.regfile_inst.registers\[24\]\[13\]
+ sky130_fd_sc_hd__dfxtp_1
XFILLER_0_11_169 VPWR VGND VPWR VGND sky130_ef_sc_hd__decap_12
X_5152_ clknet_leaf_25_clk _0072_ VGND VGND VPWR VPWR cpu_inst.regfile_inst.registers\[25\]\[8\]
+ sky130_fd_sc_hd__dfxtp_1
XFILLER_0_20_681 VPWR VGND VPWR VGND sky130_ef_sc_hd__decap_12
X_4103_ _0544_ _1291_ _1988_ VGND VGND VPWR VPWR _1989_ sky130_fd_sc_hd__and3_1
X_5083_ clknet_leaf_39_clk _0003_ VGND VGND VPWR VPWR cpu_inst.regfile_inst.registers\[6\]\[3\]
+ sky130_fd_sc_hd__dfxtp_1
X_4034_ cpu_inst.regfile_inst.registers\[2\]\[4\] VGND VGND VPWR VPWR _1953_ sky130_fd_sc_hd__clkbuf_1
XFILLER_0_63_51 VGND VGND VPWR VPWR sky130_fd_sc_hd__decap_4
XFILLER_0_2_65 VPWR VGND VPWR VGND sky130_ef_sc_hd__decap_12
XFILLER_0_137_709 VPWR VGND VPWR VGND sky130_ef_sc_hd__decap_12
XFILLER_0_87_681 VGND VGND VPWR VPWR sky130_fd_sc_hd__decap_3
XFILLER_0_75_821 VGND VGND VPWR VPWR sky130_fd_sc_hd__decap_6
X_4936_ _2455_ VGND VGND VPWR VPWR _0435_ sky130_fd_sc_hd__clkbuf_1
XFILLER_0_19_225 VPWR VGND VPWR VGND sky130_ef_sc_hd__decap_12
XFILLER_0_129_293 VPWR VGND VPWR VGND sky130_ef_sc_hd__decap_12
X_4867_ _2418_ VGND VGND VPWR VPWR _0403_ sky130_fd_sc_hd__clkbuf_1
X_3818_ _1709_ _1738_ _1742_ _1746_ VGND VGND VPWR VPWR _1747_ sky130_fd_sc_hd__o211a_1
XFILLER_0_7_653 VPWR VGND VPWR VGND sky130_ef_sc_hd__decap_12
XFILLER_0_6_141 VPWR VGND VPWR VGND sky130_ef_sc_hd__decap_12
XFILLER_0_28_781 VPWR VGND VPWR VGND sky130_ef_sc_hd__decap_12
XTAP_TAPCELL_ROW_115_2026 VGND VPWR sky130_fd_sc_hd__tapvpwrvgnd_1
XTAP_TAPCELL_ROW_99_1781 VGND VPWR sky130_fd_sc_hd__tapvpwrvgnd_1
X_4798_ cpu_inst.regfile_inst.registers\[0\]\[17\] VGND VGND VPWR VPWR _2384_ sky130_fd_sc_hd__clkbuf_1
XFILLER_0_7_697 VPWR VGND VPWR VGND sky130_ef_sc_hd__decap_12
XFILLER_0_132_469 VGND VGND VPWR VPWR sky130_fd_sc_hd__decap_6
XTAP_TAPCELL_ROW_99_1792 VGND VPWR sky130_fd_sc_hd__tapvpwrvgnd_1
X_3749_ _1679_ _1677_ VGND VGND VPWR VPWR _1680_ sky130_fd_sc_hd__or2_1
XFILLER_0_15_497 VGND VGND VPWR VPWR sky130_fd_sc_hd__decap_6
XFILLER_0_30_401 VPWR VGND VPWR VGND sky130_ef_sc_hd__decap_12
XFILLER_0_30_445 VPWR VGND VPWR VGND sky130_ef_sc_hd__decap_12
XFILLER_0_100_333 VPWR VGND VPWR VGND sky130_ef_sc_hd__decap_12
X_5419_ clknet_leaf_5_clk _0339_ net2 VGND VGND VPWR VPWR cpu_inst.decoder_inst.current_pc\[19\]
+ sky130_fd_sc_hd__dfrtp_1
XFILLER_0_100_377 VPWR VGND VPWR VGND sky130_ef_sc_hd__decap_12
XFILLER_0_97_401 VGND VGND VPWR VPWR sky130_fd_sc_hd__decap_3
XTAP_TAPCELL_ROW_126_2188 VGND VPWR sky130_fd_sc_hd__tapvpwrvgnd_1
XFILLER_0_69_125 VPWR VGND VPWR VGND sky130_ef_sc_hd__decap_12
XFILLER_0_69_169 VPWR VGND VPWR VGND sky130_ef_sc_hd__decap_12
XFILLER_0_84_139 VGND VGND VPWR VPWR sky130_fd_sc_hd__fill_1
XTAP_TAPCELL_ROW_26_687 VGND VPWR sky130_fd_sc_hd__tapvpwrvgnd_1
XFILLER_0_38_556 VGND VGND VPWR VPWR sky130_fd_sc_hd__decap_6
XFILLER_0_108_433 VPWR VGND VPWR VGND sky130_ef_sc_hd__decap_12
XFILLER_0_93_673 VGND VGND VPWR VPWR sky130_fd_sc_hd__decap_4
XFILLER_0_80_301 VGND VGND VPWR VPWR sky130_fd_sc_hd__decap_6
XFILLER_0_108_477 VPWR VGND VPWR VGND sky130_ef_sc_hd__decap_12
XFILLER_0_65_386 VGND VGND VPWR VPWR sky130_fd_sc_hd__decap_6
XFILLER_0_25_217 VGND VGND VPWR VPWR sky130_fd_sc_hd__decap_6
XFILLER_0_80_345 VPWR VGND VPWR VGND sky130_ef_sc_hd__decap_12
XFILLER_0_40_209 VPWR VGND VPWR VGND sky130_ef_sc_hd__decap_12
XFILLER_0_123_447 VGND VGND VPWR VPWR sky130_fd_sc_hd__fill_1
XFILLER_0_111_609 VGND VGND VPWR VPWR sky130_fd_sc_hd__decap_6
XFILLER_0_33_261 VPWR VGND VPWR VGND sky130_ef_sc_hd__decap_12
XFILLER_0_68_29 VPWR VGND VPWR VGND sky130_ef_sc_hd__decap_12
XFILLER_0_104_694 VGND VGND VPWR VPWR sky130_fd_sc_hd__decap_6
XFILLER_0_103_193 VPWR VGND VPWR VGND sky130_ef_sc_hd__decap_12
XTAP_TAPCELL_ROW_55_1128 VGND VPWR sky130_fd_sc_hd__tapvpwrvgnd_1
XTAP_TAPCELL_ROW_6_390 VGND VPWR sky130_fd_sc_hd__tapvpwrvgnd_1
XFILLER_0_17_55 VGND VGND VPWR VPWR sky130_fd_sc_hd__fill_1
XFILLER_0_76_607 VPWR VGND VPWR VGND sky130_ef_sc_hd__decap_12
XFILLER_0_48_309 VPWR VGND VPWR VGND sky130_ef_sc_hd__decap_12
XFILLER_0_119_709 VPWR VGND VPWR VGND sky130_ef_sc_hd__decap_12
XFILLER_0_130_3 VPWR VGND VPWR VGND sky130_ef_sc_hd__decap_12
X_2982_ cpu_inst.regfile_inst.registers\[25\]\[6\] _0903_ _0669_ _0944_ VGND VGND
+ VPWR VPWR _0947_ sky130_fd_sc_hd__o211a_1
XTAP_TAPCELL_ROW_45_974 VGND VPWR sky130_fd_sc_hd__tapvpwrvgnd_1
XFILLER_0_90_109 VPWR VGND VPWR VGND sky130_ef_sc_hd__decap_12
XFILLER_0_72_813 VGND VGND VPWR VPWR sky130_fd_sc_hd__decap_4
X_4721_ cpu_inst.decoder_inst.current_pc\[19\] _2334_ VGND VGND VPWR VPWR _2337_ sky130_fd_sc_hd__xor2_1
XFILLER_0_17_729 VPWR VGND VPWR VGND sky130_ef_sc_hd__decap_12
XFILLER_0_127_753 VPWR VGND VPWR VGND sky130_ef_sc_hd__decap_12
XFILLER_0_83_161 VGND VGND VPWR VPWR sky130_fd_sc_hd__decap_6
X_4652_ _0685_ _1288_ VGND VGND VPWR VPWR _2285_ sky130_fd_sc_hd__nor2_2
XFILLER_0_4_601 VPWR VGND VPWR VGND sky130_ef_sc_hd__decap_12
XFILLER_0_44_526 VGND VGND VPWR VPWR sky130_fd_sc_hd__decap_6
XFILLER_0_127_797 VPWR VGND VPWR VGND sky130_ef_sc_hd__decap_12
X_3603_ cpu_inst.regfile_inst.registers\[5\]\[21\] cpu_inst.regfile_inst.registers\[4\]\[21\]
+ _1348_ VGND VGND VPWR VPWR _1537_ sky130_fd_sc_hd__mux2_1
XFILLER_0_3_111 VGND VGND VPWR VPWR sky130_fd_sc_hd__fill_1
XFILLER_0_114_469 VGND VGND VPWR VPWR sky130_fd_sc_hd__decap_6
XFILLER_0_12_401 VPWR VGND VPWR VGND sky130_ef_sc_hd__decap_12
XFILLER_0_4_645 VPWR VGND VPWR VGND sky130_ef_sc_hd__decap_12
X_4583_ _2239_ VGND VGND VPWR VPWR _0298_ sky130_fd_sc_hd__clkbuf_1
X_3534_ _0849_ VGND VGND VPWR VPWR _1470_ sky130_fd_sc_hd__buf_2
XFILLER_0_12_445 VPWR VGND VPWR VGND sky130_ef_sc_hd__decap_12
X_3465_ _1397_ _1400_ _1402_ _0843_ VGND VGND VPWR VPWR _1403_ sky130_fd_sc_hd__a31o_1
XFILLER_0_12_489 VPWR VGND VPWR VGND sky130_ef_sc_hd__decap_12
XFILLER_0_40_787 VGND VGND VPWR VPWR sky130_fd_sc_hd__decap_8
X_5204_ clknet_leaf_7_clk _0124_ VGND VGND VPWR VPWR cpu_inst.regfile_inst.registers\[4\]\[28\]
+ sky130_fd_sc_hd__dfxtp_1
X_3396_ _1215_ cpu_inst.regfile_inst.registers\[6\]\[11\] _1339_ VGND VGND VPWR VPWR
+ _1340_ sky130_fd_sc_hd__mux2_1
X_5135_ clknet_leaf_15_clk _0055_ VGND VGND VPWR VPWR cpu_inst.regfile_inst.registers\[2\]\[23\]
+ sky130_fd_sc_hd__dfxtp_1
XFILLER_0_35_3 VPWR VGND VPWR VGND sky130_ef_sc_hd__decap_12
XFILLER_0_98_209 VPWR VGND VPWR VGND sky130_ef_sc_hd__decap_12
X_5066_ _2525_ _2526_ VGND VGND VPWR VPWR _0494_ sky130_fd_sc_hd__nor2_1
XFILLER_0_74_83 VGND VGND VPWR VPWR sky130_fd_sc_hd__fill_1
X_4017_ _1385_ _1166_ _1939_ _0684_ VGND VGND VPWR VPWR _1940_ sky130_fd_sc_hd__a22o_1
XFILLER_0_137_517 VPWR VGND VPWR VGND sky130_ef_sc_hd__decap_12
XFILLER_0_94_437 VPWR VGND VPWR VGND sky130_ef_sc_hd__decap_12
XFILLER_0_66_139 VGND VGND VPWR VPWR sky130_fd_sc_hd__fill_1
XFILLER_0_75_673 VGND VGND VPWR VPWR sky130_fd_sc_hd__decap_6
XTAP_TAPCELL_ROW_23_646 VGND VPWR sky130_fd_sc_hd__tapvpwrvgnd_1
X_4919_ _2446_ VGND VGND VPWR VPWR _0427_ sky130_fd_sc_hd__clkbuf_1
XFILLER_0_90_643 VGND VGND VPWR VPWR sky130_fd_sc_hd__fill_1
XFILLER_0_62_301 VGND VGND VPWR VPWR sky130_fd_sc_hd__decap_6
XFILLER_0_62_356 VGND VGND VPWR VPWR sky130_fd_sc_hd__decap_8
XFILLER_0_7_461 VPWR VGND VPWR VGND sky130_ef_sc_hd__decap_12
XFILLER_0_132_233 VPWR VGND VPWR VGND sky130_ef_sc_hd__decap_12
XFILLER_0_15_261 VPWR VGND VPWR VGND sky130_ef_sc_hd__decap_12
XFILLER_0_22_209 VPWR VGND VPWR VGND sky130_ef_sc_hd__decap_12
XFILLER_0_132_277 VPWR VGND VPWR VGND sky130_ef_sc_hd__decap_12
XFILLER_0_30_253 VPWR VGND VPWR VGND sky130_ef_sc_hd__decap_12
XFILLER_0_31_765 VPWR VGND VPWR VGND sky130_ef_sc_hd__decap_12
XFILLER_0_100_141 VPWR VGND VPWR VGND sky130_ef_sc_hd__decap_12
XFILLER_0_31_798 VPWR VGND VPWR VGND sky130_ef_sc_hd__decap_12
XTAP_TAPCELL_ROW_128_2217 VGND VPWR sky130_fd_sc_hd__tapvpwrvgnd_1
XFILLER_0_101_697 VGND VGND VPWR VPWR sky130_fd_sc_hd__fill_1
XTAP_TAPCELL_ROW_50_1047 VGND VPWR sky130_fd_sc_hd__tapvpwrvgnd_1
XFILLER_0_66_640 VGND VGND VPWR VPWR sky130_fd_sc_hd__decap_4
XFILLER_0_72_109 VPWR VGND VPWR VGND sky130_ef_sc_hd__decap_12
XTAP_TAPCELL_ROW_42_933 VGND VPWR sky130_fd_sc_hd__tapvpwrvgnd_1
XFILLER_0_124_701 VPWR VGND VPWR VGND sky130_ef_sc_hd__decap_12
XFILLER_0_109_753 VPWR VGND VPWR VGND sky130_ef_sc_hd__decap_12
XFILLER_0_66_684 VGND VGND VPWR VPWR sky130_fd_sc_hd__decap_8
XFILLER_0_65_161 VGND VGND VPWR VPWR sky130_fd_sc_hd__decap_6
XFILLER_0_109_797 VPWR VGND VPWR VGND sky130_ef_sc_hd__decap_12
XFILLER_0_53_356 VPWR VGND VPWR VGND sky130_ef_sc_hd__decap_12
XFILLER_0_80_153 VPWR VGND VPWR VGND sky130_ef_sc_hd__decap_12
XFILLER_0_79_39 VPWR VGND VPWR VGND sky130_ef_sc_hd__decap_12
XFILLER_0_111_417 VPWR VGND VPWR VGND sky130_ef_sc_hd__decap_12
XFILLER_0_80_197 VPWR VGND VPWR VGND sky130_ef_sc_hd__decap_12
XFILLER_0_1_615 VGND VGND VPWR VPWR sky130_fd_sc_hd__fill_1
XFILLER_0_0_125 VPWR VGND VPWR VGND sky130_ef_sc_hd__decap_12
XFILLER_0_95_27 VPWR VGND VPWR VGND sky130_ef_sc_hd__decap_12
XFILLER_0_0_169 VPWR VGND VPWR VGND sky130_ef_sc_hd__decap_12
X_3250_ _1088_ _1206_ _1207_ _1214_ VGND VGND VPWR VPWR _1215_ sky130_fd_sc_hd__o31ai_4
X_3181_ _1070_ _1132_ _1060_ VGND VGND VPWR VPWR _1146_ sky130_fd_sc_hd__mux2_1
XFILLER_0_28_65 VPWR VGND VPWR VGND sky130_ef_sc_hd__decap_12
XTAP_TAPCELL_ROW_68_1319 VGND VPWR sky130_fd_sc_hd__tapvpwrvgnd_1
XTAP_TAPCELL_ROW_1_308 VGND VPWR sky130_fd_sc_hd__tapvpwrvgnd_1
XTAP_TAPCELL_ROW_1_319 VGND VPWR sky130_fd_sc_hd__tapvpwrvgnd_1
XFILLER_0_135_55 VGND VGND VPWR VPWR sky130_fd_sc_hd__fill_1
XFILLER_0_44_53 VPWR VGND VPWR VGND sky130_ef_sc_hd__decap_12
XFILLER_0_88_253 VPWR VGND VPWR VGND sky130_ef_sc_hd__decap_12
XTAP_TAPCELL_ROW_81_1508 VGND VPWR sky130_fd_sc_hd__tapvpwrvgnd_1
XFILLER_0_119_517 VPWR VGND VPWR VGND sky130_ef_sc_hd__decap_12
XTAP_TAPCELL_ROW_81_1519 VGND VPWR sky130_fd_sc_hd__tapvpwrvgnd_1
XFILLER_0_44_97 VPWR VGND VPWR VGND sky130_ef_sc_hd__decap_12
XFILLER_0_48_139 VGND VGND VPWR VPWR sky130_fd_sc_hd__fill_1
XFILLER_0_84_492 VGND VGND VPWR VPWR sky130_fd_sc_hd__fill_1
X_4704_ _2323_ _2324_ VGND VGND VPWR VPWR _2325_ sky130_fd_sc_hd__nor2_1
XFILLER_0_60_41 VPWR VGND VPWR VGND sky130_ef_sc_hd__decap_12
X_2965_ _0805_ VGND VGND VPWR VPWR _0930_ sky130_fd_sc_hd__inv_2
XTAP_TAPCELL_ROW_20_605 VGND VPWR sky130_fd_sc_hd__tapvpwrvgnd_1
XFILLER_0_44_301 VGND VGND VPWR VPWR sky130_fd_sc_hd__decap_6
XFILLER_0_127_561 VPWR VGND VPWR VGND sky130_ef_sc_hd__decap_12
XFILLER_0_72_643 VGND VGND VPWR VPWR sky130_fd_sc_hd__fill_1
X_2896_ _0610_ _0860_ VGND VGND VPWR VPWR _0861_ sky130_fd_sc_hd__or2_1
XFILLER_0_60_85 VPWR VGND VPWR VGND sky130_ef_sc_hd__decap_12
XFILLER_0_17_559 VGND VGND VPWR VPWR sky130_fd_sc_hd__fill_1
XFILLER_0_44_345 VPWR VGND VPWR VGND sky130_ef_sc_hd__decap_12
XFILLER_0_114_233 VPWR VGND VPWR VGND sky130_ef_sc_hd__decap_12
X_4635_ _2269_ VGND VGND VPWR VPWR _2270_ sky130_fd_sc_hd__buf_2
XFILLER_0_44_389 VPWR VGND VPWR VGND sky130_ef_sc_hd__decap_12
XFILLER_0_114_277 VPWR VGND VPWR VGND sky130_ef_sc_hd__decap_12
XTAP_TAPCELL_ROW_96_1740 VGND VPWR sky130_fd_sc_hd__tapvpwrvgnd_1
XFILLER_0_8_53 VPWR VGND VPWR VGND sky130_ef_sc_hd__decap_12
XFILLER_0_4_475 VGND VGND VPWR VPWR sky130_fd_sc_hd__fill_1
XFILLER_0_13_721 VGND VGND VPWR VPWR sky130_fd_sc_hd__decap_6
XFILLER_0_25_592 VGND VGND VPWR VPWR sky130_fd_sc_hd__fill_1
X_4566_ _0575_ _2021_ _1990_ cpu_inst.regfile_inst.registers\[10\]\[1\] VGND VGND
+ VPWR VPWR _0289_ sky130_fd_sc_hd__a31o_1
XFILLER_0_130_737 VPWR VGND VPWR VGND sky130_ef_sc_hd__decap_12
X_3517_ _1144_ _1453_ VGND VGND VPWR VPWR _1454_ sky130_fd_sc_hd__nor2_1
XFILLER_0_12_253 VPWR VGND VPWR VGND sky130_ef_sc_hd__decap_12
XFILLER_0_8_97 VPWR VGND VPWR VGND sky130_ef_sc_hd__decap_12
XFILLER_0_13_765 VPWR VGND VPWR VGND sky130_ef_sc_hd__decap_12
X_4497_ _2196_ VGND VGND VPWR VPWR _0255_ sky130_fd_sc_hd__clkbuf_1
X_3448_ _0867_ VGND VGND VPWR VPWR _1386_ sky130_fd_sc_hd__buf_4
X_3379_ _0684_ _0577_ _0582_ _1296_ VGND VGND VPWR VPWR _1329_ sky130_fd_sc_hd__or4_1
XFILLER_0_85_93 VPWR VGND VPWR VGND sky130_ef_sc_hd__decap_12
X_5118_ clknet_leaf_33_clk _0038_ VGND VGND VPWR VPWR cpu_inst.regfile_inst.registers\[2\]\[6\]
+ sky130_fd_sc_hd__dfxtp_1
XTAP_TAPCELL_ROW_123_2147 VGND VPWR sky130_fd_sc_hd__tapvpwrvgnd_1
XTAP_TAPCELL_ROW_28_716 VGND VPWR sky130_fd_sc_hd__tapvpwrvgnd_1
XTAP_TAPCELL_ROW_28_727 VGND VPWR sky130_fd_sc_hd__tapvpwrvgnd_1
X_5049_ cpu_inst.display_inst.counter\[7\] _2512_ cpu_inst.display_inst.counter\[8\]
+ VGND VGND VPWR VPWR _2516_ sky130_fd_sc_hd__a21oi_1
XFILLER_0_94_245 VGND VGND VPWR VPWR sky130_fd_sc_hd__decap_6
XFILLER_0_138_837 VGND VGND VPWR VPWR sky130_fd_sc_hd__decap_3
XTAP_TAPCELL_ROW_105_1880 VGND VPWR sky130_fd_sc_hd__tapvpwrvgnd_1
XFILLER_0_82_418 VGND VGND VPWR VPWR sky130_fd_sc_hd__fill_2
XFILLER_0_54_109 VPWR VGND VPWR VGND sky130_ef_sc_hd__decap_12
XFILLER_0_36_813 VGND VGND VPWR VPWR sky130_fd_sc_hd__fill_2
XFILLER_0_94_289 VPWR VGND VPWR VGND sky130_ef_sc_hd__decap_12
XFILLER_0_63_610 VGND VGND VPWR VPWR sky130_fd_sc_hd__decap_6
XFILLER_0_47_161 VGND VGND VPWR VPWR sky130_fd_sc_hd__decap_6
XFILLER_0_48_695 VGND VGND VPWR VPWR sky130_fd_sc_hd__decap_4
XFILLER_0_106_701 VPWR VGND VPWR VGND sky130_ef_sc_hd__decap_12
XFILLER_0_90_451 VPWR VGND VPWR VGND sky130_ef_sc_hd__decap_12
XFILLER_0_8_781 VPWR VGND VPWR VGND sky130_ef_sc_hd__decap_12
XTAP_TAPCELL_ROW_138_2390 VGND VPWR sky130_fd_sc_hd__tapvpwrvgnd_1
XFILLER_0_133_553 VGND VGND VPWR VPWR sky130_fd_sc_hd__decap_6
XFILLER_0_62_153 VPWR VGND VPWR VGND sky130_ef_sc_hd__decap_12
XFILLER_0_23_529 VPWR VGND VPWR VGND sky130_ef_sc_hd__decap_12
XFILLER_0_51_838 VGND VGND VPWR VPWR sky130_fd_sc_hd__fill_2
XFILLER_0_62_197 VPWR VGND VPWR VGND sky130_ef_sc_hd__decap_12
XFILLER_0_16_581 VGND VGND VPWR VPWR sky130_fd_sc_hd__decap_6
XFILLER_0_133_597 VPWR VGND VPWR VGND sky130_ef_sc_hd__decap_12
XFILLER_0_31_595 VGND VGND VPWR VPWR sky130_fd_sc_hd__decap_4
XFILLER_0_85_223 VGND VGND VPWR VPWR sky130_fd_sc_hd__fill_1
XFILLER_0_105_69 VPWR VGND VPWR VGND sky130_ef_sc_hd__decap_12
XTAP_TAPCELL_ROW_63_1249 VGND VPWR sky130_fd_sc_hd__tapvpwrvgnd_1
XTAP_TAPCELL_ROW_63_1238 VGND VPWR sky130_fd_sc_hd__tapvpwrvgnd_1
XFILLER_0_26_301 VGND VGND VPWR VPWR sky130_fd_sc_hd__decap_6
XFILLER_0_39_673 VGND VGND VPWR VPWR sky130_fd_sc_hd__decap_3
XFILLER_0_109_561 VPWR VGND VPWR VGND sky130_ef_sc_hd__decap_12
XFILLER_0_5_217 VGND VGND VPWR VPWR sky130_fd_sc_hd__decap_6
XFILLER_0_26_345 VPWR VGND VPWR VGND sky130_ef_sc_hd__decap_12
X_2750_ cpu_inst.regfile_inst.registers\[15\]\[10\] _0710_ _0713_ _0714_ VGND VGND
+ VPWR VPWR _0715_ sky130_fd_sc_hd__a211o_1
XFILLER_0_124_531 VGND VGND VPWR VPWR sky130_fd_sc_hd__fill_1
XFILLER_0_121_57 VPWR VGND VPWR VGND sky130_ef_sc_hd__decap_12
X_2681_ _0514_ _0644_ _0619_ VGND VGND VPWR VPWR _0646_ sky130_fd_sc_hd__or3_1
XFILLER_0_26_389 VPWR VGND VPWR VGND sky130_ef_sc_hd__decap_12
X_4420_ _2155_ VGND VGND VPWR VPWR _0219_ sky130_fd_sc_hd__clkbuf_1
XFILLER_0_30_77 VGND VGND VPWR VPWR sky130_fd_sc_hd__decap_6
XFILLER_0_41_337 VPWR VGND VPWR VGND sky130_ef_sc_hd__decap_12
XFILLER_0_112_737 VPWR VGND VPWR VGND sky130_ef_sc_hd__decap_12
XFILLER_0_111_225 VPWR VGND VPWR VGND sky130_ef_sc_hd__decap_12
XTAP_TAPCELL_ROW_78_1470 VGND VPWR sky130_fd_sc_hd__tapvpwrvgnd_1
X_4351_ _1726_ cpu_inst.regfile_inst.registers\[5\]\[25\] _2117_ VGND VGND VPWR VPWR
+ _2121_ sky130_fd_sc_hd__mux2_1
XFILLER_0_10_713 VPWR VGND VPWR VGND sky130_ef_sc_hd__decap_12
XFILLER_0_120_781 VPWR VGND VPWR VGND sky130_ef_sc_hd__decap_12
X_4282_ _2083_ VGND VGND VPWR VPWR _0153_ sky130_fd_sc_hd__clkbuf_1
X_3302_ _1102_ _1172_ VGND VGND VPWR VPWR _1267_ sky130_fd_sc_hd__or2_1
XFILLER_0_10_757 VPWR VGND VPWR VGND sky130_ef_sc_hd__decap_12
XTAP_TAPCELL_ROW_91_1670 VGND VPWR sky130_fd_sc_hd__tapvpwrvgnd_1
X_3233_ _0691_ _1192_ _1197_ VGND VGND VPWR VPWR _1198_ sky130_fd_sc_hd__a21oi_1
X_3164_ cpu_inst.regfile_inst.registers\[9\]\[14\] cpu_inst.regfile_inst.registers\[8\]\[14\]
+ _0867_ VGND VGND VPWR VPWR _1129_ sky130_fd_sc_hd__mux2_1
X_3095_ _1057_ VGND VGND VPWR VPWR _1060_ sky130_fd_sc_hd__clkbuf_4
XFILLER_0_76_245 VGND VGND VPWR VPWR sky130_fd_sc_hd__decap_6
XFILLER_0_71_51 VGND VGND VPWR VPWR sky130_fd_sc_hd__decap_4
XFILLER_0_36_109 VPWR VGND VPWR VGND sky130_ef_sc_hd__decap_12
XFILLER_0_91_237 VPWR VGND VPWR VGND sky130_ef_sc_hd__decap_12
X_3997_ _1894_ _1896_ _1920_ VGND VGND VPWR VPWR _1921_ sky130_fd_sc_hd__or3_1
XFILLER_0_76_289 VPWR VGND VPWR VGND sky130_ef_sc_hd__decap_12
XFILLER_0_18_813 VPWR VGND VPWR VGND sky130_ef_sc_hd__decap_12
XFILLER_0_29_161 VGND VGND VPWR VPWR sky130_fd_sc_hd__decap_6
X_2948_ _0619_ _0644_ _0912_ _0514_ VGND VGND VPWR VPWR _0913_ sky130_fd_sc_hd__a31o_1
XTAP_TAPCELL_ROW_33_796 VGND VPWR sky130_fd_sc_hd__tapvpwrvgnd_1
XFILLER_0_127_391 VGND VGND VPWR VPWR sky130_fd_sc_hd__fill_1
XFILLER_0_33_838 VGND VGND VPWR VPWR sky130_fd_sc_hd__fill_2
XFILLER_0_44_153 VPWR VGND VPWR VGND sky130_ef_sc_hd__decap_12
XFILLER_0_130_501 VPWR VGND VPWR VGND sky130_ef_sc_hd__decap_12
XFILLER_0_115_553 VGND VGND VPWR VPWR sky130_fd_sc_hd__decap_6
X_4618_ cpu_inst.regfile_inst.registers\[10\]\[27\] _2252_ VGND VGND VPWR VPWR _2258_
+ sky130_fd_sc_hd__and2_1
XFILLER_0_44_197 VPWR VGND VPWR VGND sky130_ef_sc_hd__decap_12
X_2879_ _0714_ VGND VGND VPWR VPWR _0844_ sky130_fd_sc_hd__clkbuf_4
XFILLER_0_130_545 VPWR VGND VPWR VGND sky130_ef_sc_hd__decap_12
XFILLER_0_115_597 VPWR VGND VPWR VGND sky130_ef_sc_hd__decap_12
X_4549_ _2222_ VGND VGND VPWR VPWR _0281_ sky130_fd_sc_hd__clkbuf_1
XFILLER_0_13_573 VPWR VGND VPWR VGND sky130_ef_sc_hd__decap_12
XFILLER_0_130_589 VPWR VGND VPWR VGND sky130_ef_sc_hd__decap_12
XFILLER_0_99_337 VPWR VGND VPWR VGND sky130_ef_sc_hd__decap_12
XFILLER_0_138_601 VPWR VGND VPWR VGND sky130_ef_sc_hd__decap_12
XFILLER_0_68_757 VGND VGND VPWR VPWR sky130_fd_sc_hd__decap_4
XFILLER_0_68_746 VGND VGND VPWR VPWR sky130_fd_sc_hd__decap_8
XFILLER_0_68_735 VGND VGND VPWR VPWR sky130_fd_sc_hd__fill_2
XFILLER_0_67_223 VGND VGND VPWR VPWR sky130_fd_sc_hd__fill_1
XFILLER_0_138_645 VPWR VGND VPWR VGND sky130_ef_sc_hd__decap_12
XFILLER_0_137_111 VGND VGND VPWR VPWR sky130_fd_sc_hd__fill_1
XTAP_TAPCELL_ROW_103_1839 VGND VPWR sky130_fd_sc_hd__tapvpwrvgnd_1
XFILLER_0_48_470 VGND VGND VPWR VPWR sky130_fd_sc_hd__decap_6
XFILLER_0_125_317 VPWR VGND VPWR VGND sky130_ef_sc_hd__decap_12
XFILLER_0_24_805 VGND VGND VPWR VPWR sky130_fd_sc_hd__decap_6
XTAP_TAPCELL_ROW_136_2338 VGND VPWR sky130_fd_sc_hd__tapvpwrvgnd_1
XFILLER_0_36_665 VGND VGND VPWR VPWR sky130_fd_sc_hd__fill_1
XFILLER_0_133_361 VPWR VGND VPWR VGND sky130_ef_sc_hd__decap_12
Xclkload19 clknet_leaf_24_clk VGND VGND VPWR VPWR clkload19/Y sky130_fd_sc_hd__inv_16
XFILLER_0_63_484 VGND VGND VPWR VPWR sky130_fd_sc_hd__decap_6
XTAP_TAPCELL_ROW_11_468 VGND VPWR sky130_fd_sc_hd__tapvpwrvgnd_1
XFILLER_0_2_209 VPWR VGND VPWR VGND sky130_ef_sc_hd__decap_12
XFILLER_0_23_337 VPWR VGND VPWR VGND sky130_ef_sc_hd__decap_12
XFILLER_0_50_189 VGND VGND VPWR VPWR sky130_fd_sc_hd__decap_6
XFILLER_0_76_29 VPWR VGND VPWR VGND sky130_ef_sc_hd__decap_12
X_3920_ cpu_inst.regfile_inst.registers\[2\]\[29\] _1804_ _1805_ cpu_inst.regfile_inst.registers\[7\]\[29\]
+ _1739_ VGND VGND VPWR VPWR _1846_ sky130_fd_sc_hd__o221a_1
XTAP_TAPCELL_ROW_19_579 VGND VPWR sky130_fd_sc_hd__tapvpwrvgnd_1
XFILLER_0_25_55 VGND VGND VPWR VPWR sky130_fd_sc_hd__fill_1
XFILLER_0_58_245 VGND VGND VPWR VPWR sky130_fd_sc_hd__decap_6
XFILLER_0_128_133 VGND VGND VPWR VPWR sky130_fd_sc_hd__decap_6
X_3851_ cpu_inst.regfile_inst.registers\[24\]\[27\] _1384_ VGND VGND VPWR VPWR _1779_
+ sky130_fd_sc_hd__or2_1
XFILLER_0_86_587 VGND VGND VPWR VPWR sky130_fd_sc_hd__fill_1
XFILLER_0_58_289 VGND VGND VPWR VPWR sky130_fd_sc_hd__decap_8
XFILLER_0_18_109 VPWR VGND VPWR VGND sky130_ef_sc_hd__decap_12
XFILLER_0_27_610 VGND VGND VPWR VPWR sky130_fd_sc_hd__fill_1
XFILLER_0_128_177 VPWR VGND VPWR VGND sky130_ef_sc_hd__decap_12
X_3782_ cpu_inst.regfile_inst.registers\[1\]\[25\] _1667_ _1668_ cpu_inst.regfile_inst.registers\[5\]\[25\]
+ _0562_ VGND VGND VPWR VPWR _1712_ sky130_fd_sc_hd__o221a_1
XFILLER_0_73_237 VPWR VGND VPWR VGND sky130_ef_sc_hd__decap_12
X_2802_ _0765_ _0766_ _0642_ VGND VGND VPWR VPWR _0767_ sky130_fd_sc_hd__a21oi_1
XFILLER_0_109_391 VGND VGND VPWR VPWR sky130_fd_sc_hd__fill_1
X_5521_ clknet_leaf_9_clk _0441_ VGND VGND VPWR VPWR cpu_inst.regfile_inst.registers\[8\]\[25\]
+ sky130_fd_sc_hd__dfxtp_1
X_2733_ _0697_ VGND VGND VPWR VPWR _0698_ sky130_fd_sc_hd__buf_2
XFILLER_0_26_153 VPWR VGND VPWR VGND sky130_ef_sc_hd__decap_12
XTAP_TAPCELL_ROW_30_744 VGND VPWR sky130_fd_sc_hd__tapvpwrvgnd_1
XTAP_TAPCELL_ROW_30_755 VGND VPWR sky130_fd_sc_hd__tapvpwrvgnd_1
XFILLER_0_42_613 VGND VGND VPWR VPWR sky130_fd_sc_hd__decap_3
XFILLER_0_112_501 VPWR VGND VPWR VGND sky130_ef_sc_hd__decap_12
XFILLER_0_81_281 VPWR VGND VPWR VGND sky130_ef_sc_hd__decap_12
XFILLER_0_54_484 VGND VGND VPWR VPWR sky130_fd_sc_hd__fill_1
XFILLER_0_26_197 VPWR VGND VPWR VGND sky130_ef_sc_hd__decap_12
X_5452_ clknet_leaf_20_clk _0372_ VGND VGND VPWR VPWR cpu_inst.regfile_inst.registers\[0\]\[20\]
+ sky130_fd_sc_hd__dfxtp_1
X_2664_ cpu_inst.regfile_inst.registers\[1\]\[1\] _0592_ _0602_ cpu_inst.regfile_inst.registers\[5\]\[1\]
+ VGND VGND VPWR VPWR _0629_ sky130_fd_sc_hd__o22a_1
XFILLER_0_41_167 VGND VGND VPWR VPWR sky130_fd_sc_hd__fill_1
XFILLER_0_112_545 VPWR VGND VPWR VGND sky130_ef_sc_hd__decap_12
X_4403_ cpu_inst.regfile_inst.registers\[1\]\[19\] VGND VGND VPWR VPWR _2147_ sky130_fd_sc_hd__clkbuf_1
X_5383_ clknet_leaf_27_clk _0303_ VGND VGND VPWR VPWR cpu_inst.regfile_inst.registers\[10\]\[15\]
+ sky130_fd_sc_hd__dfxtp_1
X_2595_ _0559_ _0553_ VGND VGND VPWR VPWR _0560_ sky130_fd_sc_hd__nand2_4
XFILLER_0_112_589 VPWR VGND VPWR VGND sky130_ef_sc_hd__decap_12
X_4334_ _1418_ cpu_inst.regfile_inst.registers\[5\]\[17\] _2098_ VGND VGND VPWR VPWR
+ _2112_ sky130_fd_sc_hd__mux2_1
XFILLER_0_10_587 VGND VGND VPWR VPWR sky130_fd_sc_hd__fill_1
X_4265_ cpu_inst.regfile_inst.registers\[24\]\[17\] VGND VGND VPWR VPWR _2075_ sky130_fd_sc_hd__clkbuf_1
X_4196_ cpu_inst.regfile_inst.registers\[4\]\[15\] _2035_ VGND VGND VPWR VPWR _2040_
+ sky130_fd_sc_hd__and2_1
X_3216_ _1055_ _1178_ _1180_ _0911_ VGND VGND VPWR VPWR _1181_ sky130_fd_sc_hd__o211a_1
X_3147_ _0860_ _1038_ VGND VGND VPWR VPWR _1112_ sky130_fd_sc_hd__nor2_1
XFILLER_0_96_307 VGND VGND VPWR VPWR sky130_fd_sc_hd__fill_1
XTAP_TAPCELL_ROW_120_2106 VGND VPWR sky130_fd_sc_hd__tapvpwrvgnd_1
XFILLER_0_82_83 VGND VGND VPWR VPWR sky130_fd_sc_hd__fill_1
X_3078_ cpu_inst.regfile_inst.registers\[9\]\[13\] cpu_inst.regfile_inst.registers\[8\]\[13\]
+ _0867_ VGND VGND VPWR VPWR _1043_ sky130_fd_sc_hd__mux2_1
XTAP_TAPCELL_ROW_38_866 VGND VPWR sky130_fd_sc_hd__tapvpwrvgnd_1
XTAP_TAPCELL_ROW_38_877 VGND VPWR sky130_fd_sc_hd__tapvpwrvgnd_1
XFILLER_0_49_223 VGND VGND VPWR VPWR sky130_fd_sc_hd__fill_1
XFILLER_0_119_111 VGND VGND VPWR VPWR sky130_fd_sc_hd__fill_1
XFILLER_0_37_429 VGND VGND VPWR VPWR sky130_fd_sc_hd__decap_8
XFILLER_0_135_615 VGND VGND VPWR VPWR sky130_fd_sc_hd__fill_1
XFILLER_0_107_317 VPWR VGND VPWR VGND sky130_ef_sc_hd__decap_12
XFILLER_0_92_568 VPWR VGND VPWR VGND sky130_ef_sc_hd__decap_12
XFILLER_0_18_643 VGND VGND VPWR VPWR sky130_fd_sc_hd__fill_1
XFILLER_0_122_309 VPWR VGND VPWR VGND sky130_ef_sc_hd__decap_12
XTAP_TAPCELL_ROW_118_2068 VGND VPWR sky130_fd_sc_hd__tapvpwrvgnd_1
XFILLER_0_60_421 VGND VGND VPWR VPWR sky130_fd_sc_hd__fill_1
XFILLER_0_131_821 VPWR VGND VPWR VGND sky130_ef_sc_hd__decap_12
XFILLER_0_115_361 VPWR VGND VPWR VGND sky130_ef_sc_hd__decap_12
XFILLER_0_20_307 VGND VGND VPWR VPWR sky130_fd_sc_hd__fill_1
XFILLER_0_32_189 VGND VGND VPWR VPWR sky130_fd_sc_hd__decap_6
XTAP_TAPCELL_ROW_131_2268 VGND VPWR sky130_fd_sc_hd__tapvpwrvgnd_1
XTAP_TAPCELL_ROW_113_1990 VGND VPWR sky130_fd_sc_hd__tapvpwrvgnd_1
XFILLER_0_99_167 VGND VGND VPWR VPWR sky130_fd_sc_hd__fill_1
XFILLER_0_96_841 VGND VGND VPWR VPWR sky130_fd_sc_hd__fill_1
XFILLER_0_87_329 VGND VGND VPWR VPWR sky130_fd_sc_hd__decap_6
XTAP_TAPCELL_ROW_47_1008 VGND VPWR sky130_fd_sc_hd__tapvpwrvgnd_1
XFILLER_0_68_565 VPWR VGND VPWR VGND sky130_ef_sc_hd__decap_12
XTAP_TAPCELL_ROW_16_538 VGND VPWR sky130_fd_sc_hd__tapvpwrvgnd_1
XFILLER_0_95_373 VPWR VGND VPWR VGND sky130_ef_sc_hd__decap_12
XFILLER_0_83_502 VGND VGND VPWR VPWR sky130_fd_sc_hd__fill_2
XFILLER_0_71_708 VGND VGND VPWR VPWR sky130_fd_sc_hd__fill_2
XFILLER_0_55_237 VPWR VGND VPWR VGND sky130_ef_sc_hd__decap_12
XFILLER_0_126_637 VGND VGND VPWR VPWR sky130_fd_sc_hd__decap_6
XFILLER_0_125_125 VPWR VGND VPWR VGND sky130_ef_sc_hd__decap_12
XFILLER_0_102_15 VPWR VGND VPWR VGND sky130_ef_sc_hd__decap_12
XFILLER_0_125_169 VPWR VGND VPWR VGND sky130_ef_sc_hd__decap_12
XFILLER_0_63_281 VPWR VGND VPWR VGND sky130_ef_sc_hd__decap_12
XFILLER_0_11_57 VPWR VGND VPWR VGND sky130_ef_sc_hd__decap_12
XFILLER_0_51_410 VGND VGND VPWR VPWR sky130_fd_sc_hd__fill_1
XFILLER_0_134_681 VPWR VGND VPWR VGND sky130_ef_sc_hd__decap_12
XFILLER_0_3_529 VPWR VGND VPWR VGND sky130_ef_sc_hd__decap_12
XFILLER_0_24_657 VPWR VGND VPWR VGND sky130_ef_sc_hd__decap_12
XFILLER_0_87_39 VPWR VGND VPWR VGND sky130_ef_sc_hd__decap_12
XFILLER_0_11_329 VGND VGND VPWR VPWR sky130_fd_sc_hd__decap_6
XFILLER_0_23_167 VGND VGND VPWR VPWR sky130_fd_sc_hd__fill_1
XFILLER_0_20_841 VGND VGND VPWR VPWR sky130_fd_sc_hd__fill_1
XTAP_TAPCELL_ROW_71_1359 VGND VPWR sky130_fd_sc_hd__tapvpwrvgnd_1
X_4050_ cpu_inst.regfile_inst.registers\[2\]\[12\] VGND VGND VPWR VPWR _1961_ sky130_fd_sc_hd__clkbuf_1
X_3001_ _0965_ _0964_ VGND VGND VPWR VPWR _0966_ sky130_fd_sc_hd__xnor2_1
XFILLER_0_78_307 VGND VGND VPWR VPWR sky130_fd_sc_hd__fill_1
XFILLER_0_36_65 VPWR VGND VPWR VGND sky130_ef_sc_hd__decap_12
XFILLER_0_87_841 VGND VGND VPWR VPWR sky130_fd_sc_hd__fill_1
X_4952_ _2463_ VGND VGND VPWR VPWR _0443_ sky130_fd_sc_hd__clkbuf_1
XTAP_TAPCELL_ROW_86_1591 VGND VPWR sky130_fd_sc_hd__tapvpwrvgnd_1
XTAP_TAPCELL_ROW_35_825 VGND VPWR sky130_fd_sc_hd__tapvpwrvgnd_1
X_4883_ _2426_ VGND VGND VPWR VPWR _0411_ sky130_fd_sc_hd__clkbuf_1
X_3903_ _1306_ _1755_ _1829_ _1251_ VGND VGND VPWR VPWR _1830_ sky130_fd_sc_hd__o211a_1
XFILLER_0_74_513 VPWR VGND VPWR VGND sky130_ef_sc_hd__decap_12
XFILLER_0_74_502 VGND VGND VPWR VPWR sky130_fd_sc_hd__decap_3
XFILLER_0_19_429 VPWR VGND VPWR VGND sky130_ef_sc_hd__decap_12
XFILLER_0_52_53 VPWR VGND VPWR VGND sky130_ef_sc_hd__decap_12
XFILLER_0_117_615 VGND VGND VPWR VPWR sky130_fd_sc_hd__fill_1
X_3834_ cpu_inst.regfile_inst.registers\[5\]\[27\] cpu_inst.regfile_inst.registers\[4\]\[27\]
+ _1657_ VGND VGND VPWR VPWR _1762_ sky130_fd_sc_hd__mux2_1
XFILLER_0_74_557 VPWR VGND VPWR VGND sky130_ef_sc_hd__decap_12
XFILLER_0_6_301 VGND VGND VPWR VPWR sky130_fd_sc_hd__decap_6
XFILLER_0_52_97 VPWR VGND VPWR VGND sky130_ef_sc_hd__decap_12
XFILLER_0_129_497 VGND VGND VPWR VPWR sky130_fd_sc_hd__decap_6
XFILLER_0_55_760 VGND VGND VPWR VPWR sky130_fd_sc_hd__fill_1
XFILLER_0_104_309 VPWR VGND VPWR VGND sky130_ef_sc_hd__decap_12
X_3765_ cpu_inst.regfile_inst.registers\[7\]\[25\] cpu_inst.regfile_inst.registers\[6\]\[25\]
+ _1348_ VGND VGND VPWR VPWR _1695_ sky130_fd_sc_hd__mux2_1
XFILLER_0_6_345 VPWR VGND VPWR VGND sky130_ef_sc_hd__decap_12
XFILLER_0_27_473 VPWR VGND VPWR VGND sky130_ef_sc_hd__decap_12
XFILLER_0_113_821 VPWR VGND VPWR VGND sky130_ef_sc_hd__decap_12
X_3696_ _1552_ _1623_ _1624_ _1627_ VGND VGND VPWR VPWR _1628_ sky130_fd_sc_hd__o22a_1
X_2716_ _0667_ _0680_ VGND VGND VPWR VPWR _0681_ sky130_fd_sc_hd__xnor2_1
XFILLER_0_6_389 VPWR VGND VPWR VGND sky130_ef_sc_hd__decap_12
XFILLER_0_42_443 VPWR VGND VPWR VGND sky130_ef_sc_hd__decap_12
X_5504_ clknet_leaf_34_clk _0424_ VGND VGND VPWR VPWR cpu_inst.regfile_inst.registers\[8\]\[8\]
+ sky130_fd_sc_hd__dfxtp_1
X_2647_ _0610_ _0611_ VGND VGND VPWR VPWR _0612_ sky130_fd_sc_hd__nor2_2
XFILLER_0_14_189 VGND VGND VPWR VPWR sky130_fd_sc_hd__decap_6
X_5435_ clknet_leaf_38_clk _0355_ VGND VGND VPWR VPWR cpu_inst.regfile_inst.registers\[0\]\[2\]
+ sky130_fd_sc_hd__dfxtp_1
XFILLER_0_65_3 VPWR VGND VPWR VGND sky130_ef_sc_hd__decap_12
XFILLER_0_11_841 VGND VGND VPWR VPWR sky130_fd_sc_hd__fill_1
X_5366_ clknet_leaf_4_clk _0286_ VGND VGND VPWR VPWR cpu_inst.regfile_inst.registers\[11\]\[30\]
+ sky130_fd_sc_hd__dfxtp_1
X_2578_ _0523_ _0531_ VGND VGND VPWR VPWR _0543_ sky130_fd_sc_hd__or2_1
X_5297_ clknet_leaf_14_clk _0217_ VGND VGND VPWR VPWR cpu_inst.regfile_inst.registers\[1\]\[25\]
+ sky130_fd_sc_hd__dfxtp_1
X_4317_ _1100_ cpu_inst.regfile_inst.registers\[5\]\[9\] _2092_ VGND VGND VPWR VPWR
+ _2103_ sky130_fd_sc_hd__mux2_1
X_4248_ _2066_ VGND VGND VPWR VPWR _0136_ sky130_fd_sc_hd__clkbuf_1
XFILLER_0_93_93 VPWR VGND VPWR VGND sky130_ef_sc_hd__decap_12
X_4179_ cpu_inst.regfile_inst.registers\[4\]\[7\] _2024_ VGND VGND VPWR VPWR _2031_
+ sky130_fd_sc_hd__and2_1
XFILLER_0_93_811 VPWR VGND VPWR VGND sky130_ef_sc_hd__decap_12
XFILLER_0_77_373 VGND VGND VPWR VPWR sky130_fd_sc_hd__decap_4
XFILLER_0_92_321 VPWR VGND VPWR VGND sky130_ef_sc_hd__decap_12
XFILLER_0_9_161 VGND VGND VPWR VPWR sky130_fd_sc_hd__decap_6
XFILLER_0_37_237 VPWR VGND VPWR VGND sky130_ef_sc_hd__decap_12
XFILLER_0_107_125 VPWR VGND VPWR VGND sky130_ef_sc_hd__decap_12
XFILLER_0_92_365 VPWR VGND VPWR VGND sky130_ef_sc_hd__decap_12
XPHY_EDGE_ROW_14_Right_14 VGND VGND VPWR VPWR sky130_fd_sc_hd__decap_3
XFILLER_0_107_169 VPWR VGND VPWR VGND sky130_ef_sc_hd__decap_12
XFILLER_0_45_281 VPWR VGND VPWR VGND sky130_ef_sc_hd__decap_12
XFILLER_0_123_629 VPWR VGND VPWR VGND sky130_ef_sc_hd__decap_12
XFILLER_0_116_681 VPWR VGND VPWR VGND sky130_ef_sc_hd__decap_12
XFILLER_0_61_741 VGND VGND VPWR VPWR sky130_fd_sc_hd__decap_3
XFILLER_0_122_139 VGND VGND VPWR VPWR sky130_fd_sc_hd__fill_1
XFILLER_0_60_251 VGND VGND VPWR VPWR sky130_fd_sc_hd__fill_1
XFILLER_0_131_673 VPWR VGND VPWR VGND sky130_ef_sc_hd__decap_12
XPHY_EDGE_ROW_23_Right_23 VGND VGND VPWR VPWR sky130_fd_sc_hd__decap_3
XTAP_TAPCELL_ROW_53_1089 VGND VPWR sky130_fd_sc_hd__tapvpwrvgnd_1
XFILLER_0_87_137 VPWR VGND VPWR VGND sky130_ef_sc_hd__decap_12
XFILLER_0_69_841 VGND VGND VPWR VPWR sky130_fd_sc_hd__fill_1
XFILLER_0_84_833 VGND VGND VPWR VPWR sky130_fd_sc_hd__decap_8
XFILLER_0_68_362 VGND VGND VPWR VPWR sky130_fd_sc_hd__fill_2
XPHY_EDGE_ROW_32_Right_32 VGND VGND VPWR VPWR sky130_fd_sc_hd__decap_3
XFILLER_0_126_401 VPWR VGND VPWR VGND sky130_ef_sc_hd__decap_12
XFILLER_0_95_181 VPWR VGND VPWR VGND sky130_ef_sc_hd__decap_12
XFILLER_0_113_69 VPWR VGND VPWR VGND sky130_ef_sc_hd__decap_12
XFILLER_0_126_445 VPWR VGND VPWR VGND sky130_ef_sc_hd__decap_12
XFILLER_0_4_805 VGND VGND VPWR VPWR sky130_fd_sc_hd__decap_6
XFILLER_0_24_421 VPWR VGND VPWR VGND sky130_ef_sc_hd__decap_12
XFILLER_0_126_489 VPWR VGND VPWR VGND sky130_ef_sc_hd__decap_12
XFILLER_0_107_670 VGND VGND VPWR VPWR sky130_fd_sc_hd__fill_2
XFILLER_0_98_27 VGND VGND VPWR VPWR sky130_fd_sc_hd__fill_1
X_3550_ _1458_ _1446_ _1484_ VGND VGND VPWR VPWR _1486_ sky130_fd_sc_hd__nand3_1
XTAP_TAPCELL_ROW_40_894 VGND VPWR sky130_fd_sc_hd__tapvpwrvgnd_1
XFILLER_0_3_337 VPWR VGND VPWR VGND sky130_ef_sc_hd__decap_12
XFILLER_0_51_273 VGND VGND VPWR VPWR sky130_fd_sc_hd__decap_6
XFILLER_0_121_161 VGND VGND VPWR VPWR sky130_fd_sc_hd__decap_6
XFILLER_0_110_813 VPWR VGND VPWR VGND sky130_ef_sc_hd__decap_12
X_5220_ clknet_leaf_22_clk _0140_ VGND VGND VPWR VPWR cpu_inst.regfile_inst.registers\[24\]\[12\]
+ sky130_fd_sc_hd__dfxtp_1
XFILLER_0_11_137 VPWR VGND VPWR VGND sky130_ef_sc_hd__decap_12
X_3481_ cpu_inst.regfile_inst.registers\[6\]\[17\] _1418_ _1332_ VGND VGND VPWR VPWR
+ _1419_ sky130_fd_sc_hd__mux2_1
XPHY_EDGE_ROW_41_Right_41 VGND VGND VPWR VPWR sky130_fd_sc_hd__decap_3
X_5151_ clknet_leaf_36_clk _0071_ VGND VGND VPWR VPWR cpu_inst.regfile_inst.registers\[25\]\[7\]
+ sky130_fd_sc_hd__dfxtp_1
XFILLER_0_20_693 VGND VGND VPWR VPWR sky130_fd_sc_hd__decap_6
X_4102_ edge_det.signal_reg net1 VGND VGND VPWR VPWR _1988_ sky130_fd_sc_hd__nor2b_2
X_5082_ clknet_leaf_38_clk _0002_ VGND VGND VPWR VPWR cpu_inst.regfile_inst.registers\[6\]\[2\]
+ sky130_fd_sc_hd__dfxtp_1
X_4033_ _1952_ VGND VGND VPWR VPWR _0035_ sky130_fd_sc_hd__clkbuf_1
XTAP_TAPCELL_ROW_88_1620 VGND VPWR sky130_fd_sc_hd__tapvpwrvgnd_1
XFILLER_0_2_77 VGND VGND VPWR VPWR sky130_fd_sc_hd__decap_6
XPHY_EDGE_ROW_50_Right_50 VGND VGND VPWR VPWR sky130_fd_sc_hd__decap_3
XFILLER_0_136_209 VPWR VGND VPWR VGND sky130_ef_sc_hd__decap_12
XFILLER_0_129_261 VPWR VGND VPWR VGND sky130_ef_sc_hd__decap_12
X_4935_ _1493_ cpu_inst.regfile_inst.registers\[8\]\[19\] _2449_ VGND VGND VPWR VPWR
+ _2455_ sky130_fd_sc_hd__mux2_1
XFILLER_0_75_833 VGND VGND VPWR VPWR sky130_fd_sc_hd__decap_6
XFILLER_0_74_321 VPWR VGND VPWR VGND sky130_ef_sc_hd__decap_12
XFILLER_0_19_237 VPWR VGND VPWR VGND sky130_ef_sc_hd__decap_12
X_4866_ cpu_inst.regfile_inst.registers\[9\]\[19\] VGND VGND VPWR VPWR _2418_ sky130_fd_sc_hd__clkbuf_1
XFILLER_0_74_365 VPWR VGND VPWR VGND sky130_ef_sc_hd__decap_12
X_3817_ cpu_inst.regfile_inst.registers\[15\]\[26\] _0729_ _1745_ _1552_ VGND VGND
+ VPWR VPWR _1746_ sky130_fd_sc_hd__a211o_1
X_4797_ _2383_ VGND VGND VPWR VPWR _0368_ sky130_fd_sc_hd__clkbuf_1
XFILLER_0_7_665 VGND VGND VPWR VPWR sky130_fd_sc_hd__decap_6
XFILLER_0_6_153 VPWR VGND VPWR VGND sky130_ef_sc_hd__decap_12
XFILLER_0_27_281 VPWR VGND VPWR VGND sky130_ef_sc_hd__decap_12
XFILLER_0_28_793 VGND VGND VPWR VPWR sky130_fd_sc_hd__decap_6
XTAP_TAPCELL_ROW_115_2027 VGND VPWR sky130_fd_sc_hd__tapvpwrvgnd_1
XTAP_TAPCELL_ROW_99_1782 VGND VPWR sky130_fd_sc_hd__tapvpwrvgnd_1
X_3748_ cpu_inst.regfile_inst.registers\[25\]\[24\] _1252_ _1069_ _1660_ VGND VGND
+ VPWR VPWR _1679_ sky130_fd_sc_hd__o211ai_1
XFILLER_0_104_139 VGND VGND VPWR VPWR sky130_fd_sc_hd__fill_1
XFILLER_0_6_197 VPWR VGND VPWR VGND sky130_ef_sc_hd__decap_12
XFILLER_0_30_413 VGND VGND VPWR VPWR sky130_fd_sc_hd__decap_6
XFILLER_0_42_251 VGND VGND VPWR VPWR sky130_fd_sc_hd__fill_1
XFILLER_0_113_673 VPWR VGND VPWR VGND sky130_ef_sc_hd__decap_12
XFILLER_0_100_301 VGND VGND VPWR VPWR sky130_fd_sc_hd__decap_6
X_3679_ _1603_ _1599_ VGND VGND VPWR VPWR _1611_ sky130_fd_sc_hd__or2_1
X_5418_ clknet_leaf_5_clk _0338_ net2 VGND VGND VPWR VPWR cpu_inst.decoder_inst.current_pc\[18\]
+ sky130_fd_sc_hd__dfrtp_1
XFILLER_0_30_457 VPWR VGND VPWR VGND sky130_ef_sc_hd__decap_12
XFILLER_0_100_345 VPWR VGND VPWR VGND sky130_ef_sc_hd__decap_12
X_5349_ clknet_leaf_26_clk _0269_ VGND VGND VPWR VPWR cpu_inst.regfile_inst.registers\[11\]\[13\]
+ sky130_fd_sc_hd__dfxtp_1
XFILLER_0_11_671 VGND VGND VPWR VPWR sky130_fd_sc_hd__fill_1
XFILLER_0_100_389 VPWR VGND VPWR VGND sky130_ef_sc_hd__decap_12
XTAP_TAPCELL_ROW_126_2189 VGND VPWR sky130_fd_sc_hd__tapvpwrvgnd_1
XFILLER_0_69_137 VPWR VGND VPWR VGND sky130_ef_sc_hd__decap_12
XFILLER_0_78_671 VGND VGND VPWR VPWR sky130_fd_sc_hd__decap_8
XFILLER_0_38_502 VGND VGND VPWR VPWR sky130_fd_sc_hd__fill_1
XFILLER_0_108_401 VPWR VGND VPWR VGND sky130_ef_sc_hd__decap_12
XFILLER_0_77_181 VPWR VGND VPWR VGND sky130_ef_sc_hd__decap_12
XTAP_TAPCELL_ROW_26_688 VGND VPWR sky130_fd_sc_hd__tapvpwrvgnd_1
XFILLER_0_65_365 VGND VGND VPWR VPWR sky130_fd_sc_hd__fill_1
XFILLER_0_38_579 VGND VGND VPWR VPWR sky130_fd_sc_hd__fill_1
XFILLER_0_108_445 VPWR VGND VPWR VGND sky130_ef_sc_hd__decap_12
XFILLER_0_93_696 VGND VGND VPWR VPWR sky130_fd_sc_hd__decap_6
XFILLER_0_108_489 VPWR VGND VPWR VGND sky130_ef_sc_hd__decap_12
XFILLER_0_92_195 VGND VGND VPWR VPWR sky130_fd_sc_hd__fill_1
XFILLER_0_80_357 VGND VGND VPWR VPWR sky130_fd_sc_hd__decap_6
XFILLER_0_61_582 VGND VGND VPWR VPWR sky130_fd_sc_hd__decap_8
XPHY_EDGE_ROW_12_Left_151 VGND VGND VPWR VPWR sky130_fd_sc_hd__decap_3
XFILLER_0_33_273 VGND VGND VPWR VPWR sky130_fd_sc_hd__decap_6
XFILLER_0_110_109 VPWR VGND VPWR VGND sky130_ef_sc_hd__decap_12
XFILLER_0_103_161 VGND VGND VPWR VPWR sky130_fd_sc_hd__decap_6
XTAP_TAPCELL_ROW_55_1129 VGND VPWR sky130_fd_sc_hd__tapvpwrvgnd_1
XTAP_TAPCELL_ROW_55_1118 VGND VPWR sky130_fd_sc_hd__tapvpwrvgnd_1
XFILLER_0_84_29 VPWR VGND VPWR VGND sky130_ef_sc_hd__decap_12
XTAP_TAPCELL_ROW_6_391 VGND VPWR sky130_fd_sc_hd__tapvpwrvgnd_1
XPHY_EDGE_ROW_21_Left_160 VGND VGND VPWR VPWR sky130_fd_sc_hd__decap_3
XFILLER_0_76_619 VPWR VGND VPWR VGND sky130_ef_sc_hd__decap_12
XFILLER_0_69_671 VGND VGND VPWR VPWR sky130_fd_sc_hd__fill_1
XFILLER_0_118_209 VPWR VGND VPWR VGND sky130_ef_sc_hd__decap_12
XTAP_TAPCELL_ROW_83_1550 VGND VPWR sky130_fd_sc_hd__tapvpwrvgnd_1
X_2981_ _0938_ _0945_ VGND VGND VPWR VPWR _0946_ sky130_fd_sc_hd__or2_1
XFILLER_0_56_332 VGND VGND VPWR VPWR sky130_fd_sc_hd__decap_4
XFILLER_0_33_55 VGND VGND VPWR VPWR sky130_fd_sc_hd__fill_1
XTAP_TAPCELL_ROW_45_975 VGND VPWR sky130_fd_sc_hd__tapvpwrvgnd_1
XFILLER_0_127_721 VGND VGND VPWR VPWR sky130_fd_sc_hd__decap_6
X_4720_ cpu_inst.decoder_inst.current_pc\[18\] _2288_ _2318_ _2336_ VGND VGND VPWR
+ VPWR _0338_ sky130_fd_sc_hd__o22a_1
XFILLER_0_29_579 VGND VGND VPWR VPWR sky130_fd_sc_hd__decap_3
Xclkbuf_leaf_41_clk clknet_2_0__leaf_clk VGND VGND VPWR VPWR clknet_leaf_41_clk sky130_fd_sc_hd__clkbuf_8
XFILLER_0_127_765 VPWR VGND VPWR VGND sky130_ef_sc_hd__decap_12
XFILLER_0_126_253 VPWR VGND VPWR VGND sky130_ef_sc_hd__decap_12
XFILLER_0_123_3 VPWR VGND VPWR VGND sky130_ef_sc_hd__decap_12
X_4651_ _1899_ _1928_ _2281_ _2283_ VGND VGND VPWR VPWR _2284_ sky130_fd_sc_hd__or4_4
X_3602_ _0864_ VGND VGND VPWR VPWR _1536_ sky130_fd_sc_hd__clkbuf_4
XFILLER_0_4_613 VPWR VGND VPWR VGND sky130_ef_sc_hd__decap_12
XFILLER_0_25_741 VPWR VGND VPWR VGND sky130_ef_sc_hd__decap_12
XFILLER_0_12_413 VGND VGND VPWR VPWR sky130_fd_sc_hd__decap_6
XFILLER_0_4_657 VPWR VGND VPWR VGND sky130_ef_sc_hd__decap_12
XFILLER_0_24_251 VGND VGND VPWR VPWR sky130_fd_sc_hd__fill_1
XFILLER_0_25_785 VPWR VGND VPWR VGND sky130_ef_sc_hd__decap_12
X_4582_ cpu_inst.regfile_inst.registers\[10\]\[10\] _2230_ VGND VGND VPWR VPWR _2239_
+ sky130_fd_sc_hd__and2_1
X_3533_ _0848_ VGND VGND VPWR VPWR _1469_ sky130_fd_sc_hd__buf_2
XFILLER_0_3_167 VGND VGND VPWR VPWR sky130_fd_sc_hd__fill_1
XFILLER_0_40_755 VGND VGND VPWR VPWR sky130_fd_sc_hd__fill_1
X_3464_ _0735_ _1401_ VGND VGND VPWR VPWR _1402_ sky130_fd_sc_hd__or2_1
XFILLER_0_12_457 VPWR VGND VPWR VGND sky130_ef_sc_hd__decap_12
XFILLER_0_0_841 VGND VGND VPWR VPWR sky130_fd_sc_hd__fill_1
XFILLER_0_40_766 VGND VGND VPWR VPWR sky130_fd_sc_hd__decap_4
XFILLER_0_110_643 VGND VGND VPWR VPWR sky130_fd_sc_hd__fill_1
X_5203_ clknet_leaf_7_clk _0123_ VGND VGND VPWR VPWR cpu_inst.regfile_inst.registers\[4\]\[27\]
+ sky130_fd_sc_hd__dfxtp_1
XFILLER_0_58_41 VPWR VGND VPWR VGND sky130_ef_sc_hd__decap_12
X_5134_ clknet_leaf_16_clk _0054_ VGND VGND VPWR VPWR cpu_inst.regfile_inst.registers\[2\]\[22\]
+ sky130_fd_sc_hd__dfxtp_1
X_3395_ _1299_ VGND VGND VPWR VPWR _1339_ sky130_fd_sc_hd__buf_4
XFILLER_0_58_85 VPWR VGND VPWR VGND sky130_ef_sc_hd__decap_12
X_5065_ cpu_inst.display_inst.counter\[13\] cpu_inst.display_inst.counter\[12\] cpu_inst.display_inst.counter\[14\]
+ _2522_ VGND VGND VPWR VPWR _2526_ sky130_fd_sc_hd__and4_1
X_4016_ _1937_ _1938_ _1308_ VGND VGND VPWR VPWR _1939_ sky130_fd_sc_hd__mux2_1
XFILLER_0_28_3 VPWR VGND VPWR VGND sky130_ef_sc_hd__decap_12
XFILLER_0_137_529 VPWR VGND VPWR VGND sky130_ef_sc_hd__decap_12
XFILLER_0_94_449 VGND VGND VPWR VPWR sky130_fd_sc_hd__decap_4
XFILLER_0_59_181 VPWR VGND VPWR VGND sky130_ef_sc_hd__decap_12
XFILLER_0_90_83 VGND VGND VPWR VPWR sky130_fd_sc_hd__fill_1
XTAP_TAPCELL_ROW_23_647 VGND VPWR sky130_fd_sc_hd__tapvpwrvgnd_1
Xclkbuf_leaf_32_clk clknet_2_2__leaf_clk VGND VGND VPWR VPWR clknet_leaf_32_clk sky130_fd_sc_hd__clkbuf_8
X_4918_ _1215_ cpu_inst.regfile_inst.registers\[8\]\[11\] _2432_ VGND VGND VPWR VPWR
+ _2446_ sky130_fd_sc_hd__mux2_1
XFILLER_0_63_825 VPWR VGND VPWR VGND sky130_ef_sc_hd__decap_12
XFILLER_0_35_538 VGND VGND VPWR VPWR sky130_fd_sc_hd__fill_2
XFILLER_0_74_195 VGND VGND VPWR VPWR sky130_fd_sc_hd__fill_1
XFILLER_0_7_473 VPWR VGND VPWR VGND sky130_ef_sc_hd__decap_12
X_4849_ _2409_ VGND VGND VPWR VPWR _0394_ sky130_fd_sc_hd__clkbuf_1
XFILLER_0_132_245 VGND VGND VPWR VPWR sky130_fd_sc_hd__decap_6
XFILLER_0_99_81 VPWR VGND VPWR VGND sky130_ef_sc_hd__decap_12
XFILLER_0_90_699 VGND VGND VPWR VPWR sky130_fd_sc_hd__fill_1
XFILLER_0_31_711 VGND VGND VPWR VPWR sky130_fd_sc_hd__decap_4
XFILLER_0_15_273 VGND VGND VPWR VPWR sky130_fd_sc_hd__decap_6
XFILLER_0_30_221 VPWR VGND VPWR VGND sky130_ef_sc_hd__decap_12
XFILLER_0_132_289 VPWR VGND VPWR VGND sky130_ef_sc_hd__decap_12
XFILLER_0_30_265 VPWR VGND VPWR VGND sky130_ef_sc_hd__decap_12
XFILLER_0_31_777 VGND VGND VPWR VPWR sky130_fd_sc_hd__decap_6
XFILLER_0_100_153 VPWR VGND VPWR VGND sky130_ef_sc_hd__decap_12
XTAP_TAPCELL_ROW_128_2218 VGND VPWR sky130_fd_sc_hd__tapvpwrvgnd_1
XFILLER_0_100_197 VPWR VGND VPWR VGND sky130_ef_sc_hd__decap_12
XTAP_TAPCELL_ROW_50_1048 VGND VPWR sky130_fd_sc_hd__tapvpwrvgnd_1
XTAP_TAPCELL_ROW_3_350 VGND VPWR sky130_fd_sc_hd__tapvpwrvgnd_1
XFILLER_0_39_811 VGND VGND VPWR VPWR sky130_fd_sc_hd__fill_2
XFILLER_0_38_321 VPWR VGND VPWR VGND sky130_ef_sc_hd__decap_12
XTAP_TAPCELL_ROW_42_923 VGND VPWR sky130_fd_sc_hd__tapvpwrvgnd_1
XFILLER_0_109_721 VGND VGND VPWR VPWR sky130_fd_sc_hd__decap_6
Xclkbuf_leaf_23_clk clknet_2_3__leaf_clk VGND VGND VPWR VPWR clknet_leaf_23_clk sky130_fd_sc_hd__clkbuf_8
XTAP_TAPCELL_ROW_65_1280 VGND VPWR sky130_fd_sc_hd__tapvpwrvgnd_1
XFILLER_0_54_803 VGND VGND VPWR VPWR sky130_fd_sc_hd__decap_8
XFILLER_0_38_365 VPWR VGND VPWR VGND sky130_ef_sc_hd__decap_12
XTAP_TAPCELL_ROW_42_934 VGND VPWR sky130_fd_sc_hd__tapvpwrvgnd_1
XFILLER_0_109_765 VPWR VGND VPWR VGND sky130_ef_sc_hd__decap_12
XFILLER_0_124_713 VPWR VGND VPWR VGND sky130_ef_sc_hd__decap_12
XFILLER_0_108_253 VPWR VGND VPWR VGND sky130_ef_sc_hd__decap_12
XFILLER_0_80_121 VPWR VGND VPWR VGND sky130_ef_sc_hd__decap_12
XFILLER_0_53_335 VGND VGND VPWR VPWR sky130_fd_sc_hd__fill_1
XFILLER_0_124_757 VPWR VGND VPWR VGND sky130_ef_sc_hd__decap_12
XFILLER_0_123_223 VGND VGND VPWR VPWR sky130_fd_sc_hd__fill_1
XFILLER_0_110_15 VPWR VGND VPWR VGND sky130_ef_sc_hd__decap_12
XFILLER_0_80_165 VPWR VGND VPWR VGND sky130_ef_sc_hd__decap_12
XFILLER_0_53_368 VPWR VGND VPWR VGND sky130_ef_sc_hd__decap_12
XFILLER_0_111_429 VPWR VGND VPWR VGND sky130_ef_sc_hd__decap_12
XFILLER_0_22_755 VGND VGND VPWR VPWR sky130_fd_sc_hd__fill_1
XFILLER_0_95_39 VPWR VGND VPWR VGND sky130_ef_sc_hd__decap_12
XFILLER_0_0_137 VGND VGND VPWR VPWR sky130_fd_sc_hd__decap_3
XFILLER_0_119_57 VPWR VGND VPWR VGND sky130_ef_sc_hd__decap_12
X_3180_ _1065_ _1023_ _1060_ VGND VGND VPWR VPWR _1145_ sky130_fd_sc_hd__mux2_1
XFILLER_0_28_77 VGND VGND VPWR VPWR sky130_fd_sc_hd__decap_6
XTAP_TAPCELL_ROW_1_309 VGND VPWR sky130_fd_sc_hd__tapvpwrvgnd_1
XFILLER_0_88_221 VPWR VGND VPWR VGND sky130_ef_sc_hd__decap_12
XFILLER_0_88_265 VPWR VGND VPWR VGND sky130_ef_sc_hd__decap_12
XFILLER_0_44_65 VPWR VGND VPWR VGND sky130_ef_sc_hd__decap_12
XTAP_TAPCELL_ROW_81_1509 VGND VPWR sky130_fd_sc_hd__tapvpwrvgnd_1
XFILLER_0_9_727 VGND VGND VPWR VPWR sky130_fd_sc_hd__fill_1
XFILLER_0_119_529 VPWR VGND VPWR VGND sky130_ef_sc_hd__decap_12
X_2964_ cpu_inst.regfile_inst.registers\[25\]\[5\] _0903_ _0921_ _0928_ VGND VGND
+ VPWR VPWR _0929_ sky130_fd_sc_hd__o211ai_2
XFILLER_0_17_505 VPWR VGND VPWR VGND sky130_ef_sc_hd__decap_12
Xclkbuf_leaf_14_clk clknet_2_3__leaf_clk VGND VGND VPWR VPWR clknet_leaf_14_clk sky130_fd_sc_hd__clkbuf_8
XFILLER_0_72_622 VGND VGND VPWR VPWR sky130_fd_sc_hd__fill_1
X_4703_ cpu_inst.decoder_inst.current_pc\[14\] _2320_ VGND VGND VPWR VPWR _2324_ sky130_fd_sc_hd__nor2_1
XFILLER_0_60_53 VPWR VGND VPWR VGND sky130_ef_sc_hd__decap_12
XTAP_TAPCELL_ROW_20_606 VGND VPWR sky130_fd_sc_hd__tapvpwrvgnd_1
XFILLER_0_127_573 VPWR VGND VPWR VGND sky130_ef_sc_hd__decap_12
X_2895_ _0843_ _0857_ _0858_ _0859_ VGND VGND VPWR VPWR _0860_ sky130_fd_sc_hd__o211a_1
XFILLER_0_60_97 VPWR VGND VPWR VGND sky130_ef_sc_hd__decap_12
XFILLER_0_56_195 VGND VGND VPWR VPWR sky130_fd_sc_hd__fill_1
XFILLER_0_44_357 VGND VGND VPWR VPWR sky130_fd_sc_hd__decap_6
XFILLER_0_72_699 VGND VGND VPWR VPWR sky130_fd_sc_hd__fill_1
XFILLER_0_60_828 VPWR VGND VPWR VGND sky130_ef_sc_hd__decap_12
XFILLER_0_4_421 VPWR VGND VPWR VGND sky130_ef_sc_hd__decap_12
X_4634_ _2265_ _2266_ _2267_ _2268_ VGND VGND VPWR VPWR _2269_ sky130_fd_sc_hd__or4_1
XFILLER_0_114_245 VGND VGND VPWR VPWR sky130_fd_sc_hd__decap_6
XTAP_TAPCELL_ROW_96_1741 VGND VPWR sky130_fd_sc_hd__tapvpwrvgnd_1
XFILLER_0_12_221 VPWR VGND VPWR VGND sky130_ef_sc_hd__decap_12
XFILLER_0_8_65 VPWR VGND VPWR VGND sky130_ef_sc_hd__decap_12
X_4565_ _2231_ VGND VGND VPWR VPWR _0288_ sky130_fd_sc_hd__clkbuf_1
XFILLER_0_130_749 VGND VGND VPWR VPWR sky130_fd_sc_hd__decap_6
XFILLER_0_114_289 VPWR VGND VPWR VGND sky130_ef_sc_hd__decap_12
XFILLER_0_102_429 VGND VGND VPWR VPWR sky130_fd_sc_hd__decap_4
X_3516_ _1378_ _1452_ _1255_ VGND VGND VPWR VPWR _1453_ sky130_fd_sc_hd__mux2_1
XFILLER_0_13_777 VGND VGND VPWR VPWR sky130_fd_sc_hd__decap_6
X_4496_ _1928_ cpu_inst.regfile_inst.registers\[7\]\[31\] _2186_ VGND VGND VPWR VPWR
+ _2196_ sky130_fd_sc_hd__mux2_1
XFILLER_0_12_265 VPWR VGND VPWR VGND sky130_ef_sc_hd__decap_12
XPHY_EDGE_ROW_4_Right_4 VGND VGND VPWR VPWR sky130_fd_sc_hd__decap_3
XFILLER_0_40_574 VPWR VGND VPWR VGND sky130_ef_sc_hd__decap_12
X_3447_ _1092_ _1384_ _0527_ _1295_ VGND VGND VPWR VPWR _1385_ sky130_fd_sc_hd__a31o_4
X_3378_ _0512_ _1288_ _1291_ VGND VGND VPWR VPWR _1328_ sky130_fd_sc_hd__or3b_1
X_5117_ clknet_leaf_35_clk _0037_ VGND VGND VPWR VPWR cpu_inst.regfile_inst.registers\[2\]\[5\]
+ sky130_fd_sc_hd__dfxtp_1
X_5048_ cpu_inst.display_inst.counter\[7\] cpu_inst.display_inst.counter\[8\] _2512_
+ VGND VGND VPWR VPWR _2515_ sky130_fd_sc_hd__and3_1
XTAP_TAPCELL_ROW_28_717 VGND VPWR sky130_fd_sc_hd__tapvpwrvgnd_1
XTAP_TAPCELL_ROW_123_2148 VGND VPWR sky130_fd_sc_hd__tapvpwrvgnd_1
XFILLER_0_67_449 VPWR VGND VPWR VGND sky130_ef_sc_hd__decap_12
XFILLER_0_137_337 VPWR VGND VPWR VGND sky130_ef_sc_hd__decap_12
XTAP_TAPCELL_ROW_105_1881 VGND VPWR sky130_fd_sc_hd__tapvpwrvgnd_1
XTAP_TAPCELL_ROW_105_1870 VGND VPWR sky130_fd_sc_hd__tapvpwrvgnd_1
XFILLER_0_106_713 VPWR VGND VPWR VGND sky130_ef_sc_hd__decap_12
XFILLER_0_62_121 VPWR VGND VPWR VGND sky130_ef_sc_hd__decap_12
XFILLER_0_35_335 VGND VGND VPWR VPWR sky130_fd_sc_hd__fill_1
XTAP_TAPCELL_ROW_138_2391 VGND VPWR sky130_fd_sc_hd__tapvpwrvgnd_1
XTAP_TAPCELL_ROW_138_2380 VGND VPWR sky130_fd_sc_hd__tapvpwrvgnd_1
XFILLER_0_106_757 VPWR VGND VPWR VGND sky130_ef_sc_hd__decap_12
XFILLER_0_105_223 VGND VGND VPWR VPWR sky130_fd_sc_hd__fill_1
XFILLER_0_90_463 VGND VGND VPWR VPWR sky130_fd_sc_hd__decap_8
XFILLER_0_62_165 VPWR VGND VPWR VGND sky130_ef_sc_hd__decap_12
XFILLER_0_8_793 VPWR VGND VPWR VGND sky130_ef_sc_hd__decap_12
XFILLER_0_7_281 VPWR VGND VPWR VGND sky130_ef_sc_hd__decap_12
XFILLER_0_121_727 VGND VGND VPWR VPWR sky130_fd_sc_hd__fill_1
XTAP_TAPCELL_ROW_8_420 VGND VPWR sky130_fd_sc_hd__tapvpwrvgnd_1
XFILLER_0_105_15 VPWR VGND VPWR VGND sky130_ef_sc_hd__decap_12
XTAP_TAPCELL_ROW_63_1239 VGND VPWR sky130_fd_sc_hd__tapvpwrvgnd_1
XFILLER_0_39_652 VGND VGND VPWR VPWR sky130_fd_sc_hd__decap_4
XFILLER_0_85_279 VGND VGND VPWR VPWR sky130_fd_sc_hd__fill_1
XFILLER_0_109_573 VPWR VGND VPWR VGND sky130_ef_sc_hd__decap_12
XFILLER_0_38_195 VGND VGND VPWR VPWR sky130_fd_sc_hd__fill_1
XFILLER_0_121_69 VPWR VGND VPWR VGND sky130_ef_sc_hd__decap_12
XFILLER_0_81_474 VGND VGND VPWR VPWR sky130_fd_sc_hd__fill_1
X_2680_ _0514_ _0619_ _0644_ VGND VGND VPWR VPWR _0645_ sky130_fd_sc_hd__o21ai_1
XFILLER_0_26_357 VGND VGND VPWR VPWR sky130_fd_sc_hd__decap_6
XFILLER_0_41_305 VPWR VGND VPWR VGND sky130_ef_sc_hd__decap_12
XFILLER_0_41_349 VPWR VGND VPWR VGND sky130_ef_sc_hd__decap_12
XFILLER_0_124_587 VGND VGND VPWR VPWR sky130_fd_sc_hd__fill_1
XFILLER_0_112_749 VGND VGND VPWR VPWR sky130_fd_sc_hd__decap_6
X_4350_ _2120_ VGND VGND VPWR VPWR _0184_ sky130_fd_sc_hd__clkbuf_1
XTAP_TAPCELL_ROW_78_1471 VGND VPWR sky130_fd_sc_hd__tapvpwrvgnd_1
XFILLER_0_111_237 VPWR VGND VPWR VGND sky130_ef_sc_hd__decap_12
X_3301_ _1200_ _1265_ VGND VGND VPWR VPWR _1266_ sky130_fd_sc_hd__nand2_1
XFILLER_0_10_725 VPWR VGND VPWR VGND sky130_ef_sc_hd__decap_12
X_4281_ cpu_inst.regfile_inst.registers\[24\]\[25\] VGND VGND VPWR VPWR _2083_ sky130_fd_sc_hd__clkbuf_1
XFILLER_0_10_769 VPWR VGND VPWR VGND sky130_ef_sc_hd__decap_12
XFILLER_0_120_793 VPWR VGND VPWR VGND sky130_ef_sc_hd__decap_12
XTAP_TAPCELL_ROW_91_1671 VGND VPWR sky130_fd_sc_hd__tapvpwrvgnd_1
XTAP_TAPCELL_ROW_91_1660 VGND VPWR sky130_fd_sc_hd__tapvpwrvgnd_1
Xclkbuf_leaf_3_clk clknet_2_1__leaf_clk VGND VGND VPWR VPWR clknet_leaf_3_clk sky130_fd_sc_hd__clkbuf_8
X_3232_ _0689_ _1196_ _0690_ VGND VGND VPWR VPWR _1197_ sky130_fd_sc_hd__o21a_1
X_3163_ _1126_ _1127_ _0871_ VGND VGND VPWR VPWR _1128_ sky130_fd_sc_hd__mux2_1
X_3094_ cpu_inst.regfile_inst.registers\[25\]\[9\] _1022_ _0921_ _0972_ VGND VGND
+ VPWR VPWR _1059_ sky130_fd_sc_hd__o211a_1
XFILLER_0_49_449 VPWR VGND VPWR VGND sky130_ef_sc_hd__decap_12
XFILLER_0_119_337 VPWR VGND VPWR VGND sky130_ef_sc_hd__decap_12
XFILLER_0_92_728 VGND VGND VPWR VPWR sky130_fd_sc_hd__decap_4
XFILLER_0_91_205 VPWR VGND VPWR VGND sky130_ef_sc_hd__decap_12
X_3996_ _1901_ _1919_ VGND VGND VPWR VPWR _1920_ sky130_fd_sc_hd__xnor2_1
XFILLER_0_18_825 VPWR VGND VPWR VGND sky130_ef_sc_hd__decap_12
XFILLER_0_45_611 VGND VGND VPWR VPWR sky130_fd_sc_hd__decap_4
XFILLER_0_134_307 VGND VGND VPWR VPWR sky130_fd_sc_hd__fill_1
XFILLER_0_91_249 VPWR VGND VPWR VGND sky130_ef_sc_hd__decap_12
XFILLER_0_72_430 VGND VGND VPWR VPWR sky130_fd_sc_hd__fill_1
X_2947_ _0859_ _0757_ _0768_ _0769_ VGND VGND VPWR VPWR _0912_ sky130_fd_sc_hd__a31oi_4
XFILLER_0_17_335 VGND VGND VPWR VPWR sky130_fd_sc_hd__fill_1
XTAP_TAPCELL_ROW_33_797 VGND VPWR sky130_fd_sc_hd__tapvpwrvgnd_1
XFILLER_0_44_121 VPWR VGND VPWR VGND sky130_ef_sc_hd__decap_12
XFILLER_0_95_3 VPWR VGND VPWR VGND sky130_ef_sc_hd__decap_12
XFILLER_0_5_741 VPWR VGND VPWR VGND sky130_ef_sc_hd__decap_12
XFILLER_0_44_165 VPWR VGND VPWR VGND sky130_ef_sc_hd__decap_12
X_4617_ _2257_ VGND VGND VPWR VPWR _0314_ sky130_fd_sc_hd__clkbuf_1
XFILLER_0_72_496 VGND VGND VPWR VPWR sky130_fd_sc_hd__decap_8
X_2878_ _0611_ VGND VGND VPWR VPWR _0843_ sky130_fd_sc_hd__buf_4
XFILLER_0_4_251 VGND VGND VPWR VPWR sky130_fd_sc_hd__fill_1
XFILLER_0_45_699 VGND VGND VPWR VPWR sky130_fd_sc_hd__decap_8
XFILLER_0_130_513 VPWR VGND VPWR VGND sky130_ef_sc_hd__decap_12
XFILLER_0_103_727 VGND VGND VPWR VPWR sky130_fd_sc_hd__fill_1
XFILLER_0_5_785 VPWR VGND VPWR VGND sky130_ef_sc_hd__decap_12
XFILLER_0_13_541 VPWR VGND VPWR VGND sky130_ef_sc_hd__decap_12
XFILLER_0_130_557 VPWR VGND VPWR VGND sky130_ef_sc_hd__decap_12
X_4548_ cpu_inst.regfile_inst.registers\[11\]\[25\] VGND VGND VPWR VPWR _2222_ sky130_fd_sc_hd__clkbuf_1
XFILLER_0_13_585 VPWR VGND VPWR VGND sky130_ef_sc_hd__decap_12
X_4479_ _2187_ VGND VGND VPWR VPWR _0246_ sky130_fd_sc_hd__clkbuf_1
XFILLER_0_99_305 VPWR VGND VPWR VGND sky130_ef_sc_hd__decap_12
XTAP_TAPCELL_ROW_107_1910 VGND VPWR sky130_fd_sc_hd__tapvpwrvgnd_1
XFILLER_0_99_349 VPWR VGND VPWR VGND sky130_ef_sc_hd__decap_12
XPHY_EDGE_ROW_79_Right_79 VGND VGND VPWR VPWR sky130_fd_sc_hd__decap_3
XFILLER_0_138_613 VGND VGND VPWR VPWR sky130_fd_sc_hd__decap_3
XFILLER_0_138_657 VPWR VGND VPWR VGND sky130_ef_sc_hd__decap_12
XFILLER_0_67_279 VGND VGND VPWR VPWR sky130_fd_sc_hd__fill_1
XFILLER_0_137_167 VGND VGND VPWR VPWR sky130_fd_sc_hd__fill_1
XFILLER_0_125_329 VGND VGND VPWR VPWR sky130_fd_sc_hd__decap_6
XFILLER_0_36_633 VGND VGND VPWR VPWR sky130_fd_sc_hd__decap_4
XTAP_TAPCELL_ROW_136_2339 VGND VPWR sky130_fd_sc_hd__tapvpwrvgnd_1
XFILLER_0_23_305 VPWR VGND VPWR VGND sky130_ef_sc_hd__decap_12
XFILLER_0_36_688 VGND VGND VPWR VPWR sky130_fd_sc_hd__decap_3
XPHY_EDGE_ROW_88_Right_88 VGND VGND VPWR VPWR sky130_fd_sc_hd__decap_3
XTAP_TAPCELL_ROW_11_469 VGND VPWR sky130_fd_sc_hd__tapvpwrvgnd_1
XTAP_TAPCELL_ROW_11_458 VGND VPWR sky130_fd_sc_hd__tapvpwrvgnd_1
XFILLER_0_133_373 VPWR VGND VPWR VGND sky130_ef_sc_hd__decap_12
XFILLER_0_23_349 VPWR VGND VPWR VGND sky130_ef_sc_hd__decap_12
XFILLER_0_31_393 VPWR VGND VPWR VGND sky130_ef_sc_hd__decap_12
XFILLER_0_101_281 VPWR VGND VPWR VGND sky130_ef_sc_hd__decap_12
XTAP_TAPCELL_ROW_73_1390 VGND VPWR sky130_fd_sc_hd__tapvpwrvgnd_1
XPHY_EDGE_ROW_97_Right_97 VGND VGND VPWR VPWR sky130_fd_sc_hd__decap_3
XFILLER_0_92_29 VPWR VGND VPWR VGND sky130_ef_sc_hd__decap_12
XFILLER_0_86_533 VPWR VGND VPWR VGND sky130_ef_sc_hd__decap_12
X_3850_ _1772_ _1777_ _0843_ VGND VGND VPWR VPWR _1778_ sky130_fd_sc_hd__a21o_1
XFILLER_0_73_205 VPWR VGND VPWR VGND sky130_ef_sc_hd__decap_12
XFILLER_0_116_307 VGND VGND VPWR VPWR sky130_fd_sc_hd__fill_1
X_3781_ cpu_inst.regfile_inst.registers\[0\]\[25\] _1469_ _1470_ cpu_inst.regfile_inst.registers\[4\]\[25\]
+ _1560_ VGND VGND VPWR VPWR _1711_ sky130_fd_sc_hd__o221a_1
XFILLER_0_73_249 VPWR VGND VPWR VGND sky130_ef_sc_hd__decap_12
XPHY_EDGE_ROW_4_Left_143 VGND VGND VPWR VPWR sky130_fd_sc_hd__decap_3
XFILLER_0_26_121 VPWR VGND VPWR VGND sky130_ef_sc_hd__decap_12
XFILLER_0_27_633 VPWR VGND VPWR VGND sky130_ef_sc_hd__decap_12
X_2801_ cpu_inst.regfile_inst.registers\[4\]\[2\] _0622_ _0614_ cpu_inst.regfile_inst.registers\[0\]\[2\]
+ VGND VGND VPWR VPWR _0766_ sky130_fd_sc_hd__o22a_1
XFILLER_0_41_55 VGND VGND VPWR VPWR sky130_fd_sc_hd__fill_1
XFILLER_0_128_189 VGND VGND VPWR VPWR sky130_fd_sc_hd__decap_6
XFILLER_0_125_841 VGND VGND VPWR VPWR sky130_fd_sc_hd__fill_1
X_5520_ clknet_leaf_9_clk _0440_ VGND VGND VPWR VPWR cpu_inst.regfile_inst.registers\[8\]\[24\]
+ sky130_fd_sc_hd__dfxtp_1
XFILLER_0_26_165 VPWR VGND VPWR VGND sky130_ef_sc_hd__decap_12
XTAP_TAPCELL_ROW_30_745 VGND VPWR sky130_fd_sc_hd__tapvpwrvgnd_1
XTAP_TAPCELL_ROW_30_756 VGND VPWR sky130_fd_sc_hd__tapvpwrvgnd_1
X_2732_ _0524_ VGND VGND VPWR VPWR _0697_ sky130_fd_sc_hd__buf_2
XFILLER_0_81_293 VPWR VGND VPWR VGND sky130_ef_sc_hd__decap_12
XFILLER_0_15_839 VGND VGND VPWR VPWR sky130_fd_sc_hd__fill_1
XFILLER_0_41_113 VPWR VGND VPWR VGND sky130_ef_sc_hd__decap_12
XFILLER_0_112_513 VPWR VGND VPWR VGND sky130_ef_sc_hd__decap_12
X_5451_ clknet_leaf_18_clk _0371_ VGND VGND VPWR VPWR cpu_inst.regfile_inst.registers\[0\]\[19\]
+ sky130_fd_sc_hd__dfxtp_1
XTAP_TAPCELL_ROW_93_1700 VGND VPWR sky130_fd_sc_hd__tapvpwrvgnd_1
XFILLER_0_30_809 VGND VGND VPWR VPWR sky130_fd_sc_hd__decap_3
X_2663_ cpu_inst.regfile_inst.registers\[2\]\[1\] _0627_ _0603_ cpu_inst.regfile_inst.registers\[7\]\[1\]
+ VGND VGND VPWR VPWR _0628_ sky130_fd_sc_hd__o22a_1
XFILLER_0_112_557 VPWR VGND VPWR VGND sky130_ef_sc_hd__decap_12
X_4402_ _2146_ VGND VGND VPWR VPWR _0210_ sky130_fd_sc_hd__clkbuf_1
X_5382_ clknet_leaf_26_clk _0302_ VGND VGND VPWR VPWR cpu_inst.regfile_inst.registers\[10\]\[14\]
+ sky130_fd_sc_hd__dfxtp_1
X_2594_ _0558_ _0556_ _0555_ _0557_ VGND VGND VPWR VPWR _0559_ sky130_fd_sc_hd__and4_1
XFILLER_0_2_755 VGND VGND VPWR VPWR sky130_fd_sc_hd__fill_1
X_4333_ _2111_ VGND VGND VPWR VPWR _0176_ sky130_fd_sc_hd__clkbuf_1
XFILLER_0_10_533 VPWR VGND VPWR VGND sky130_ef_sc_hd__decap_12
X_4264_ _2074_ VGND VGND VPWR VPWR _0144_ sky130_fd_sc_hd__clkbuf_1
XFILLER_0_66_41 VPWR VGND VPWR VGND sky130_ef_sc_hd__decap_12
X_3215_ _0912_ _1179_ VGND VGND VPWR VPWR _1180_ sky130_fd_sc_hd__or2_1
XFILLER_0_5_55 VGND VGND VPWR VPWR sky130_fd_sc_hd__fill_1
XFILLER_0_66_85 VPWR VGND VPWR VGND sky130_ef_sc_hd__decap_12
X_4195_ _2039_ VGND VGND VPWR VPWR _0110_ sky130_fd_sc_hd__clkbuf_1
X_3146_ _1039_ _1046_ _1047_ _0878_ VGND VGND VPWR VPWR _1111_ sky130_fd_sc_hd__o2bb2a_1
X_3077_ _1040_ _1041_ _0870_ VGND VGND VPWR VPWR _1042_ sky130_fd_sc_hd__mux2_1
XTAP_TAPCELL_ROW_120_2107 VGND VPWR sky130_fd_sc_hd__tapvpwrvgnd_1
XFILLER_0_10_3 VPWR VGND VPWR VGND sky130_ef_sc_hd__decap_12
XTAP_TAPCELL_ROW_38_867 VGND VPWR sky130_fd_sc_hd__tapvpwrvgnd_1
XFILLER_0_49_279 VGND VGND VPWR VPWR sky130_fd_sc_hd__fill_1
XFILLER_0_119_167 VGND VGND VPWR VPWR sky130_fd_sc_hd__fill_1
XFILLER_0_92_547 VGND VGND VPWR VPWR sky130_fd_sc_hd__decap_4
XFILLER_0_92_536 VGND VGND VPWR VPWR sky130_fd_sc_hd__decap_3
XPHY_EDGE_ROW_59_Left_198 VGND VGND VPWR VPWR sky130_fd_sc_hd__decap_3
XFILLER_0_116_841 VGND VGND VPWR VPWR sky130_fd_sc_hd__fill_1
XFILLER_0_107_329 VGND VGND VPWR VPWR sky130_fd_sc_hd__decap_6
X_3979_ cpu_inst.regfile_inst.registers\[7\]\[31\] cpu_inst.regfile_inst.registers\[6\]\[31\]
+ _1797_ VGND VGND VPWR VPWR _1903_ sky130_fd_sc_hd__mux2_1
XTAP_TAPCELL_ROW_118_2069 VGND VPWR sky130_fd_sc_hd__tapvpwrvgnd_1
XFILLER_0_18_699 VGND VGND VPWR VPWR sky130_fd_sc_hd__fill_1
XFILLER_0_131_833 VGND VGND VPWR VPWR sky130_fd_sc_hd__decap_6
XFILLER_0_115_373 VPWR VGND VPWR VGND sky130_ef_sc_hd__decap_12
XFILLER_0_21_809 VPWR VGND VPWR VGND sky130_ef_sc_hd__decap_12
XTAP_TAPCELL_ROW_131_2258 VGND VPWR sky130_fd_sc_hd__tapvpwrvgnd_1
XFILLER_0_130_321 VPWR VGND VPWR VGND sky130_ef_sc_hd__decap_12
XFILLER_0_60_477 VGND VGND VPWR VPWR sky130_fd_sc_hd__decap_6
XTAP_TAPCELL_ROW_131_2269 VGND VPWR sky130_fd_sc_hd__tapvpwrvgnd_1
XFILLER_0_130_365 VPWR VGND VPWR VGND sky130_ef_sc_hd__decap_12
XFILLER_0_13_393 VPWR VGND VPWR VGND sky130_ef_sc_hd__decap_12
XTAP_TAPCELL_ROW_113_1991 VGND VPWR sky130_fd_sc_hd__tapvpwrvgnd_1
XPHY_EDGE_ROW_130_Right_130 VGND VGND VPWR VPWR sky130_fd_sc_hd__decap_3
XFILLER_0_99_113 VPWR VGND VPWR VGND sky130_ef_sc_hd__decap_12
XFILLER_0_88_809 VGND VGND VPWR VPWR sky130_fd_sc_hd__decap_3
XFILLER_0_68_511 VPWR VGND VPWR VGND sky130_ef_sc_hd__decap_12
XTAP_TAPCELL_ROW_47_1009 VGND VPWR sky130_fd_sc_hd__tapvpwrvgnd_1
XTAP_TAPCELL_ROW_16_539 VGND VPWR sky130_fd_sc_hd__tapvpwrvgnd_1
XFILLER_0_138_421 VPWR VGND VPWR VGND sky130_ef_sc_hd__decap_12
XFILLER_0_95_385 VGND VGND VPWR VPWR sky130_fd_sc_hd__decap_6
XFILLER_0_68_577 VGND VGND VPWR VPWR sky130_fd_sc_hd__decap_4
XFILLER_0_55_205 VPWR VGND VPWR VGND sky130_ef_sc_hd__decap_12
XFILLER_0_28_419 VGND VGND VPWR VPWR sky130_fd_sc_hd__fill_1
XFILLER_0_55_249 VPWR VGND VPWR VGND sky130_ef_sc_hd__decap_12
XFILLER_0_125_137 VPWR VGND VPWR VGND sky130_ef_sc_hd__decap_12
XFILLER_0_107_841 VGND VGND VPWR VPWR sky130_fd_sc_hd__fill_1
XFILLER_0_102_27 VGND VGND VPWR VPWR sky130_fd_sc_hd__fill_1
XFILLER_0_23_113 VPWR VGND VPWR VGND sky130_ef_sc_hd__decap_12
XFILLER_0_36_474 VGND VGND VPWR VPWR sky130_fd_sc_hd__fill_2
XFILLER_0_134_693 VGND VGND VPWR VPWR sky130_fd_sc_hd__decap_6
XFILLER_0_122_811 VGND VGND VPWR VPWR sky130_fd_sc_hd__fill_1
XFILLER_0_63_293 VGND VGND VPWR VPWR sky130_fd_sc_hd__decap_8
XFILLER_0_11_69 VPWR VGND VPWR VGND sky130_ef_sc_hd__decap_12
XFILLER_0_24_669 VPWR VGND VPWR VGND sky130_ef_sc_hd__decap_12
XFILLER_0_133_181 VPWR VGND VPWR VGND sky130_ef_sc_hd__decap_12
XTAP_TAPCELL_ROW_75_1430 VGND VPWR sky130_fd_sc_hd__tapvpwrvgnd_1
XFILLER_0_127_57 VPWR VGND VPWR VGND sky130_ef_sc_hd__decap_12
X_3000_ _0859_ _0827_ _0828_ _0610_ VGND VGND VPWR VPWR _0965_ sky130_fd_sc_hd__a31o_1
XFILLER_0_36_77 VGND VGND VPWR VPWR sky130_fd_sc_hd__decap_6
X_4951_ _1946_ cpu_inst.regfile_inst.registers\[8\]\[27\] _2436_ VGND VGND VPWR VPWR
+ _2463_ sky130_fd_sc_hd__mux2_1
XTAP_TAPCELL_ROW_86_1592 VGND VPWR sky130_fd_sc_hd__tapvpwrvgnd_1
XTAP_TAPCELL_ROW_35_826 VGND VPWR sky130_fd_sc_hd__tapvpwrvgnd_1
X_4882_ cpu_inst.regfile_inst.registers\[9\]\[27\] VGND VGND VPWR VPWR _2426_ sky130_fd_sc_hd__clkbuf_1
XFILLER_0_86_363 VGND VGND VPWR VPWR sky130_fd_sc_hd__fill_1
X_3902_ _1176_ _1828_ VGND VGND VPWR VPWR _1829_ sky130_fd_sc_hd__or2_1
XFILLER_0_74_525 VGND VGND VPWR VPWR sky130_fd_sc_hd__decap_6
XFILLER_0_52_65 VPWR VGND VPWR VGND sky130_ef_sc_hd__decap_12
X_3833_ _1761_ VGND VGND VPWR VPWR _0026_ sky130_fd_sc_hd__clkbuf_1
XFILLER_0_74_569 VGND VGND VPWR VPWR sky130_fd_sc_hd__decap_4
XFILLER_0_27_441 VGND VGND VPWR VPWR sky130_fd_sc_hd__decap_6
X_3764_ cpu_inst.regfile_inst.registers\[5\]\[25\] cpu_inst.regfile_inst.registers\[4\]\[25\]
+ _1348_ VGND VGND VPWR VPWR _1694_ sky130_fd_sc_hd__mux2_1
XFILLER_0_6_357 VGND VGND VPWR VPWR sky130_fd_sc_hd__decap_6
XFILLER_0_27_485 VPWR VGND VPWR VGND sky130_ef_sc_hd__decap_12
XFILLER_0_125_671 VGND VGND VPWR VPWR sky130_fd_sc_hd__fill_1
XFILLER_0_113_833 VGND VGND VPWR VPWR sky130_fd_sc_hd__decap_6
X_3695_ cpu_inst.regfile_inst.registers\[0\]\[23\] _0615_ _1625_ _1560_ _1626_ VGND
+ VGND VPWR VPWR _1627_ sky130_fd_sc_hd__o221a_1
X_2715_ _0619_ _0679_ VGND VGND VPWR VPWR _0680_ sky130_fd_sc_hd__nor2_1
X_5503_ clknet_leaf_34_clk _0423_ VGND VGND VPWR VPWR cpu_inst.regfile_inst.registers\[8\]\[7\]
+ sky130_fd_sc_hd__dfxtp_1
XFILLER_0_42_455 VGND VGND VPWR VPWR sky130_fd_sc_hd__fill_2
XFILLER_0_112_321 VPWR VGND VPWR VGND sky130_ef_sc_hd__decap_12
X_5434_ clknet_leaf_40_clk _0354_ VGND VGND VPWR VPWR cpu_inst.regfile_inst.registers\[0\]\[1\]
+ sky130_fd_sc_hd__dfxtp_1
XFILLER_0_42_477 VPWR VGND VPWR VGND sky130_ef_sc_hd__decap_12
X_2646_ _0520_ _0564_ VGND VGND VPWR VPWR _0611_ sky130_fd_sc_hd__nor2_4
XFILLER_0_112_365 VPWR VGND VPWR VGND sky130_ef_sc_hd__decap_12
X_5365_ clknet_leaf_6_clk _0285_ VGND VGND VPWR VPWR cpu_inst.regfile_inst.registers\[11\]\[29\]
+ sky130_fd_sc_hd__dfxtp_1
XFILLER_0_77_51 VGND VGND VPWR VPWR sky130_fd_sc_hd__decap_4
XFILLER_0_58_3 VPWR VGND VPWR VGND sky130_ef_sc_hd__decap_12
XFILLER_0_10_363 VGND VGND VPWR VPWR sky130_fd_sc_hd__fill_1
X_2577_ _0536_ _0541_ VGND VGND VPWR VPWR _0542_ sky130_fd_sc_hd__and2_1
X_5296_ clknet_leaf_9_clk _0216_ VGND VGND VPWR VPWR cpu_inst.regfile_inst.registers\[1\]\[24\]
+ sky130_fd_sc_hd__dfxtp_1
X_4316_ _2102_ VGND VGND VPWR VPWR _0168_ sky130_fd_sc_hd__clkbuf_1
X_4247_ cpu_inst.regfile_inst.registers\[24\]\[8\] VGND VGND VPWR VPWR _2066_ sky130_fd_sc_hd__clkbuf_1
X_4178_ _2030_ VGND VGND VPWR VPWR _0102_ sky130_fd_sc_hd__clkbuf_1
X_3129_ _1055_ _1083_ _1093_ _0756_ VGND VGND VPWR VPWR _1094_ sky130_fd_sc_hd__a211o_1
XPHY_EDGE_ROW_67_Left_206 VGND VGND VPWR VPWR sky130_fd_sc_hd__decap_3
XFILLER_0_93_823 VPWR VGND VPWR VGND sky130_ef_sc_hd__decap_12
XFILLER_0_37_205 VPWR VGND VPWR VGND sky130_ef_sc_hd__decap_12
XFILLER_0_92_333 VPWR VGND VPWR VGND sky130_ef_sc_hd__decap_12
XFILLER_0_65_558 VGND VGND VPWR VPWR sky130_fd_sc_hd__fill_2
XFILLER_0_65_536 VGND VGND VPWR VPWR sky130_fd_sc_hd__fill_1
XFILLER_0_37_249 VPWR VGND VPWR VGND sky130_ef_sc_hd__decap_12
XFILLER_0_92_377 VPWR VGND VPWR VGND sky130_ef_sc_hd__decap_12
XFILLER_0_80_517 VGND VGND VPWR VPWR sky130_fd_sc_hd__fill_2
XFILLER_0_107_137 VPWR VGND VPWR VGND sky130_ef_sc_hd__decap_12
XFILLER_0_104_811 VGND VGND VPWR VPWR sky130_fd_sc_hd__fill_1
XFILLER_0_61_753 VGND VGND VPWR VPWR sky130_fd_sc_hd__fill_1
XFILLER_0_45_293 VPWR VGND VPWR VGND sky130_ef_sc_hd__decap_12
XFILLER_0_131_641 VPWR VGND VPWR VGND sky130_ef_sc_hd__decap_12
XFILLER_0_116_693 VGND VGND VPWR VPWR sky130_fd_sc_hd__decap_6
XFILLER_0_115_181 VPWR VGND VPWR VGND sky130_ef_sc_hd__decap_12
XFILLER_0_21_617 VPWR VGND VPWR VGND sky130_ef_sc_hd__decap_12
XFILLER_0_131_685 VPWR VGND VPWR VGND sky130_ef_sc_hd__decap_12
XPHY_EDGE_ROW_76_Left_215 VGND VGND VPWR VPWR sky130_fd_sc_hd__decap_3
XFILLER_0_130_195 VGND VGND VPWR VPWR sky130_fd_sc_hd__fill_1
XTAP_TAPCELL_ROW_57_1160 VGND VPWR sky130_fd_sc_hd__tapvpwrvgnd_1
XFILLER_0_87_105 VGND VGND VPWR VPWR sky130_fd_sc_hd__decap_6
XPHY_EDGE_ROW_85_Left_224 VGND VGND VPWR VPWR sky130_fd_sc_hd__decap_3
XFILLER_0_87_149 VPWR VGND VPWR VGND sky130_ef_sc_hd__decap_12
XFILLER_0_68_341 VGND VGND VPWR VPWR sky130_fd_sc_hd__decap_3
XFILLER_0_56_514 VGND VGND VPWR VPWR sky130_fd_sc_hd__fill_2
XFILLER_0_113_15 VPWR VGND VPWR VGND sky130_ef_sc_hd__decap_12
XFILLER_0_95_193 VPWR VGND VPWR VGND sky130_ef_sc_hd__decap_12
XFILLER_0_126_413 VGND VGND VPWR VPWR sky130_fd_sc_hd__decap_6
XFILLER_0_126_457 VPWR VGND VPWR VGND sky130_ef_sc_hd__decap_12
XFILLER_0_37_783 VGND VGND VPWR VPWR sky130_fd_sc_hd__fill_1
XFILLER_0_3_305 VPWR VGND VPWR VGND sky130_ef_sc_hd__decap_12
XFILLER_0_24_433 VPWR VGND VPWR VGND sky130_ef_sc_hd__decap_12
XTAP_TAPCELL_ROW_40_895 VGND VPWR sky130_fd_sc_hd__tapvpwrvgnd_1
XPHY_EDGE_ROW_94_Left_233 VGND VGND VPWR VPWR sky130_fd_sc_hd__decap_3
X_3480_ _1385_ _1408_ _1409_ _1411_ _1417_ VGND VGND VPWR VPWR _1418_ sky130_fd_sc_hd__a41o_1
XFILLER_0_52_775 VGND VGND VPWR VPWR sky130_fd_sc_hd__decap_4
XFILLER_0_11_105 VGND VGND VPWR VPWR sky130_fd_sc_hd__decap_6
XFILLER_0_3_349 VPWR VGND VPWR VGND sky130_ef_sc_hd__decap_12
XFILLER_0_24_477 VPWR VGND VPWR VGND sky130_ef_sc_hd__decap_12
XFILLER_0_110_825 VPWR VGND VPWR VGND sky130_ef_sc_hd__decap_12
XFILLER_0_11_149 VPWR VGND VPWR VGND sky130_ef_sc_hd__decap_12
X_5150_ clknet_leaf_36_clk _0070_ VGND VGND VPWR VPWR cpu_inst.regfile_inst.registers\[25\]\[6\]
+ sky130_fd_sc_hd__dfxtp_1
X_4101_ _1987_ VGND VGND VPWR VPWR _0068_ sky130_fd_sc_hd__clkbuf_1
X_5081_ clknet_leaf_40_clk _0001_ VGND VGND VPWR VPWR cpu_inst.regfile_inst.registers\[6\]\[1\]
+ sky130_fd_sc_hd__dfxtp_1
X_4032_ cpu_inst.regfile_inst.registers\[2\]\[3\] VGND VGND VPWR VPWR _1952_ sky130_fd_sc_hd__clkbuf_1
XTAP_TAPCELL_ROW_88_1621 VGND VPWR sky130_fd_sc_hd__tapvpwrvgnd_1
XFILLER_0_79_617 VGND VGND VPWR VPWR sky130_fd_sc_hd__fill_2
X_4934_ _2454_ VGND VGND VPWR VPWR _0434_ sky130_fd_sc_hd__clkbuf_1
XFILLER_0_19_205 VPWR VGND VPWR VGND sky130_ef_sc_hd__decap_12
XFILLER_0_47_503 VGND VGND VPWR VPWR sky130_fd_sc_hd__fill_1
XFILLER_0_74_333 VPWR VGND VPWR VGND sky130_ef_sc_hd__decap_12
XFILLER_0_47_536 VGND VGND VPWR VPWR sky130_fd_sc_hd__decap_3
XFILLER_0_129_273 VGND VGND VPWR VPWR sky130_fd_sc_hd__decap_6
X_4865_ _2417_ VGND VGND VPWR VPWR _0402_ sky130_fd_sc_hd__clkbuf_1
XFILLER_0_19_249 VPWR VGND VPWR VGND sky130_ef_sc_hd__decap_12
X_3816_ _1709_ _1743_ _1744_ _1555_ VGND VGND VPWR VPWR _1745_ sky130_fd_sc_hd__o211a_1
X_4796_ cpu_inst.regfile_inst.registers\[0\]\[16\] VGND VGND VPWR VPWR _2383_ sky130_fd_sc_hd__clkbuf_1
XFILLER_0_74_377 VGND VGND VPWR VPWR sky130_fd_sc_hd__decap_4
XFILLER_0_6_121 VPWR VGND VPWR VGND sky130_ef_sc_hd__decap_12
XTAP_TAPCELL_ROW_115_2028 VGND VPWR sky130_fd_sc_hd__tapvpwrvgnd_1
XFILLER_0_103_81 VPWR VGND VPWR VGND sky130_ef_sc_hd__decap_12
X_3747_ _1661_ _1677_ VGND VGND VPWR VPWR _1678_ sky130_fd_sc_hd__nand2_1
XFILLER_0_6_165 VPWR VGND VPWR VGND sky130_ef_sc_hd__decap_12
XFILLER_0_27_293 VPWR VGND VPWR VGND sky130_ef_sc_hd__decap_12
XFILLER_0_113_641 VPWR VGND VPWR VGND sky130_ef_sc_hd__decap_12
XTAP_TAPCELL_ROW_99_1783 VGND VPWR sky130_fd_sc_hd__tapvpwrvgnd_1
X_3678_ _1610_ VGND VGND VPWR VPWR _0022_ sky130_fd_sc_hd__clkbuf_1
XFILLER_0_113_685 VPWR VGND VPWR VGND sky130_ef_sc_hd__decap_12
XFILLER_0_88_83 VGND VGND VPWR VPWR sky130_fd_sc_hd__fill_1
X_5417_ clknet_leaf_5_clk _0337_ net2 VGND VGND VPWR VPWR cpu_inst.decoder_inst.current_pc\[17\]
+ sky130_fd_sc_hd__dfrtp_1
X_2629_ _0529_ _0549_ _0531_ _0548_ _0552_ VGND VGND VPWR VPWR _0594_ sky130_fd_sc_hd__o311a_4
XFILLER_0_112_195 VGND VGND VPWR VPWR sky130_fd_sc_hd__fill_1
XFILLER_0_100_357 VGND VGND VPWR VPWR sky130_fd_sc_hd__decap_6
X_5348_ clknet_leaf_21_clk _0268_ VGND VGND VPWR VPWR cpu_inst.regfile_inst.registers\[11\]\[12\]
+ sky130_fd_sc_hd__dfxtp_1
XTAP_TAPCELL_ROW_110_1950 VGND VPWR sky130_fd_sc_hd__tapvpwrvgnd_1
X_5279_ clknet_leaf_34_clk _0199_ VGND VGND VPWR VPWR cpu_inst.regfile_inst.registers\[1\]\[7\]
+ sky130_fd_sc_hd__dfxtp_1
XFILLER_0_69_105 VGND VGND VPWR VPWR sky130_fd_sc_hd__decap_6
XFILLER_0_97_447 VGND VGND VPWR VPWR sky130_fd_sc_hd__fill_1
XFILLER_0_69_149 VPWR VGND VPWR VGND sky130_ef_sc_hd__decap_12
XFILLER_0_93_620 VGND VGND VPWR VPWR sky130_fd_sc_hd__decap_3
XFILLER_0_77_193 VPWR VGND VPWR VGND sky130_ef_sc_hd__decap_12
XTAP_TAPCELL_ROW_26_689 VGND VPWR sky130_fd_sc_hd__tapvpwrvgnd_1
XFILLER_0_108_413 VGND VGND VPWR VPWR sky130_fd_sc_hd__decap_6
XFILLER_0_93_664 VGND VGND VPWR VPWR sky130_fd_sc_hd__decap_8
XFILLER_0_92_141 VPWR VGND VPWR VGND sky130_ef_sc_hd__decap_12
XFILLER_0_136_755 VGND VGND VPWR VPWR sky130_fd_sc_hd__fill_1
XFILLER_0_108_457 VPWR VGND VPWR VGND sky130_ef_sc_hd__decap_12
XFILLER_0_19_783 VGND VGND VPWR VPWR sky130_fd_sc_hd__fill_1
XFILLER_0_123_405 VPWR VGND VPWR VGND sky130_ef_sc_hd__decap_12
XFILLER_0_123_449 VPWR VGND VPWR VGND sky130_ef_sc_hd__decap_12
XFILLER_0_61_561 VPWR VGND VPWR VGND sky130_ef_sc_hd__decap_12
XFILLER_0_1_809 VPWR VGND VPWR VGND sky130_ef_sc_hd__decap_12
XFILLER_0_104_663 VGND VGND VPWR VPWR sky130_fd_sc_hd__fill_1
XFILLER_0_104_652 VGND VGND VPWR VPWR sky130_fd_sc_hd__decap_4
XFILLER_0_21_447 VGND VGND VPWR VPWR sky130_fd_sc_hd__fill_1
XTAP_TAPCELL_ROW_55_1119 VGND VPWR sky130_fd_sc_hd__tapvpwrvgnd_1
XFILLER_0_108_15 VPWR VGND VPWR VGND sky130_ef_sc_hd__decap_12
XTAP_TAPCELL_ROW_6_392 VGND VPWR sky130_fd_sc_hd__tapvpwrvgnd_1
XFILLER_0_17_57 VPWR VGND VPWR VGND sky130_ef_sc_hd__decap_12
XTAP_TAPCELL_ROW_83_1540 VGND VPWR sky130_fd_sc_hd__tapvpwrvgnd_1
XFILLER_0_29_503 VGND VGND VPWR VPWR sky130_fd_sc_hd__fill_1
XTAP_TAPCELL_ROW_83_1551 VGND VPWR sky130_fd_sc_hd__tapvpwrvgnd_1
XFILLER_0_69_694 VGND VGND VPWR VPWR sky130_fd_sc_hd__fill_2
X_2980_ cpu_inst.regfile_inst.registers\[25\]\[6\] _0692_ _0694_ _0944_ VGND VGND
+ VPWR VPWR _0945_ sky130_fd_sc_hd__o211a_1
XFILLER_0_8_419 VGND VGND VPWR VPWR sky130_fd_sc_hd__fill_1
XTAP_TAPCELL_ROW_45_976 VGND VPWR sky130_fd_sc_hd__tapvpwrvgnd_1
XFILLER_0_84_653 VPWR VGND VPWR VGND sky130_ef_sc_hd__decap_12
XFILLER_0_17_709 VPWR VGND VPWR VGND sky130_ef_sc_hd__decap_12
XFILLER_0_29_558 VGND VGND VPWR VPWR sky130_fd_sc_hd__fill_2
XFILLER_0_29_569 VGND VGND VPWR VPWR sky130_fd_sc_hd__fill_2
XFILLER_0_126_221 VPWR VGND VPWR VGND sky130_ef_sc_hd__decap_12
X_4650_ _1792_ _1867_ _2282_ VGND VGND VPWR VPWR _2283_ sky130_fd_sc_hd__or3_4
XFILLER_0_127_777 VGND VGND VPWR VPWR sky130_fd_sc_hd__decap_6
XFILLER_0_126_265 VPWR VGND VPWR VGND sky130_ef_sc_hd__decap_12
XFILLER_0_116_3 VPWR VGND VPWR VGND sky130_ef_sc_hd__decap_12
X_3601_ _1535_ VGND VGND VPWR VPWR _0020_ sky130_fd_sc_hd__clkbuf_1
XFILLER_0_4_625 VPWR VGND VPWR VGND sky130_ef_sc_hd__decap_12
XFILLER_0_25_753 VPWR VGND VPWR VGND sky130_ef_sc_hd__decap_12
XFILLER_0_3_113 VPWR VGND VPWR VGND sky130_ef_sc_hd__decap_12
X_4581_ _2238_ VGND VGND VPWR VPWR _0297_ sky130_fd_sc_hd__clkbuf_1
X_3532_ _1359_ _1467_ _1295_ VGND VGND VPWR VPWR _1468_ sky130_fd_sc_hd__a21oi_1
XFILLER_0_4_669 VPWR VGND VPWR VGND sky130_ef_sc_hd__decap_12
XFILLER_0_25_797 VPWR VGND VPWR VGND sky130_ef_sc_hd__decap_12
X_3463_ cpu_inst.regfile_inst.registers\[2\]\[17\] _0820_ _0821_ cpu_inst.regfile_inst.registers\[7\]\[17\]
+ VGND VGND VPWR VPWR _1401_ sky130_fd_sc_hd__o22a_1
XFILLER_0_12_469 VGND VGND VPWR VPWR sky130_fd_sc_hd__decap_6
X_5202_ clknet_leaf_8_clk _0122_ VGND VGND VPWR VPWR cpu_inst.regfile_inst.registers\[4\]\[26\]
+ sky130_fd_sc_hd__dfxtp_1
XFILLER_0_58_53 VPWR VGND VPWR VGND sky130_ef_sc_hd__decap_12
XFILLER_0_110_699 VGND VGND VPWR VPWR sky130_fd_sc_hd__fill_1
X_5133_ clknet_leaf_16_clk _0053_ VGND VGND VPWR VPWR cpu_inst.regfile_inst.registers\[2\]\[21\]
+ sky130_fd_sc_hd__dfxtp_1
XFILLER_0_58_97 VPWR VGND VPWR VGND sky130_ef_sc_hd__decap_12
X_3394_ _1338_ VGND VGND VPWR VPWR _0010_ sky130_fd_sc_hd__clkbuf_1
XFILLER_0_74_41 VPWR VGND VPWR VGND sky130_ef_sc_hd__decap_12
X_5064_ cpu_inst.display_inst.counter\[14\] _2524_ VGND VGND VPWR VPWR _2525_ sky130_fd_sc_hd__nor2_1
XFILLER_0_79_425 VGND VGND VPWR VPWR sky130_fd_sc_hd__decap_6
XFILLER_0_74_85 VPWR VGND VPWR VGND sky130_ef_sc_hd__decap_12
X_4015_ _1932_ VGND VGND VPWR VPWR _1938_ sky130_fd_sc_hd__inv_2
XFILLER_0_74_141 VPWR VGND VPWR VGND sky130_ef_sc_hd__decap_12
XFILLER_0_59_193 VPWR VGND VPWR VGND sky130_ef_sc_hd__decap_12
XTAP_TAPCELL_ROW_23_648 VGND VPWR sky130_fd_sc_hd__tapvpwrvgnd_1
X_4917_ _2445_ VGND VGND VPWR VPWR _0426_ sky130_fd_sc_hd__clkbuf_1
XFILLER_0_118_755 VGND VGND VPWR VPWR sky130_fd_sc_hd__fill_1
XFILLER_0_63_837 VGND VGND VPWR VPWR sky130_fd_sc_hd__decap_3
XFILLER_0_7_441 VGND VGND VPWR VPWR sky130_fd_sc_hd__decap_6
X_4848_ cpu_inst.regfile_inst.registers\[9\]\[10\] VGND VGND VPWR VPWR _2409_ sky130_fd_sc_hd__clkbuf_1
XFILLER_0_105_405 VPWR VGND VPWR VGND sky130_ef_sc_hd__decap_12
XFILLER_0_7_485 VPWR VGND VPWR VGND sky130_ef_sc_hd__decap_12
XFILLER_0_105_449 VGND VGND VPWR VPWR sky130_fd_sc_hd__decap_3
X_4779_ _2374_ VGND VGND VPWR VPWR _0359_ sky130_fd_sc_hd__clkbuf_1
XFILLER_0_43_572 VGND VGND VPWR VPWR sky130_fd_sc_hd__fill_1
XFILLER_0_120_419 VGND VGND VPWR VPWR sky130_fd_sc_hd__fill_1
XFILLER_0_99_93 VPWR VGND VPWR VGND sky130_ef_sc_hd__decap_12
XFILLER_0_30_233 VPWR VGND VPWR VGND sky130_ef_sc_hd__decap_12
XFILLER_0_100_121 VPWR VGND VPWR VGND sky130_ef_sc_hd__decap_12
XFILLER_0_30_277 VPWR VGND VPWR VGND sky130_ef_sc_hd__decap_12
XFILLER_0_100_165 VPWR VGND VPWR VGND sky130_ef_sc_hd__decap_12
XTAP_TAPCELL_ROW_128_2219 VGND VPWR sky130_fd_sc_hd__tapvpwrvgnd_1
XTAP_TAPCELL_ROW_50_1049 VGND VPWR sky130_fd_sc_hd__tapvpwrvgnd_1
XTAP_TAPCELL_ROW_3_351 VGND VPWR sky130_fd_sc_hd__tapvpwrvgnd_1
XTAP_TAPCELL_ROW_3_340 VGND VPWR sky130_fd_sc_hd__tapvpwrvgnd_1
XFILLER_0_66_664 VGND VGND VPWR VPWR sky130_fd_sc_hd__fill_1
XTAP_TAPCELL_ROW_65_1281 VGND VPWR sky130_fd_sc_hd__tapvpwrvgnd_1
XTAP_TAPCELL_ROW_65_1270 VGND VPWR sky130_fd_sc_hd__tapvpwrvgnd_1
XFILLER_0_38_333 VPWR VGND VPWR VGND sky130_ef_sc_hd__decap_12
XTAP_TAPCELL_ROW_42_924 VGND VPWR sky130_fd_sc_hd__tapvpwrvgnd_1
XTAP_TAPCELL_ROW_42_935 VGND VPWR sky130_fd_sc_hd__tapvpwrvgnd_1
XFILLER_0_108_221 VPWR VGND VPWR VGND sky130_ef_sc_hd__decap_12
XFILLER_0_38_377 VPWR VGND VPWR VGND sky130_ef_sc_hd__decap_12
XFILLER_0_124_725 VPWR VGND VPWR VGND sky130_ef_sc_hd__decap_12
XFILLER_0_109_777 VGND VGND VPWR VPWR sky130_fd_sc_hd__decap_6
XFILLER_0_108_265 VPWR VGND VPWR VGND sky130_ef_sc_hd__decap_12
XFILLER_0_80_133 VGND VGND VPWR VPWR sky130_fd_sc_hd__decap_6
XFILLER_0_80_177 VPWR VGND VPWR VGND sky130_ef_sc_hd__decap_12
XFILLER_0_22_701 VPWR VGND VPWR VGND sky130_ef_sc_hd__decap_12
XFILLER_0_124_769 VPWR VGND VPWR VGND sky130_ef_sc_hd__decap_12
XFILLER_0_110_27 VGND VGND VPWR VPWR sky130_fd_sc_hd__fill_1
XFILLER_0_1_617 VPWR VGND VPWR VGND sky130_ef_sc_hd__decap_12
XFILLER_0_123_279 VGND VGND VPWR VPWR sky130_fd_sc_hd__fill_1
XFILLER_0_119_69 VPWR VGND VPWR VGND sky130_ef_sc_hd__decap_12
XFILLER_0_135_57 VPWR VGND VPWR VGND sky130_ef_sc_hd__decap_12
XFILLER_0_89_756 VGND VGND VPWR VPWR sky130_fd_sc_hd__decap_3
XFILLER_0_88_233 VPWR VGND VPWR VGND sky130_ef_sc_hd__decap_12
XFILLER_0_88_277 VPWR VGND VPWR VGND sky130_ef_sc_hd__decap_12
XFILLER_0_44_77 VGND VGND VPWR VPWR sky130_fd_sc_hd__decap_6
XFILLER_0_56_141 VPWR VGND VPWR VGND sky130_ef_sc_hd__decap_12
X_2963_ _0863_ _0925_ _0927_ _0875_ VGND VGND VPWR VPWR _0928_ sky130_fd_sc_hd__o22a_1
XFILLER_0_127_541 VPWR VGND VPWR VGND sky130_ef_sc_hd__decap_12
X_4702_ cpu_inst.decoder_inst.current_pc\[14\] _2320_ VGND VGND VPWR VPWR _2323_ sky130_fd_sc_hd__and2_1
XFILLER_0_17_517 VPWR VGND VPWR VGND sky130_ef_sc_hd__decap_12
XFILLER_0_127_585 VPWR VGND VPWR VGND sky130_ef_sc_hd__decap_12
XFILLER_0_71_111 VGND VGND VPWR VPWR sky130_fd_sc_hd__fill_1
XFILLER_0_60_65 VPWR VGND VPWR VGND sky130_ef_sc_hd__decap_12
X_2894_ _0617_ VGND VGND VPWR VPWR _0859_ sky130_fd_sc_hd__buf_4
XTAP_TAPCELL_ROW_20_607 VGND VPWR sky130_fd_sc_hd__tapvpwrvgnd_1
XFILLER_0_4_433 VPWR VGND VPWR VGND sky130_ef_sc_hd__decap_12
XFILLER_0_25_561 VGND VGND VPWR VPWR sky130_fd_sc_hd__decap_4
X_4633_ cpu_inst.display_inst.counter\[8\] cpu_inst.display_inst.counter\[11\] cpu_inst.display_inst.counter\[10\]
+ cpu_inst.display_inst.counter\[9\] VGND VGND VPWR VPWR _2268_ sky130_fd_sc_hd__or4bb_1
XTAP_TAPCELL_ROW_96_1742 VGND VPWR sky130_fd_sc_hd__tapvpwrvgnd_1
X_4564_ cpu_inst.regfile_inst.registers\[10\]\[0\] _2230_ VGND VGND VPWR VPWR _2231_
+ sky130_fd_sc_hd__and2_1
XFILLER_0_102_419 VGND VGND VPWR VPWR sky130_fd_sc_hd__fill_1
X_3515_ _1412_ _1450_ _1451_ VGND VGND VPWR VPWR _1452_ sky130_fd_sc_hd__mux2_1
XFILLER_0_12_233 VPWR VGND VPWR VGND sky130_ef_sc_hd__decap_12
XFILLER_0_8_77 VGND VGND VPWR VPWR sky130_fd_sc_hd__decap_6
XFILLER_0_4_477 VPWR VGND VPWR VGND sky130_ef_sc_hd__decap_12
X_4495_ _2195_ VGND VGND VPWR VPWR _0254_ sky130_fd_sc_hd__clkbuf_1
XFILLER_0_12_277 VPWR VGND VPWR VGND sky130_ef_sc_hd__decap_12
XFILLER_0_40_586 VGND VGND VPWR VPWR sky130_fd_sc_hd__fill_2
X_3446_ _0698_ VGND VGND VPWR VPWR _1384_ sky130_fd_sc_hd__clkbuf_4
XFILLER_0_85_51 VGND VGND VPWR VPWR sky130_fd_sc_hd__decap_4
X_3377_ _1310_ _0647_ _1293_ VGND VGND VPWR VPWR _1327_ sky130_fd_sc_hd__and3_1
XFILLER_0_40_3 VPWR VGND VPWR VGND sky130_ef_sc_hd__decap_12
X_5116_ clknet_leaf_33_clk _0036_ VGND VGND VPWR VPWR cpu_inst.regfile_inst.registers\[2\]\[4\]
+ sky130_fd_sc_hd__dfxtp_1
X_5047_ cpu_inst.display_inst.counter\[7\] _2512_ _2514_ VGND VGND VPWR VPWR _0487_
+ sky130_fd_sc_hd__a21oi_1
XTAP_TAPCELL_ROW_123_2138 VGND VPWR sky130_fd_sc_hd__tapvpwrvgnd_1
XTAP_TAPCELL_ROW_28_718 VGND VPWR sky130_fd_sc_hd__tapvpwrvgnd_1
XTAP_TAPCELL_ROW_123_2149 VGND VPWR sky130_fd_sc_hd__tapvpwrvgnd_1
XPHY_EDGE_ROW_40_Left_179 VGND VGND VPWR VPWR sky130_fd_sc_hd__decap_3
XFILLER_0_137_305 VPWR VGND VPWR VGND sky130_ef_sc_hd__decap_12
XTAP_TAPCELL_ROW_105_1882 VGND VPWR sky130_fd_sc_hd__tapvpwrvgnd_1
XTAP_TAPCELL_ROW_105_1871 VGND VPWR sky130_fd_sc_hd__tapvpwrvgnd_1
XFILLER_0_137_349 VPWR VGND VPWR VGND sky130_ef_sc_hd__decap_12
XFILLER_0_106_725 VPWR VGND VPWR VGND sky130_ef_sc_hd__decap_12
XFILLER_0_62_133 VGND VGND VPWR VPWR sky130_fd_sc_hd__decap_6
XTAP_TAPCELL_ROW_138_2392 VGND VPWR sky130_fd_sc_hd__tapvpwrvgnd_1
XTAP_TAPCELL_ROW_138_2381 VGND VPWR sky130_fd_sc_hd__tapvpwrvgnd_1
XTAP_TAPCELL_ROW_138_2370 VGND VPWR sky130_fd_sc_hd__tapvpwrvgnd_1
XFILLER_0_90_475 VGND VGND VPWR VPWR sky130_fd_sc_hd__fill_1
XFILLER_0_7_293 VPWR VGND VPWR VGND sky130_ef_sc_hd__decap_12
XFILLER_0_51_818 VPWR VGND VPWR VGND sky130_ef_sc_hd__decap_12
XFILLER_0_106_769 VPWR VGND VPWR VGND sky130_ef_sc_hd__decap_12
XFILLER_0_62_177 VPWR VGND VPWR VGND sky130_ef_sc_hd__decap_12
XFILLER_0_105_279 VGND VGND VPWR VPWR sky130_fd_sc_hd__fill_1
XFILLER_0_43_391 VGND VGND VPWR VPWR sky130_fd_sc_hd__fill_1
XTAP_TAPCELL_ROW_8_421 VGND VPWR sky130_fd_sc_hd__tapvpwrvgnd_1
XFILLER_0_101_485 VGND VGND VPWR VPWR sky130_fd_sc_hd__decap_3
XFILLER_0_98_542 VGND VGND VPWR VPWR sky130_fd_sc_hd__decap_6
XTAP_TAPCELL_ROW_67_1310 VGND VPWR sky130_fd_sc_hd__tapvpwrvgnd_1
XFILLER_0_98_553 VGND VGND VPWR VPWR sky130_fd_sc_hd__decap_3
XFILLER_0_105_27 VPWR VGND VPWR VGND sky130_ef_sc_hd__decap_12
XFILLER_0_85_225 VPWR VGND VPWR VGND sky130_ef_sc_hd__decap_12
XFILLER_0_129_839 VGND VGND VPWR VPWR sky130_fd_sc_hd__fill_1
XFILLER_0_109_541 VPWR VGND VPWR VGND sky130_ef_sc_hd__decap_12
XFILLER_0_54_623 VGND VGND VPWR VPWR sky130_fd_sc_hd__decap_8
XFILLER_0_54_612 VGND VGND VPWR VPWR sky130_fd_sc_hd__decap_8
XFILLER_0_38_141 VPWR VGND VPWR VGND sky130_ef_sc_hd__decap_12
XFILLER_0_39_664 VGND VGND VPWR VPWR sky130_fd_sc_hd__fill_1
XFILLER_0_39_697 VGND VGND VPWR VPWR sky130_fd_sc_hd__decap_4
XFILLER_0_121_15 VPWR VGND VPWR VGND sky130_ef_sc_hd__decap_12
XFILLER_0_54_645 VGND VGND VPWR VPWR sky130_fd_sc_hd__decap_8
XFILLER_0_53_111 VGND VGND VPWR VPWR sky130_fd_sc_hd__fill_1
XFILLER_0_124_533 VPWR VGND VPWR VGND sky130_ef_sc_hd__decap_12
XFILLER_0_109_585 VPWR VGND VPWR VGND sky130_ef_sc_hd__decap_12
XFILLER_0_41_317 VPWR VGND VPWR VGND sky130_ef_sc_hd__decap_12
XFILLER_0_111_205 VPWR VGND VPWR VGND sky130_ef_sc_hd__decap_12
XTAP_TAPCELL_ROW_78_1472 VGND VPWR sky130_fd_sc_hd__tapvpwrvgnd_1
XFILLER_0_22_531 VGND VGND VPWR VPWR sky130_fd_sc_hd__fill_1
XFILLER_0_50_840 VGND VGND VPWR VPWR sky130_fd_sc_hd__fill_2
XFILLER_0_111_249 VPWR VGND VPWR VGND sky130_ef_sc_hd__decap_12
X_3300_ _1263_ _1264_ VGND VGND VPWR VPWR _1265_ sky130_fd_sc_hd__nand2_1
XFILLER_0_10_737 VPWR VGND VPWR VGND sky130_ef_sc_hd__decap_12
XFILLER_0_1_447 VGND VGND VPWR VPWR sky130_fd_sc_hd__fill_1
X_4280_ _2082_ VGND VGND VPWR VPWR _0152_ sky130_fd_sc_hd__clkbuf_1
XFILLER_0_39_55 VGND VGND VPWR VPWR sky130_fd_sc_hd__fill_1
XTAP_TAPCELL_ROW_91_1672 VGND VPWR sky130_fd_sc_hd__tapvpwrvgnd_1
XTAP_TAPCELL_ROW_91_1661 VGND VPWR sky130_fd_sc_hd__tapvpwrvgnd_1
X_3231_ _0685_ _1195_ VGND VGND VPWR VPWR _1196_ sky130_fd_sc_hd__nand2b_4
X_3162_ cpu_inst.regfile_inst.registers\[7\]\[14\] cpu_inst.regfile_inst.registers\[6\]\[14\]
+ _0867_ VGND VGND VPWR VPWR _1127_ sky130_fd_sc_hd__mux2_1
X_3093_ _0947_ _1056_ _1057_ VGND VGND VPWR VPWR _1058_ sky130_fd_sc_hd__mux2_1
XFILLER_0_89_564 VPWR VGND VPWR VGND sky130_ef_sc_hd__decap_12
XFILLER_0_77_715 VGND VGND VPWR VPWR sky130_fd_sc_hd__decap_8
XFILLER_0_119_305 VPWR VGND VPWR VGND sky130_ef_sc_hd__decap_12
XFILLER_0_92_718 VGND VGND VPWR VPWR sky130_fd_sc_hd__fill_1
XFILLER_0_9_503 VGND VGND VPWR VPWR sky130_fd_sc_hd__fill_1
XFILLER_0_135_809 VPWR VGND VPWR VGND sky130_ef_sc_hd__decap_12
XFILLER_0_119_349 VPWR VGND VPWR VGND sky130_ef_sc_hd__decap_12
XFILLER_0_91_217 VGND VGND VPWR VPWR sky130_fd_sc_hd__decap_6
X_3995_ _1908_ _1918_ VGND VGND VPWR VPWR _1919_ sky130_fd_sc_hd__xnor2_1
XFILLER_0_18_837 VGND VGND VPWR VPWR sky130_fd_sc_hd__decap_4
XTAP_TAPCELL_ROW_33_798 VGND VPWR sky130_fd_sc_hd__tapvpwrvgnd_1
X_2946_ _0753_ _0754_ _0755_ VGND VGND VPWR VPWR _0911_ sky130_fd_sc_hd__o21a_2
XFILLER_0_127_393 VPWR VGND VPWR VGND sky130_ef_sc_hd__decap_12
X_2877_ _0696_ _0841_ VGND VGND VPWR VPWR _0842_ sky130_fd_sc_hd__nor2_1
XFILLER_0_33_818 VGND VGND VPWR VPWR sky130_fd_sc_hd__fill_1
XFILLER_0_44_133 VGND VGND VPWR VPWR sky130_fd_sc_hd__decap_6
X_4616_ cpu_inst.regfile_inst.registers\[10\]\[26\] _2252_ VGND VGND VPWR VPWR _2257_
+ sky130_fd_sc_hd__and2_1
XFILLER_0_88_3 VPWR VGND VPWR VGND sky130_ef_sc_hd__decap_12
XFILLER_0_5_753 VPWR VGND VPWR VGND sky130_ef_sc_hd__decap_12
XFILLER_0_44_177 VPWR VGND VPWR VGND sky130_ef_sc_hd__decap_12
XFILLER_0_130_525 VGND VGND VPWR VPWR sky130_fd_sc_hd__decap_6
XPHY_EDGE_ROW_111_Right_111 VGND VGND VPWR VPWR sky130_fd_sc_hd__decap_3
XFILLER_0_111_81 VPWR VGND VPWR VGND sky130_ef_sc_hd__decap_12
XFILLER_0_5_797 VPWR VGND VPWR VGND sky130_ef_sc_hd__decap_12
XFILLER_0_13_553 VGND VGND VPWR VPWR sky130_fd_sc_hd__decap_6
XFILLER_0_25_391 VGND VGND VPWR VPWR sky130_fd_sc_hd__fill_1
XFILLER_0_130_569 VPWR VGND VPWR VGND sky130_ef_sc_hd__decap_12
X_4547_ _2221_ VGND VGND VPWR VPWR _0280_ sky130_fd_sc_hd__clkbuf_1
XFILLER_0_111_783 VGND VGND VPWR VPWR sky130_fd_sc_hd__fill_1
X_4478_ _1608_ cpu_inst.regfile_inst.registers\[7\]\[22\] _2186_ VGND VGND VPWR VPWR
+ _2187_ sky130_fd_sc_hd__mux2_1
XFILLER_0_13_597 VPWR VGND VPWR VGND sky130_ef_sc_hd__decap_12
XFILLER_0_96_83 VGND VGND VPWR VPWR sky130_fd_sc_hd__fill_1
X_3429_ cpu_inst.regfile_inst.registers\[24\]\[16\] _0697_ _0859_ VGND VGND VPWR VPWR
+ _1368_ sky130_fd_sc_hd__o21ai_1
XFILLER_0_99_317 VPWR VGND VPWR VGND sky130_ef_sc_hd__decap_12
XTAP_TAPCELL_ROW_107_1911 VGND VPWR sky130_fd_sc_hd__tapvpwrvgnd_1
XTAP_TAPCELL_ROW_107_1900 VGND VPWR sky130_fd_sc_hd__tapvpwrvgnd_1
XFILLER_0_95_523 VGND VGND VPWR VPWR sky130_fd_sc_hd__decap_4
XFILLER_0_67_225 VPWR VGND VPWR VGND sky130_ef_sc_hd__decap_12
XTAP_TAPCELL_ROW_49_1040 VGND VPWR sky130_fd_sc_hd__tapvpwrvgnd_1
XFILLER_0_95_567 VGND VGND VPWR VPWR sky130_fd_sc_hd__fill_2
XFILLER_0_138_669 VGND VGND VPWR VPWR sky130_fd_sc_hd__decap_3
XFILLER_0_137_113 VPWR VGND VPWR VGND sky130_ef_sc_hd__decap_12
XFILLER_0_95_578 VGND VGND VPWR VPWR sky130_fd_sc_hd__decap_8
XFILLER_0_35_111 VGND VGND VPWR VPWR sky130_fd_sc_hd__fill_1
XFILLER_0_106_533 VGND VGND VPWR VPWR sky130_fd_sc_hd__decap_8
XFILLER_0_91_773 VGND VGND VPWR VPWR sky130_fd_sc_hd__decap_4
XTAP_TAPCELL_ROW_11_459 VGND VPWR sky130_fd_sc_hd__tapvpwrvgnd_1
XFILLER_0_23_317 VPWR VGND VPWR VGND sky130_ef_sc_hd__decap_12
XFILLER_0_133_385 VGND VGND VPWR VPWR sky130_fd_sc_hd__decap_6
XFILLER_0_121_503 VGND VGND VPWR VPWR sky130_fd_sc_hd__fill_1
XFILLER_0_31_361 VPWR VGND VPWR VGND sky130_ef_sc_hd__decap_12
XFILLER_0_101_293 VPWR VGND VPWR VGND sky130_ef_sc_hd__decap_12
XTAP_TAPCELL_ROW_73_1391 VGND VPWR sky130_fd_sc_hd__tapvpwrvgnd_1
XFILLER_0_116_15 VPWR VGND VPWR VGND sky130_ef_sc_hd__decap_12
XFILLER_0_86_512 VGND VGND VPWR VPWR sky130_fd_sc_hd__decap_6
XFILLER_0_59_748 VGND VGND VPWR VPWR sky130_fd_sc_hd__decap_6
XFILLER_0_25_57 VPWR VGND VPWR VGND sky130_ef_sc_hd__decap_12
XFILLER_0_86_545 VGND VGND VPWR VPWR sky130_fd_sc_hd__decap_8
XFILLER_0_117_809 VPWR VGND VPWR VGND sky130_ef_sc_hd__decap_12
XFILLER_0_86_589 VGND VGND VPWR VPWR sky130_fd_sc_hd__decap_4
XFILLER_0_74_718 VGND VGND VPWR VPWR sky130_fd_sc_hd__decap_3
XFILLER_0_73_217 VGND VGND VPWR VPWR sky130_fd_sc_hd__decap_6
X_3780_ cpu_inst.regfile_inst.registers\[2\]\[25\] _1667_ _1668_ cpu_inst.regfile_inst.registers\[7\]\[25\]
+ VGND VGND VPWR VPWR _1710_ sky130_fd_sc_hd__o22a_1
XFILLER_0_27_645 VGND VGND VPWR VPWR sky130_fd_sc_hd__fill_2
X_2800_ _0561_ _0764_ VGND VGND VPWR VPWR _0765_ sky130_fd_sc_hd__nand2_1
X_2731_ _0514_ VGND VGND VPWR VPWR _0696_ sky130_fd_sc_hd__clkbuf_4
XFILLER_0_26_133 VGND VGND VPWR VPWR sky130_fd_sc_hd__decap_6
XTAP_TAPCELL_ROW_30_746 VGND VPWR sky130_fd_sc_hd__tapvpwrvgnd_1
XFILLER_0_109_393 VPWR VGND VPWR VGND sky130_ef_sc_hd__decap_12
X_5450_ clknet_leaf_20_clk _0370_ VGND VGND VPWR VPWR cpu_inst.regfile_inst.registers\[0\]\[18\]
+ sky130_fd_sc_hd__dfxtp_1
XFILLER_0_81_261 VPWR VGND VPWR VGND sky130_ef_sc_hd__decap_12
XFILLER_0_26_177 VPWR VGND VPWR VGND sky130_ef_sc_hd__decap_12
XTAP_TAPCELL_ROW_30_757 VGND VPWR sky130_fd_sc_hd__tapvpwrvgnd_1
XFILLER_0_124_363 VGND VGND VPWR VPWR sky130_fd_sc_hd__fill_1
XFILLER_0_112_525 VGND VGND VPWR VPWR sky130_fd_sc_hd__decap_6
XTAP_TAPCELL_ROW_93_1701 VGND VPWR sky130_fd_sc_hd__tapvpwrvgnd_1
X_4401_ cpu_inst.regfile_inst.registers\[1\]\[18\] VGND VGND VPWR VPWR _2146_ sky130_fd_sc_hd__clkbuf_1
XFILLER_0_2_701 VPWR VGND VPWR VGND sky130_ef_sc_hd__decap_12
X_2662_ _0592_ VGND VGND VPWR VPWR _0627_ sky130_fd_sc_hd__clkbuf_4
XFILLER_0_41_125 VPWR VGND VPWR VGND sky130_ef_sc_hd__decap_12
X_5381_ clknet_leaf_26_clk _0301_ VGND VGND VPWR VPWR cpu_inst.regfile_inst.registers\[10\]\[13\]
+ sky130_fd_sc_hd__dfxtp_1
X_2593_ _0526_ _0538_ _0549_ _0537_ VGND VGND VPWR VPWR _0558_ sky130_fd_sc_hd__or4_4
XFILLER_0_10_501 VPWR VGND VPWR VGND sky130_ef_sc_hd__decap_12
XFILLER_0_41_169 VPWR VGND VPWR VGND sky130_ef_sc_hd__decap_12
XFILLER_0_112_569 VPWR VGND VPWR VGND sky130_ef_sc_hd__decap_12
X_4332_ _1382_ cpu_inst.regfile_inst.registers\[5\]\[16\] _2105_ VGND VGND VPWR VPWR
+ _2111_ sky130_fd_sc_hd__mux2_1
XFILLER_0_10_545 VPWR VGND VPWR VGND sky130_ef_sc_hd__decap_12
X_4263_ cpu_inst.regfile_inst.registers\[24\]\[16\] VGND VGND VPWR VPWR _2074_ sky130_fd_sc_hd__clkbuf_1
X_3214_ _1105_ _1138_ _0644_ VGND VGND VPWR VPWR _1179_ sky130_fd_sc_hd__mux2_1
XFILLER_0_66_53 VPWR VGND VPWR VGND sky130_ef_sc_hd__decap_12
XFILLER_0_10_589 VPWR VGND VPWR VGND sky130_ef_sc_hd__decap_12
XPHY_EDGE_ROW_105_Left_244 VGND VGND VPWR VPWR sky130_fd_sc_hd__decap_3
XFILLER_0_66_97 VPWR VGND VPWR VGND sky130_ef_sc_hd__decap_12
X_4194_ cpu_inst.regfile_inst.registers\[4\]\[14\] _2035_ VGND VGND VPWR VPWR _2039_
+ sky130_fd_sc_hd__and2_1
X_3145_ _0682_ _1107_ _1109_ _1052_ VGND VGND VPWR VPWR _1110_ sky130_fd_sc_hd__a22o_2
XFILLER_0_96_309 VPWR VGND VPWR VGND sky130_ef_sc_hd__decap_12
XFILLER_0_82_41 VPWR VGND VPWR VGND sky130_ef_sc_hd__decap_12
X_3076_ cpu_inst.regfile_inst.registers\[7\]\[13\] cpu_inst.regfile_inst.registers\[6\]\[13\]
+ _0866_ VGND VGND VPWR VPWR _1041_ sky130_fd_sc_hd__mux2_1
XFILLER_0_89_361 VPWR VGND VPWR VGND sky130_ef_sc_hd__decap_12
XFILLER_0_77_523 VGND VGND VPWR VPWR sky130_fd_sc_hd__fill_1
XTAP_TAPCELL_ROW_38_868 VGND VPWR sky130_fd_sc_hd__tapvpwrvgnd_1
XFILLER_0_82_85 VPWR VGND VPWR VGND sky130_ef_sc_hd__decap_12
XTAP_TAPCELL_ROW_18_570 VGND VPWR sky130_fd_sc_hd__tapvpwrvgnd_1
XFILLER_0_49_225 VPWR VGND VPWR VGND sky130_ef_sc_hd__decap_12
XFILLER_0_119_113 VPWR VGND VPWR VGND sky130_ef_sc_hd__decap_12
XTAP_TAPCELL_ROW_102_1830 VGND VPWR sky130_fd_sc_hd__tapvpwrvgnd_1
XFILLER_0_65_729 VGND VGND VPWR VPWR sky130_fd_sc_hd__decap_6
XFILLER_0_18_601 VPWR VGND VPWR VGND sky130_ef_sc_hd__decap_12
XFILLER_0_135_617 VPWR VGND VPWR VGND sky130_ef_sc_hd__decap_12
XPHY_EDGE_ROW_114_Left_253 VGND VGND VPWR VPWR sky130_fd_sc_hd__decap_3
X_3978_ cpu_inst.regfile_inst.registers\[5\]\[31\] cpu_inst.regfile_inst.registers\[4\]\[31\]
+ _1797_ VGND VGND VPWR VPWR _1902_ sky130_fd_sc_hd__mux2_1
XFILLER_0_17_111 VGND VGND VPWR VPWR sky130_fd_sc_hd__fill_1
XFILLER_0_18_645 VPWR VGND VPWR VGND sky130_ef_sc_hd__decap_12
X_2929_ cpu_inst.regfile_inst.registers\[7\]\[2\] cpu_inst.regfile_inst.registers\[6\]\[2\]
+ _0675_ VGND VGND VPWR VPWR _0894_ sky130_fd_sc_hd__mux2_1
XFILLER_0_33_626 VGND VGND VPWR VPWR sky130_fd_sc_hd__fill_1
XFILLER_0_115_385 VGND VGND VPWR VPWR sky130_fd_sc_hd__decap_6
XFILLER_0_5_561 VPWR VGND VPWR VGND sky130_ef_sc_hd__decap_12
XFILLER_0_130_333 VPWR VGND VPWR VGND sky130_ef_sc_hd__decap_12
XFILLER_0_13_361 VPWR VGND VPWR VGND sky130_ef_sc_hd__decap_12
XFILLER_0_20_309 VPWR VGND VPWR VGND sky130_ef_sc_hd__decap_12
XFILLER_0_41_670 VGND VGND VPWR VPWR sky130_fd_sc_hd__fill_2
X_5579_ clknet_leaf_29_clk _0499_ VGND VGND VPWR VPWR cpu_inst.display_inst.counter\[19\]
+ sky130_fd_sc_hd__dfxtp_1
XTAP_TAPCELL_ROW_131_2259 VGND VPWR sky130_fd_sc_hd__tapvpwrvgnd_1
XFILLER_0_130_377 VPWR VGND VPWR VGND sky130_ef_sc_hd__decap_12
XPHY_EDGE_ROW_123_Left_262 VGND VGND VPWR VPWR sky130_fd_sc_hd__decap_3
XTAP_TAPCELL_ROW_113_1992 VGND VPWR sky130_fd_sc_hd__tapvpwrvgnd_1
XFILLER_0_99_125 VPWR VGND VPWR VGND sky130_ef_sc_hd__decap_12
XFILLER_0_99_169 VPWR VGND VPWR VGND sky130_ef_sc_hd__decap_12
XFILLER_0_68_523 VGND VGND VPWR VPWR sky130_fd_sc_hd__decap_8
XFILLER_0_68_545 VGND VGND VPWR VPWR sky130_fd_sc_hd__fill_2
XFILLER_0_138_433 VPWR VGND VPWR VGND sky130_ef_sc_hd__decap_12
XPHY_EDGE_ROW_132_Left_271 VGND VGND VPWR VPWR sky130_fd_sc_hd__decap_3
XFILLER_0_68_589 VGND VGND VPWR VPWR sky130_fd_sc_hd__decap_3
XFILLER_0_55_217 VGND VGND VPWR VPWR sky130_fd_sc_hd__decap_6
XFILLER_0_138_477 VPWR VGND VPWR VGND sky130_ef_sc_hd__decap_12
XFILLER_0_125_105 VGND VGND VPWR VPWR sky130_fd_sc_hd__decap_6
XFILLER_0_70_209 VPWR VGND VPWR VGND sky130_ef_sc_hd__decap_12
XFILLER_0_11_15 VPWR VGND VPWR VGND sky130_ef_sc_hd__decap_12
XFILLER_0_125_149 VPWR VGND VPWR VGND sky130_ef_sc_hd__decap_12
XFILLER_0_63_261 VPWR VGND VPWR VGND sky130_ef_sc_hd__decap_12
XFILLER_0_106_363 VGND VGND VPWR VPWR sky130_fd_sc_hd__fill_1
XFILLER_0_23_125 VPWR VGND VPWR VGND sky130_ef_sc_hd__decap_12
XFILLER_0_133_193 VPWR VGND VPWR VGND sky130_ef_sc_hd__decap_12
XTAP_TAPCELL_ROW_75_1420 VGND VPWR sky130_fd_sc_hd__tapvpwrvgnd_1
XFILLER_0_23_169 VPWR VGND VPWR VGND sky130_ef_sc_hd__decap_12
XTAP_TAPCELL_ROW_75_1431 VGND VPWR sky130_fd_sc_hd__tapvpwrvgnd_1
XFILLER_0_127_69 VPWR VGND VPWR VGND sky130_ef_sc_hd__decap_12
XFILLER_0_78_309 VPWR VGND VPWR VGND sky130_ef_sc_hd__decap_12
X_4950_ _2462_ VGND VGND VPWR VPWR _0442_ sky130_fd_sc_hd__clkbuf_1
XTAP_TAPCELL_ROW_35_827 VGND VPWR sky130_fd_sc_hd__tapvpwrvgnd_1
X_4881_ _2425_ VGND VGND VPWR VPWR _0410_ sky130_fd_sc_hd__clkbuf_1
XTAP_TAPCELL_ROW_86_1593 VGND VPWR sky130_fd_sc_hd__tapvpwrvgnd_1
X_3901_ _1801_ _1768_ net18 VGND VGND VPWR VPWR _1828_ sky130_fd_sc_hd__mux2_1
XFILLER_0_47_729 VGND VGND VPWR VPWR sky130_fd_sc_hd__fill_1
XFILLER_0_117_617 VPWR VGND VPWR VGND sky130_ef_sc_hd__decap_12
X_3832_ _1760_ cpu_inst.regfile_inst.registers\[6\]\[26\] _1609_ VGND VGND VPWR VPWR
+ _1761_ sky130_fd_sc_hd__mux2_1
XFILLER_0_52_77 VGND VGND VPWR VPWR sky130_fd_sc_hd__decap_6
X_3763_ _1693_ VGND VGND VPWR VPWR _0024_ sky130_fd_sc_hd__clkbuf_1
XFILLER_0_15_615 VGND VGND VPWR VPWR sky130_fd_sc_hd__fill_1
XFILLER_0_42_401 VGND VGND VPWR VPWR sky130_fd_sc_hd__decap_3
X_5502_ clknet_leaf_35_clk _0422_ VGND VGND VPWR VPWR cpu_inst.regfile_inst.registers\[8\]\[6\]
+ sky130_fd_sc_hd__dfxtp_1
X_3694_ cpu_inst.regfile_inst.registers\[4\]\[23\] _0854_ _1028_ VGND VGND VPWR VPWR
+ _1626_ sky130_fd_sc_hd__o21a_1
X_2714_ cpu_inst.regfile_inst.registers\[25\]\[0\] _0557_ _0669_ _0673_ _0678_ VGND
+ VGND VPWR VPWR _0679_ sky130_fd_sc_hd__o2111a_1
XFILLER_0_112_333 VPWR VGND VPWR VGND sky130_ef_sc_hd__decap_12
X_2645_ _0608_ _0575_ _0609_ VGND VGND VPWR VPWR _0610_ sky130_fd_sc_hd__and3_4
XFILLER_0_2_531 VGND VGND VPWR VPWR sky130_fd_sc_hd__fill_1
X_5433_ clknet_leaf_41_clk _0353_ VGND VGND VPWR VPWR cpu_inst.regfile_inst.registers\[0\]\[0\]
+ sky130_fd_sc_hd__dfxtp_1
XFILLER_0_42_467 VGND VGND VPWR VPWR sky130_fd_sc_hd__fill_1
XFILLER_0_42_489 VGND VGND VPWR VPWR sky130_fd_sc_hd__decap_4
X_5364_ clknet_leaf_6_clk _0284_ VGND VGND VPWR VPWR cpu_inst.regfile_inst.registers\[11\]\[28\]
+ sky130_fd_sc_hd__dfxtp_1
XFILLER_0_11_821 VPWR VGND VPWR VGND sky130_ef_sc_hd__decap_12
XFILLER_0_112_377 VPWR VGND VPWR VGND sky130_ef_sc_hd__decap_12
X_4315_ _1183_ cpu_inst.regfile_inst.registers\[5\]\[8\] _2092_ VGND VGND VPWR VPWR
+ _2102_ sky130_fd_sc_hd__mux2_1
X_2576_ _0539_ _0540_ VGND VGND VPWR VPWR _0541_ sky130_fd_sc_hd__nand2_1
X_5295_ clknet_leaf_15_clk _0215_ VGND VGND VPWR VPWR cpu_inst.regfile_inst.registers\[1\]\[23\]
+ sky130_fd_sc_hd__dfxtp_1
X_4246_ _2065_ VGND VGND VPWR VPWR _0135_ sky130_fd_sc_hd__clkbuf_1
XFILLER_0_93_51 VGND VGND VPWR VPWR sky130_fd_sc_hd__decap_4
X_4177_ cpu_inst.regfile_inst.registers\[4\]\[6\] _2024_ VGND VGND VPWR VPWR _2030_
+ sky130_fd_sc_hd__and2_1
X_3128_ _1055_ _1063_ VGND VGND VPWR VPWR _1093_ sky130_fd_sc_hd__nor2_1
XFILLER_0_78_832 VGND VGND VPWR VPWR sky130_fd_sc_hd__decap_8
XFILLER_0_96_139 VGND VGND VPWR VPWR sky130_fd_sc_hd__fill_1
X_3059_ _0862_ _1023_ VGND VGND VPWR VPWR _1024_ sky130_fd_sc_hd__or2_1
XFILLER_0_92_301 VGND VGND VPWR VPWR sky130_fd_sc_hd__decap_6
XFILLER_0_38_718 VGND VGND VPWR VPWR sky130_fd_sc_hd__decap_3
XFILLER_0_93_835 VGND VGND VPWR VPWR sky130_fd_sc_hd__decap_4
XFILLER_0_37_217 VGND VGND VPWR VPWR sky130_fd_sc_hd__decap_6
XFILLER_0_107_105 VGND VGND VPWR VPWR sky130_fd_sc_hd__decap_6
XFILLER_0_92_345 VPWR VGND VPWR VGND sky130_ef_sc_hd__decap_12
XFILLER_0_135_447 VGND VGND VPWR VPWR sky130_fd_sc_hd__fill_1
XFILLER_0_123_609 VGND VGND VPWR VPWR sky130_fd_sc_hd__decap_6
XFILLER_0_107_149 VPWR VGND VPWR VGND sky130_ef_sc_hd__decap_12
XFILLER_0_92_389 VGND VGND VPWR VPWR sky130_fd_sc_hd__fill_1
XFILLER_0_61_721 VGND VGND VPWR VPWR sky130_fd_sc_hd__decap_6
XFILLER_0_18_475 VGND VGND VPWR VPWR sky130_fd_sc_hd__fill_1
XFILLER_0_45_261 VPWR VGND VPWR VGND sky130_ef_sc_hd__decap_12
XFILLER_0_46_773 VGND VGND VPWR VPWR sky130_fd_sc_hd__fill_1
XFILLER_0_52_209 VPWR VGND VPWR VGND sky130_ef_sc_hd__decap_12
XFILLER_0_115_193 VPWR VGND VPWR VGND sky130_ef_sc_hd__decap_12
XFILLER_0_60_253 VPWR VGND VPWR VGND sky130_ef_sc_hd__decap_12
XFILLER_0_5_391 VGND VGND VPWR VPWR sky130_fd_sc_hd__fill_1
XFILLER_0_21_629 VPWR VGND VPWR VGND sky130_ef_sc_hd__decap_12
XFILLER_0_131_653 VPWR VGND VPWR VGND sky130_ef_sc_hd__decap_12
XFILLER_0_130_141 VPWR VGND VPWR VGND sky130_ef_sc_hd__decap_12
XFILLER_0_14_681 VPWR VGND VPWR VGND sky130_ef_sc_hd__decap_12
XFILLER_0_20_139 VGND VGND VPWR VPWR sky130_fd_sc_hd__fill_1
XFILLER_0_131_697 VPWR VGND VPWR VGND sky130_ef_sc_hd__decap_12
XTAP_TAPCELL_ROW_57_1161 VGND VPWR sky130_fd_sc_hd__tapvpwrvgnd_1
XTAP_TAPCELL_ROW_57_1150 VGND VPWR sky130_fd_sc_hd__tapvpwrvgnd_1
XTAP_TAPCELL_ROW_70_1350 VGND VPWR sky130_fd_sc_hd__tapvpwrvgnd_1
XFILLER_0_68_375 VGND VGND VPWR VPWR sky130_fd_sc_hd__decap_4
XFILLER_0_29_729 VPWR VGND VPWR VGND sky130_ef_sc_hd__decap_12
XFILLER_0_113_27 VPWR VGND VPWR VGND sky130_ef_sc_hd__decap_12
XFILLER_0_95_161 VGND VGND VPWR VPWR sky130_fd_sc_hd__decap_6
XFILLER_0_126_469 VGND VGND VPWR VPWR sky130_fd_sc_hd__decap_6
XFILLER_0_118_7 VPWR VGND VPWR VGND sky130_ef_sc_hd__decap_12
XFILLER_0_24_401 VPWR VGND VPWR VGND sky130_ef_sc_hd__decap_12
XFILLER_0_98_29 VPWR VGND VPWR VGND sky130_ef_sc_hd__decap_12
XFILLER_0_3_317 VPWR VGND VPWR VGND sky130_ef_sc_hd__decap_12
XFILLER_0_24_445 VPWR VGND VPWR VGND sky130_ef_sc_hd__decap_12
XTAP_TAPCELL_ROW_40_896 VGND VPWR sky130_fd_sc_hd__tapvpwrvgnd_1
XFILLER_0_24_489 VPWR VGND VPWR VGND sky130_ef_sc_hd__decap_12
XFILLER_0_110_837 VGND VGND VPWR VPWR sky130_fd_sc_hd__decap_4
XFILLER_0_138_57 VPWR VGND VPWR VGND sky130_ef_sc_hd__decap_12
X_4100_ _1196_ cpu_inst.regfile_inst.registers\[25\]\[4\] _1982_ VGND VGND VPWR VPWR
+ _1987_ sky130_fd_sc_hd__mux2_1
X_5080_ clknet_leaf_40_clk _0000_ VGND VGND VPWR VPWR cpu_inst.regfile_inst.registers\[6\]\[0\]
+ sky130_fd_sc_hd__dfxtp_1
XFILLER_0_47_55 VGND VGND VPWR VPWR sky130_fd_sc_hd__fill_1
X_4031_ _1951_ VGND VGND VPWR VPWR _0034_ sky130_fd_sc_hd__clkbuf_1
XTAP_TAPCELL_ROW_88_1622 VGND VPWR sky130_fd_sc_hd__tapvpwrvgnd_1
XFILLER_0_78_139 VGND VGND VPWR VPWR sky130_fd_sc_hd__fill_1
X_4933_ _1456_ cpu_inst.regfile_inst.registers\[8\]\[18\] _2449_ VGND VGND VPWR VPWR
+ _2454_ sky130_fd_sc_hd__mux2_1
XFILLER_0_87_673 VGND VGND VPWR VPWR sky130_fd_sc_hd__decap_8
XFILLER_0_74_301 VGND VGND VPWR VPWR sky130_fd_sc_hd__decap_6
XFILLER_0_19_217 VGND VGND VPWR VPWR sky130_fd_sc_hd__decap_6
X_4864_ cpu_inst.regfile_inst.registers\[9\]\[18\] VGND VGND VPWR VPWR _2417_ sky130_fd_sc_hd__clkbuf_1
XFILLER_0_74_345 VPWR VGND VPWR VGND sky130_ef_sc_hd__decap_12
XFILLER_0_62_507 VGND VGND VPWR VPWR sky130_fd_sc_hd__decap_3
XFILLER_0_117_447 VGND VGND VPWR VPWR sky130_fd_sc_hd__fill_1
XFILLER_0_105_609 VGND VGND VPWR VPWR sky130_fd_sc_hd__decap_4
X_3815_ cpu_inst.regfile_inst.registers\[8\]\[26\] _1557_ VGND VGND VPWR VPWR _1744_
+ sky130_fd_sc_hd__or2_1
X_4795_ _2382_ VGND VGND VPWR VPWR _0367_ sky130_fd_sc_hd__clkbuf_1
XFILLER_0_6_133 VGND VGND VPWR VPWR sky130_fd_sc_hd__decap_6
XFILLER_0_27_261 VPWR VGND VPWR VGND sky130_ef_sc_hd__decap_12
XFILLER_0_34_209 VPWR VGND VPWR VGND sky130_ef_sc_hd__decap_12
XTAP_TAPCELL_ROW_115_2018 VGND VPWR sky130_fd_sc_hd__tapvpwrvgnd_1
XFILLER_0_103_93 VPWR VGND VPWR VGND sky130_ef_sc_hd__decap_12
X_3746_ _1663_ _1676_ VGND VGND VPWR VPWR _1677_ sky130_fd_sc_hd__xnor2_1
XFILLER_0_6_177 VPWR VGND VPWR VGND sky130_ef_sc_hd__decap_12
XTAP_TAPCELL_ROW_115_2029 VGND VPWR sky130_fd_sc_hd__tapvpwrvgnd_1
XTAP_TAPCELL_ROW_99_1784 VGND VPWR sky130_fd_sc_hd__tapvpwrvgnd_1
XFILLER_0_42_253 VPWR VGND VPWR VGND sky130_ef_sc_hd__decap_12
XFILLER_0_113_653 VPWR VGND VPWR VGND sky130_ef_sc_hd__decap_12
XFILLER_0_112_141 VPWR VGND VPWR VGND sky130_ef_sc_hd__decap_12
X_3677_ _1608_ cpu_inst.regfile_inst.registers\[6\]\[22\] _1609_ VGND VGND VPWR VPWR
+ _1610_ sky130_fd_sc_hd__mux2_1
X_5416_ clknet_leaf_4_clk _0336_ net2 VGND VGND VPWR VPWR cpu_inst.decoder_inst.current_pc\[16\]
+ sky130_fd_sc_hd__dfrtp_1
XFILLER_0_70_3 VPWR VGND VPWR VGND sky130_ef_sc_hd__decap_12
XFILLER_0_113_697 VPWR VGND VPWR VGND sky130_ef_sc_hd__decap_12
X_2628_ _0592_ VGND VGND VPWR VPWR _0593_ sky130_fd_sc_hd__clkbuf_4
XFILLER_0_11_673 VPWR VGND VPWR VGND sky130_ef_sc_hd__decap_12
X_5347_ clknet_leaf_29_clk _0267_ VGND VGND VPWR VPWR cpu_inst.regfile_inst.registers\[11\]\[11\]
+ sky130_fd_sc_hd__dfxtp_1
X_2559_ net17 _0518_ _0520_ _0523_ VGND VGND VPWR VPWR _0524_ sky130_fd_sc_hd__or4_4
XTAP_TAPCELL_ROW_110_1951 VGND VPWR sky130_fd_sc_hd__tapvpwrvgnd_1
X_5278_ clknet_leaf_33_clk _0198_ VGND VGND VPWR VPWR cpu_inst.regfile_inst.registers\[1\]\[6\]
+ sky130_fd_sc_hd__dfxtp_1
X_4229_ cpu_inst.regfile_inst.registers\[4\]\[31\] _2023_ VGND VGND VPWR VPWR _2057_
+ sky130_fd_sc_hd__and2_1
XTAP_TAPCELL_ROW_52_1080 VGND VPWR sky130_fd_sc_hd__tapvpwrvgnd_1
XFILLER_0_84_109 VPWR VGND VPWR VGND sky130_ef_sc_hd__decap_12
XFILLER_0_66_813 VGND VGND VPWR VPWR sky130_fd_sc_hd__fill_2
XFILLER_0_136_701 VPWR VGND VPWR VGND sky130_ef_sc_hd__decap_12
XFILLER_0_77_161 VGND VGND VPWR VPWR sky130_fd_sc_hd__decap_6
XFILLER_0_92_153 VPWR VGND VPWR VGND sky130_ef_sc_hd__decap_12
XFILLER_0_81_827 VPWR VGND VPWR VGND sky130_ef_sc_hd__decap_12
XFILLER_0_123_417 VPWR VGND VPWR VGND sky130_ef_sc_hd__decap_12
XFILLER_0_108_469 VGND VGND VPWR VPWR sky130_fd_sc_hd__decap_6
XFILLER_0_92_197 VPWR VGND VPWR VGND sky130_ef_sc_hd__decap_12
XFILLER_0_61_573 VGND VGND VPWR VPWR sky130_fd_sc_hd__fill_2
XFILLER_0_0_309 VPWR VGND VPWR VGND sky130_ef_sc_hd__decap_12
XFILLER_0_131_461 VPWR VGND VPWR VGND sky130_ef_sc_hd__decap_12
XFILLER_0_104_686 VGND VGND VPWR VPWR sky130_fd_sc_hd__decap_4
XFILLER_0_108_27 VGND VGND VPWR VPWR sky130_fd_sc_hd__fill_1
XTAP_TAPCELL_ROW_6_393 VGND VPWR sky130_fd_sc_hd__tapvpwrvgnd_1
XFILLER_0_17_69 VPWR VGND VPWR VGND sky130_ef_sc_hd__decap_12
XFILLER_0_124_15 VPWR VGND VPWR VGND sky130_ef_sc_hd__decap_12
XTAP_TAPCELL_ROW_83_1552 VGND VPWR sky130_fd_sc_hd__tapvpwrvgnd_1
XTAP_TAPCELL_ROW_83_1541 VGND VPWR sky130_fd_sc_hd__tapvpwrvgnd_1
XFILLER_0_56_301 VGND VGND VPWR VPWR sky130_fd_sc_hd__fill_2
XFILLER_0_33_57 VPWR VGND VPWR VGND sky130_ef_sc_hd__decap_12
XTAP_TAPCELL_ROW_45_977 VGND VPWR sky130_fd_sc_hd__tapvpwrvgnd_1
XFILLER_0_84_665 VGND VGND VPWR VPWR sky130_fd_sc_hd__fill_1
XFILLER_0_126_233 VPWR VGND VPWR VGND sky130_ef_sc_hd__decap_12
XFILLER_0_16_209 VPWR VGND VPWR VGND sky130_ef_sc_hd__decap_12
XFILLER_0_126_277 VPWR VGND VPWR VGND sky130_ef_sc_hd__decap_12
X_3600_ _1534_ cpu_inst.regfile_inst.registers\[6\]\[20\] _1339_ VGND VGND VPWR VPWR
+ _1535_ sky130_fd_sc_hd__mux2_1
XFILLER_0_25_721 VGND VGND VPWR VPWR sky130_fd_sc_hd__decap_6
X_4580_ cpu_inst.regfile_inst.registers\[10\]\[9\] _2230_ VGND VGND VPWR VPWR _2238_
+ sky130_fd_sc_hd__and2_1
XFILLER_0_109_3 VPWR VGND VPWR VGND sky130_ef_sc_hd__decap_12
X_3531_ _1466_ VGND VGND VPWR VPWR _1467_ sky130_fd_sc_hd__inv_2
XFILLER_0_4_637 VGND VGND VPWR VPWR sky130_fd_sc_hd__decap_6
XFILLER_0_3_125 VPWR VGND VPWR VGND sky130_ef_sc_hd__decap_12
XFILLER_0_24_253 VPWR VGND VPWR VGND sky130_ef_sc_hd__decap_12
XFILLER_0_25_765 VPWR VGND VPWR VGND sky130_ef_sc_hd__decap_12
XFILLER_0_3_169 VPWR VGND VPWR VGND sky130_ef_sc_hd__decap_12
XFILLER_0_110_601 VPWR VGND VPWR VGND sky130_ef_sc_hd__decap_12
X_3462_ _0725_ _1398_ _1399_ VGND VGND VPWR VPWR _1400_ sky130_fd_sc_hd__or3_1
XFILLER_0_110_645 VPWR VGND VPWR VGND sky130_ef_sc_hd__decap_12
X_5201_ clknet_leaf_15_clk _0121_ VGND VGND VPWR VPWR cpu_inst.regfile_inst.registers\[4\]\[25\]
+ sky130_fd_sc_hd__dfxtp_1
XFILLER_0_58_65 VPWR VGND VPWR VGND sky130_ef_sc_hd__decap_12
X_3393_ _1164_ cpu_inst.regfile_inst.registers\[6\]\[10\] _1300_ VGND VGND VPWR VPWR
+ _1338_ sky130_fd_sc_hd__mux2_1
X_5132_ clknet_leaf_19_clk _0052_ VGND VGND VPWR VPWR cpu_inst.regfile_inst.registers\[2\]\[20\]
+ sky130_fd_sc_hd__dfxtp_1
X_5063_ _2523_ _2524_ VGND VGND VPWR VPWR _0493_ sky130_fd_sc_hd__nor2_1
XFILLER_0_74_53 VPWR VGND VPWR VGND sky130_ef_sc_hd__decap_12
X_4014_ _1935_ _1936_ _1306_ VGND VGND VPWR VPWR _1937_ sky130_fd_sc_hd__mux2_1
XFILLER_0_74_97 VPWR VGND VPWR VGND sky130_ef_sc_hd__decap_12
XTAP_TAPCELL_ROW_125_2180 VGND VPWR sky130_fd_sc_hd__tapvpwrvgnd_1
XFILLER_0_66_109 VPWR VGND VPWR VGND sky130_ef_sc_hd__decap_12
XFILLER_0_48_813 VPWR VGND VPWR VGND sky130_ef_sc_hd__decap_12
XFILLER_0_90_41 VPWR VGND VPWR VGND sky130_ef_sc_hd__decap_12
XFILLER_0_59_161 VGND VGND VPWR VPWR sky130_fd_sc_hd__decap_6
XFILLER_0_118_701 VPWR VGND VPWR VGND sky130_ef_sc_hd__decap_12
XFILLER_0_90_85 VPWR VGND VPWR VGND sky130_ef_sc_hd__decap_12
XFILLER_0_75_654 VPWR VGND VPWR VGND sky130_ef_sc_hd__decap_12
XFILLER_0_63_805 VPWR VGND VPWR VGND sky130_ef_sc_hd__decap_12
XTAP_TAPCELL_ROW_23_638 VGND VPWR sky130_fd_sc_hd__tapvpwrvgnd_1
X_4916_ _1164_ cpu_inst.regfile_inst.registers\[8\]\[10\] _2432_ VGND VGND VPWR VPWR
+ _2445_ sky130_fd_sc_hd__mux2_1
XFILLER_0_90_624 VGND VGND VPWR VPWR sky130_fd_sc_hd__decap_3
XFILLER_0_74_153 VPWR VGND VPWR VGND sky130_ef_sc_hd__decap_12
XTAP_TAPCELL_ROW_23_649 VGND VPWR sky130_fd_sc_hd__tapvpwrvgnd_1
X_4847_ _2408_ VGND VGND VPWR VPWR _0393_ sky130_fd_sc_hd__clkbuf_1
XFILLER_0_105_417 VPWR VGND VPWR VGND sky130_ef_sc_hd__decap_12
XFILLER_0_90_657 VGND VGND VPWR VPWR sky130_fd_sc_hd__fill_1
XFILLER_0_74_197 VPWR VGND VPWR VGND sky130_ef_sc_hd__decap_12
XFILLER_0_7_497 VGND VGND VPWR VPWR sky130_fd_sc_hd__decap_6
X_4778_ cpu_inst.regfile_inst.registers\[0\]\[7\] VGND VGND VPWR VPWR _2374_ sky130_fd_sc_hd__clkbuf_1
X_3729_ _1536_ _1656_ _1659_ _1314_ VGND VGND VPWR VPWR _1660_ sky130_fd_sc_hd__o22a_1
XFILLER_0_113_461 VPWR VGND VPWR VGND sky130_ef_sc_hd__decap_12
XFILLER_0_30_245 VGND VGND VPWR VPWR sky130_fd_sc_hd__decap_6
XFILLER_0_100_133 VGND VGND VPWR VPWR sky130_fd_sc_hd__decap_6
XFILLER_0_30_289 VPWR VGND VPWR VGND sky130_ef_sc_hd__decap_12
XFILLER_0_100_177 VPWR VGND VPWR VGND sky130_ef_sc_hd__decap_12
XTAP_TAPCELL_ROW_3_352 VGND VPWR sky130_fd_sc_hd__tapvpwrvgnd_1
XTAP_TAPCELL_ROW_3_341 VGND VPWR sky130_fd_sc_hd__tapvpwrvgnd_1
XFILLER_0_97_223 VGND VGND VPWR VPWR sky130_fd_sc_hd__fill_1
XFILLER_0_38_301 VGND VGND VPWR VPWR sky130_fd_sc_hd__decap_6
XPHY_EDGE_ROW_125_Right_125 VGND VGND VPWR VPWR sky130_fd_sc_hd__decap_3
XTAP_TAPCELL_ROW_65_1282 VGND VPWR sky130_fd_sc_hd__tapvpwrvgnd_1
XTAP_TAPCELL_ROW_65_1271 VGND VPWR sky130_fd_sc_hd__tapvpwrvgnd_1
XFILLER_0_38_345 VPWR VGND VPWR VGND sky130_ef_sc_hd__decap_12
XTAP_TAPCELL_ROW_42_925 VGND VPWR sky130_fd_sc_hd__tapvpwrvgnd_1
XTAP_TAPCELL_ROW_42_936 VGND VPWR sky130_fd_sc_hd__tapvpwrvgnd_1
XFILLER_0_136_531 VGND VGND VPWR VPWR sky130_fd_sc_hd__fill_1
XFILLER_0_108_233 VPWR VGND VPWR VGND sky130_ef_sc_hd__decap_12
XFILLER_0_66_698 VGND VGND VPWR VPWR sky130_fd_sc_hd__fill_2
XFILLER_0_38_389 VPWR VGND VPWR VGND sky130_ef_sc_hd__decap_12
XFILLER_0_53_337 VGND VGND VPWR VPWR sky130_fd_sc_hd__fill_1
XFILLER_0_124_737 VPWR VGND VPWR VGND sky130_ef_sc_hd__decap_12
XFILLER_0_123_225 VPWR VGND VPWR VGND sky130_ef_sc_hd__decap_12
XFILLER_0_108_277 VPWR VGND VPWR VGND sky130_ef_sc_hd__decap_12
XFILLER_0_80_189 VGND VGND VPWR VPWR sky130_fd_sc_hd__decap_6
XFILLER_0_22_713 VPWR VGND VPWR VGND sky130_ef_sc_hd__decap_12
XFILLER_0_132_781 VPWR VGND VPWR VGND sky130_ef_sc_hd__decap_12
XFILLER_0_1_629 VPWR VGND VPWR VGND sky130_ef_sc_hd__decap_12
XFILLER_0_21_223 VGND VGND VPWR VPWR sky130_fd_sc_hd__fill_1
XFILLER_0_22_757 VPWR VGND VPWR VGND sky130_ef_sc_hd__decap_12
XFILLER_0_119_15 VPWR VGND VPWR VGND sky130_ef_sc_hd__decap_12
XFILLER_0_135_69 VPWR VGND VPWR VGND sky130_ef_sc_hd__decap_12
XFILLER_0_89_779 VGND VGND VPWR VPWR sky130_fd_sc_hd__decap_4
XFILLER_0_89_768 VGND VGND VPWR VPWR sky130_fd_sc_hd__fill_2
XFILLER_0_88_245 VGND VGND VPWR VPWR sky130_fd_sc_hd__decap_6
XFILLER_0_88_289 VPWR VGND VPWR VGND sky130_ef_sc_hd__decap_12
XFILLER_0_69_470 VGND VGND VPWR VPWR sky130_fd_sc_hd__decap_4
XFILLER_0_48_109 VPWR VGND VPWR VGND sky130_ef_sc_hd__decap_12
XFILLER_0_9_729 VPWR VGND VPWR VGND sky130_ef_sc_hd__decap_12
X_2962_ _0926_ cpu_inst.regfile_inst.registers\[10\]\[5\] _0870_ VGND VGND VPWR VPWR
+ _0927_ sky130_fd_sc_hd__mux2_1
XFILLER_0_84_462 VGND VGND VPWR VPWR sky130_fd_sc_hd__fill_1
X_4701_ cpu_inst.decoder_inst.current_pc\[13\] _2285_ _2286_ _2322_ VGND VGND VPWR
+ VPWR _0333_ sky130_fd_sc_hd__o22a_1
XFILLER_0_56_153 VPWR VGND VPWR VGND sky130_ef_sc_hd__decap_12
XFILLER_0_17_529 VPWR VGND VPWR VGND sky130_ef_sc_hd__decap_12
XFILLER_0_127_553 VGND VGND VPWR VPWR sky130_fd_sc_hd__decap_6
X_2893_ cpu_inst.regfile_inst.registers\[24\]\[12\] _0697_ VGND VGND VPWR VPWR _0858_
+ sky130_fd_sc_hd__or2_1
XFILLER_0_60_77 VGND VGND VPWR VPWR sky130_fd_sc_hd__decap_6
XFILLER_0_56_197 VPWR VGND VPWR VGND sky130_ef_sc_hd__decap_12
X_4632_ cpu_inst.display_inst.counter\[13\] cpu_inst.display_inst.counter\[12\] cpu_inst.display_inst.counter\[14\]
+ cpu_inst.display_inst.counter\[15\] VGND VGND VPWR VPWR _2267_ sky130_fd_sc_hd__or4b_1
XFILLER_0_127_597 VPWR VGND VPWR VGND sky130_ef_sc_hd__decap_12
XFILLER_0_71_167 VGND VGND VPWR VPWR sky130_fd_sc_hd__fill_1
XFILLER_0_4_401 VPWR VGND VPWR VGND sky130_ef_sc_hd__decap_12
XTAP_TAPCELL_ROW_96_1743 VGND VPWR sky130_fd_sc_hd__tapvpwrvgnd_1
XFILLER_0_69_31 VPWR VGND VPWR VGND sky130_ef_sc_hd__decap_12
XFILLER_0_4_445 VPWR VGND VPWR VGND sky130_ef_sc_hd__decap_12
X_4563_ _2229_ VGND VGND VPWR VPWR _2230_ sky130_fd_sc_hd__buf_2
X_3514_ _1060_ VGND VGND VPWR VPWR _1451_ sky130_fd_sc_hd__clkbuf_4
X_4494_ _1899_ cpu_inst.regfile_inst.registers\[7\]\[30\] _2186_ VGND VGND VPWR VPWR
+ _2195_ sky130_fd_sc_hd__mux2_1
XFILLER_0_12_245 VGND VGND VPWR VPWR sky130_fd_sc_hd__decap_6
XFILLER_0_4_489 VPWR VGND VPWR VGND sky130_ef_sc_hd__decap_12
XFILLER_0_100_83 VGND VGND VPWR VPWR sky130_fd_sc_hd__fill_1
X_3445_ _1383_ VGND VGND VPWR VPWR _0016_ sky130_fd_sc_hd__clkbuf_1
XFILLER_0_110_475 VGND VGND VPWR VPWR sky130_fd_sc_hd__fill_1
XFILLER_0_12_289 VPWR VGND VPWR VGND sky130_ef_sc_hd__decap_12
XFILLER_0_0_673 VPWR VGND VPWR VGND sky130_ef_sc_hd__decap_12
X_3376_ _0655_ _0558_ _1282_ VGND VGND VPWR VPWR _1326_ sky130_fd_sc_hd__and3_1
X_5115_ clknet_leaf_39_clk _0035_ VGND VGND VPWR VPWR cpu_inst.regfile_inst.registers\[2\]\[3\]
+ sky130_fd_sc_hd__dfxtp_1
XFILLER_0_109_81 VPWR VGND VPWR VGND sky130_ef_sc_hd__decap_12
X_5046_ cpu_inst.display_inst.counter\[7\] _2512_ _2270_ VGND VGND VPWR VPWR _2514_
+ sky130_fd_sc_hd__o21ai_1
XFILLER_0_33_3 VPWR VGND VPWR VGND sky130_ef_sc_hd__decap_12
XFILLER_0_79_223 VGND VGND VPWR VPWR sky130_fd_sc_hd__fill_1
XTAP_TAPCELL_ROW_0_300 VGND VPWR sky130_fd_sc_hd__tapvpwrvgnd_1
XTAP_TAPCELL_ROW_28_719 VGND VPWR sky130_fd_sc_hd__tapvpwrvgnd_1
XTAP_TAPCELL_ROW_123_2139 VGND VPWR sky130_fd_sc_hd__tapvpwrvgnd_1
XFILLER_0_95_727 VGND VGND VPWR VPWR sky130_fd_sc_hd__fill_1
XFILLER_0_88_790 VGND VGND VPWR VPWR sky130_fd_sc_hd__decap_8
XFILLER_0_137_317 VPWR VGND VPWR VGND sky130_ef_sc_hd__decap_12
XTAP_TAPCELL_ROW_105_1872 VGND VPWR sky130_fd_sc_hd__tapvpwrvgnd_1
XFILLER_0_48_643 VGND VGND VPWR VPWR sky130_fd_sc_hd__fill_1
XFILLER_0_118_531 VGND VGND VPWR VPWR sky130_fd_sc_hd__fill_1
XFILLER_0_35_337 VPWR VGND VPWR VGND sky130_ef_sc_hd__decap_12
XTAP_TAPCELL_ROW_138_2382 VGND VPWR sky130_fd_sc_hd__tapvpwrvgnd_1
XTAP_TAPCELL_ROW_138_2371 VGND VPWR sky130_fd_sc_hd__tapvpwrvgnd_1
XFILLER_0_106_737 VPWR VGND VPWR VGND sky130_ef_sc_hd__decap_12
XFILLER_0_105_225 VPWR VGND VPWR VGND sky130_ef_sc_hd__decap_12
XFILLER_0_90_443 VGND VGND VPWR VPWR sky130_fd_sc_hd__decap_3
XFILLER_0_63_679 VPWR VGND VPWR VGND sky130_ef_sc_hd__decap_12
XFILLER_0_7_261 VPWR VGND VPWR VGND sky130_ef_sc_hd__decap_12
XFILLER_0_50_307 VGND VGND VPWR VPWR sky130_fd_sc_hd__fill_1
XFILLER_0_62_189 VGND VGND VPWR VPWR sky130_fd_sc_hd__decap_6
XFILLER_0_121_729 VPWR VGND VPWR VGND sky130_ef_sc_hd__decap_12
XFILLER_0_114_781 VPWR VGND VPWR VGND sky130_ef_sc_hd__decap_12
XTAP_TAPCELL_ROW_8_422 VGND VPWR sky130_fd_sc_hd__tapvpwrvgnd_1
XTAP_TAPCELL_ROW_67_1300 VGND VPWR sky130_fd_sc_hd__tapvpwrvgnd_1
XTAP_TAPCELL_ROW_67_1311 VGND VPWR sky130_fd_sc_hd__tapvpwrvgnd_1
XFILLER_0_105_39 VPWR VGND VPWR VGND sky130_ef_sc_hd__decap_12
XFILLER_0_14_15 VPWR VGND VPWR VGND sky130_ef_sc_hd__decap_12
XFILLER_0_85_237 VPWR VGND VPWR VGND sky130_ef_sc_hd__decap_12
XTAP_TAPCELL_ROW_80_1500 VGND VPWR sky130_fd_sc_hd__tapvpwrvgnd_1
XFILLER_0_66_451 VGND VGND VPWR VPWR sky130_fd_sc_hd__fill_1
XFILLER_0_38_153 VPWR VGND VPWR VGND sky130_ef_sc_hd__decap_12
XFILLER_0_124_501 VPWR VGND VPWR VGND sky130_ef_sc_hd__decap_12
XFILLER_0_121_27 VPWR VGND VPWR VGND sky130_ef_sc_hd__decap_12
XFILLER_0_109_553 VGND VGND VPWR VPWR sky130_fd_sc_hd__decap_6
XFILLER_0_93_281 VPWR VGND VPWR VGND sky130_ef_sc_hd__decap_12
XFILLER_0_38_197 VPWR VGND VPWR VGND sky130_ef_sc_hd__decap_12
XFILLER_0_109_597 VPWR VGND VPWR VGND sky130_ef_sc_hd__decap_12
XFILLER_0_124_545 VPWR VGND VPWR VGND sky130_ef_sc_hd__decap_12
XFILLER_0_41_329 VGND VGND VPWR VPWR sky130_fd_sc_hd__decap_6
XFILLER_0_53_167 VGND VGND VPWR VPWR sky130_fd_sc_hd__fill_1
XFILLER_0_124_589 VPWR VGND VPWR VGND sky130_ef_sc_hd__decap_12
XFILLER_0_111_217 VGND VGND VPWR VPWR sky130_fd_sc_hd__decap_6
XTAP_TAPCELL_ROW_78_1473 VGND VPWR sky130_fd_sc_hd__tapvpwrvgnd_1
XFILLER_0_22_587 VGND VGND VPWR VPWR sky130_fd_sc_hd__fill_1
XFILLER_0_10_749 VGND VGND VPWR VPWR sky130_fd_sc_hd__decap_6
XTAP_TAPCELL_ROW_91_1662 VGND VPWR sky130_fd_sc_hd__tapvpwrvgnd_1
X_3230_ _0573_ _1187_ _1194_ _1088_ VGND VGND VPWR VPWR _1195_ sky130_fd_sc_hd__o22a_1
X_3161_ cpu_inst.regfile_inst.registers\[5\]\[14\] cpu_inst.regfile_inst.registers\[4\]\[14\]
+ _0867_ VGND VGND VPWR VPWR _1126_ sky130_fd_sc_hd__mux2_1
X_3092_ _0619_ VGND VGND VPWR VPWR _1057_ sky130_fd_sc_hd__clkbuf_4
XFILLER_0_55_55 VGND VGND VPWR VPWR sky130_fd_sc_hd__fill_1
XFILLER_0_89_543 VPWR VGND VPWR VGND sky130_ef_sc_hd__decap_12
XFILLER_0_89_587 VGND VGND VPWR VPWR sky130_fd_sc_hd__fill_1
XFILLER_0_89_576 VGND VGND VPWR VPWR sky130_fd_sc_hd__decap_4
XFILLER_0_77_738 VGND VGND VPWR VPWR sky130_fd_sc_hd__fill_2
XFILLER_0_119_317 VPWR VGND VPWR VGND sky130_ef_sc_hd__decap_12
X_3994_ cpu_inst.regfile_inst.registers\[24\]\[31\] _1384_ _0700_ _1917_ _0699_ VGND
+ VGND VPWR VPWR _1918_ sky130_fd_sc_hd__o221a_1
XFILLER_0_57_462 VGND VGND VPWR VPWR sky130_fd_sc_hd__decap_8
XFILLER_0_57_440 VGND VGND VPWR VPWR sky130_fd_sc_hd__decap_8
XFILLER_0_9_559 VGND VGND VPWR VPWR sky130_fd_sc_hd__fill_1
XFILLER_0_18_805 VGND VGND VPWR VPWR sky130_fd_sc_hd__decap_6
XFILLER_0_134_309 VPWR VGND VPWR VGND sky130_ef_sc_hd__decap_12
X_2945_ cpu_inst.regfile_inst.registers\[25\]\[3\] _0903_ _0669_ _0909_ VGND VGND
+ VPWR VPWR _0910_ sky130_fd_sc_hd__o211ai_2
XFILLER_0_57_484 VPWR VGND VPWR VGND sky130_ef_sc_hd__decap_12
XFILLER_0_17_337 VPWR VGND VPWR VGND sky130_ef_sc_hd__decap_12
XTAP_TAPCELL_ROW_33_788 VGND VPWR sky130_fd_sc_hd__tapvpwrvgnd_1
XFILLER_0_45_624 VGND VGND VPWR VPWR sky130_fd_sc_hd__fill_2
XFILLER_0_127_361 VPWR VGND VPWR VGND sky130_ef_sc_hd__decap_12
XFILLER_0_72_443 VGND VGND VPWR VPWR sky130_fd_sc_hd__fill_1
X_2876_ _0718_ _0739_ _0816_ _0840_ VGND VGND VPWR VPWR _0841_ sky130_fd_sc_hd__and4bb_1
XFILLER_0_5_721 VGND VGND VPWR VPWR sky130_fd_sc_hd__decap_6
XTAP_TAPCELL_ROW_33_799 VGND VPWR sky130_fd_sc_hd__tapvpwrvgnd_1
X_4615_ _2256_ VGND VGND VPWR VPWR _0313_ sky130_fd_sc_hd__clkbuf_1
XTAP_TAPCELL_ROW_13_490 VGND VPWR sky130_fd_sc_hd__tapvpwrvgnd_1
XFILLER_0_5_765 VPWR VGND VPWR VGND sky130_ef_sc_hd__decap_12
XFILLER_0_32_307 VGND VGND VPWR VPWR sky130_fd_sc_hd__fill_1
XFILLER_0_44_189 VGND VGND VPWR VPWR sky130_fd_sc_hd__decap_6
X_4546_ cpu_inst.regfile_inst.registers\[11\]\[24\] VGND VGND VPWR VPWR _2221_ sky130_fd_sc_hd__clkbuf_1
XFILLER_0_103_729 VPWR VGND VPWR VGND sky130_ef_sc_hd__decap_12
XFILLER_0_4_253 VPWR VGND VPWR VGND sky130_ef_sc_hd__decap_12
XFILLER_0_41_841 VGND VGND VPWR VPWR sky130_fd_sc_hd__fill_1
XTAP_TAPCELL_ROW_133_2290 VGND VPWR sky130_fd_sc_hd__tapvpwrvgnd_1
XFILLER_0_111_93 VPWR VGND VPWR VGND sky130_ef_sc_hd__decap_12
X_4477_ _2160_ VGND VGND VPWR VPWR _2186_ sky130_fd_sc_hd__buf_4
X_3428_ _1362_ _1363_ _1366_ VGND VGND VPWR VPWR _1367_ sky130_fd_sc_hd__o21ai_1
X_3359_ _0664_ VGND VGND VPWR VPWR _1309_ sky130_fd_sc_hd__inv_2
XTAP_TAPCELL_ROW_107_1901 VGND VPWR sky130_fd_sc_hd__tapvpwrvgnd_1
XFILLER_0_99_329 VGND VGND VPWR VPWR sky130_fd_sc_hd__decap_6
XTAP_TAPCELL_ROW_107_1912 VGND VPWR sky130_fd_sc_hd__tapvpwrvgnd_1
X_5029_ cpu_inst.display_inst.counter\[0\] _2270_ VGND VGND VPWR VPWR _2504_ sky130_fd_sc_hd__and2b_1
XFILLER_0_68_727 VGND VGND VPWR VPWR sky130_fd_sc_hd__decap_8
XTAP_TAPCELL_ROW_49_1030 VGND VPWR sky130_fd_sc_hd__tapvpwrvgnd_1
XTAP_TAPCELL_ROW_49_1041 VGND VPWR sky130_fd_sc_hd__tapvpwrvgnd_1
XFILLER_0_67_237 VPWR VGND VPWR VGND sky130_ef_sc_hd__decap_12
XFILLER_0_137_125 VPWR VGND VPWR VGND sky130_ef_sc_hd__decap_12
XTAP_TAPCELL_ROW_62_1230 VGND VPWR sky130_fd_sc_hd__tapvpwrvgnd_1
XFILLER_0_137_169 VPWR VGND VPWR VGND sky130_ef_sc_hd__decap_12
XFILLER_0_75_281 VPWR VGND VPWR VGND sky130_ef_sc_hd__decap_12
XFILLER_0_90_251 VGND VGND VPWR VPWR sky130_fd_sc_hd__fill_1
XFILLER_0_8_581 VGND VGND VPWR VPWR sky130_fd_sc_hd__decap_6
XFILLER_0_51_605 VGND VGND VPWR VPWR sky130_fd_sc_hd__decap_4
XFILLER_0_23_329 VGND VGND VPWR VPWR sky130_fd_sc_hd__decap_6
XFILLER_0_35_167 VGND VGND VPWR VPWR sky130_fd_sc_hd__fill_1
XFILLER_0_106_589 VGND VGND VPWR VPWR sky130_fd_sc_hd__decap_6
XFILLER_0_121_559 VGND VGND VPWR VPWR sky130_fd_sc_hd__fill_1
XFILLER_0_31_373 VPWR VGND VPWR VGND sky130_ef_sc_hd__decap_12
XFILLER_0_101_261 VPWR VGND VPWR VGND sky130_ef_sc_hd__decap_12
XTAP_TAPCELL_ROW_73_1392 VGND VPWR sky130_fd_sc_hd__tapvpwrvgnd_1
XFILLER_0_99_841 VGND VGND VPWR VPWR sky130_fd_sc_hd__fill_1
XFILLER_0_116_27 VGND VGND VPWR VPWR sky130_fd_sc_hd__fill_1
XFILLER_0_86_524 VGND VGND VPWR VPWR sky130_fd_sc_hd__decap_8
XFILLER_0_25_69 VPWR VGND VPWR VGND sky130_ef_sc_hd__decap_12
XFILLER_0_129_615 VGND VGND VPWR VPWR sky130_fd_sc_hd__fill_1
XFILLER_0_132_15 VPWR VGND VPWR VGND sky130_ef_sc_hd__decap_12
XFILLER_0_116_309 VPWR VGND VPWR VGND sky130_ef_sc_hd__decap_12
XFILLER_0_41_57 VPWR VGND VPWR VGND sky130_ef_sc_hd__decap_12
XFILLER_0_125_821 VPWR VGND VPWR VGND sky130_ef_sc_hd__decap_12
XFILLER_0_109_361 VPWR VGND VPWR VGND sky130_ef_sc_hd__decap_12
X_2730_ _0694_ VGND VGND VPWR VPWR _0695_ sky130_fd_sc_hd__buf_4
XFILLER_0_54_443 VGND VGND VPWR VPWR sky130_fd_sc_hd__fill_1
XTAP_TAPCELL_ROW_30_747 VGND VPWR sky130_fd_sc_hd__tapvpwrvgnd_1
XFILLER_0_42_605 VGND VGND VPWR VPWR sky130_fd_sc_hd__fill_1
XFILLER_0_82_785 VGND VGND VPWR VPWR sky130_fd_sc_hd__fill_1
XFILLER_0_81_273 VGND VGND VPWR VPWR sky130_fd_sc_hd__decap_6
XFILLER_0_14_307 VGND VGND VPWR VPWR sky130_fd_sc_hd__fill_1
XFILLER_0_26_189 VGND VGND VPWR VPWR sky130_fd_sc_hd__decap_6
X_2661_ cpu_inst.regfile_inst.registers\[15\]\[1\] _0566_ _0625_ _0571_ VGND VGND
+ VPWR VPWR _0626_ sky130_fd_sc_hd__a211o_1
XTAP_TAPCELL_ROW_93_1702 VGND VPWR sky130_fd_sc_hd__tapvpwrvgnd_1
XFILLER_0_2_713 VPWR VGND VPWR VGND sky130_ef_sc_hd__decap_12
XFILLER_0_23_841 VGND VGND VPWR VPWR sky130_fd_sc_hd__fill_1
XFILLER_0_41_137 VPWR VGND VPWR VGND sky130_ef_sc_hd__decap_12
X_4400_ _2145_ VGND VGND VPWR VPWR _0209_ sky130_fd_sc_hd__clkbuf_1
X_5380_ clknet_leaf_21_clk _0300_ VGND VGND VPWR VPWR cpu_inst.regfile_inst.registers\[10\]\[12\]
+ sky130_fd_sc_hd__dfxtp_1
X_2592_ _0551_ _0538_ _0554_ _0537_ VGND VGND VPWR VPWR _0557_ sky130_fd_sc_hd__or4_4
XFILLER_0_1_223 VGND VGND VPWR VPWR sky130_fd_sc_hd__fill_1
XFILLER_0_2_757 VPWR VGND VPWR VGND sky130_ef_sc_hd__decap_12
X_4331_ _2110_ VGND VGND VPWR VPWR _0175_ sky130_fd_sc_hd__clkbuf_1
XFILLER_0_10_513 VPWR VGND VPWR VGND sky130_ef_sc_hd__decap_12
XFILLER_0_120_581 VGND VGND VPWR VPWR sky130_fd_sc_hd__decap_6
X_4262_ _2073_ VGND VGND VPWR VPWR _0143_ sky130_fd_sc_hd__clkbuf_1
XFILLER_0_10_557 VPWR VGND VPWR VGND sky130_ef_sc_hd__decap_12
X_3213_ _1176_ _1149_ _1177_ VGND VGND VPWR VPWR _1178_ sky130_fd_sc_hd__o21ai_1
XFILLER_0_5_57 VPWR VGND VPWR VGND sky130_ef_sc_hd__decap_12
XFILLER_0_66_65 VPWR VGND VPWR VGND sky130_ef_sc_hd__decap_12
X_4193_ _2038_ VGND VGND VPWR VPWR _0109_ sky130_fd_sc_hd__clkbuf_1
X_3144_ _0890_ _1108_ VGND VGND VPWR VPWR _1109_ sky130_fd_sc_hd__xor2_1
X_3075_ cpu_inst.regfile_inst.registers\[5\]\[13\] cpu_inst.regfile_inst.registers\[4\]\[13\]
+ _0866_ VGND VGND VPWR VPWR _1040_ sky130_fd_sc_hd__mux2_1
XFILLER_0_89_373 VPWR VGND VPWR VGND sky130_ef_sc_hd__decap_12
XFILLER_0_82_53 VPWR VGND VPWR VGND sky130_ef_sc_hd__decap_12
XTAP_TAPCELL_ROW_38_869 VGND VPWR sky130_fd_sc_hd__tapvpwrvgnd_1
XFILLER_0_82_97 VPWR VGND VPWR VGND sky130_ef_sc_hd__decap_12
XTAP_TAPCELL_ROW_18_571 VGND VPWR sky130_fd_sc_hd__tapvpwrvgnd_1
XFILLER_0_49_237 VPWR VGND VPWR VGND sky130_ef_sc_hd__decap_12
XFILLER_0_119_125 VPWR VGND VPWR VGND sky130_ef_sc_hd__decap_12
XTAP_TAPCELL_ROW_102_1831 VGND VPWR sky130_fd_sc_hd__tapvpwrvgnd_1
XFILLER_0_119_169 VPWR VGND VPWR VGND sky130_ef_sc_hd__decap_12
XFILLER_0_92_527 VGND VGND VPWR VPWR sky130_fd_sc_hd__fill_1
X_3977_ _1880_ _1891_ _0686_ VGND VGND VPWR VPWR _1901_ sky130_fd_sc_hd__o21ai_1
XFILLER_0_57_281 VPWR VGND VPWR VGND sky130_ef_sc_hd__decap_12
XFILLER_0_18_613 VPWR VGND VPWR VGND sky130_ef_sc_hd__decap_12
XFILLER_0_135_629 VPWR VGND VPWR VGND sky130_ef_sc_hd__decap_12
XFILLER_0_128_681 VPWR VGND VPWR VGND sky130_ef_sc_hd__decap_12
XFILLER_0_18_657 VPWR VGND VPWR VGND sky130_ef_sc_hd__decap_12
X_2928_ cpu_inst.regfile_inst.registers\[5\]\[2\] cpu_inst.regfile_inst.registers\[4\]\[2\]
+ _0675_ VGND VGND VPWR VPWR _0893_ sky130_fd_sc_hd__mux2_1
XTAP_TAPCELL_ROW_135_2330 VGND VPWR sky130_fd_sc_hd__tapvpwrvgnd_1
XFILLER_0_134_139 VGND VGND VPWR VPWR sky130_fd_sc_hd__fill_1
XFILLER_0_73_774 VGND VGND VPWR VPWR sky130_fd_sc_hd__fill_1
XFILLER_0_72_251 VGND VGND VPWR VPWR sky130_fd_sc_hd__fill_1
XFILLER_0_17_167 VGND VGND VPWR VPWR sky130_fd_sc_hd__fill_1
XFILLER_0_45_476 VGND VGND VPWR VPWR sky130_fd_sc_hd__decap_3
XFILLER_0_130_301 VGND VGND VPWR VPWR sky130_fd_sc_hd__decap_6
XFILLER_0_5_573 VPWR VGND VPWR VGND sky130_ef_sc_hd__decap_12
XFILLER_0_14_841 VGND VGND VPWR VPWR sky130_fd_sc_hd__fill_1
X_2859_ cpu_inst.regfile_inst.registers\[8\]\[9\] _0823_ _0613_ VGND VGND VPWR VPWR
+ _0824_ sky130_fd_sc_hd__mux2_1
X_5578_ clknet_leaf_30_clk _0498_ VGND VGND VPWR VPWR cpu_inst.display_inst.counter\[18\]
+ sky130_fd_sc_hd__dfxtp_1
XFILLER_0_130_345 VPWR VGND VPWR VGND sky130_ef_sc_hd__decap_12
X_4529_ _2212_ VGND VGND VPWR VPWR _0271_ sky130_fd_sc_hd__clkbuf_1
XFILLER_0_13_373 VPWR VGND VPWR VGND sky130_ef_sc_hd__decap_12
XFILLER_0_130_389 VPWR VGND VPWR VGND sky130_ef_sc_hd__decap_12
XTAP_TAPCELL_ROW_113_1993 VGND VPWR sky130_fd_sc_hd__tapvpwrvgnd_1
XFILLER_0_99_137 VPWR VGND VPWR VGND sky130_ef_sc_hd__decap_12
XFILLER_0_83_505 VPWR VGND VPWR VGND sky130_ef_sc_hd__decap_12
XFILLER_0_49_760 VGND VGND VPWR VPWR sky130_fd_sc_hd__decap_3
XFILLER_0_138_445 VGND VGND VPWR VPWR sky130_fd_sc_hd__decap_3
XFILLER_0_36_421 VPWR VGND VPWR VGND sky130_ef_sc_hd__decap_12
XFILLER_0_138_489 VPWR VGND VPWR VGND sky130_ef_sc_hd__decap_12
XFILLER_0_107_821 VPWR VGND VPWR VGND sky130_ef_sc_hd__decap_12
XFILLER_0_102_29 VPWR VGND VPWR VGND sky130_ef_sc_hd__decap_12
XFILLER_0_63_273 VGND VGND VPWR VPWR sky130_fd_sc_hd__decap_6
XFILLER_0_11_27 VPWR VGND VPWR VGND sky130_ef_sc_hd__decap_12
XFILLER_0_122_813 VPWR VGND VPWR VGND sky130_ef_sc_hd__decap_12
XFILLER_0_23_137 VPWR VGND VPWR VGND sky130_ef_sc_hd__decap_12
XFILLER_0_51_424 VGND VGND VPWR VPWR sky130_fd_sc_hd__decap_3
XFILLER_0_133_161 VGND VGND VPWR VPWR sky130_fd_sc_hd__decap_6
XTAP_TAPCELL_ROW_75_1432 VGND VPWR sky130_fd_sc_hd__tapvpwrvgnd_1
XTAP_TAPCELL_ROW_75_1421 VGND VPWR sky130_fd_sc_hd__tapvpwrvgnd_1
XFILLER_0_20_811 VGND VGND VPWR VPWR sky130_fd_sc_hd__fill_1
XFILLER_0_31_181 VPWR VGND VPWR VGND sky130_ef_sc_hd__decap_12
XFILLER_0_127_15 VPWR VGND VPWR VGND sky130_ef_sc_hd__decap_12
XFILLER_0_86_321 VPWR VGND VPWR VGND sky130_ef_sc_hd__decap_12
XTAP_TAPCELL_ROW_86_1583 VGND VPWR sky130_fd_sc_hd__tapvpwrvgnd_1
XTAP_TAPCELL_ROW_35_828 VGND VPWR sky130_fd_sc_hd__tapvpwrvgnd_1
X_4880_ cpu_inst.regfile_inst.registers\[9\]\[26\] VGND VGND VPWR VPWR _2425_ sky130_fd_sc_hd__clkbuf_1
XTAP_TAPCELL_ROW_86_1594 VGND VPWR sky130_fd_sc_hd__tapvpwrvgnd_1
XFILLER_0_86_365 VPWR VGND VPWR VGND sky130_ef_sc_hd__decap_12
X_3900_ _1826_ _1819_ VGND VGND VPWR VPWR _1827_ sky130_fd_sc_hd__xnor2_1
X_3831_ _1088_ _1753_ _1759_ VGND VGND VPWR VPWR _1760_ sky130_fd_sc_hd__o21ai_2
XTAP_TAPCELL_ROW_15_530 VGND VPWR sky130_fd_sc_hd__tapvpwrvgnd_1
XFILLER_0_117_629 VPWR VGND VPWR VGND sky130_ef_sc_hd__decap_12
X_3762_ _1692_ cpu_inst.regfile_inst.registers\[6\]\[24\] _1609_ VGND VGND VPWR VPWR
+ _1693_ sky130_fd_sc_hd__mux2_1
XFILLER_0_39_281 VPWR VGND VPWR VGND sky130_ef_sc_hd__decap_12
XFILLER_0_116_139 VGND VGND VPWR VPWR sky130_fd_sc_hd__fill_1
XFILLER_0_82_571 VGND VGND VPWR VPWR sky130_fd_sc_hd__fill_1
XFILLER_0_70_722 VGND VGND VPWR VPWR sky130_fd_sc_hd__decap_6
XFILLER_0_70_711 VGND VGND VPWR VPWR sky130_fd_sc_hd__decap_4
XFILLER_0_55_785 VGND VGND VPWR VPWR sky130_fd_sc_hd__fill_1
XFILLER_0_54_251 VGND VGND VPWR VPWR sky130_fd_sc_hd__fill_1
X_5501_ clknet_leaf_35_clk _0421_ VGND VGND VPWR VPWR cpu_inst.regfile_inst.registers\[8\]\[5\]
+ sky130_fd_sc_hd__dfxtp_1
XFILLER_0_125_673 VPWR VGND VPWR VGND sky130_ef_sc_hd__decap_12
XTAP_TAPCELL_ROW_117_2060 VGND VPWR sky130_fd_sc_hd__tapvpwrvgnd_1
X_3693_ cpu_inst.regfile_inst.registers\[1\]\[23\] _1469_ _1470_ cpu_inst.regfile_inst.registers\[5\]\[23\]
+ VGND VGND VPWR VPWR _1625_ sky130_fd_sc_hd__o22a_1
X_2713_ cpu_inst.regfile_inst.registers\[10\]\[0\] _0674_ _0657_ _0677_ VGND VGND
+ VPWR VPWR _0678_ sky130_fd_sc_hd__a211o_1
XFILLER_0_112_301 VGND VGND VPWR VPWR sky130_fd_sc_hd__decap_6
XFILLER_0_70_788 VGND VGND VPWR VPWR sky130_fd_sc_hd__fill_1
X_2644_ cpu_inst.decoder_inst.current_pc\[1\] cpu_inst.decoder_inst.current_pc\[2\]
+ _0521_ VGND VGND VPWR VPWR _0609_ sky130_fd_sc_hd__and3b_1
X_5432_ clknet_leaf_42_clk _0352_ net2 VGND VGND VPWR VPWR cpu_inst.decoder_inst.current_pc\[1\]
+ sky130_fd_sc_hd__dfrtp_2
XFILLER_0_112_345 VPWR VGND VPWR VGND sky130_ef_sc_hd__decap_12
XFILLER_0_100_507 VPWR VGND VPWR VGND sky130_ef_sc_hd__decap_12
X_5363_ clknet_leaf_8_clk _0283_ VGND VGND VPWR VPWR cpu_inst.regfile_inst.registers\[11\]\[27\]
+ sky130_fd_sc_hd__dfxtp_1
XFILLER_0_11_833 VGND VGND VPWR VPWR sky130_fd_sc_hd__decap_6
XFILLER_0_23_671 VGND VGND VPWR VPWR sky130_fd_sc_hd__fill_1
X_2575_ _0511_ VGND VGND VPWR VPWR _0540_ sky130_fd_sc_hd__inv_2
XFILLER_0_112_389 VPWR VGND VPWR VGND sky130_ef_sc_hd__decap_12
XFILLER_0_10_321 VPWR VGND VPWR VGND sky130_ef_sc_hd__decap_12
XFILLER_0_2_587 VGND VGND VPWR VPWR sky130_fd_sc_hd__fill_1
X_4314_ _2101_ VGND VGND VPWR VPWR _0167_ sky130_fd_sc_hd__clkbuf_1
X_5294_ clknet_leaf_15_clk _0214_ VGND VGND VPWR VPWR cpu_inst.regfile_inst.registers\[1\]\[22\]
+ sky130_fd_sc_hd__dfxtp_1
XFILLER_0_10_365 VPWR VGND VPWR VGND sky130_ef_sc_hd__decap_12
X_4245_ cpu_inst.regfile_inst.registers\[24\]\[7\] VGND VGND VPWR VPWR _2065_ sky130_fd_sc_hd__clkbuf_1
X_4176_ _2029_ VGND VGND VPWR VPWR _0101_ sky130_fd_sc_hd__clkbuf_1
X_3127_ _0573_ VGND VGND VPWR VPWR _1092_ sky130_fd_sc_hd__clkbuf_4
XFILLER_0_117_81 VPWR VGND VPWR VGND sky130_ef_sc_hd__decap_12
XFILLER_0_89_181 VPWR VGND VPWR VGND sky130_ef_sc_hd__decap_12
X_3058_ cpu_inst.regfile_inst.registers\[25\]\[12\] _1022_ _0921_ _0877_ VGND VGND
+ VPWR VPWR _1023_ sky130_fd_sc_hd__o211a_1
XFILLER_0_65_505 VPWR VGND VPWR VGND sky130_ef_sc_hd__decap_12
XFILLER_0_92_357 VGND VGND VPWR VPWR sky130_fd_sc_hd__decap_6
XFILLER_0_18_421 VPWR VGND VPWR VGND sky130_ef_sc_hd__decap_12
XFILLER_0_61_700 VGND VGND VPWR VPWR sky130_fd_sc_hd__fill_2
XFILLER_0_45_273 VGND VGND VPWR VPWR sky130_fd_sc_hd__decap_6
XFILLER_0_122_109 VPWR VGND VPWR VGND sky130_ef_sc_hd__decap_12
XFILLER_0_104_813 VPWR VGND VPWR VGND sky130_ef_sc_hd__decap_12
XFILLER_0_60_221 VPWR VGND VPWR VGND sky130_ef_sc_hd__decap_12
XFILLER_0_115_161 VGND VGND VPWR VPWR sky130_fd_sc_hd__decap_6
XFILLER_0_60_265 VPWR VGND VPWR VGND sky130_ef_sc_hd__decap_12
XFILLER_0_33_457 VGND VGND VPWR VPWR sky130_fd_sc_hd__fill_2
XFILLER_0_131_665 VGND VGND VPWR VPWR sky130_fd_sc_hd__decap_6
XFILLER_0_14_693 VGND VGND VPWR VPWR sky130_fd_sc_hd__decap_6
XFILLER_0_130_153 VPWR VGND VPWR VGND sky130_ef_sc_hd__decap_12
XTAP_TAPCELL_ROW_57_1162 VGND VPWR sky130_fd_sc_hd__tapvpwrvgnd_1
XTAP_TAPCELL_ROW_57_1151 VGND VPWR sky130_fd_sc_hd__tapvpwrvgnd_1
XFILLER_0_13_181 VPWR VGND VPWR VGND sky130_ef_sc_hd__decap_12
XFILLER_0_130_197 VPWR VGND VPWR VGND sky130_ef_sc_hd__decap_12
XTAP_TAPCELL_ROW_70_1351 VGND VPWR sky130_fd_sc_hd__tapvpwrvgnd_1
XFILLER_0_88_619 VGND VGND VPWR VPWR sky130_fd_sc_hd__fill_1
XFILLER_0_56_549 VGND VGND VPWR VPWR sky130_fd_sc_hd__fill_1
XFILLER_0_22_15 VPWR VGND VPWR VGND sky130_ef_sc_hd__decap_12
XFILLER_0_138_253 VPWR VGND VPWR VGND sky130_ef_sc_hd__decap_12
XFILLER_0_113_39 VPWR VGND VPWR VGND sky130_ef_sc_hd__decap_12
XFILLER_0_83_335 VGND VGND VPWR VPWR sky130_fd_sc_hd__fill_1
XFILLER_0_37_741 VPWR VGND VPWR VGND sky130_ef_sc_hd__decap_12
XFILLER_0_36_251 VGND VGND VPWR VPWR sky130_fd_sc_hd__fill_1
XFILLER_0_107_673 VPWR VGND VPWR VGND sky130_ef_sc_hd__decap_12
XFILLER_0_107_662 VGND VGND VPWR VPWR sky130_fd_sc_hd__decap_8
XFILLER_0_52_755 VGND VGND VPWR VPWR sky130_fd_sc_hd__fill_1
XFILLER_0_24_413 VGND VGND VPWR VPWR sky130_fd_sc_hd__decap_6
XTAP_TAPCELL_ROW_40_897 VGND VPWR sky130_fd_sc_hd__tapvpwrvgnd_1
XFILLER_0_3_329 VGND VGND VPWR VPWR sky130_fd_sc_hd__decap_6
XFILLER_0_24_457 VPWR VGND VPWR VGND sky130_ef_sc_hd__decap_12
XFILLER_0_122_643 VGND VGND VPWR VPWR sky130_fd_sc_hd__fill_1
XFILLER_0_110_805 VGND VGND VPWR VPWR sky130_fd_sc_hd__decap_6
XFILLER_0_138_69 VPWR VGND VPWR VGND sky130_ef_sc_hd__decap_12
XPHY_EDGE_ROW_10_Right_10 VGND VGND VPWR VPWR sky130_fd_sc_hd__decap_3
X_4030_ cpu_inst.regfile_inst.registers\[2\]\[2\] VGND VGND VPWR VPWR _1951_ sky130_fd_sc_hd__clkbuf_1
XTAP_TAPCELL_ROW_88_1623 VGND VPWR sky130_fd_sc_hd__tapvpwrvgnd_1
XFILLER_0_87_630 VGND VGND VPWR VPWR sky130_fd_sc_hd__decap_8
XFILLER_0_63_55 VGND VGND VPWR VPWR sky130_fd_sc_hd__fill_1
XFILLER_0_59_321 VGND VGND VPWR VPWR sky130_fd_sc_hd__fill_2
XFILLER_0_75_803 VGND VGND VPWR VPWR sky130_fd_sc_hd__fill_2
X_4932_ _2453_ VGND VGND VPWR VPWR _0433_ sky130_fd_sc_hd__clkbuf_1
XFILLER_0_47_505 VGND VGND VPWR VPWR sky130_fd_sc_hd__fill_1
XFILLER_0_59_387 VGND VGND VPWR VPWR sky130_fd_sc_hd__fill_1
XFILLER_0_59_376 VGND VGND VPWR VPWR sky130_fd_sc_hd__decap_4
XFILLER_0_86_195 VGND VGND VPWR VPWR sky130_fd_sc_hd__fill_1
XFILLER_0_74_357 VGND VGND VPWR VPWR sky130_fd_sc_hd__decap_6
X_4863_ _2416_ VGND VGND VPWR VPWR _0401_ sky130_fd_sc_hd__clkbuf_1
X_3814_ cpu_inst.regfile_inst.registers\[11\]\[26\] cpu_inst.regfile_inst.registers\[10\]\[26\]
+ _1592_ VGND VGND VPWR VPWR _1743_ sky130_fd_sc_hd__mux2_1
X_4794_ cpu_inst.regfile_inst.registers\[0\]\[15\] VGND VGND VPWR VPWR _2382_ sky130_fd_sc_hd__clkbuf_1
XTAP_TAPCELL_ROW_115_2019 VGND VPWR sky130_fd_sc_hd__tapvpwrvgnd_1
XFILLER_0_104_109 VPWR VGND VPWR VGND sky130_ef_sc_hd__decap_12
X_3745_ _0610_ _1675_ VGND VGND VPWR VPWR _1676_ sky130_fd_sc_hd__or2_1
XFILLER_0_27_273 VGND VGND VPWR VPWR sky130_fd_sc_hd__decap_6
XFILLER_0_42_221 VPWR VGND VPWR VGND sky130_ef_sc_hd__decap_12
XFILLER_0_43_722 VGND VGND VPWR VPWR sky130_fd_sc_hd__fill_1
XTAP_TAPCELL_ROW_99_1785 VGND VPWR sky130_fd_sc_hd__tapvpwrvgnd_1
XFILLER_0_70_541 VGND VGND VPWR VPWR sky130_fd_sc_hd__decap_6
XFILLER_0_6_189 VGND VGND VPWR VPWR sky130_fd_sc_hd__decap_6
XFILLER_0_113_665 VGND VGND VPWR VPWR sky130_fd_sc_hd__decap_6
XFILLER_0_88_41 VPWR VGND VPWR VGND sky130_ef_sc_hd__decap_12
X_3676_ _1299_ VGND VGND VPWR VPWR _1609_ sky130_fd_sc_hd__buf_4
X_5415_ clknet_leaf_4_clk _0335_ net2 VGND VGND VPWR VPWR cpu_inst.decoder_inst.current_pc\[15\]
+ sky130_fd_sc_hd__dfrtp_1
XFILLER_0_70_585 VGND VGND VPWR VPWR sky130_fd_sc_hd__decap_3
XFILLER_0_3_841 VGND VGND VPWR VPWR sky130_fd_sc_hd__fill_1
XFILLER_0_42_265 VPWR VGND VPWR VGND sky130_ef_sc_hd__decap_12
XFILLER_0_43_799 VGND VGND VPWR VPWR sky130_fd_sc_hd__fill_1
XFILLER_0_112_153 VPWR VGND VPWR VGND sky130_ef_sc_hd__decap_12
XFILLER_0_88_85 VPWR VGND VPWR VGND sky130_ef_sc_hd__decap_12
XFILLER_0_63_3 VPWR VGND VPWR VGND sky130_ef_sc_hd__decap_12
XFILLER_0_11_641 VPWR VGND VPWR VGND sky130_ef_sc_hd__decap_12
X_2627_ _0591_ VGND VGND VPWR VPWR _0592_ sky130_fd_sc_hd__buf_2
XFILLER_0_112_197 VPWR VGND VPWR VGND sky130_ef_sc_hd__decap_12
XFILLER_0_11_685 VPWR VGND VPWR VGND sky130_ef_sc_hd__decap_12
X_5346_ clknet_leaf_32_clk _0266_ VGND VGND VPWR VPWR cpu_inst.regfile_inst.registers\[11\]\[10\]
+ sky130_fd_sc_hd__dfxtp_1
X_2558_ _0522_ VGND VGND VPWR VPWR _0523_ sky130_fd_sc_hd__buf_2
XFILLER_0_10_195 VGND VGND VPWR VPWR sky130_fd_sc_hd__fill_1
X_5277_ clknet_leaf_35_clk _0197_ VGND VGND VPWR VPWR cpu_inst.regfile_inst.registers\[1\]\[5\]
+ sky130_fd_sc_hd__dfxtp_1
XTAP_TAPCELL_ROW_110_1952 VGND VPWR sky130_fd_sc_hd__tapvpwrvgnd_1
X_4228_ _2056_ VGND VGND VPWR VPWR _0126_ sky130_fd_sc_hd__clkbuf_1
XTAP_TAPCELL_ROW_52_1081 VGND VPWR sky130_fd_sc_hd__tapvpwrvgnd_1
XPHY_EDGE_ROW_106_Right_106 VGND VGND VPWR VPWR sky130_fd_sc_hd__decap_3
X_4159_ _2019_ VGND VGND VPWR VPWR _0094_ sky130_fd_sc_hd__clkbuf_1
XFILLER_0_97_449 VGND VGND VPWR VPWR sky130_fd_sc_hd__fill_1
Xclkbuf_leaf_35_clk clknet_2_2__leaf_clk VGND VGND VPWR VPWR clknet_leaf_35_clk sky130_fd_sc_hd__clkbuf_8
XFILLER_0_136_713 VPWR VGND VPWR VGND sky130_ef_sc_hd__decap_12
XFILLER_0_92_121 VPWR VGND VPWR VGND sky130_ef_sc_hd__decap_12
XFILLER_0_19_741 VPWR VGND VPWR VGND sky130_ef_sc_hd__decap_12
XFILLER_0_136_757 VPWR VGND VPWR VGND sky130_ef_sc_hd__decap_12
XFILLER_0_135_223 VGND VGND VPWR VPWR sky130_fd_sc_hd__fill_1
XFILLER_0_92_165 VPWR VGND VPWR VGND sky130_ef_sc_hd__decap_12
XFILLER_0_81_839 VGND VGND VPWR VPWR sky130_fd_sc_hd__fill_1
XFILLER_0_18_251 VGND VGND VPWR VPWR sky130_fd_sc_hd__fill_1
XFILLER_0_19_785 VPWR VGND VPWR VGND sky130_ef_sc_hd__decap_12
XFILLER_0_46_593 VPWR VGND VPWR VGND sky130_ef_sc_hd__decap_12
XFILLER_0_123_429 VPWR VGND VPWR VGND sky130_ef_sc_hd__decap_12
XFILLER_0_34_755 VGND VGND VPWR VPWR sky130_fd_sc_hd__fill_1
XFILLER_0_21_405 VPWR VGND VPWR VGND sky130_ef_sc_hd__decap_12
XFILLER_0_131_473 VPWR VGND VPWR VGND sky130_ef_sc_hd__decap_12
XFILLER_0_21_449 VPWR VGND VPWR VGND sky130_ef_sc_hd__decap_12
XTAP_TAPCELL_ROW_6_394 VGND VPWR sky130_fd_sc_hd__tapvpwrvgnd_1
XTAP_TAPCELL_ROW_6_383 VGND VPWR sky130_fd_sc_hd__tapvpwrvgnd_1
XFILLER_0_17_15 VPWR VGND VPWR VGND sky130_ef_sc_hd__decap_12
XFILLER_0_124_27 VGND VGND VPWR VPWR sky130_fd_sc_hd__fill_1
XFILLER_0_96_471 VGND VGND VPWR VPWR sky130_fd_sc_hd__decap_4
XTAP_TAPCELL_ROW_83_1542 VGND VPWR sky130_fd_sc_hd__tapvpwrvgnd_1
Xclkbuf_leaf_26_clk clknet_2_2__leaf_clk VGND VGND VPWR VPWR clknet_leaf_26_clk sky130_fd_sc_hd__clkbuf_8
XFILLER_0_29_505 VGND VGND VPWR VPWR sky130_fd_sc_hd__decap_6
XTAP_TAPCELL_ROW_45_978 VGND VPWR sky130_fd_sc_hd__tapvpwrvgnd_1
XFILLER_0_84_633 VGND VGND VPWR VPWR sky130_fd_sc_hd__decap_3
XFILLER_0_68_195 VGND VGND VPWR VPWR sky130_fd_sc_hd__fill_1
XFILLER_0_33_69 VPWR VGND VPWR VGND sky130_ef_sc_hd__decap_12
XFILLER_0_71_305 VGND VGND VPWR VPWR sky130_fd_sc_hd__decap_3
XTAP_TAPCELL_ROW_25_680 VGND VPWR sky130_fd_sc_hd__tapvpwrvgnd_1
XFILLER_0_126_245 VGND VGND VPWR VPWR sky130_fd_sc_hd__decap_6
XFILLER_0_24_221 VPWR VGND VPWR VGND sky130_ef_sc_hd__decap_12
XFILLER_0_126_289 VPWR VGND VPWR VGND sky130_ef_sc_hd__decap_12
X_3530_ _1405_ _1440_ _1369_ VGND VGND VPWR VPWR _1466_ sky130_fd_sc_hd__or3b_1
XFILLER_0_25_777 VGND VGND VPWR VPWR sky130_fd_sc_hd__decap_6
XFILLER_0_3_137 VPWR VGND VPWR VGND sky130_ef_sc_hd__decap_12
XFILLER_0_24_265 VPWR VGND VPWR VGND sky130_ef_sc_hd__decap_12
XFILLER_0_110_613 VPWR VGND VPWR VGND sky130_ef_sc_hd__decap_12
X_3461_ cpu_inst.regfile_inst.registers\[1\]\[17\] _0726_ _0730_ cpu_inst.regfile_inst.registers\[5\]\[17\]
+ _0732_ VGND VGND VPWR VPWR _1399_ sky130_fd_sc_hd__o221a_1
XFILLER_0_110_657 VPWR VGND VPWR VGND sky130_ef_sc_hd__decap_12
X_5200_ clknet_leaf_9_clk _0120_ VGND VGND VPWR VPWR cpu_inst.regfile_inst.registers\[4\]\[24\]
+ sky130_fd_sc_hd__dfxtp_1
X_3392_ _1337_ VGND VGND VPWR VPWR _0009_ sky130_fd_sc_hd__clkbuf_1
X_5131_ clknet_leaf_18_clk _0051_ VGND VGND VPWR VPWR cpu_inst.regfile_inst.registers\[2\]\[19\]
+ sky130_fd_sc_hd__dfxtp_1
XFILLER_0_58_77 VGND VGND VPWR VPWR sky130_fd_sc_hd__decap_6
X_5062_ cpu_inst.display_inst.counter\[11\] cpu_inst.display_inst.counter\[13\] cpu_inst.display_inst.counter\[12\]
+ _2520_ VGND VGND VPWR VPWR _2524_ sky130_fd_sc_hd__and4_1
X_4013_ _0945_ _0935_ _1317_ VGND VGND VPWR VPWR _1936_ sky130_fd_sc_hd__mux2_1
XFILLER_0_74_65 VPWR VGND VPWR VGND sky130_ef_sc_hd__decap_12
XTAP_TAPCELL_ROW_125_2170 VGND VPWR sky130_fd_sc_hd__tapvpwrvgnd_1
XFILLER_0_79_449 VGND VGND VPWR VPWR sky130_fd_sc_hd__decap_6
XTAP_TAPCELL_ROW_125_2181 VGND VPWR sky130_fd_sc_hd__tapvpwrvgnd_1
Xclkbuf_leaf_17_clk clknet_2_3__leaf_clk VGND VGND VPWR VPWR clknet_leaf_17_clk sky130_fd_sc_hd__clkbuf_8
XFILLER_0_90_53 VPWR VGND VPWR VGND sky130_ef_sc_hd__decap_12
XFILLER_0_48_825 VPWR VGND VPWR VGND sky130_ef_sc_hd__decap_12
XFILLER_0_118_713 VPWR VGND VPWR VGND sky130_ef_sc_hd__decap_12
XFILLER_0_90_97 VPWR VGND VPWR VGND sky130_ef_sc_hd__decap_12
XFILLER_0_74_121 VPWR VGND VPWR VGND sky130_ef_sc_hd__decap_12
XTAP_TAPCELL_ROW_23_639 VGND VPWR sky130_fd_sc_hd__tapvpwrvgnd_1
X_4915_ _2444_ VGND VGND VPWR VPWR _0425_ sky130_fd_sc_hd__clkbuf_1
XFILLER_0_47_335 VGND VGND VPWR VPWR sky130_fd_sc_hd__fill_1
XFILLER_0_118_757 VPWR VGND VPWR VGND sky130_ef_sc_hd__decap_12
XFILLER_0_117_223 VGND VGND VPWR VPWR sky130_fd_sc_hd__fill_1
XFILLER_0_75_688 VGND VGND VPWR VPWR sky130_fd_sc_hd__fill_1
XFILLER_0_75_666 VGND VGND VPWR VPWR sky130_fd_sc_hd__decap_6
XFILLER_0_74_165 VPWR VGND VPWR VGND sky130_ef_sc_hd__decap_12
XFILLER_0_63_817 VGND VGND VPWR VPWR sky130_fd_sc_hd__decap_4
X_4846_ cpu_inst.regfile_inst.registers\[9\]\[9\] VGND VGND VPWR VPWR _2408_ sky130_fd_sc_hd__clkbuf_1
XFILLER_0_133_727 VGND VGND VPWR VPWR sky130_fd_sc_hd__fill_1
XFILLER_0_105_429 VGND VGND VPWR VPWR sky130_fd_sc_hd__decap_6
XFILLER_0_99_51 VGND VGND VPWR VPWR sky130_fd_sc_hd__decap_4
XFILLER_0_16_755 VGND VGND VPWR VPWR sky130_fd_sc_hd__fill_1
X_4777_ _2373_ VGND VGND VPWR VPWR _0358_ sky130_fd_sc_hd__clkbuf_1
X_3728_ _1658_ cpu_inst.regfile_inst.registers\[10\]\[24\] _1312_ VGND VGND VPWR VPWR
+ _1659_ sky130_fd_sc_hd__mux2_1
XFILLER_0_113_473 VPWR VGND VPWR VGND sky130_ef_sc_hd__decap_12
X_3659_ _0731_ VGND VGND VPWR VPWR _1592_ sky130_fd_sc_hd__buf_4
XFILLER_0_3_671 VGND VGND VPWR VPWR sky130_fd_sc_hd__fill_1
XTAP_TAPCELL_ROW_54_1110 VGND VPWR sky130_fd_sc_hd__tapvpwrvgnd_1
X_5329_ clknet_leaf_9_clk _0249_ VGND VGND VPWR VPWR cpu_inst.regfile_inst.registers\[7\]\[25\]
+ sky130_fd_sc_hd__dfxtp_1
XFILLER_0_100_189 VGND VGND VPWR VPWR sky130_fd_sc_hd__decap_6
XTAP_TAPCELL_ROW_3_342 VGND VPWR sky130_fd_sc_hd__tapvpwrvgnd_1
XFILLER_0_97_279 VGND VGND VPWR VPWR sky130_fd_sc_hd__fill_1
XTAP_TAPCELL_ROW_65_1272 VGND VPWR sky130_fd_sc_hd__tapvpwrvgnd_1
XTAP_TAPCELL_ROW_42_926 VGND VPWR sky130_fd_sc_hd__tapvpwrvgnd_1
XTAP_TAPCELL_ROW_42_937 VGND VPWR sky130_fd_sc_hd__tapvpwrvgnd_1
XFILLER_0_81_603 VGND VGND VPWR VPWR sky130_fd_sc_hd__decap_3
XFILLER_0_53_305 VPWR VGND VPWR VGND sky130_ef_sc_hd__decap_12
XFILLER_0_38_357 VGND VGND VPWR VPWR sky130_fd_sc_hd__decap_6
XFILLER_0_108_245 VGND VGND VPWR VPWR sky130_fd_sc_hd__decap_6
XFILLER_0_93_496 VGND VGND VPWR VPWR sky130_fd_sc_hd__decap_4
XFILLER_0_81_625 VGND VGND VPWR VPWR sky130_fd_sc_hd__decap_3
XFILLER_0_136_587 VGND VGND VPWR VPWR sky130_fd_sc_hd__fill_1
XFILLER_0_124_749 VGND VGND VPWR VPWR sky130_fd_sc_hd__decap_6
XFILLER_0_108_289 VPWR VGND VPWR VGND sky130_ef_sc_hd__decap_12
XFILLER_0_34_530 VGND VGND VPWR VPWR sky130_fd_sc_hd__fill_2
XFILLER_0_123_237 VPWR VGND VPWR VGND sky130_ef_sc_hd__decap_12
XFILLER_0_110_29 VPWR VGND VPWR VGND sky130_ef_sc_hd__decap_12
XFILLER_0_22_725 VPWR VGND VPWR VGND sky130_ef_sc_hd__decap_12
XFILLER_0_104_473 VGND VGND VPWR VPWR sky130_fd_sc_hd__decap_3
XFILLER_0_22_769 VPWR VGND VPWR VGND sky130_ef_sc_hd__decap_12
XFILLER_0_132_793 VPWR VGND VPWR VGND sky130_ef_sc_hd__decap_12
XFILLER_0_131_281 VPWR VGND VPWR VGND sky130_ef_sc_hd__decap_12
XFILLER_0_21_279 VGND VGND VPWR VPWR sky130_fd_sc_hd__fill_1
XFILLER_0_119_27 VPWR VGND VPWR VGND sky130_ef_sc_hd__decap_12
XFILLER_0_89_703 VGND VGND VPWR VPWR sky130_fd_sc_hd__fill_1
XFILLER_0_135_15 VPWR VGND VPWR VGND sky130_ef_sc_hd__decap_12
XFILLER_0_56_121 VPWR VGND VPWR VGND sky130_ef_sc_hd__decap_12
XFILLER_0_29_335 VGND VGND VPWR VPWR sky130_fd_sc_hd__fill_1
X_2961_ cpu_inst.regfile_inst.registers\[9\]\[5\] cpu_inst.regfile_inst.registers\[8\]\[5\]
+ _0866_ VGND VGND VPWR VPWR _0926_ sky130_fd_sc_hd__mux2_1
X_4700_ _2320_ _2321_ VGND VGND VPWR VPWR _2322_ sky130_fd_sc_hd__nor2_1
XFILLER_0_56_165 VPWR VGND VPWR VGND sky130_ef_sc_hd__decap_12
XFILLER_0_121_3 VPWR VGND VPWR VGND sky130_ef_sc_hd__decap_12
X_2892_ _0844_ _0847_ _0851_ _0856_ VGND VGND VPWR VPWR _0857_ sky130_fd_sc_hd__o22a_1
XFILLER_0_71_113 VPWR VGND VPWR VGND sky130_ef_sc_hd__decap_12
X_4631_ cpu_inst.display_inst.counter\[17\] cpu_inst.display_inst.counter\[19\] cpu_inst.display_inst.counter\[18\]
+ cpu_inst.display_inst.counter\[16\] VGND VGND VPWR VPWR _2266_ sky130_fd_sc_hd__or4b_1
XFILLER_0_45_839 VGND VGND VPWR VPWR sky130_fd_sc_hd__fill_1
XFILLER_0_115_727 VGND VGND VPWR VPWR sky130_fd_sc_hd__fill_1
XFILLER_0_4_413 VGND VGND VPWR VPWR sky130_fd_sc_hd__decap_6
XTAP_TAPCELL_ROW_96_1744 VGND VPWR sky130_fd_sc_hd__tapvpwrvgnd_1
XTAP_TAPCELL_ROW_96_1733 VGND VPWR sky130_fd_sc_hd__tapvpwrvgnd_1
XFILLER_0_4_457 VPWR VGND VPWR VGND sky130_ef_sc_hd__decap_12
X_4562_ _0554_ _2022_ VGND VGND VPWR VPWR _2229_ sky130_fd_sc_hd__or2_2
X_4493_ _2194_ VGND VGND VPWR VPWR _0253_ sky130_fd_sc_hd__clkbuf_1
X_3513_ cpu_inst.regfile_inst.registers\[25\]\[18\] _1252_ _1449_ _1427_ VGND VGND
+ VPWR VPWR _1450_ sky130_fd_sc_hd__o211ai_2
XFILLER_0_69_43 VPWR VGND VPWR VGND sky130_ef_sc_hd__decap_12
XFILLER_0_25_596 VGND VGND VPWR VPWR sky130_fd_sc_hd__decap_4
XFILLER_0_40_533 VGND VGND VPWR VPWR sky130_fd_sc_hd__decap_3
XFILLER_0_40_555 VPWR VGND VPWR VGND sky130_ef_sc_hd__decap_12
XFILLER_0_110_421 VPWR VGND VPWR VGND sky130_ef_sc_hd__decap_12
Xclkbuf_leaf_6_clk clknet_2_1__leaf_clk VGND VGND VPWR VPWR clknet_leaf_6_clk sky130_fd_sc_hd__clkbuf_8
X_3444_ _1382_ cpu_inst.regfile_inst.registers\[6\]\[16\] _1339_ VGND VGND VPWR VPWR
+ _1383_ sky130_fd_sc_hd__mux2_1
XFILLER_0_0_641 VGND VGND VPWR VPWR sky130_fd_sc_hd__decap_3
X_3375_ _0687_ _1086_ _1324_ _0684_ VGND VGND VPWR VPWR _1325_ sky130_fd_sc_hd__a2bb2o_1
XFILLER_0_0_685 VPWR VGND VPWR VGND sky130_ef_sc_hd__decap_12
XTAP_TAPCELL_ROW_127_2210 VGND VPWR sky130_fd_sc_hd__tapvpwrvgnd_1
X_5114_ clknet_leaf_38_clk _0034_ VGND VGND VPWR VPWR cpu_inst.regfile_inst.registers\[2\]\[2\]
+ sky130_fd_sc_hd__dfxtp_1
XFILLER_0_109_93 VPWR VGND VPWR VGND sky130_ef_sc_hd__decap_12
X_5045_ _2512_ _2513_ VGND VGND VPWR VPWR _0486_ sky130_fd_sc_hd__nor2_1
XTAP_TAPCELL_ROW_0_301 VGND VPWR sky130_fd_sc_hd__tapvpwrvgnd_1
XFILLER_0_26_3 VPWR VGND VPWR VGND sky130_ef_sc_hd__decap_12
XFILLER_0_79_279 VGND VGND VPWR VPWR sky130_fd_sc_hd__fill_1
XFILLER_0_125_81 VPWR VGND VPWR VGND sky130_ef_sc_hd__decap_12
XTAP_TAPCELL_ROW_105_1873 VGND VPWR sky130_fd_sc_hd__tapvpwrvgnd_1
XFILLER_0_137_329 VGND VGND VPWR VPWR sky130_fd_sc_hd__decap_6
XFILLER_0_35_305 VPWR VGND VPWR VGND sky130_ef_sc_hd__decap_12
XFILLER_0_48_699 VGND VGND VPWR VPWR sky130_fd_sc_hd__fill_1
XTAP_TAPCELL_ROW_138_2383 VGND VPWR sky130_fd_sc_hd__tapvpwrvgnd_1
XTAP_TAPCELL_ROW_138_2372 VGND VPWR sky130_fd_sc_hd__tapvpwrvgnd_1
XFILLER_0_118_587 VGND VGND VPWR VPWR sky130_fd_sc_hd__fill_1
XFILLER_0_106_749 VGND VGND VPWR VPWR sky130_fd_sc_hd__decap_6
XFILLER_0_7_273 VGND VGND VPWR VPWR sky130_fd_sc_hd__decap_6
XFILLER_0_35_349 VPWR VGND VPWR VGND sky130_ef_sc_hd__decap_12
X_4829_ _2399_ VGND VGND VPWR VPWR _0384_ sky130_fd_sc_hd__clkbuf_1
XFILLER_0_105_237 VPWR VGND VPWR VGND sky130_ef_sc_hd__decap_12
XFILLER_0_90_477 VGND VGND VPWR VPWR sky130_fd_sc_hd__decap_8
XFILLER_0_43_393 VPWR VGND VPWR VGND sky130_ef_sc_hd__decap_12
XFILLER_0_114_793 VPWR VGND VPWR VGND sky130_ef_sc_hd__decap_12
XFILLER_0_113_281 VPWR VGND VPWR VGND sky130_ef_sc_hd__decap_12
XFILLER_0_101_443 VGND VGND VPWR VPWR sky130_fd_sc_hd__decap_4
XTAP_TAPCELL_ROW_8_423 VGND VPWR sky130_fd_sc_hd__tapvpwrvgnd_1
XFILLER_0_31_599 VGND VGND VPWR VPWR sky130_fd_sc_hd__fill_1
XTAP_TAPCELL_ROW_67_1301 VGND VPWR sky130_fd_sc_hd__tapvpwrvgnd_1
XTAP_TAPCELL_ROW_67_1312 VGND VPWR sky130_fd_sc_hd__tapvpwrvgnd_1
XFILLER_0_85_205 VPWR VGND VPWR VGND sky130_ef_sc_hd__decap_12
XFILLER_0_58_419 VGND VGND VPWR VPWR sky130_fd_sc_hd__fill_1
XFILLER_0_58_408 VGND VGND VPWR VPWR sky130_fd_sc_hd__fill_2
XFILLER_0_14_27 VGND VGND VPWR VPWR sky130_fd_sc_hd__fill_1
XFILLER_0_128_307 VGND VGND VPWR VPWR sky130_fd_sc_hd__fill_1
XFILLER_0_85_249 VPWR VGND VPWR VGND sky130_ef_sc_hd__decap_12
XTAP_TAPCELL_ROW_80_1501 VGND VPWR sky130_fd_sc_hd__tapvpwrvgnd_1
XFILLER_0_38_121 VPWR VGND VPWR VGND sky130_ef_sc_hd__decap_12
XFILLER_0_39_633 VGND VGND VPWR VPWR sky130_fd_sc_hd__decap_3
XFILLER_0_137_841 VGND VGND VPWR VPWR sky130_fd_sc_hd__fill_1
XFILLER_0_27_839 VGND VGND VPWR VPWR sky130_fd_sc_hd__fill_1
XFILLER_0_38_165 VPWR VGND VPWR VGND sky130_ef_sc_hd__decap_12
XFILLER_0_53_113 VPWR VGND VPWR VGND sky130_ef_sc_hd__decap_12
XFILLER_0_124_513 VPWR VGND VPWR VGND sky130_ef_sc_hd__decap_12
XFILLER_0_121_39 VPWR VGND VPWR VGND sky130_ef_sc_hd__decap_12
XFILLER_0_93_293 VPWR VGND VPWR VGND sky130_ef_sc_hd__decap_12
XFILLER_0_30_15 VPWR VGND VPWR VGND sky130_ef_sc_hd__decap_12
XFILLER_0_124_557 VPWR VGND VPWR VGND sky130_ef_sc_hd__decap_12
XTAP_TAPCELL_ROW_78_1463 VGND VPWR sky130_fd_sc_hd__tapvpwrvgnd_1
XFILLER_0_1_405 VPWR VGND VPWR VGND sky130_ef_sc_hd__decap_12
XFILLER_0_22_533 VPWR VGND VPWR VGND sky130_ef_sc_hd__decap_12
XTAP_TAPCELL_ROW_78_1474 VGND VPWR sky130_fd_sc_hd__tapvpwrvgnd_1
XFILLER_0_1_449 VPWR VGND VPWR VGND sky130_ef_sc_hd__decap_12
XFILLER_0_39_57 VPWR VGND VPWR VGND sky130_ef_sc_hd__decap_12
XTAP_TAPCELL_ROW_91_1663 VGND VPWR sky130_fd_sc_hd__tapvpwrvgnd_1
X_3160_ _1113_ _1124_ VGND VGND VPWR VPWR _1125_ sky130_fd_sc_hd__xnor2_2
X_3091_ _0959_ VGND VGND VPWR VPWR _1056_ sky130_fd_sc_hd__inv_2
XFILLER_0_89_555 VGND VGND VPWR VPWR sky130_fd_sc_hd__decap_4
XFILLER_0_89_599 VGND VGND VPWR VPWR sky130_fd_sc_hd__fill_1
XFILLER_0_71_55 VGND VGND VPWR VPWR sky130_fd_sc_hd__fill_1
XFILLER_0_9_505 VPWR VGND VPWR VGND sky130_ef_sc_hd__decap_12
XPHY_EDGE_ROW_8_Right_8 VGND VGND VPWR VPWR sky130_fd_sc_hd__decap_3
XFILLER_0_128_841 VGND VGND VPWR VPWR sky130_fd_sc_hd__fill_1
XFILLER_0_119_329 VGND VGND VPWR VPWR sky130_fd_sc_hd__decap_6
XFILLER_0_85_750 VGND VGND VPWR VPWR sky130_fd_sc_hd__fill_2
X_3993_ _1709_ _1909_ _1912_ _1916_ VGND VGND VPWR VPWR _1917_ sky130_fd_sc_hd__o211a_1
XFILLER_0_85_783 VGND VGND VPWR VPWR sky130_fd_sc_hd__fill_1
XFILLER_0_57_496 VGND VGND VPWR VPWR sky130_fd_sc_hd__decap_4
XFILLER_0_17_305 VPWR VGND VPWR VGND sky130_ef_sc_hd__decap_12
XTAP_TAPCELL_ROW_33_789 VGND VPWR sky130_fd_sc_hd__tapvpwrvgnd_1
X_2944_ _0658_ _0906_ _0908_ _0657_ VGND VGND VPWR VPWR _0909_ sky130_fd_sc_hd__o22a_1
XFILLER_0_127_373 VPWR VGND VPWR VGND sky130_ef_sc_hd__decap_12
X_2875_ _0637_ _0827_ _0828_ _0839_ VGND VGND VPWR VPWR _0840_ sky130_fd_sc_hd__a31oi_2
XFILLER_0_17_349 VPWR VGND VPWR VGND sky130_ef_sc_hd__decap_12
X_4614_ cpu_inst.regfile_inst.registers\[10\]\[25\] _2252_ VGND VGND VPWR VPWR _2256_
+ sky130_fd_sc_hd__and2_1
XFILLER_0_60_639 VGND VGND VPWR VPWR sky130_fd_sc_hd__fill_1
XFILLER_0_60_628 VGND VGND VPWR VPWR sky130_fd_sc_hd__decap_4
XTAP_TAPCELL_ROW_13_491 VGND VPWR sky130_fd_sc_hd__tapvpwrvgnd_1
XFILLER_0_4_221 VPWR VGND VPWR VGND sky130_ef_sc_hd__decap_12
X_4545_ _2220_ VGND VGND VPWR VPWR _0279_ sky130_fd_sc_hd__clkbuf_1
XFILLER_0_5_777 VGND VGND VPWR VPWR sky130_fd_sc_hd__decap_6
XFILLER_0_4_265 VPWR VGND VPWR VGND sky130_ef_sc_hd__decap_12
XFILLER_0_25_393 VPWR VGND VPWR VGND sky130_ef_sc_hd__decap_12
XFILLER_0_41_831 VGND VGND VPWR VPWR sky130_fd_sc_hd__decap_8
XFILLER_0_40_363 VGND VGND VPWR VPWR sky130_fd_sc_hd__fill_1
XTAP_TAPCELL_ROW_133_2291 VGND VPWR sky130_fd_sc_hd__tapvpwrvgnd_1
XFILLER_0_111_741 VPWR VGND VPWR VGND sky130_ef_sc_hd__decap_12
X_4476_ _2185_ VGND VGND VPWR VPWR _0245_ sky130_fd_sc_hd__clkbuf_1
XFILLER_0_96_41 VPWR VGND VPWR VGND sky130_ef_sc_hd__decap_12
XFILLER_0_111_785 VPWR VGND VPWR VGND sky130_ef_sc_hd__decap_12
XFILLER_0_110_251 VGND VGND VPWR VPWR sky130_fd_sc_hd__fill_1
XFILLER_0_96_85 VPWR VGND VPWR VGND sky130_ef_sc_hd__decap_12
X_3427_ cpu_inst.regfile_inst.registers\[15\]\[16\] _0710_ _0721_ _1365_ _0844_ VGND
+ VGND VPWR VPWR _1366_ sky130_fd_sc_hd__a221o_1
XPHY_EDGE_ROW_39_Right_39 VGND VGND VPWR VPWR sky130_fd_sc_hd__decap_3
X_3358_ net42 _0768_ _1307_ _0769_ VGND VGND VPWR VPWR _1308_ sky130_fd_sc_hd__a31o_1
XTAP_TAPCELL_ROW_107_1902 VGND VPWR sky130_fd_sc_hd__tapvpwrvgnd_1
X_3289_ _1132_ _1253_ _1060_ VGND VGND VPWR VPWR _1254_ sky130_fd_sc_hd__mux2_1
X_5028_ _2503_ VGND VGND VPWR VPWR _0479_ sky130_fd_sc_hd__clkbuf_1
XFILLER_0_67_205 VPWR VGND VPWR VGND sky130_ef_sc_hd__decap_12
XTAP_TAPCELL_ROW_49_1031 VGND VPWR sky130_fd_sc_hd__tapvpwrvgnd_1
XTAP_TAPCELL_ROW_49_1042 VGND VPWR sky130_fd_sc_hd__tapvpwrvgnd_1
XFILLER_0_67_249 VPWR VGND VPWR VGND sky130_ef_sc_hd__decap_12
XFILLER_0_137_137 VPWR VGND VPWR VGND sky130_ef_sc_hd__decap_12
XTAP_TAPCELL_ROW_62_1231 VGND VPWR sky130_fd_sc_hd__tapvpwrvgnd_1
XPHY_EDGE_ROW_48_Right_48 VGND VGND VPWR VPWR sky130_fd_sc_hd__decap_3
XFILLER_0_119_841 VGND VGND VPWR VPWR sky130_fd_sc_hd__fill_1
XFILLER_0_35_113 VPWR VGND VPWR VGND sky130_ef_sc_hd__decap_12
XFILLER_0_134_811 VGND VGND VPWR VPWR sky130_fd_sc_hd__fill_1
XFILLER_0_75_293 VPWR VGND VPWR VGND sky130_ef_sc_hd__decap_12
XFILLER_0_51_617 VGND VGND VPWR VPWR sky130_fd_sc_hd__decap_4
XFILLER_0_121_505 VPWR VGND VPWR VGND sky130_ef_sc_hd__decap_12
XPHY_EDGE_ROW_57_Right_57 VGND VGND VPWR VPWR sky130_fd_sc_hd__decap_3
XFILLER_0_31_385 VGND VGND VPWR VPWR sky130_fd_sc_hd__decap_6
XFILLER_0_101_273 VGND VGND VPWR VPWR sky130_fd_sc_hd__decap_6
XTAP_TAPCELL_ROW_73_1393 VGND VPWR sky130_fd_sc_hd__tapvpwrvgnd_1
XFILLER_0_25_15 VPWR VGND VPWR VGND sky130_ef_sc_hd__decap_12
XFILLER_0_98_363 VGND VGND VPWR VPWR sky130_fd_sc_hd__fill_1
XPHY_EDGE_ROW_66_Right_66 VGND VGND VPWR VPWR sky130_fd_sc_hd__decap_3
XFILLER_0_132_27 VGND VGND VPWR VPWR sky130_fd_sc_hd__fill_1
XFILLER_0_67_783 VGND VGND VPWR VPWR sky130_fd_sc_hd__fill_1
XFILLER_0_27_614 VGND VGND VPWR VPWR sky130_fd_sc_hd__fill_2
XFILLER_0_137_671 VGND VGND VPWR VPWR sky130_fd_sc_hd__fill_1
XFILLER_0_125_833 VGND VGND VPWR VPWR sky130_fd_sc_hd__decap_6
XFILLER_0_109_373 VPWR VGND VPWR VGND sky130_ef_sc_hd__decap_12
XFILLER_0_15_809 VPWR VGND VPWR VGND sky130_ef_sc_hd__decap_12
XFILLER_0_41_69 VPWR VGND VPWR VGND sky130_ef_sc_hd__decap_12
XFILLER_0_124_321 VPWR VGND VPWR VGND sky130_ef_sc_hd__decap_12
XFILLER_0_54_466 VGND VGND VPWR VPWR sky130_fd_sc_hd__decap_4
XTAP_TAPCELL_ROW_30_748 VGND VPWR sky130_fd_sc_hd__tapvpwrvgnd_1
XFILLER_0_41_105 VGND VGND VPWR VPWR sky130_fd_sc_hd__decap_6
X_2660_ _0584_ _0621_ _0623_ _0624_ VGND VGND VPWR VPWR _0625_ sky130_fd_sc_hd__o211a_1
XFILLER_0_124_365 VPWR VGND VPWR VGND sky130_ef_sc_hd__decap_12
XTAP_TAPCELL_ROW_10_450 VGND VPWR sky130_fd_sc_hd__tapvpwrvgnd_1
XFILLER_0_41_149 VPWR VGND VPWR VGND sky130_ef_sc_hd__decap_12
XPHY_EDGE_ROW_75_Right_75 VGND VGND VPWR VPWR sky130_fd_sc_hd__decap_3
X_2591_ _0534_ _0543_ _0537_ _0538_ VGND VGND VPWR VPWR _0556_ sky130_fd_sc_hd__a211o_1
XFILLER_0_2_725 VPWR VGND VPWR VGND sky130_ef_sc_hd__decap_12
X_4330_ _1260_ cpu_inst.regfile_inst.registers\[5\]\[15\] _2105_ VGND VGND VPWR VPWR
+ _2110_ sky130_fd_sc_hd__mux2_1
XFILLER_0_10_525 VGND VGND VPWR VPWR sky130_fd_sc_hd__decap_6
XFILLER_0_2_769 VPWR VGND VPWR VGND sky130_ef_sc_hd__decap_12
XFILLER_0_22_363 VGND VGND VPWR VPWR sky130_fd_sc_hd__fill_1
X_4261_ cpu_inst.regfile_inst.registers\[24\]\[15\] VGND VGND VPWR VPWR _2073_ sky130_fd_sc_hd__clkbuf_1
XFILLER_0_10_569 VPWR VGND VPWR VGND sky130_ef_sc_hd__decap_12
XFILLER_0_1_279 VGND VGND VPWR VPWR sky130_fd_sc_hd__fill_1
X_3212_ _1176_ _1140_ VGND VGND VPWR VPWR _1177_ sky130_fd_sc_hd__nand2_1
XFILLER_0_5_69 VPWR VGND VPWR VGND sky130_ef_sc_hd__decap_12
XFILLER_0_66_77 VGND VGND VPWR VPWR sky130_fd_sc_hd__decap_6
X_4192_ cpu_inst.regfile_inst.registers\[4\]\[13\] _2035_ VGND VGND VPWR VPWR _2038_
+ sky130_fd_sc_hd__and2_1
X_3143_ _0900_ _0901_ VGND VGND VPWR VPWR _1108_ sky130_fd_sc_hd__and2_1
XPHY_EDGE_ROW_84_Right_84 VGND VGND VPWR VPWR sky130_fd_sc_hd__decap_3
X_3074_ _1027_ _1038_ VGND VGND VPWR VPWR _1039_ sky130_fd_sc_hd__xnor2_2
XPHY_EDGE_ROW_19_Left_158 VGND VGND VPWR VPWR sky130_fd_sc_hd__decap_3
XFILLER_0_82_65 VPWR VGND VPWR VGND sky130_ef_sc_hd__decap_12
XFILLER_0_77_503 VGND VGND VPWR VPWR sky130_fd_sc_hd__fill_1
XFILLER_0_49_205 VPWR VGND VPWR VGND sky130_ef_sc_hd__decap_12
XFILLER_0_89_385 VGND VGND VPWR VPWR sky130_fd_sc_hd__decap_6
XFILLER_0_49_249 VPWR VGND VPWR VGND sky130_ef_sc_hd__decap_12
XFILLER_0_106_83 VGND VGND VPWR VPWR sky130_fd_sc_hd__fill_1
XTAP_TAPCELL_ROW_102_1832 VGND VPWR sky130_fd_sc_hd__tapvpwrvgnd_1
XFILLER_0_15_81 VPWR VGND VPWR VGND sky130_ef_sc_hd__decap_12
XTAP_TAPCELL_ROW_18_572 VGND VPWR sky130_fd_sc_hd__tapvpwrvgnd_1
XFILLER_0_119_137 VPWR VGND VPWR VGND sky130_ef_sc_hd__decap_12
X_3976_ _1900_ VGND VGND VPWR VPWR _0030_ sky130_fd_sc_hd__clkbuf_1
XFILLER_0_9_335 VGND VGND VPWR VPWR sky130_fd_sc_hd__fill_1
XFILLER_0_17_113 VPWR VGND VPWR VGND sky130_ef_sc_hd__decap_12
XFILLER_0_18_625 VPWR VGND VPWR VGND sky130_ef_sc_hd__decap_12
XFILLER_0_116_811 VGND VGND VPWR VPWR sky130_fd_sc_hd__fill_1
X_2927_ _0770_ _0891_ VGND VGND VPWR VPWR _0892_ sky130_fd_sc_hd__xnor2_1
XFILLER_0_57_293 VGND VGND VPWR VPWR sky130_fd_sc_hd__decap_4
XFILLER_0_18_669 VPWR VGND VPWR VGND sky130_ef_sc_hd__decap_12
XTAP_TAPCELL_ROW_135_2331 VGND VPWR sky130_fd_sc_hd__tapvpwrvgnd_1
XTAP_TAPCELL_ROW_135_2320 VGND VPWR sky130_fd_sc_hd__tapvpwrvgnd_1
XFILLER_0_128_693 VGND VGND VPWR VPWR sky130_fd_sc_hd__decap_6
XFILLER_0_127_181 VPWR VGND VPWR VGND sky130_ef_sc_hd__decap_12
XFILLER_0_93_3 VPWR VGND VPWR VGND sky130_ef_sc_hd__decap_12
XFILLER_0_5_541 VPWR VGND VPWR VGND sky130_ef_sc_hd__decap_12
XPHY_EDGE_ROW_93_Right_93 VGND VGND VPWR VPWR sky130_fd_sc_hd__decap_3
XPHY_EDGE_ROW_28_Left_167 VGND VGND VPWR VPWR sky130_fd_sc_hd__decap_3
X_2858_ cpu_inst.regfile_inst.registers\[11\]\[9\] cpu_inst.regfile_inst.registers\[10\]\[9\]
+ _0620_ VGND VGND VPWR VPWR _0823_ sky130_fd_sc_hd__mux2_1
XFILLER_0_60_458 VGND VGND VPWR VPWR sky130_fd_sc_hd__fill_1
XFILLER_0_5_585 VPWR VGND VPWR VGND sky130_ef_sc_hd__decap_12
X_5577_ clknet_leaf_29_clk _0497_ VGND VGND VPWR VPWR cpu_inst.display_inst.counter\[17\]
+ sky130_fd_sc_hd__dfxtp_1
X_2789_ cpu_inst.regfile_inst.registers\[24\]\[3\] _0612_ _0617_ VGND VGND VPWR VPWR
+ _0754_ sky130_fd_sc_hd__o21ai_2
XFILLER_0_130_357 VGND VGND VPWR VPWR sky130_fd_sc_hd__decap_6
X_4528_ cpu_inst.regfile_inst.registers\[11\]\[15\] VGND VGND VPWR VPWR _2212_ sky130_fd_sc_hd__clkbuf_1
XFILLER_0_13_385 VGND VGND VPWR VPWR sky130_fd_sc_hd__decap_6
X_4459_ net16 cpu_inst.regfile_inst.registers\[7\]\[13\] _2174_ VGND VGND VPWR VPWR
+ _2177_ sky130_fd_sc_hd__mux2_1
XTAP_TAPCELL_ROW_113_1994 VGND VPWR sky130_fd_sc_hd__tapvpwrvgnd_1
XFILLER_0_99_105 VGND VGND VPWR VPWR sky130_fd_sc_hd__decap_6
XPHY_EDGE_ROW_37_Left_176 VGND VGND VPWR VPWR sky130_fd_sc_hd__decap_3
XFILLER_0_99_149 VPWR VGND VPWR VGND sky130_ef_sc_hd__decap_12
XFILLER_0_83_539 VGND VGND VPWR VPWR sky130_fd_sc_hd__decap_6
XFILLER_0_83_517 VPWR VGND VPWR VGND sky130_ef_sc_hd__decap_12
XFILLER_0_119_671 VGND VGND VPWR VPWR sky130_fd_sc_hd__fill_1
XFILLER_0_107_833 VGND VGND VPWR VPWR sky130_fd_sc_hd__decap_6
XFILLER_0_106_321 VPWR VGND VPWR VGND sky130_ef_sc_hd__decap_12
XFILLER_0_11_39 VPWR VGND VPWR VGND sky130_ef_sc_hd__decap_12
XFILLER_0_23_105 VGND VGND VPWR VPWR sky130_fd_sc_hd__decap_6
XPHY_EDGE_ROW_46_Left_185 VGND VGND VPWR VPWR sky130_fd_sc_hd__decap_3
XFILLER_0_106_365 VPWR VGND VPWR VGND sky130_ef_sc_hd__decap_12
XFILLER_0_51_447 VGND VGND VPWR VPWR sky130_fd_sc_hd__fill_1
XFILLER_0_122_825 VPWR VGND VPWR VGND sky130_ef_sc_hd__decap_12
XFILLER_0_23_149 VPWR VGND VPWR VGND sky130_ef_sc_hd__decap_12
XFILLER_0_121_335 VGND VGND VPWR VPWR sky130_fd_sc_hd__fill_1
XTAP_TAPCELL_ROW_75_1422 VGND VPWR sky130_fd_sc_hd__tapvpwrvgnd_1
XFILLER_0_102_560 VGND VGND VPWR VPWR sky130_fd_sc_hd__fill_1
XFILLER_0_31_193 VPWR VGND VPWR VGND sky130_ef_sc_hd__decap_12
XPHY_EDGE_ROW_55_Left_194 VGND VGND VPWR VPWR sky130_fd_sc_hd__decap_3
XFILLER_0_127_27 VPWR VGND VPWR VGND sky130_ef_sc_hd__decap_12
XFILLER_0_99_661 VGND VGND VPWR VPWR sky130_fd_sc_hd__decap_8
XFILLER_0_59_503 VGND VGND VPWR VPWR sky130_fd_sc_hd__fill_1
XFILLER_0_86_333 VPWR VGND VPWR VGND sky130_ef_sc_hd__decap_12
XTAP_TAPCELL_ROW_35_818 VGND VPWR sky130_fd_sc_hd__tapvpwrvgnd_1
XTAP_TAPCELL_ROW_35_829 VGND VPWR sky130_fd_sc_hd__tapvpwrvgnd_1
XTAP_TAPCELL_ROW_86_1595 VGND VPWR sky130_fd_sc_hd__tapvpwrvgnd_1
XTAP_TAPCELL_ROW_86_1584 VGND VPWR sky130_fd_sc_hd__tapvpwrvgnd_1
XTAP_TAPCELL_ROW_15_520 VGND VPWR sky130_fd_sc_hd__tapvpwrvgnd_1
XFILLER_0_86_377 VGND VGND VPWR VPWR sky130_fd_sc_hd__decap_3
X_3830_ _1153_ _1757_ _1758_ _1092_ VGND VGND VPWR VPWR _1759_ sky130_fd_sc_hd__a31o_1
XTAP_TAPCELL_ROW_15_531 VGND VPWR sky130_fd_sc_hd__tapvpwrvgnd_1
X_3761_ _1224_ _1684_ _1691_ VGND VGND VPWR VPWR _1692_ sky130_fd_sc_hd__a21o_1
XFILLER_0_7_839 VGND VGND VPWR VPWR sky130_fd_sc_hd__fill_1
XFILLER_0_39_293 VPWR VGND VPWR VGND sky130_ef_sc_hd__decap_12
XFILLER_0_125_641 VPWR VGND VPWR VGND sky130_ef_sc_hd__decap_12
XFILLER_0_109_181 VPWR VGND VPWR VGND sky130_ef_sc_hd__decap_12
XFILLER_0_15_617 VPWR VGND VPWR VGND sky130_ef_sc_hd__decap_12
X_5500_ clknet_leaf_38_clk _0420_ VGND VGND VPWR VPWR cpu_inst.regfile_inst.registers\[8\]\[4\]
+ sky130_fd_sc_hd__dfxtp_1
X_2712_ _0653_ _0676_ VGND VGND VPWR VPWR _0677_ sky130_fd_sc_hd__and2b_1
XTAP_TAPCELL_ROW_117_2050 VGND VPWR sky130_fd_sc_hd__tapvpwrvgnd_1
X_3692_ cpu_inst.regfile_inst.registers\[2\]\[23\] _1469_ _1470_ cpu_inst.regfile_inst.registers\[7\]\[23\]
+ _1557_ VGND VGND VPWR VPWR _1624_ sky130_fd_sc_hd__o221a_1
XFILLER_0_70_734 VGND VGND VPWR VPWR sky130_fd_sc_hd__fill_1
XFILLER_0_125_685 VPWR VGND VPWR VGND sky130_ef_sc_hd__decap_12
XTAP_TAPCELL_ROW_117_2061 VGND VPWR sky130_fd_sc_hd__tapvpwrvgnd_1
X_5431_ clknet_leaf_42_clk _0351_ net2 VGND VGND VPWR VPWR cpu_inst.decoder_inst.current_pc\[31\]
+ sky130_fd_sc_hd__dfrtp_1
X_2643_ _0537_ _0538_ VGND VGND VPWR VPWR _0608_ sky130_fd_sc_hd__nor2_1
XFILLER_0_2_533 VPWR VGND VPWR VGND sky130_ef_sc_hd__decap_12
XFILLER_0_124_195 VGND VGND VPWR VPWR sky130_fd_sc_hd__fill_1
XFILLER_0_112_357 VGND VGND VPWR VPWR sky130_fd_sc_hd__decap_6
X_5362_ clknet_leaf_8_clk _0282_ VGND VGND VPWR VPWR cpu_inst.regfile_inst.registers\[11\]\[26\]
+ sky130_fd_sc_hd__dfxtp_1
X_2574_ _0537_ _0538_ _0523_ VGND VGND VPWR VPWR _0539_ sky130_fd_sc_hd__nor3_2
XTAP_TAPCELL_ROW_130_2250 VGND VPWR sky130_fd_sc_hd__tapvpwrvgnd_1
XFILLER_0_100_519 VGND VGND VPWR VPWR sky130_fd_sc_hd__fill_1
XFILLER_0_10_333 VPWR VGND VPWR VGND sky130_ef_sc_hd__decap_12
X_4313_ _1223_ cpu_inst.regfile_inst.registers\[5\]\[7\] _2092_ VGND VGND VPWR VPWR
+ _2101_ sky130_fd_sc_hd__mux2_1
X_5293_ clknet_leaf_18_clk _0213_ VGND VGND VPWR VPWR cpu_inst.regfile_inst.registers\[1\]\[21\]
+ sky130_fd_sc_hd__dfxtp_1
XFILLER_0_10_377 VPWR VGND VPWR VGND sky130_ef_sc_hd__decap_12
X_4244_ _2064_ VGND VGND VPWR VPWR _0134_ sky130_fd_sc_hd__clkbuf_1
X_4175_ cpu_inst.regfile_inst.registers\[4\]\[5\] _2024_ VGND VGND VPWR VPWR _2029_
+ sky130_fd_sc_hd__and2_1
X_3126_ _0691_ net16 _1090_ VGND VGND VPWR VPWR _1091_ sky130_fd_sc_hd__a21oi_1
XFILLER_0_117_93 VPWR VGND VPWR VGND sky130_ef_sc_hd__decap_12
X_3057_ _0903_ VGND VGND VPWR VPWR _1022_ sky130_fd_sc_hd__buf_2
XFILLER_0_89_193 VPWR VGND VPWR VGND sky130_ef_sc_hd__decap_12
XFILLER_0_77_388 VGND VGND VPWR VPWR sky130_fd_sc_hd__decap_4
XFILLER_0_77_377 VGND VGND VPWR VPWR sky130_fd_sc_hd__fill_1
XFILLER_0_65_528 VGND VGND VPWR VPWR sky130_fd_sc_hd__decap_8
XFILLER_0_135_405 VPWR VGND VPWR VGND sky130_ef_sc_hd__decap_12
XFILLER_0_133_81 VPWR VGND VPWR VGND sky130_ef_sc_hd__decap_12
XFILLER_0_18_433 VPWR VGND VPWR VGND sky130_ef_sc_hd__decap_12
XFILLER_0_135_449 VPWR VGND VPWR VGND sky130_ef_sc_hd__decap_12
X_3959_ cpu_inst.regfile_inst.registers\[15\]\[30\] _1883_ _1555_ VGND VGND VPWR VPWR
+ _1884_ sky130_fd_sc_hd__mux2_1
XFILLER_0_73_561 VGND VGND VPWR VPWR sky130_fd_sc_hd__decap_3
XFILLER_0_18_477 VPWR VGND VPWR VGND sky130_ef_sc_hd__decap_12
XFILLER_0_73_594 VGND VGND VPWR VPWR sky130_fd_sc_hd__fill_1
XFILLER_0_33_447 VGND VGND VPWR VPWR sky130_fd_sc_hd__fill_1
XFILLER_0_104_825 VPWR VGND VPWR VGND sky130_ef_sc_hd__decap_12
XFILLER_0_60_233 VPWR VGND VPWR VGND sky130_ef_sc_hd__decap_12
XFILLER_0_21_609 VGND VGND VPWR VPWR sky130_fd_sc_hd__decap_6
XFILLER_0_130_121 VPWR VGND VPWR VGND sky130_ef_sc_hd__decap_12
XFILLER_0_103_335 VGND VGND VPWR VPWR sky130_fd_sc_hd__fill_1
XFILLER_0_60_277 VPWR VGND VPWR VGND sky130_ef_sc_hd__decap_12
XFILLER_0_5_393 VPWR VGND VPWR VGND sky130_ef_sc_hd__decap_12
XFILLER_0_130_165 VPWR VGND VPWR VGND sky130_ef_sc_hd__decap_12
XTAP_TAPCELL_ROW_57_1152 VGND VPWR sky130_fd_sc_hd__tapvpwrvgnd_1
XFILLER_0_13_193 VPWR VGND VPWR VGND sky130_ef_sc_hd__decap_12
XTAP_TAPCELL_ROW_70_1352 VGND VPWR sky130_fd_sc_hd__tapvpwrvgnd_1
XFILLER_0_96_642 VGND VGND VPWR VPWR sky130_fd_sc_hd__fill_2
XFILLER_0_68_333 VGND VGND VPWR VPWR sky130_fd_sc_hd__decap_8
XFILLER_0_138_221 VGND VGND VPWR VPWR sky130_fd_sc_hd__decap_3
XFILLER_0_96_697 VGND VGND VPWR VPWR sky130_fd_sc_hd__decap_3
XFILLER_0_56_528 VGND VGND VPWR VPWR sky130_fd_sc_hd__fill_1
XFILLER_0_138_265 VPWR VGND VPWR VGND sky130_ef_sc_hd__decap_12
XFILLER_0_22_27 VGND VGND VPWR VPWR sky130_fd_sc_hd__fill_1
XFILLER_0_37_753 VPWR VGND VPWR VGND sky130_ef_sc_hd__decap_12
XFILLER_0_107_685 VPWR VGND VPWR VGND sky130_ef_sc_hd__decap_12
XFILLER_0_24_469 VGND VGND VPWR VPWR sky130_fd_sc_hd__decap_6
XTAP_TAPCELL_ROW_40_898 VGND VPWR sky130_fd_sc_hd__tapvpwrvgnd_1
XFILLER_0_106_195 VGND VGND VPWR VPWR sky130_fd_sc_hd__fill_1
XFILLER_0_122_699 VGND VGND VPWR VPWR sky130_fd_sc_hd__fill_1
XFILLER_0_138_15 VPWR VGND VPWR VGND sky130_ef_sc_hd__decap_12
XPHY_EDGE_ROW_63_Left_202 VGND VGND VPWR VPWR sky130_fd_sc_hd__decap_3
XFILLER_0_47_57 VPWR VGND VPWR VGND sky130_ef_sc_hd__decap_12
XTAP_TAPCELL_ROW_88_1624 VGND VPWR sky130_fd_sc_hd__tapvpwrvgnd_1
XTAP_TAPCELL_ROW_88_1613 VGND VPWR sky130_fd_sc_hd__tapvpwrvgnd_1
XFILLER_0_2_15 VPWR VGND VPWR VGND sky130_ef_sc_hd__decap_12
XFILLER_0_86_141 VPWR VGND VPWR VGND sky130_ef_sc_hd__decap_12
XPHY_EDGE_ROW_72_Left_211 VGND VGND VPWR VPWR sky130_fd_sc_hd__decap_3
X_4931_ _1418_ cpu_inst.regfile_inst.registers\[8\]\[17\] _2449_ VGND VGND VPWR VPWR
+ _2453_ sky130_fd_sc_hd__mux2_1
X_4862_ cpu_inst.regfile_inst.registers\[9\]\[17\] VGND VGND VPWR VPWR _2416_ sky130_fd_sc_hd__clkbuf_1
XFILLER_0_117_405 VPWR VGND VPWR VGND sky130_ef_sc_hd__decap_12
X_3813_ _1739_ _1740_ _1741_ VGND VGND VPWR VPWR _1742_ sky130_fd_sc_hd__or3_1
XFILLER_0_117_449 VPWR VGND VPWR VGND sky130_ef_sc_hd__decap_12
XFILLER_0_103_51 VGND VGND VPWR VPWR sky130_fd_sc_hd__decap_4
XFILLER_0_90_829 VPWR VGND VPWR VGND sky130_ef_sc_hd__decap_12
XFILLER_0_43_712 VGND VGND VPWR VPWR sky130_fd_sc_hd__fill_1
X_4793_ _2381_ VGND VGND VPWR VPWR _0366_ sky130_fd_sc_hd__clkbuf_1
XFILLER_0_132_419 VGND VGND VPWR VPWR sky130_fd_sc_hd__fill_1
X_3744_ _0843_ _1673_ _1674_ _0859_ VGND VGND VPWR VPWR _1675_ sky130_fd_sc_hd__o211a_1
XFILLER_0_82_391 VPWR VGND VPWR VGND sky130_ef_sc_hd__decap_12
XFILLER_0_70_531 VGND VGND VPWR VPWR sky130_fd_sc_hd__fill_1
XTAP_TAPCELL_ROW_99_1786 VGND VPWR sky130_fd_sc_hd__tapvpwrvgnd_1
X_3675_ _1224_ _1601_ _1602_ _1607_ _0684_ VGND VGND VPWR VPWR _1608_ sky130_fd_sc_hd__a32o_1
XFILLER_0_15_447 VGND VGND VPWR VPWR sky130_fd_sc_hd__fill_1
XFILLER_0_42_233 VPWR VGND VPWR VGND sky130_ef_sc_hd__decap_12
XFILLER_0_112_121 VPWR VGND VPWR VGND sky130_ef_sc_hd__decap_12
XFILLER_0_88_53 VPWR VGND VPWR VGND sky130_ef_sc_hd__decap_12
X_5414_ clknet_leaf_4_clk _0334_ net2 VGND VGND VPWR VPWR cpu_inst.decoder_inst.current_pc\[14\]
+ sky130_fd_sc_hd__dfrtp_1
XFILLER_0_42_277 VPWR VGND VPWR VGND sky130_ef_sc_hd__decap_12
X_2626_ _0528_ _0566_ _0570_ VGND VGND VPWR VPWR _0591_ sky130_fd_sc_hd__or3_1
XFILLER_0_112_165 VPWR VGND VPWR VGND sky130_ef_sc_hd__decap_12
XFILLER_0_101_839 VGND VGND VPWR VPWR sky130_fd_sc_hd__fill_1
XFILLER_0_88_97 VPWR VGND VPWR VGND sky130_ef_sc_hd__decap_12
XPHY_EDGE_ROW_81_Left_220 VGND VGND VPWR VPWR sky130_fd_sc_hd__decap_3
XFILLER_0_2_363 VGND VGND VPWR VPWR sky130_fd_sc_hd__fill_1
XFILLER_0_56_3 VPWR VGND VPWR VGND sky130_ef_sc_hd__decap_12
XFILLER_0_11_653 VPWR VGND VPWR VGND sky130_ef_sc_hd__decap_12
XFILLER_0_10_141 VPWR VGND VPWR VGND sky130_ef_sc_hd__decap_12
X_5345_ clknet_leaf_32_clk _0265_ VGND VGND VPWR VPWR cpu_inst.regfile_inst.registers\[11\]\[9\]
+ sky130_fd_sc_hd__dfxtp_1
X_2557_ _0521_ cpu_inst.decoder_inst.current_pc\[1\] cpu_inst.decoder_inst.current_pc\[2\]
+ VGND VGND VPWR VPWR _0522_ sky130_fd_sc_hd__or3b_1
XFILLER_0_11_697 VPWR VGND VPWR VGND sky130_ef_sc_hd__decap_12
X_5276_ clknet_leaf_38_clk _0196_ VGND VGND VPWR VPWR cpu_inst.regfile_inst.registers\[1\]\[4\]
+ sky130_fd_sc_hd__dfxtp_1
XTAP_TAPCELL_ROW_110_1953 VGND VPWR sky130_fd_sc_hd__tapvpwrvgnd_1
X_4227_ cpu_inst.regfile_inst.registers\[4\]\[30\] _2046_ VGND VGND VPWR VPWR _2056_
+ sky130_fd_sc_hd__and2_1
XTAP_TAPCELL_ROW_52_1082 VGND VPWR sky130_fd_sc_hd__tapvpwrvgnd_1
X_4158_ _1899_ cpu_inst.regfile_inst.registers\[25\]\[30\] _2010_ VGND VGND VPWR VPWR
+ _2019_ sky130_fd_sc_hd__mux2_1
X_4089_ _1980_ VGND VGND VPWR VPWR _0063_ sky130_fd_sc_hd__clkbuf_1
X_3109_ _1055_ _1063_ _1073_ _0756_ VGND VGND VPWR VPWR _1074_ sky130_fd_sc_hd__a211o_1
XFILLER_0_66_804 VGND VGND VPWR VPWR sky130_fd_sc_hd__decap_4
XFILLER_0_93_612 VGND VGND VPWR VPWR sky130_fd_sc_hd__decap_4
XFILLER_0_93_601 VGND VGND VPWR VPWR sky130_fd_sc_hd__fill_2
XFILLER_0_38_528 VGND VGND VPWR VPWR sky130_fd_sc_hd__decap_4
XFILLER_0_136_725 VPWR VGND VPWR VGND sky130_ef_sc_hd__decap_12
XFILLER_0_92_133 VGND VGND VPWR VPWR sky130_fd_sc_hd__decap_6
XFILLER_0_19_753 VPWR VGND VPWR VGND sky130_ef_sc_hd__decap_12
XFILLER_0_34_701 VGND VGND VPWR VPWR sky130_fd_sc_hd__fill_1
XFILLER_0_136_769 VPWR VGND VPWR VGND sky130_ef_sc_hd__decap_12
XFILLER_0_92_177 VPWR VGND VPWR VGND sky130_ef_sc_hd__decap_12
XFILLER_0_61_520 VGND VGND VPWR VPWR sky130_fd_sc_hd__decap_8
XFILLER_0_19_797 VPWR VGND VPWR VGND sky130_ef_sc_hd__decap_12
XFILLER_0_34_723 VPWR VGND VPWR VGND sky130_ef_sc_hd__decap_12
XFILLER_0_46_583 VGND VGND VPWR VPWR sky130_fd_sc_hd__decap_4
XFILLER_0_135_279 VGND VGND VPWR VPWR sky130_fd_sc_hd__fill_1
XFILLER_0_131_441 VGND VGND VPWR VPWR sky130_fd_sc_hd__decap_6
XFILLER_0_21_417 VPWR VGND VPWR VGND sky130_ef_sc_hd__decap_12
XFILLER_0_34_789 VGND VGND VPWR VPWR sky130_fd_sc_hd__fill_2
XFILLER_0_131_485 VPWR VGND VPWR VGND sky130_ef_sc_hd__decap_12
XFILLER_0_108_29 VPWR VGND VPWR VGND sky130_ef_sc_hd__decap_12
XTAP_TAPCELL_ROW_6_395 VGND VPWR sky130_fd_sc_hd__tapvpwrvgnd_1
XTAP_TAPCELL_ROW_6_384 VGND VPWR sky130_fd_sc_hd__tapvpwrvgnd_1
XFILLER_0_17_27 VPWR VGND VPWR VGND sky130_ef_sc_hd__decap_12
XFILLER_0_33_15 VPWR VGND VPWR VGND sky130_ef_sc_hd__decap_12
XTAP_TAPCELL_ROW_83_1543 VGND VPWR sky130_fd_sc_hd__tapvpwrvgnd_1
XFILLER_0_68_141 VPWR VGND VPWR VGND sky130_ef_sc_hd__decap_12
XTAP_TAPCELL_ROW_45_968 VGND VPWR sky130_fd_sc_hd__tapvpwrvgnd_1
XTAP_TAPCELL_ROW_45_979 VGND VPWR sky130_fd_sc_hd__tapvpwrvgnd_1
XFILLER_0_83_111 VGND VGND VPWR VPWR sky130_fd_sc_hd__fill_1
XTAP_TAPCELL_ROW_25_670 VGND VPWR sky130_fd_sc_hd__tapvpwrvgnd_1
XTAP_TAPCELL_ROW_25_681 VGND VPWR sky130_fd_sc_hd__tapvpwrvgnd_1
XFILLER_0_37_561 VGND VGND VPWR VPWR sky130_fd_sc_hd__decap_8
XFILLER_0_44_509 VGND VGND VPWR VPWR sky130_fd_sc_hd__decap_4
XFILLER_0_114_419 VGND VGND VPWR VPWR sky130_fd_sc_hd__fill_1
XFILLER_0_80_840 VGND VGND VPWR VPWR sky130_fd_sc_hd__fill_2
XFILLER_0_3_105 VGND VGND VPWR VPWR sky130_fd_sc_hd__decap_6
XFILLER_0_24_233 VPWR VGND VPWR VGND sky130_ef_sc_hd__decap_12
XFILLER_0_3_149 VPWR VGND VPWR VGND sky130_ef_sc_hd__decap_12
XFILLER_0_24_277 VPWR VGND VPWR VGND sky130_ef_sc_hd__decap_12
X_3460_ cpu_inst.regfile_inst.registers\[0\]\[17\] _0726_ _0703_ cpu_inst.regfile_inst.registers\[4\]\[17\]
+ _0853_ VGND VGND VPWR VPWR _1398_ sky130_fd_sc_hd__o221a_1
XFILLER_0_110_625 VPWR VGND VPWR VGND sky130_ef_sc_hd__decap_12
X_3391_ _1100_ cpu_inst.regfile_inst.registers\[6\]\[9\] _1300_ VGND VGND VPWR VPWR
+ _1337_ sky130_fd_sc_hd__mux2_1
XFILLER_0_110_669 VPWR VGND VPWR VGND sky130_ef_sc_hd__decap_12
X_5130_ clknet_leaf_19_clk _0050_ VGND VGND VPWR VPWR cpu_inst.regfile_inst.registers\[2\]\[18\]
+ sky130_fd_sc_hd__dfxtp_1
X_5061_ cpu_inst.display_inst.counter\[12\] _2522_ cpu_inst.display_inst.counter\[13\]
+ VGND VGND VPWR VPWR _2523_ sky130_fd_sc_hd__a21oi_1
X_4012_ _0888_ _1319_ _1317_ VGND VGND VPWR VPWR _1935_ sky130_fd_sc_hd__mux2_1
XFILLER_0_74_77 VGND VGND VPWR VPWR sky130_fd_sc_hd__decap_6
XTAP_TAPCELL_ROW_125_2182 VGND VPWR sky130_fd_sc_hd__tapvpwrvgnd_1
XTAP_TAPCELL_ROW_125_2171 VGND VPWR sky130_fd_sc_hd__tapvpwrvgnd_1
X_4914_ _1100_ cpu_inst.regfile_inst.registers\[8\]\[9\] _2432_ VGND VGND VPWR VPWR
+ _2444_ sky130_fd_sc_hd__mux2_1
XFILLER_0_48_837 VGND VGND VPWR VPWR sky130_fd_sc_hd__decap_4
XFILLER_0_90_65 VPWR VGND VPWR VGND sky130_ef_sc_hd__decap_12
XFILLER_0_74_133 VGND VGND VPWR VPWR sky130_fd_sc_hd__decap_6
XFILLER_0_118_725 VPWR VGND VPWR VGND sky130_ef_sc_hd__decap_12
XFILLER_0_114_83 VGND VGND VPWR VPWR sky130_fd_sc_hd__fill_1
XFILLER_0_16_701 VPWR VGND VPWR VGND sky130_ef_sc_hd__decap_12
XFILLER_0_23_81 VPWR VGND VPWR VGND sky130_ef_sc_hd__decap_12
X_4845_ _2407_ VGND VGND VPWR VPWR _0392_ sky130_fd_sc_hd__clkbuf_1
XFILLER_0_118_769 VPWR VGND VPWR VGND sky130_ef_sc_hd__decap_12
XFILLER_0_74_177 VPWR VGND VPWR VGND sky130_ef_sc_hd__decap_12
X_4776_ cpu_inst.regfile_inst.registers\[0\]\[6\] VGND VGND VPWR VPWR _2373_ sky130_fd_sc_hd__clkbuf_1
XFILLER_0_117_279 VGND VGND VPWR VPWR sky130_fd_sc_hd__fill_1
X_3727_ cpu_inst.regfile_inst.registers\[9\]\[24\] cpu_inst.regfile_inst.registers\[8\]\[24\]
+ _1657_ VGND VGND VPWR VPWR _1658_ sky130_fd_sc_hd__mux2_1
XFILLER_0_113_441 VGND VGND VPWR VPWR sky130_fd_sc_hd__decap_6
XFILLER_0_31_715 VGND VGND VPWR VPWR sky130_fd_sc_hd__fill_1
XFILLER_0_43_564 VGND VGND VPWR VPWR sky130_fd_sc_hd__decap_3
X_3658_ _1557_ _1589_ _1590_ VGND VGND VPWR VPWR _1591_ sky130_fd_sc_hd__or3_1
XFILLER_0_70_394 VGND VGND VPWR VPWR sky130_fd_sc_hd__decap_8
XFILLER_0_113_485 VPWR VGND VPWR VGND sky130_ef_sc_hd__decap_12
X_3589_ _1507_ _1523_ VGND VGND VPWR VPWR _1524_ sky130_fd_sc_hd__nor2_1
XTAP_TAPCELL_ROW_54_1111 VGND VPWR sky130_fd_sc_hd__tapvpwrvgnd_1
X_2609_ _0573_ _0567_ VGND VGND VPWR VPWR _0574_ sky130_fd_sc_hd__nand2_2
X_5328_ clknet_leaf_8_clk _0248_ VGND VGND VPWR VPWR cpu_inst.regfile_inst.registers\[7\]\[24\]
+ sky130_fd_sc_hd__dfxtp_1
XFILLER_0_11_461 VPWR VGND VPWR VGND sky130_ef_sc_hd__decap_12
X_5259_ clknet_leaf_18_clk _0179_ VGND VGND VPWR VPWR cpu_inst.regfile_inst.registers\[5\]\[19\]
+ sky130_fd_sc_hd__dfxtp_1
XTAP_TAPCELL_ROW_3_343 VGND VPWR sky130_fd_sc_hd__tapvpwrvgnd_1
XFILLER_0_97_225 VPWR VGND VPWR VGND sky130_ef_sc_hd__decap_12
Xclkbuf_2_2__f_clk clknet_0_clk VGND VGND VPWR VPWR clknet_2_2__leaf_clk sky130_fd_sc_hd__clkbuf_16
XFILLER_0_39_837 VGND VGND VPWR VPWR sky130_fd_sc_hd__decap_3
XFILLER_0_66_645 VGND VGND VPWR VPWR sky130_fd_sc_hd__fill_1
XTAP_TAPCELL_ROW_65_1273 VGND VPWR sky130_fd_sc_hd__tapvpwrvgnd_1
XFILLER_0_65_111 VGND VGND VPWR VPWR sky130_fd_sc_hd__fill_1
XTAP_TAPCELL_ROW_42_927 VGND VPWR sky130_fd_sc_hd__tapvpwrvgnd_1
XFILLER_0_136_533 VPWR VGND VPWR VGND sky130_ef_sc_hd__decap_12
XFILLER_0_81_615 VGND VGND VPWR VPWR sky130_fd_sc_hd__fill_1
XFILLER_0_19_561 VPWR VGND VPWR VGND sky130_ef_sc_hd__decap_12
XFILLER_0_53_317 VGND VGND VPWR VPWR sky130_fd_sc_hd__decap_4
XFILLER_0_123_205 VPWR VGND VPWR VGND sky130_ef_sc_hd__decap_12
XFILLER_0_62_840 VGND VGND VPWR VPWR sky130_fd_sc_hd__fill_2
XFILLER_0_123_249 VPWR VGND VPWR VGND sky130_ef_sc_hd__decap_12
XFILLER_0_104_430 VGND VGND VPWR VPWR sky130_fd_sc_hd__decap_3
XFILLER_0_61_361 VGND VGND VPWR VPWR sky130_fd_sc_hd__decap_8
XFILLER_0_61_383 VGND VGND VPWR VPWR sky130_fd_sc_hd__fill_2
XFILLER_0_1_609 VGND VGND VPWR VPWR sky130_fd_sc_hd__decap_6
XFILLER_0_21_225 VPWR VGND VPWR VGND sky130_ef_sc_hd__decap_12
XFILLER_0_22_737 VPWR VGND VPWR VGND sky130_ef_sc_hd__decap_12
XFILLER_0_131_293 VPWR VGND VPWR VGND sky130_ef_sc_hd__decap_12
XFILLER_0_30_781 VGND VGND VPWR VPWR sky130_fd_sc_hd__fill_2
XFILLER_0_119_39 VPWR VGND VPWR VGND sky130_ef_sc_hd__decap_12
XFILLER_0_28_15 VPWR VGND VPWR VGND sky130_ef_sc_hd__decap_12
XFILLER_0_135_27 VPWR VGND VPWR VGND sky130_ef_sc_hd__decap_12
XFILLER_0_89_748 VGND VGND VPWR VPWR sky130_fd_sc_hd__decap_8
XFILLER_0_89_726 VGND VGND VPWR VPWR sky130_fd_sc_hd__fill_2
XFILLER_0_9_709 VPWR VGND VPWR VGND sky130_ef_sc_hd__decap_12
X_2960_ _0923_ _0924_ _0870_ VGND VGND VPWR VPWR _0925_ sky130_fd_sc_hd__mux2_1
X_2891_ cpu_inst.regfile_inst.registers\[0\]\[12\] _0615_ _0852_ _0853_ _0855_ VGND
+ VGND VPWR VPWR _0856_ sky130_fd_sc_hd__o221a_1
XFILLER_0_56_133 VGND VGND VPWR VPWR sky130_fd_sc_hd__decap_6
XFILLER_0_45_807 VPWR VGND VPWR VGND sky130_ef_sc_hd__decap_12
XFILLER_0_71_125 VPWR VGND VPWR VGND sky130_ef_sc_hd__decap_12
XFILLER_0_56_177 VPWR VGND VPWR VGND sky130_ef_sc_hd__decap_12
X_4630_ cpu_inst.display_inst.counter\[4\] cpu_inst.display_inst.counter\[6\] _2263_
+ _2264_ VGND VGND VPWR VPWR _2265_ sky130_fd_sc_hd__or4_1
XFILLER_0_114_3 VPWR VGND VPWR VGND sky130_ef_sc_hd__decap_12
XFILLER_0_72_659 VGND VGND VPWR VPWR sky130_fd_sc_hd__decap_4
XFILLER_0_37_391 VGND VGND VPWR VPWR sky130_fd_sc_hd__fill_1
XTAP_TAPCELL_ROW_96_1745 VGND VPWR sky130_fd_sc_hd__tapvpwrvgnd_1
XTAP_TAPCELL_ROW_96_1734 VGND VPWR sky130_fd_sc_hd__tapvpwrvgnd_1
X_4561_ _2228_ VGND VGND VPWR VPWR _0287_ sky130_fd_sc_hd__clkbuf_1
XFILLER_0_71_169 VPWR VGND VPWR VGND sky130_ef_sc_hd__decap_12
X_3512_ _1069_ VGND VGND VPWR VPWR _1449_ sky130_fd_sc_hd__clkbuf_4
X_4492_ _1867_ cpu_inst.regfile_inst.registers\[7\]\[29\] _2186_ VGND VGND VPWR VPWR
+ _2194_ sky130_fd_sc_hd__mux2_1
XFILLER_0_69_55 VGND VGND VPWR VPWR sky130_fd_sc_hd__fill_1
XFILLER_0_4_469 VGND VGND VPWR VPWR sky130_fd_sc_hd__decap_6
XFILLER_0_123_783 VGND VGND VPWR VPWR sky130_fd_sc_hd__fill_1
XFILLER_0_110_433 VPWR VGND VPWR VGND sky130_ef_sc_hd__decap_12
XFILLER_0_100_41 VPWR VGND VPWR VGND sky130_ef_sc_hd__decap_12
X_3443_ _1088_ _1376_ _1377_ _1381_ _1092_ VGND VGND VPWR VPWR _1382_ sky130_fd_sc_hd__o32ai_4
XFILLER_0_40_567 VGND VGND VPWR VPWR sky130_fd_sc_hd__fill_1
XFILLER_0_100_85 VPWR VGND VPWR VGND sky130_ef_sc_hd__decap_12
XFILLER_0_40_589 VGND VGND VPWR VPWR sky130_fd_sc_hd__fill_1
XFILLER_0_110_477 VPWR VGND VPWR VGND sky130_ef_sc_hd__decap_12
X_3374_ _1306_ _1308_ _1318_ _1323_ VGND VGND VPWR VPWR _1324_ sky130_fd_sc_hd__a31o_1
XFILLER_0_0_697 VGND VGND VPWR VPWR sky130_fd_sc_hd__decap_3
X_5113_ clknet_leaf_39_clk _0033_ VGND VGND VPWR VPWR cpu_inst.regfile_inst.registers\[2\]\[1\]
+ sky130_fd_sc_hd__dfxtp_1
XTAP_TAPCELL_ROW_127_2211 VGND VPWR sky130_fd_sc_hd__tapvpwrvgnd_1
XTAP_TAPCELL_ROW_127_2200 VGND VPWR sky130_fd_sc_hd__tapvpwrvgnd_1
X_5044_ cpu_inst.display_inst.counter\[6\] _2509_ VGND VGND VPWR VPWR _2513_ sky130_fd_sc_hd__nor2_1
XFILLER_0_79_225 VPWR VGND VPWR VGND sky130_ef_sc_hd__decap_12
XTAP_TAPCELL_ROW_0_302 VGND VPWR sky130_fd_sc_hd__tapvpwrvgnd_1
XFILLER_0_19_3 VPWR VGND VPWR VGND sky130_ef_sc_hd__decap_12
XFILLER_0_138_809 VGND VGND VPWR VPWR sky130_fd_sc_hd__decap_3
XFILLER_0_125_93 VPWR VGND VPWR VGND sky130_ef_sc_hd__decap_12
XTAP_TAPCELL_ROW_105_1874 VGND VPWR sky130_fd_sc_hd__tapvpwrvgnd_1
XFILLER_0_75_420 VGND VGND VPWR VPWR sky130_fd_sc_hd__decap_3
XFILLER_0_47_111 VGND VGND VPWR VPWR sky130_fd_sc_hd__fill_1
XFILLER_0_118_533 VPWR VGND VPWR VGND sky130_ef_sc_hd__decap_12
XFILLER_0_63_604 VGND VGND VPWR VPWR sky130_fd_sc_hd__decap_3
XFILLER_0_35_317 VPWR VGND VPWR VGND sky130_ef_sc_hd__decap_12
X_4828_ cpu_inst.regfile_inst.registers\[9\]\[0\] VGND VGND VPWR VPWR _2399_ sky130_fd_sc_hd__clkbuf_1
XTAP_TAPCELL_ROW_138_2384 VGND VPWR sky130_fd_sc_hd__tapvpwrvgnd_1
XTAP_TAPCELL_ROW_138_2373 VGND VPWR sky130_fd_sc_hd__tapvpwrvgnd_1
XFILLER_0_133_503 VGND VGND VPWR VPWR sky130_fd_sc_hd__fill_1
XFILLER_0_105_205 VPWR VGND VPWR VGND sky130_ef_sc_hd__decap_12
XFILLER_0_16_531 VGND VGND VPWR VPWR sky130_fd_sc_hd__fill_1
XFILLER_0_44_840 VGND VGND VPWR VPWR sky130_fd_sc_hd__fill_2
XFILLER_0_121_709 VPWR VGND VPWR VGND sky130_ef_sc_hd__decap_12
XFILLER_0_105_249 VPWR VGND VPWR VGND sky130_ef_sc_hd__decap_12
X_4759_ cpu_inst.decoder_inst.current_pc\[29\] _2359_ cpu_inst.decoder_inst.current_pc\[30\]
+ VGND VGND VPWR VPWR _2364_ sky130_fd_sc_hd__a21o_1
XFILLER_0_43_361 VPWR VGND VPWR VGND sky130_ef_sc_hd__decap_12
XFILLER_0_50_309 VPWR VGND VPWR VGND sky130_ef_sc_hd__decap_12
XFILLER_0_113_293 VPWR VGND VPWR VGND sky130_ef_sc_hd__decap_12
XFILLER_0_101_433 VGND VGND VPWR VPWR sky130_fd_sc_hd__fill_1
XFILLER_0_12_781 VPWR VGND VPWR VGND sky130_ef_sc_hd__decap_12
XTAP_TAPCELL_ROW_8_424 VGND VPWR sky130_fd_sc_hd__tapvpwrvgnd_1
XTAP_TAPCELL_ROW_8_413 VGND VPWR sky130_fd_sc_hd__tapvpwrvgnd_1
XTAP_TAPCELL_ROW_67_1302 VGND VPWR sky130_fd_sc_hd__tapvpwrvgnd_1
XTAP_TAPCELL_ROW_27_710 VGND VPWR sky130_fd_sc_hd__tapvpwrvgnd_1
XFILLER_0_129_809 VPWR VGND VPWR VGND sky130_ef_sc_hd__decap_12
XFILLER_0_98_589 VGND VGND VPWR VPWR sky130_fd_sc_hd__fill_1
XFILLER_0_85_217 VGND VGND VPWR VPWR sky130_fd_sc_hd__decap_6
XFILLER_0_79_770 VGND VGND VPWR VPWR sky130_fd_sc_hd__decap_8
XTAP_TAPCELL_ROW_80_1502 VGND VPWR sky130_fd_sc_hd__tapvpwrvgnd_1
XFILLER_0_38_133 VGND VGND VPWR VPWR sky130_fd_sc_hd__decap_6
XFILLER_0_39_656 VGND VGND VPWR VPWR sky130_fd_sc_hd__fill_1
XFILLER_0_93_261 VPWR VGND VPWR VGND sky130_ef_sc_hd__decap_12
XFILLER_0_66_497 VGND VGND VPWR VPWR sky130_fd_sc_hd__fill_2
XFILLER_0_38_177 VPWR VGND VPWR VGND sky130_ef_sc_hd__decap_12
XFILLER_0_136_363 VGND VGND VPWR VPWR sky130_fd_sc_hd__fill_1
XFILLER_0_124_525 VGND VGND VPWR VPWR sky130_fd_sc_hd__decap_6
XFILLER_0_19_391 VGND VGND VPWR VPWR sky130_fd_sc_hd__fill_1
XFILLER_0_30_27 VGND VGND VPWR VPWR sky130_fd_sc_hd__fill_1
XFILLER_0_53_125 VPWR VGND VPWR VGND sky130_ef_sc_hd__decap_12
XFILLER_0_22_501 VPWR VGND VPWR VGND sky130_ef_sc_hd__decap_12
XFILLER_0_50_810 VGND VGND VPWR VPWR sky130_fd_sc_hd__fill_2
XFILLER_0_53_169 VPWR VGND VPWR VGND sky130_ef_sc_hd__decap_12
XFILLER_0_124_569 VPWR VGND VPWR VGND sky130_ef_sc_hd__decap_12
XTAP_TAPCELL_ROW_78_1464 VGND VPWR sky130_fd_sc_hd__tapvpwrvgnd_1
XFILLER_0_1_417 VPWR VGND VPWR VGND sky130_ef_sc_hd__decap_12
XFILLER_0_22_545 VPWR VGND VPWR VGND sky130_ef_sc_hd__decap_12
XFILLER_0_105_783 VGND VGND VPWR VPWR sky130_fd_sc_hd__fill_1
XTAP_TAPCELL_ROW_78_1475 VGND VPWR sky130_fd_sc_hd__tapvpwrvgnd_1
XFILLER_0_22_589 VPWR VGND VPWR VGND sky130_ef_sc_hd__decap_12
XTAP_TAPCELL_ROW_91_1664 VGND VPWR sky130_fd_sc_hd__tapvpwrvgnd_1
XFILLER_0_39_69 VPWR VGND VPWR VGND sky130_ef_sc_hd__decap_12
X_3090_ _0770_ VGND VGND VPWR VPWR _1055_ sky130_fd_sc_hd__buf_2
XFILLER_0_89_501 VGND VGND VPWR VPWR sky130_fd_sc_hd__decap_3
XFILLER_0_55_57 VPWR VGND VPWR VGND sky130_ef_sc_hd__decap_12
XTAP_TAPCELL_ROW_122_2130 VGND VPWR sky130_fd_sc_hd__tapvpwrvgnd_1
X_3992_ cpu_inst.regfile_inst.registers\[15\]\[31\] _0729_ _1915_ _1552_ VGND VGND
+ VPWR VPWR _1916_ sky130_fd_sc_hd__a211o_1
XFILLER_0_9_517 VPWR VGND VPWR VGND sky130_ef_sc_hd__decap_12
XFILLER_0_29_111 VGND VGND VPWR VPWR sky130_fd_sc_hd__fill_1
X_2943_ _0907_ cpu_inst.regfile_inst.registers\[10\]\[3\] _0653_ VGND VGND VPWR VPWR
+ _0908_ sky130_fd_sc_hd__mux2_1
XFILLER_0_45_604 VGND VGND VPWR VPWR sky130_fd_sc_hd__fill_1
XFILLER_0_17_317 VPWR VGND VPWR VGND sky130_ef_sc_hd__decap_12
XFILLER_0_45_615 VGND VGND VPWR VPWR sky130_fd_sc_hd__fill_1
XFILLER_0_115_503 VGND VGND VPWR VPWR sky130_fd_sc_hd__fill_1
X_2874_ cpu_inst.regfile_inst.registers\[24\]\[8\] _0697_ _0699_ _0838_ VGND VGND
+ VPWR VPWR _0839_ sky130_fd_sc_hd__o211a_1
XFILLER_0_127_385 VGND VGND VPWR VPWR sky130_fd_sc_hd__decap_6
X_4613_ _2255_ VGND VGND VPWR VPWR _0312_ sky130_fd_sc_hd__clkbuf_1
XTAP_TAPCELL_ROW_100_1793 VGND VPWR sky130_fd_sc_hd__tapvpwrvgnd_1
XTAP_TAPCELL_ROW_13_492 VGND VPWR sky130_fd_sc_hd__tapvpwrvgnd_1
XFILLER_0_4_233 VPWR VGND VPWR VGND sky130_ef_sc_hd__decap_12
XFILLER_0_25_361 VPWR VGND VPWR VGND sky130_ef_sc_hd__decap_12
XFILLER_0_32_309 VPWR VGND VPWR VGND sky130_ef_sc_hd__decap_12
XFILLER_0_111_51 VGND VGND VPWR VPWR sky130_fd_sc_hd__decap_4
XFILLER_0_103_709 VPWR VGND VPWR VGND sky130_ef_sc_hd__decap_12
X_4544_ cpu_inst.regfile_inst.registers\[11\]\[23\] VGND VGND VPWR VPWR _2220_ sky130_fd_sc_hd__clkbuf_1
XFILLER_0_4_277 VPWR VGND VPWR VGND sky130_ef_sc_hd__decap_12
XTAP_TAPCELL_ROW_133_2292 VGND VPWR sky130_fd_sc_hd__tapvpwrvgnd_1
XFILLER_0_111_753 VPWR VGND VPWR VGND sky130_ef_sc_hd__decap_12
X_4475_ _1574_ cpu_inst.regfile_inst.registers\[7\]\[21\] _2174_ VGND VGND VPWR VPWR
+ _2185_ sky130_fd_sc_hd__mux2_1
XFILLER_0_96_53 VPWR VGND VPWR VGND sky130_ef_sc_hd__decap_12
XFILLER_0_111_797 VPWR VGND VPWR VGND sky130_ef_sc_hd__decap_12
X_3426_ cpu_inst.regfile_inst.registers\[8\]\[16\] _1364_ _0725_ VGND VGND VPWR VPWR
+ _1365_ sky130_fd_sc_hd__mux2_1
XFILLER_0_0_461 VPWR VGND VPWR VGND sky130_ef_sc_hd__decap_12
XFILLER_0_96_97 VPWR VGND VPWR VGND sky130_ef_sc_hd__decap_12
X_3357_ cpu_inst.regfile_inst.registers\[24\]\[2\] _0640_ VGND VGND VPWR VPWR _1307_
+ sky130_fd_sc_hd__or2_1
X_5027_ cpu_inst.regfile_inst.registers\[15\]\[31\] _2468_ VGND VGND VPWR VPWR _2503_
+ sky130_fd_sc_hd__and2_1
X_3288_ cpu_inst.regfile_inst.registers\[25\]\[15\] _1252_ _1069_ _1244_ VGND VGND
+ VPWR VPWR _1253_ sky130_fd_sc_hd__o211ai_1
XTAP_TAPCELL_ROW_107_1903 VGND VPWR sky130_fd_sc_hd__tapvpwrvgnd_1
XTAP_TAPCELL_ROW_49_1032 VGND VPWR sky130_fd_sc_hd__tapvpwrvgnd_1
XFILLER_0_138_617 VPWR VGND VPWR VGND sky130_ef_sc_hd__decap_12
XFILLER_0_95_559 VGND VGND VPWR VPWR sky130_fd_sc_hd__fill_1
XFILLER_0_67_217 VGND VGND VPWR VPWR sky130_fd_sc_hd__decap_6
XFILLER_0_137_105 VGND VGND VPWR VPWR sky130_fd_sc_hd__decap_6
XFILLER_0_82_209 VPWR VGND VPWR VGND sky130_ef_sc_hd__decap_12
XFILLER_0_137_149 VPWR VGND VPWR VGND sky130_ef_sc_hd__decap_12
XFILLER_0_91_710 VGND VGND VPWR VPWR sky130_fd_sc_hd__fill_1
XFILLER_0_76_784 VGND VGND VPWR VPWR sky130_fd_sc_hd__fill_1
XFILLER_0_76_773 VGND VGND VPWR VPWR sky130_fd_sc_hd__fill_2
XFILLER_0_75_261 VPWR VGND VPWR VGND sky130_ef_sc_hd__decap_12
XTAP_TAPCELL_ROW_62_1232 VGND VPWR sky130_fd_sc_hd__tapvpwrvgnd_1
XFILLER_0_0_81 VGND VGND VPWR VPWR sky130_fd_sc_hd__decap_3
XFILLER_0_48_486 VGND VGND VPWR VPWR sky130_fd_sc_hd__fill_1
XFILLER_0_118_363 VGND VGND VPWR VPWR sky130_fd_sc_hd__fill_1
XFILLER_0_35_125 VPWR VGND VPWR VGND sky130_ef_sc_hd__decap_12
XFILLER_0_90_253 VPWR VGND VPWR VGND sky130_ef_sc_hd__decap_12
XFILLER_0_35_169 VPWR VGND VPWR VGND sky130_ef_sc_hd__decap_12
XFILLER_0_51_629 VGND VGND VPWR VPWR sky130_fd_sc_hd__decap_4
XFILLER_0_121_517 VPWR VGND VPWR VGND sky130_ef_sc_hd__decap_12
XFILLER_0_50_139 VGND VGND VPWR VPWR sky130_fd_sc_hd__fill_1
XFILLER_0_8_3 VPWR VGND VPWR VGND sky130_ef_sc_hd__decap_12
XTAP_TAPCELL_ROW_73_1394 VGND VPWR sky130_fd_sc_hd__tapvpwrvgnd_1
XFILLER_0_99_821 VPWR VGND VPWR VGND sky130_ef_sc_hd__decap_12
XFILLER_0_116_29 VPWR VGND VPWR VGND sky130_ef_sc_hd__decap_12
XFILLER_0_25_27 VPWR VGND VPWR VGND sky130_ef_sc_hd__decap_12
XFILLER_0_129_617 VPWR VGND VPWR VGND sky130_ef_sc_hd__decap_12
XFILLER_0_82_721 VGND VGND VPWR VPWR sky130_fd_sc_hd__fill_1
XFILLER_0_41_15 VPWR VGND VPWR VGND sky130_ef_sc_hd__decap_12
XFILLER_0_124_333 VPWR VGND VPWR VGND sky130_ef_sc_hd__decap_12
XFILLER_0_109_385 VGND VGND VPWR VPWR sky130_fd_sc_hd__decap_6
XFILLER_0_14_309 VPWR VGND VPWR VGND sky130_ef_sc_hd__decap_12
XTAP_TAPCELL_ROW_30_749 VGND VPWR sky130_fd_sc_hd__tapvpwrvgnd_1
XTAP_TAPCELL_ROW_10_451 VGND VPWR sky130_fd_sc_hd__tapvpwrvgnd_1
XFILLER_0_23_821 VPWR VGND VPWR VGND sky130_ef_sc_hd__decap_12
XFILLER_0_124_377 VPWR VGND VPWR VGND sky130_ef_sc_hd__decap_12
X_2590_ _0523_ _0518_ _0554_ _0516_ VGND VGND VPWR VPWR _0555_ sky130_fd_sc_hd__or4_4
XFILLER_0_1_225 VPWR VGND VPWR VGND sky130_ef_sc_hd__decap_12
XFILLER_0_2_737 VPWR VGND VPWR VGND sky130_ef_sc_hd__decap_12
X_4260_ _2072_ VGND VGND VPWR VPWR _0142_ sky130_fd_sc_hd__clkbuf_1
XFILLER_0_5_15 VPWR VGND VPWR VGND sky130_ef_sc_hd__decap_12
X_4191_ _2037_ VGND VGND VPWR VPWR _0108_ sky130_fd_sc_hd__clkbuf_1
X_3211_ net14 VGND VGND VPWR VPWR _1176_ sky130_fd_sc_hd__buf_2
X_3142_ _0770_ _1106_ VGND VGND VPWR VPWR _1107_ sky130_fd_sc_hd__nor2_1
X_3073_ cpu_inst.regfile_inst.registers\[24\]\[13\] _0698_ _0700_ _1037_ _0961_ VGND
+ VGND VPWR VPWR _1038_ sky130_fd_sc_hd__o221a_1
XFILLER_0_77_515 VGND VGND VPWR VPWR sky130_fd_sc_hd__decap_8
XFILLER_0_82_77 VGND VGND VPWR VPWR sky130_fd_sc_hd__decap_6
XFILLER_0_49_217 VGND VGND VPWR VPWR sky130_fd_sc_hd__decap_6
XFILLER_0_119_105 VGND VGND VPWR VPWR sky130_fd_sc_hd__decap_6
XFILLER_0_77_559 VGND VGND VPWR VPWR sky130_fd_sc_hd__fill_1
XFILLER_0_58_740 VPWR VGND VPWR VGND sky130_ef_sc_hd__decap_12
XFILLER_0_15_93 VPWR VGND VPWR VGND sky130_ef_sc_hd__decap_12
XTAP_TAPCELL_ROW_18_573 VGND VPWR sky130_fd_sc_hd__tapvpwrvgnd_1
XFILLER_0_135_609 VGND VGND VPWR VPWR sky130_fd_sc_hd__decap_6
XFILLER_0_119_149 VPWR VGND VPWR VGND sky130_ef_sc_hd__decap_12
XTAP_TAPCELL_ROW_102_1833 VGND VPWR sky130_fd_sc_hd__tapvpwrvgnd_1
X_3975_ _1899_ cpu_inst.regfile_inst.registers\[6\]\[30\] _1609_ VGND VGND VPWR VPWR
+ _1900_ sky130_fd_sc_hd__mux2_1
XFILLER_0_64_209 VPWR VGND VPWR VGND sky130_ef_sc_hd__decap_12
XFILLER_0_57_261 VPWR VGND VPWR VGND sky130_ef_sc_hd__decap_12
XFILLER_0_73_754 VGND VGND VPWR VPWR sky130_fd_sc_hd__fill_1
X_2926_ _0644_ _0619_ _0514_ VGND VGND VPWR VPWR _0891_ sky130_fd_sc_hd__a21oi_1
XFILLER_0_17_125 VPWR VGND VPWR VGND sky130_ef_sc_hd__decap_12
XFILLER_0_18_637 VGND VGND VPWR VPWR sky130_fd_sc_hd__decap_6
XTAP_TAPCELL_ROW_135_2332 VGND VPWR sky130_fd_sc_hd__tapvpwrvgnd_1
XTAP_TAPCELL_ROW_135_2321 VGND VPWR sky130_fd_sc_hd__tapvpwrvgnd_1
XFILLER_0_127_193 VPWR VGND VPWR VGND sky130_ef_sc_hd__decap_12
XFILLER_0_122_83 VGND VGND VPWR VPWR sky130_fd_sc_hd__fill_1
XFILLER_0_72_253 VPWR VGND VPWR VGND sky130_ef_sc_hd__decap_12
XFILLER_0_17_169 VPWR VGND VPWR VGND sky130_ef_sc_hd__decap_12
X_2857_ cpu_inst.regfile_inst.registers\[2\]\[9\] _0820_ _0821_ cpu_inst.regfile_inst.registers\[7\]\[9\]
+ VGND VGND VPWR VPWR _0822_ sky130_fd_sc_hd__o22a_1
XFILLER_0_86_3 VPWR VGND VPWR VGND sky130_ef_sc_hd__decap_12
XFILLER_0_5_553 VGND VGND VPWR VPWR sky130_fd_sc_hd__decap_6
XFILLER_0_26_681 VPWR VGND VPWR VGND sky130_ef_sc_hd__decap_12
XFILLER_0_31_81 VPWR VGND VPWR VGND sky130_ef_sc_hd__decap_12
XFILLER_0_32_139 VGND VGND VPWR VPWR sky130_fd_sc_hd__fill_1
XFILLER_0_5_597 VPWR VGND VPWR VGND sky130_ef_sc_hd__decap_12
X_5576_ clknet_leaf_30_clk _0496_ VGND VGND VPWR VPWR cpu_inst.display_inst.counter\[16\]
+ sky130_fd_sc_hd__dfxtp_1
X_2788_ _0606_ _0752_ VGND VGND VPWR VPWR _0753_ sky130_fd_sc_hd__nor2_2
XFILLER_0_41_673 VGND VGND VPWR VPWR sky130_fd_sc_hd__fill_2
X_4527_ _2211_ VGND VGND VPWR VPWR _0270_ sky130_fd_sc_hd__clkbuf_1
XFILLER_0_111_561 VPWR VGND VPWR VGND sky130_ef_sc_hd__decap_12
X_4458_ _2176_ VGND VGND VPWR VPWR _0236_ sky130_fd_sc_hd__clkbuf_1
XTAP_TAPCELL_ROW_113_1995 VGND VPWR sky130_fd_sc_hd__tapvpwrvgnd_1
X_3409_ _0867_ VGND VGND VPWR VPWR _1348_ sky130_fd_sc_hd__clkbuf_4
X_4389_ cpu_inst.regfile_inst.registers\[1\]\[12\] VGND VGND VPWR VPWR _2140_ sky130_fd_sc_hd__clkbuf_1
XFILLER_0_96_813 VPWR VGND VPWR VGND sky130_ef_sc_hd__decap_12
XFILLER_0_68_537 VGND VGND VPWR VPWR sky130_fd_sc_hd__decap_8
XTAP_TAPCELL_ROW_37_860 VGND VPWR sky130_fd_sc_hd__tapvpwrvgnd_1
XFILLER_0_83_529 VGND VGND VPWR VPWR sky130_fd_sc_hd__decap_3
XFILLER_0_36_401 VPWR VGND VPWR VGND sky130_ef_sc_hd__decap_12
XPHY_EDGE_ROW_101_Left_240 VGND VGND VPWR VPWR sky130_fd_sc_hd__decap_3
XFILLER_0_106_333 VPWR VGND VPWR VGND sky130_ef_sc_hd__decap_12
XFILLER_0_64_798 VGND VGND VPWR VPWR sky130_fd_sc_hd__fill_2
XFILLER_0_122_837 VGND VGND VPWR VPWR sky130_fd_sc_hd__decap_4
XFILLER_0_106_377 VPWR VGND VPWR VGND sky130_ef_sc_hd__decap_12
XTAP_TAPCELL_ROW_75_1423 VGND VPWR sky130_fd_sc_hd__tapvpwrvgnd_1
XFILLER_0_20_813 VPWR VGND VPWR VGND sky130_ef_sc_hd__decap_12
XFILLER_0_31_161 VGND VGND VPWR VPWR sky130_fd_sc_hd__decap_6
XFILLER_0_32_673 VGND VGND VPWR VPWR sky130_fd_sc_hd__fill_1
XFILLER_0_127_39 VPWR VGND VPWR VGND sky130_ef_sc_hd__decap_12
XFILLER_0_36_15 VPWR VGND VPWR VGND sky130_ef_sc_hd__decap_12
XFILLER_0_87_824 VPWR VGND VPWR VGND sky130_ef_sc_hd__decap_12
XFILLER_0_86_301 VGND VGND VPWR VPWR sky130_fd_sc_hd__decap_6
XTAP_TAPCELL_ROW_35_819 VGND VPWR sky130_fd_sc_hd__tapvpwrvgnd_1
XTAP_TAPCELL_ROW_86_1596 VGND VPWR sky130_fd_sc_hd__tapvpwrvgnd_1
XFILLER_0_86_345 VPWR VGND VPWR VGND sky130_ef_sc_hd__decap_12
XTAP_TAPCELL_ROW_86_1585 VGND VPWR sky130_fd_sc_hd__tapvpwrvgnd_1
XFILLER_0_129_447 VGND VGND VPWR VPWR sky130_fd_sc_hd__fill_1
XTAP_TAPCELL_ROW_15_521 VGND VPWR sky130_fd_sc_hd__tapvpwrvgnd_1
XTAP_TAPCELL_ROW_15_532 VGND VPWR sky130_fd_sc_hd__tapvpwrvgnd_1
XFILLER_0_39_261 VPWR VGND VPWR VGND sky130_ef_sc_hd__decap_12
XFILLER_0_46_209 VPWR VGND VPWR VGND sky130_ef_sc_hd__decap_12
XFILLER_0_117_609 VGND VGND VPWR VPWR sky130_fd_sc_hd__decap_6
X_3760_ _0683_ _1690_ VGND VGND VPWR VPWR _1691_ sky130_fd_sc_hd__and2_1
XFILLER_0_67_581 VGND VGND VPWR VPWR sky130_fd_sc_hd__fill_1
XFILLER_0_82_562 VGND VGND VPWR VPWR sky130_fd_sc_hd__fill_2
XFILLER_0_54_253 VPWR VGND VPWR VGND sky130_ef_sc_hd__decap_12
X_2711_ cpu_inst.regfile_inst.registers\[9\]\[0\] cpu_inst.regfile_inst.registers\[8\]\[0\]
+ _0675_ VGND VGND VPWR VPWR _0676_ sky130_fd_sc_hd__mux2_1
XFILLER_0_125_653 VPWR VGND VPWR VGND sky130_ef_sc_hd__decap_12
XFILLER_0_124_141 VPWR VGND VPWR VGND sky130_ef_sc_hd__decap_12
XTAP_TAPCELL_ROW_117_2051 VGND VPWR sky130_fd_sc_hd__tapvpwrvgnd_1
XFILLER_0_109_193 VPWR VGND VPWR VGND sky130_ef_sc_hd__decap_12
X_3691_ cpu_inst.regfile_inst.registers\[15\]\[23\] _1622_ _1555_ VGND VGND VPWR VPWR
+ _1623_ sky130_fd_sc_hd__mux2_1
XFILLER_0_82_584 VGND VGND VPWR VPWR sky130_fd_sc_hd__decap_4
X_5430_ clknet_leaf_42_clk _0350_ net2 VGND VGND VPWR VPWR cpu_inst.decoder_inst.current_pc\[30\]
+ sky130_fd_sc_hd__dfrtp_1
XFILLER_0_15_629 VPWR VGND VPWR VGND sky130_ef_sc_hd__decap_12
XFILLER_0_42_437 VGND VGND VPWR VPWR sky130_fd_sc_hd__decap_3
XFILLER_0_125_697 VPWR VGND VPWR VGND sky130_ef_sc_hd__decap_12
XTAP_TAPCELL_ROW_117_2062 VGND VPWR sky130_fd_sc_hd__tapvpwrvgnd_1
XFILLER_0_14_139 VGND VGND VPWR VPWR sky130_fd_sc_hd__fill_1
XFILLER_0_2_501 VPWR VGND VPWR VGND sky130_ef_sc_hd__decap_12
X_2642_ _0605_ _0590_ _0606_ VGND VGND VPWR VPWR _0607_ sky130_fd_sc_hd__a21o_1
X_5361_ clknet_leaf_14_clk _0281_ VGND VGND VPWR VPWR cpu_inst.regfile_inst.registers\[11\]\[25\]
+ sky130_fd_sc_hd__dfxtp_1
X_2573_ _0518_ VGND VGND VPWR VPWR _0538_ sky130_fd_sc_hd__clkbuf_4
XFILLER_0_10_301 VGND VGND VPWR VPWR sky130_fd_sc_hd__decap_6
XFILLER_0_2_545 VPWR VGND VPWR VGND sky130_ef_sc_hd__decap_12
XFILLER_0_23_673 VPWR VGND VPWR VGND sky130_ef_sc_hd__decap_12
XTAP_TAPCELL_ROW_130_2251 VGND VPWR sky130_fd_sc_hd__tapvpwrvgnd_1
X_5292_ clknet_leaf_23_clk _0212_ VGND VGND VPWR VPWR cpu_inst.regfile_inst.registers\[1\]\[20\]
+ sky130_fd_sc_hd__dfxtp_1
XFILLER_0_77_55 VGND VGND VPWR VPWR sky130_fd_sc_hd__fill_1
XFILLER_0_2_589 VPWR VGND VPWR VGND sky130_ef_sc_hd__decap_12
X_4312_ _2100_ VGND VGND VPWR VPWR _0166_ sky130_fd_sc_hd__clkbuf_1
X_4243_ cpu_inst.regfile_inst.registers\[24\]\[6\] VGND VGND VPWR VPWR _2064_ sky130_fd_sc_hd__clkbuf_1
XFILLER_0_10_345 VPWR VGND VPWR VGND sky130_ef_sc_hd__decap_12
XFILLER_0_10_389 VPWR VGND VPWR VGND sky130_ef_sc_hd__decap_12
X_4174_ _2028_ VGND VGND VPWR VPWR _0100_ sky130_fd_sc_hd__clkbuf_1
X_3125_ cpu_inst.display_inst.digit_select\[0\] _1089_ cpu_inst.display_inst.digit_select\[1\]
+ VGND VGND VPWR VPWR _1090_ sky130_fd_sc_hd__a21oi_1
XFILLER_0_96_109 VPWR VGND VPWR VGND sky130_ef_sc_hd__decap_12
X_3056_ _1002_ _1015_ _1017_ _1020_ _1003_ VGND VGND VPWR VPWR _1021_ sky130_fd_sc_hd__o221a_1
XFILLER_0_89_161 VGND VGND VPWR VPWR sky130_fd_sc_hd__decap_6
XFILLER_0_58_570 VGND VGND VPWR VPWR sky130_fd_sc_hd__decap_4
XFILLER_0_9_111 VGND VGND VPWR VPWR sky130_fd_sc_hd__fill_1
XFILLER_0_18_401 VPWR VGND VPWR VGND sky130_ef_sc_hd__decap_12
XFILLER_0_135_417 VPWR VGND VPWR VGND sky130_ef_sc_hd__decap_12
XFILLER_0_133_93 VPWR VGND VPWR VGND sky130_ef_sc_hd__decap_12
XFILLER_0_18_445 VPWR VGND VPWR VGND sky130_ef_sc_hd__decap_12
XFILLER_0_46_721 VPWR VGND VPWR VGND sky130_ef_sc_hd__decap_12
X_3958_ cpu_inst.regfile_inst.registers\[8\]\[30\] _1882_ _1739_ VGND VGND VPWR VPWR
+ _1883_ sky130_fd_sc_hd__mux2_1
XFILLER_0_73_540 VPWR VGND VPWR VGND sky130_ef_sc_hd__decap_12
X_3889_ _1803_ _1815_ VGND VGND VPWR VPWR _1816_ sky130_fd_sc_hd__xnor2_1
X_2909_ _0873_ cpu_inst.regfile_inst.registers\[10\]\[12\] _0871_ VGND VGND VPWR VPWR
+ _0874_ sky130_fd_sc_hd__mux2_1
XFILLER_0_18_489 VPWR VGND VPWR VGND sky130_ef_sc_hd__decap_12
XFILLER_0_104_837 VGND VGND VPWR VPWR sky130_fd_sc_hd__decap_4
XFILLER_0_60_245 VGND VGND VPWR VPWR sky130_fd_sc_hd__decap_6
XFILLER_0_5_361 VPWR VGND VPWR VGND sky130_ef_sc_hd__decap_12
XFILLER_0_130_133 VGND VGND VPWR VPWR sky130_fd_sc_hd__decap_6
X_5559_ clknet_leaf_2_clk _0479_ VGND VGND VPWR VPWR cpu_inst.regfile_inst.registers\[15\]\[31\]
+ sky130_fd_sc_hd__dfxtp_1
XFILLER_0_60_289 VPWR VGND VPWR VGND sky130_ef_sc_hd__decap_12
XFILLER_0_13_161 VGND VGND VPWR VPWR sky130_fd_sc_hd__decap_6
XFILLER_0_20_109 VPWR VGND VPWR VGND sky130_ef_sc_hd__decap_12
XFILLER_0_130_177 VPWR VGND VPWR VGND sky130_ef_sc_hd__decap_12
XTAP_TAPCELL_ROW_57_1153 VGND VPWR sky130_fd_sc_hd__tapvpwrvgnd_1
XFILLER_0_111_391 VGND VGND VPWR VPWR sky130_fd_sc_hd__fill_1
XTAP_TAPCELL_ROW_70_1353 VGND VPWR sky130_fd_sc_hd__tapvpwrvgnd_1
XFILLER_0_68_301 VGND VGND VPWR VPWR sky130_fd_sc_hd__decap_6
XFILLER_0_28_209 VPWR VGND VPWR VGND sky130_ef_sc_hd__decap_12
XFILLER_0_138_277 VGND VGND VPWR VPWR sky130_fd_sc_hd__decap_3
XFILLER_0_83_337 VPWR VGND VPWR VGND sky130_ef_sc_hd__decap_12
XFILLER_0_36_253 VPWR VGND VPWR VGND sky130_ef_sc_hd__decap_12
XFILLER_0_37_765 VPWR VGND VPWR VGND sky130_ef_sc_hd__decap_12
XFILLER_0_106_141 VPWR VGND VPWR VGND sky130_ef_sc_hd__decap_12
XFILLER_0_122_601 VPWR VGND VPWR VGND sky130_ef_sc_hd__decap_12
XFILLER_0_107_697 VPWR VGND VPWR VGND sky130_ef_sc_hd__decap_12
XFILLER_0_52_779 VGND VGND VPWR VPWR sky130_fd_sc_hd__fill_1
XTAP_TAPCELL_ROW_40_899 VGND VPWR sky130_fd_sc_hd__tapvpwrvgnd_1
XFILLER_0_51_223 VGND VGND VPWR VPWR sky130_fd_sc_hd__fill_1
XFILLER_0_122_645 VPWR VGND VPWR VGND sky130_ef_sc_hd__decap_12
XFILLER_0_121_111 VGND VGND VPWR VPWR sky130_fd_sc_hd__fill_1
XFILLER_0_20_643 VGND VGND VPWR VPWR sky130_fd_sc_hd__fill_1
XFILLER_0_138_27 VGND VGND VPWR VPWR sky130_fd_sc_hd__fill_1
XFILLER_0_47_69 VPWR VGND VPWR VGND sky130_ef_sc_hd__decap_12
XTAP_TAPCELL_ROW_88_1625 VGND VPWR sky130_fd_sc_hd__tapvpwrvgnd_1
XTAP_TAPCELL_ROW_88_1614 VGND VPWR sky130_fd_sc_hd__tapvpwrvgnd_1
XFILLER_0_78_109 VPWR VGND VPWR VGND sky130_ef_sc_hd__decap_12
XFILLER_0_2_27 VGND VGND VPWR VPWR sky130_fd_sc_hd__fill_1
XFILLER_0_99_481 VGND VGND VPWR VPWR sky130_fd_sc_hd__decap_3
XFILLER_0_63_57 VPWR VGND VPWR VGND sky130_ef_sc_hd__decap_12
X_4930_ _2452_ VGND VGND VPWR VPWR _0432_ sky130_fd_sc_hd__clkbuf_1
XFILLER_0_86_153 VPWR VGND VPWR VGND sky130_ef_sc_hd__decap_12
X_4861_ _2415_ VGND VGND VPWR VPWR _0400_ sky130_fd_sc_hd__clkbuf_1
XFILLER_0_117_417 VPWR VGND VPWR VGND sky130_ef_sc_hd__decap_12
X_3812_ cpu_inst.regfile_inst.registers\[1\]\[26\] _1667_ _1668_ cpu_inst.regfile_inst.registers\[5\]\[26\]
+ _0562_ VGND VGND VPWR VPWR _1741_ sky130_fd_sc_hd__o221a_1
XFILLER_0_86_197 VPWR VGND VPWR VGND sky130_ef_sc_hd__decap_12
XFILLER_0_7_615 VGND VGND VPWR VPWR sky130_fd_sc_hd__fill_1
XPHY_EDGE_ROW_120_Right_120 VGND VGND VPWR VPWR sky130_fd_sc_hd__decap_3
X_4792_ cpu_inst.regfile_inst.registers\[0\]\[14\] VGND VGND VPWR VPWR _2381_ sky130_fd_sc_hd__clkbuf_1
X_3743_ cpu_inst.regfile_inst.registers\[24\]\[24\] _1384_ VGND VGND VPWR VPWR _1674_
+ sky130_fd_sc_hd__or2_1
XFILLER_0_125_461 VPWR VGND VPWR VGND sky130_ef_sc_hd__decap_12
XTAP_TAPCELL_ROW_99_1787 VGND VPWR sky130_fd_sc_hd__tapvpwrvgnd_1
X_3674_ _1448_ _1605_ _1606_ VGND VGND VPWR VPWR _1607_ sky130_fd_sc_hd__o21ai_1
XFILLER_0_12_83 VGND VGND VPWR VPWR sky130_fd_sc_hd__fill_1
XFILLER_0_3_821 VPWR VGND VPWR VGND sky130_ef_sc_hd__decap_12
XFILLER_0_42_245 VGND VGND VPWR VPWR sky130_fd_sc_hd__decap_6
XFILLER_0_112_133 VGND VGND VPWR VPWR sky130_fd_sc_hd__decap_6
X_5413_ clknet_leaf_4_clk _0333_ net2 VGND VGND VPWR VPWR cpu_inst.decoder_inst.current_pc\[13\]
+ sky130_fd_sc_hd__dfrtp_1
XFILLER_0_42_289 VPWR VGND VPWR VGND sky130_ef_sc_hd__decap_12
X_2625_ cpu_inst.regfile_inst.registers\[15\]\[0\] _0566_ _0571_ _0589_ VGND VGND
+ VPWR VPWR _0590_ sky130_fd_sc_hd__a211o_1
XFILLER_0_88_65 VPWR VGND VPWR VGND sky130_ef_sc_hd__decap_12
X_5344_ clknet_leaf_32_clk _0264_ VGND VGND VPWR VPWR cpu_inst.regfile_inst.registers\[11\]\[8\]
+ sky130_fd_sc_hd__dfxtp_1
XFILLER_0_112_177 VPWR VGND VPWR VGND sky130_ef_sc_hd__decap_12
X_2556_ cpu_inst.decoder_inst.current_pc\[3\] VGND VGND VPWR VPWR _0521_ sky130_fd_sc_hd__buf_2
XFILLER_0_11_665 VGND VGND VPWR VPWR sky130_fd_sc_hd__decap_6
XFILLER_0_10_153 VPWR VGND VPWR VGND sky130_ef_sc_hd__decap_12
X_5275_ clknet_leaf_39_clk _0195_ VGND VGND VPWR VPWR cpu_inst.regfile_inst.registers\[1\]\[3\]
+ sky130_fd_sc_hd__dfxtp_1
XTAP_TAPCELL_ROW_110_1954 VGND VPWR sky130_fd_sc_hd__tapvpwrvgnd_1
XTAP_TAPCELL_ROW_110_1943 VGND VPWR sky130_fd_sc_hd__tapvpwrvgnd_1
X_4226_ _2055_ VGND VGND VPWR VPWR _0125_ sky130_fd_sc_hd__clkbuf_1
XFILLER_0_10_197 VPWR VGND VPWR VGND sky130_ef_sc_hd__decap_12
XFILLER_0_49_3 VPWR VGND VPWR VGND sky130_ef_sc_hd__decap_12
X_4157_ _2018_ VGND VGND VPWR VPWR _0093_ sky130_fd_sc_hd__clkbuf_1
XTAP_TAPCELL_ROW_52_1083 VGND VPWR sky130_fd_sc_hd__tapvpwrvgnd_1
X_3108_ _1055_ _1072_ VGND VGND VPWR VPWR _1073_ sky130_fd_sc_hd__nor2_1
X_4088_ cpu_inst.regfile_inst.registers\[2\]\[31\] VGND VGND VPWR VPWR _1980_ sky130_fd_sc_hd__clkbuf_1
XFILLER_0_78_654 VGND VGND VPWR VPWR sky130_fd_sc_hd__decap_4
X_3039_ _1002_ _1003_ VGND VGND VPWR VPWR _1004_ sky130_fd_sc_hd__or2b_1
XFILLER_0_93_657 VGND VGND VPWR VPWR sky130_fd_sc_hd__fill_1
XFILLER_0_65_337 VPWR VGND VPWR VGND sky130_ef_sc_hd__decap_12
XFILLER_0_19_721 VGND VGND VPWR VPWR sky130_fd_sc_hd__decap_6
XFILLER_0_136_737 VPWR VGND VPWR VGND sky130_ef_sc_hd__decap_12
XFILLER_0_135_225 VPWR VGND VPWR VGND sky130_ef_sc_hd__decap_12
XFILLER_0_80_307 VGND VGND VPWR VPWR sky130_fd_sc_hd__fill_1
XFILLER_0_18_253 VPWR VGND VPWR VGND sky130_ef_sc_hd__decap_12
XFILLER_0_19_765 VPWR VGND VPWR VGND sky130_ef_sc_hd__decap_12
XFILLER_0_92_189 VGND VGND VPWR VPWR sky130_fd_sc_hd__decap_6
XFILLER_0_34_735 VPWR VGND VPWR VGND sky130_ef_sc_hd__decap_12
XFILLER_0_46_573 VGND VGND VPWR VPWR sky130_fd_sc_hd__decap_6
XFILLER_0_104_601 VGND VGND VPWR VPWR sky130_fd_sc_hd__fill_1
XFILLER_0_6_681 VPWR VGND VPWR VGND sky130_ef_sc_hd__decap_12
XFILLER_0_33_223 VGND VGND VPWR VPWR sky130_fd_sc_hd__fill_1
XFILLER_0_34_757 VPWR VGND VPWR VGND sky130_ef_sc_hd__decap_12
XFILLER_0_104_656 VGND VGND VPWR VPWR sky130_fd_sc_hd__fill_1
XFILLER_0_103_111 VGND VGND VPWR VPWR sky130_fd_sc_hd__fill_1
XFILLER_0_61_598 VPWR VGND VPWR VGND sky130_ef_sc_hd__decap_12
XFILLER_0_21_429 VPWR VGND VPWR VGND sky130_ef_sc_hd__decap_12
XFILLER_0_131_497 VGND VGND VPWR VPWR sky130_fd_sc_hd__decap_6
XTAP_TAPCELL_ROW_6_385 VGND VPWR sky130_fd_sc_hd__tapvpwrvgnd_1
XTAP_TAPCELL_ROW_6_396 VGND VPWR sky130_fd_sc_hd__tapvpwrvgnd_1
XFILLER_0_17_39 VPWR VGND VPWR VGND sky130_ef_sc_hd__decap_12
XFILLER_0_124_29 VPWR VGND VPWR VGND sky130_ef_sc_hd__decap_12
XFILLER_0_84_613 VPWR VGND VPWR VGND sky130_ef_sc_hd__decap_12
XTAP_TAPCELL_ROW_83_1544 VGND VPWR sky130_fd_sc_hd__tapvpwrvgnd_1
XFILLER_0_69_687 VGND VGND VPWR VPWR sky130_fd_sc_hd__fill_1
XFILLER_0_69_665 VGND VGND VPWR VPWR sky130_fd_sc_hd__decap_6
XFILLER_0_68_153 VPWR VGND VPWR VGND sky130_ef_sc_hd__decap_12
XFILLER_0_57_838 VGND VGND VPWR VPWR sky130_fd_sc_hd__fill_2
XFILLER_0_57_805 VGND VGND VPWR VPWR sky130_fd_sc_hd__decap_4
XFILLER_0_33_27 VPWR VGND VPWR VGND sky130_ef_sc_hd__decap_12
XTAP_TAPCELL_ROW_45_969 VGND VPWR sky130_fd_sc_hd__tapvpwrvgnd_1
XFILLER_0_68_197 VPWR VGND VPWR VGND sky130_ef_sc_hd__decap_12
XFILLER_0_83_167 VGND VGND VPWR VPWR sky130_fd_sc_hd__fill_1
XTAP_TAPCELL_ROW_25_671 VGND VPWR sky130_fd_sc_hd__tapvpwrvgnd_1
XTAP_TAPCELL_ROW_25_682 VGND VPWR sky130_fd_sc_hd__tapvpwrvgnd_1
XFILLER_0_52_521 VGND VGND VPWR VPWR sky130_fd_sc_hd__decap_4
XFILLER_0_37_595 VGND VGND VPWR VPWR sky130_fd_sc_hd__decap_4
XFILLER_0_107_472 VGND VGND VPWR VPWR sky130_fd_sc_hd__fill_1
XFILLER_0_24_245 VGND VGND VPWR VPWR sky130_fd_sc_hd__decap_6
XTAP_TAPCELL_ROW_114_2010 VGND VPWR sky130_fd_sc_hd__tapvpwrvgnd_1
XFILLER_0_52_587 VGND VGND VPWR VPWR sky130_fd_sc_hd__fill_1
XFILLER_0_122_475 VGND VGND VPWR VPWR sky130_fd_sc_hd__fill_1
XFILLER_0_0_813 VPWR VGND VPWR VGND sky130_ef_sc_hd__decap_12
XFILLER_0_24_289 VPWR VGND VPWR VGND sky130_ef_sc_hd__decap_12
XFILLER_0_110_637 VGND VGND VPWR VPWR sky130_fd_sc_hd__decap_6
X_3390_ _1336_ VGND VGND VPWR VPWR _0008_ sky130_fd_sc_hd__clkbuf_1
X_5060_ cpu_inst.display_inst.counter\[12\] _2522_ VGND VGND VPWR VPWR _0492_ sky130_fd_sc_hd__xor2_1
X_4011_ _1385_ _1109_ _1933_ _0684_ VGND VGND VPWR VPWR _1934_ sky130_fd_sc_hd__a22o_1
XTAP_TAPCELL_ROW_125_2172 VGND VPWR sky130_fd_sc_hd__tapvpwrvgnd_1
XFILLER_0_87_473 VPWR VGND VPWR VGND sky130_ef_sc_hd__decap_12
XFILLER_0_75_613 VGND VGND VPWR VPWR sky130_fd_sc_hd__decap_3
X_4913_ _2443_ VGND VGND VPWR VPWR _0424_ sky130_fd_sc_hd__clkbuf_1
XFILLER_0_90_77 VGND VGND VPWR VPWR sky130_fd_sc_hd__decap_6
XFILLER_0_47_337 VPWR VGND VPWR VGND sky130_ef_sc_hd__decap_12
XFILLER_0_118_737 VPWR VGND VPWR VGND sky130_ef_sc_hd__decap_12
XFILLER_0_117_225 VPWR VGND VPWR VGND sky130_ef_sc_hd__decap_12
XFILLER_0_90_616 VGND VGND VPWR VPWR sky130_fd_sc_hd__decap_3
XFILLER_0_62_307 VGND VGND VPWR VPWR sky130_fd_sc_hd__fill_1
X_4844_ cpu_inst.regfile_inst.registers\[9\]\[8\] VGND VGND VPWR VPWR _2407_ sky130_fd_sc_hd__clkbuf_1
XFILLER_0_74_189 VGND VGND VPWR VPWR sky130_fd_sc_hd__decap_6
XFILLER_0_16_713 VPWR VGND VPWR VGND sky130_ef_sc_hd__decap_12
XFILLER_0_23_93 VPWR VGND VPWR VGND sky130_ef_sc_hd__decap_12
X_4775_ _2372_ VGND VGND VPWR VPWR _0357_ sky130_fd_sc_hd__clkbuf_1
XFILLER_0_28_584 VGND VGND VPWR VPWR sky130_fd_sc_hd__decap_4
XFILLER_0_133_729 VPWR VGND VPWR VGND sky130_ef_sc_hd__decap_12
XFILLER_0_126_781 VPWR VGND VPWR VGND sky130_ef_sc_hd__decap_12
X_3726_ _1540_ VGND VGND VPWR VPWR _1657_ sky130_fd_sc_hd__clkbuf_4
XFILLER_0_71_841 VGND VGND VPWR VPWR sky130_fd_sc_hd__fill_1
XFILLER_0_15_223 VGND VGND VPWR VPWR sky130_fd_sc_hd__fill_1
XFILLER_0_16_757 VPWR VGND VPWR VGND sky130_ef_sc_hd__decap_12
XFILLER_0_31_727 VGND VGND VPWR VPWR sky130_fd_sc_hd__fill_1
XFILLER_0_130_83 VGND VGND VPWR VPWR sky130_fd_sc_hd__fill_1
X_3657_ cpu_inst.regfile_inst.registers\[1\]\[22\] _1469_ _1470_ cpu_inst.regfile_inst.registers\[5\]\[22\]
+ _0562_ VGND VGND VPWR VPWR _1590_ sky130_fd_sc_hd__o221a_1
XFILLER_0_3_673 VPWR VGND VPWR VGND sky130_ef_sc_hd__decap_12
XFILLER_0_113_497 VGND VGND VPWR VPWR sky130_fd_sc_hd__decap_6
X_3588_ _1521_ _1522_ VGND VGND VPWR VPWR _1523_ sky130_fd_sc_hd__or2_1
X_2608_ _0537_ _0538_ _0572_ VGND VGND VPWR VPWR _0573_ sky130_fd_sc_hd__or3_4
X_5327_ clknet_leaf_15_clk _0247_ VGND VGND VPWR VPWR cpu_inst.regfile_inst.registers\[7\]\[23\]
+ sky130_fd_sc_hd__dfxtp_1
X_2539_ cpu_inst.decoder_inst.current_pc\[25\] cpu_inst.decoder_inst.current_pc\[26\]
+ cpu_inst.decoder_inst.current_pc\[27\] cpu_inst.decoder_inst.current_pc\[24\] VGND
+ VGND VPWR VPWR _0504_ sky130_fd_sc_hd__or4_4
XTAP_TAPCELL_ROW_54_1112 VGND VPWR sky130_fd_sc_hd__tapvpwrvgnd_1
XFILLER_0_11_473 VPWR VGND VPWR VGND sky130_ef_sc_hd__decap_12
X_5258_ clknet_leaf_20_clk _0178_ VGND VGND VPWR VPWR cpu_inst.regfile_inst.registers\[5\]\[18\]
+ sky130_fd_sc_hd__dfxtp_1
X_4209_ cpu_inst.regfile_inst.registers\[4\]\[21\] _2046_ VGND VGND VPWR VPWR _2047_
+ sky130_fd_sc_hd__and2_1
X_5189_ clknet_leaf_26_clk _0109_ VGND VGND VPWR VPWR cpu_inst.regfile_inst.registers\[4\]\[13\]
+ sky130_fd_sc_hd__dfxtp_1
XTAP_TAPCELL_ROW_3_344 VGND VPWR sky130_fd_sc_hd__tapvpwrvgnd_1
XFILLER_0_98_738 VGND VGND VPWR VPWR sky130_fd_sc_hd__fill_2
XFILLER_0_3_81 VPWR VGND VPWR VGND sky130_ef_sc_hd__decap_12
XFILLER_0_97_237 VPWR VGND VPWR VGND sky130_ef_sc_hd__decap_12
XFILLER_0_39_805 VGND VGND VPWR VPWR sky130_fd_sc_hd__decap_3
XFILLER_0_93_410 VGND VGND VPWR VPWR sky130_fd_sc_hd__fill_1
XTAP_TAPCELL_ROW_65_1274 VGND VPWR sky130_fd_sc_hd__tapvpwrvgnd_1
XTAP_TAPCELL_ROW_42_928 VGND VPWR sky130_fd_sc_hd__tapvpwrvgnd_1
XFILLER_0_136_501 VPWR VGND VPWR VGND sky130_ef_sc_hd__decap_12
XFILLER_0_136_545 VPWR VGND VPWR VGND sky130_ef_sc_hd__decap_12
XFILLER_0_65_167 VGND VGND VPWR VPWR sky130_fd_sc_hd__fill_1
XFILLER_0_53_329 VGND VGND VPWR VPWR sky130_fd_sc_hd__decap_6
XFILLER_0_19_573 VPWR VGND VPWR VGND sky130_ef_sc_hd__decap_12
XTAP_TAPCELL_ROW_22_630 VGND VPWR sky130_fd_sc_hd__tapvpwrvgnd_1
XFILLER_0_136_589 VPWR VGND VPWR VGND sky130_ef_sc_hd__decap_12
XFILLER_0_123_217 VGND VGND VPWR VPWR sky130_fd_sc_hd__decap_6
XFILLER_0_0_109 VGND VGND VPWR VPWR sky130_fd_sc_hd__decap_3
XFILLER_0_21_237 VPWR VGND VPWR VGND sky130_ef_sc_hd__decap_12
XFILLER_0_22_749 VGND VGND VPWR VPWR sky130_fd_sc_hd__decap_6
XFILLER_0_131_261 VPWR VGND VPWR VGND sky130_ef_sc_hd__decap_12
XFILLER_0_28_27 VGND VGND VPWR VPWR sky130_fd_sc_hd__fill_1
XFILLER_0_135_39 VPWR VGND VPWR VGND sky130_ef_sc_hd__decap_12
XFILLER_0_89_716 VGND VGND VPWR VPWR sky130_fd_sc_hd__fill_1
XFILLER_0_44_15 VPWR VGND VPWR VGND sky130_ef_sc_hd__decap_12
XFILLER_0_57_602 VPWR VGND VPWR VGND sky130_ef_sc_hd__decap_12
XFILLER_0_8_209 VPWR VGND VPWR VGND sky130_ef_sc_hd__decap_12
XFILLER_0_29_337 VPWR VGND VPWR VGND sky130_ef_sc_hd__decap_12
X_2890_ cpu_inst.regfile_inst.registers\[4\]\[12\] _0854_ _0735_ VGND VGND VPWR VPWR
+ _0855_ sky130_fd_sc_hd__o21a_1
XFILLER_0_45_819 VGND VGND VPWR VPWR sky130_fd_sc_hd__decap_4
XFILLER_0_56_189 VGND VGND VPWR VPWR sky130_fd_sc_hd__decap_6
XFILLER_0_44_307 VGND VGND VPWR VPWR sky130_fd_sc_hd__fill_1
XFILLER_0_115_729 VPWR VGND VPWR VGND sky130_ef_sc_hd__decap_12
X_4560_ cpu_inst.regfile_inst.registers\[11\]\[31\] VGND VGND VPWR VPWR _2228_ sky130_fd_sc_hd__clkbuf_1
XFILLER_0_71_137 VPWR VGND VPWR VGND sky130_ef_sc_hd__decap_12
XFILLER_0_65_690 VGND VGND VPWR VPWR sky130_fd_sc_hd__fill_2
XFILLER_0_53_841 VGND VGND VPWR VPWR sky130_fd_sc_hd__fill_1
XFILLER_0_108_781 VPWR VGND VPWR VGND sky130_ef_sc_hd__decap_12
XFILLER_0_107_3 VPWR VGND VPWR VGND sky130_ef_sc_hd__decap_12
XTAP_TAPCELL_ROW_96_1735 VGND VPWR sky130_fd_sc_hd__tapvpwrvgnd_1
XFILLER_0_8_15 VPWR VGND VPWR VGND sky130_ef_sc_hd__decap_12
XFILLER_0_13_727 VGND VGND VPWR VPWR sky130_fd_sc_hd__fill_1
XFILLER_0_25_565 VGND VGND VPWR VPWR sky130_fd_sc_hd__fill_1
XTAP_TAPCELL_ROW_96_1746 VGND VPWR sky130_fd_sc_hd__tapvpwrvgnd_1
X_4491_ _2193_ VGND VGND VPWR VPWR _0252_ sky130_fd_sc_hd__clkbuf_1
XFILLER_0_80_693 VGND VGND VPWR VPWR sky130_fd_sc_hd__fill_1
X_3511_ _1144_ VGND VGND VPWR VPWR _1448_ sky130_fd_sc_hd__buf_2
XFILLER_0_110_401 VPWR VGND VPWR VGND sky130_ef_sc_hd__decap_12
XFILLER_0_100_53 VPWR VGND VPWR VGND sky130_ef_sc_hd__decap_12
X_3442_ _1144_ _1379_ _1380_ _1153_ VGND VGND VPWR VPWR _1381_ sky130_fd_sc_hd__o211a_1
XFILLER_0_110_445 VPWR VGND VPWR VGND sky130_ef_sc_hd__decap_12
XFILLER_0_100_97 VPWR VGND VPWR VGND sky130_ef_sc_hd__decap_12
X_3373_ _1308_ _1322_ VGND VGND VPWR VPWR _1323_ sky130_fd_sc_hd__and2b_1
XFILLER_0_110_489 VPWR VGND VPWR VGND sky130_ef_sc_hd__decap_12
X_5112_ clknet_leaf_40_clk _0032_ VGND VGND VPWR VPWR cpu_inst.regfile_inst.registers\[2\]\[0\]
+ sky130_fd_sc_hd__dfxtp_1
XTAP_TAPCELL_ROW_127_2212 VGND VPWR sky130_fd_sc_hd__tapvpwrvgnd_1
XTAP_TAPCELL_ROW_127_2201 VGND VPWR sky130_fd_sc_hd__tapvpwrvgnd_1
XFILLER_0_85_55 VGND VGND VPWR VPWR sky130_fd_sc_hd__fill_1
XFILLER_0_109_51 VGND VGND VPWR VPWR sky130_fd_sc_hd__decap_4
X_5043_ cpu_inst.display_inst.counter\[6\] _2509_ VGND VGND VPWR VPWR _2512_ sky130_fd_sc_hd__and2_1
XTAP_TAPCELL_ROW_0_303 VGND VPWR sky130_fd_sc_hd__tapvpwrvgnd_1
XFILLER_0_79_237 VPWR VGND VPWR VGND sky130_ef_sc_hd__decap_12
XTAP_TAPCELL_ROW_105_1875 VGND VPWR sky130_fd_sc_hd__tapvpwrvgnd_1
XFILLER_0_87_281 VPWR VGND VPWR VGND sky130_ef_sc_hd__decap_12
XFILLER_0_75_410 VGND VGND VPWR VPWR sky130_fd_sc_hd__fill_1
XFILLER_0_48_613 VGND VGND VPWR VPWR sky130_fd_sc_hd__decap_3
XFILLER_0_118_501 VPWR VGND VPWR VGND sky130_ef_sc_hd__decap_12
XFILLER_0_118_545 VPWR VGND VPWR VGND sky130_ef_sc_hd__decap_12
X_4827_ _2398_ VGND VGND VPWR VPWR _0383_ sky130_fd_sc_hd__clkbuf_1
XFILLER_0_35_329 VGND VGND VPWR VPWR sky130_fd_sc_hd__decap_6
XFILLER_0_47_167 VGND VGND VPWR VPWR sky130_fd_sc_hd__fill_1
XTAP_TAPCELL_ROW_138_2374 VGND VPWR sky130_fd_sc_hd__tapvpwrvgnd_1
XTAP_TAPCELL_ROW_138_2363 VGND VPWR sky130_fd_sc_hd__tapvpwrvgnd_1
XFILLER_0_118_589 VPWR VGND VPWR VGND sky130_ef_sc_hd__decap_12
XFILLER_0_105_217 VGND VGND VPWR VPWR sky130_fd_sc_hd__decap_6
XTAP_TAPCELL_ROW_138_2385 VGND VPWR sky130_fd_sc_hd__tapvpwrvgnd_1
XFILLER_0_133_559 VGND VGND VPWR VPWR sky130_fd_sc_hd__fill_1
XFILLER_0_71_671 VGND VGND VPWR VPWR sky130_fd_sc_hd__fill_1
X_4758_ cpu_inst.decoder_inst.current_pc\[29\] cpu_inst.decoder_inst.current_pc\[30\]
+ _2359_ VGND VGND VPWR VPWR _2363_ sky130_fd_sc_hd__and3_1
XTAP_TAPCELL_ROW_60_1193 VGND VPWR sky130_fd_sc_hd__tapvpwrvgnd_1
XFILLER_0_31_502 VGND VGND VPWR VPWR sky130_fd_sc_hd__fill_2
XFILLER_0_120_209 VPWR VGND VPWR VGND sky130_ef_sc_hd__decap_12
X_3709_ _1545_ _1640_ _1255_ VGND VGND VPWR VPWR _1641_ sky130_fd_sc_hd__mux2_1
X_4689_ _2312_ _2313_ VGND VGND VPWR VPWR _2314_ sky130_fd_sc_hd__or2_1
XFILLER_0_16_587 VGND VGND VPWR VPWR sky130_fd_sc_hd__fill_1
XFILLER_0_43_373 VPWR VGND VPWR VGND sky130_ef_sc_hd__decap_12
XFILLER_0_113_261 VPWR VGND VPWR VGND sky130_ef_sc_hd__decap_12
XTAP_TAPCELL_ROW_8_425 VGND VPWR sky130_fd_sc_hd__tapvpwrvgnd_1
XTAP_TAPCELL_ROW_8_414 VGND VPWR sky130_fd_sc_hd__tapvpwrvgnd_1
XFILLER_0_12_793 VPWR VGND VPWR VGND sky130_ef_sc_hd__decap_12
XFILLER_0_11_281 VPWR VGND VPWR VGND sky130_ef_sc_hd__decap_12
XTAP_TAPCELL_ROW_67_1303 VGND VPWR sky130_fd_sc_hd__tapvpwrvgnd_1
XTAP_TAPCELL_ROW_27_700 VGND VPWR sky130_fd_sc_hd__tapvpwrvgnd_1
XTAP_TAPCELL_ROW_27_711 VGND VPWR sky130_fd_sc_hd__tapvpwrvgnd_1
XFILLER_0_86_719 VGND VGND VPWR VPWR sky130_fd_sc_hd__fill_2
XFILLER_0_128_309 VPWR VGND VPWR VGND sky130_ef_sc_hd__decap_12
XTAP_TAPCELL_ROW_80_1503 VGND VPWR sky130_fd_sc_hd__tapvpwrvgnd_1
XFILLER_0_66_421 VPWR VGND VPWR VGND sky130_ef_sc_hd__decap_12
XFILLER_0_14_29 VPWR VGND VPWR VGND sky130_ef_sc_hd__decap_12
XFILLER_0_137_821 VPWR VGND VPWR VGND sky130_ef_sc_hd__decap_12
XFILLER_0_39_668 VGND VGND VPWR VPWR sky130_fd_sc_hd__decap_4
XFILLER_0_93_273 VGND VGND VPWR VPWR sky130_fd_sc_hd__decap_6
XFILLER_0_26_307 VGND VGND VPWR VPWR sky130_fd_sc_hd__fill_1
XFILLER_0_38_189 VGND VGND VPWR VPWR sky130_fd_sc_hd__decap_6
XFILLER_0_81_446 VGND VGND VPWR VPWR sky130_fd_sc_hd__fill_2
XFILLER_0_35_841 VGND VGND VPWR VPWR sky130_fd_sc_hd__fill_1
XFILLER_0_53_137 VPWR VGND VPWR VGND sky130_ef_sc_hd__decap_12
XFILLER_0_61_181 VPWR VGND VPWR VGND sky130_ef_sc_hd__decap_12
XFILLER_0_22_513 VPWR VGND VPWR VGND sky130_ef_sc_hd__decap_12
XFILLER_0_132_581 VGND VGND VPWR VPWR sky130_fd_sc_hd__decap_6
XTAP_TAPCELL_ROW_78_1476 VGND VPWR sky130_fd_sc_hd__tapvpwrvgnd_1
XTAP_TAPCELL_ROW_78_1465 VGND VPWR sky130_fd_sc_hd__tapvpwrvgnd_1
XFILLER_0_1_429 VPWR VGND VPWR VGND sky130_ef_sc_hd__decap_12
XFILLER_0_22_557 VPWR VGND VPWR VGND sky130_ef_sc_hd__decap_12
XFILLER_0_39_15 VPWR VGND VPWR VGND sky130_ef_sc_hd__decap_12
XTAP_TAPCELL_ROW_91_1665 VGND VPWR sky130_fd_sc_hd__tapvpwrvgnd_1
XFILLER_0_55_69 VPWR VGND VPWR VGND sky130_ef_sc_hd__decap_12
XTAP_TAPCELL_ROW_122_2131 VGND VPWR sky130_fd_sc_hd__tapvpwrvgnd_1
X_3991_ _1709_ _1913_ _1914_ _1555_ VGND VGND VPWR VPWR _1915_ sky130_fd_sc_hd__o211a_1
XFILLER_0_69_281 VPWR VGND VPWR VGND sky130_ef_sc_hd__decap_12
XFILLER_0_71_57 VPWR VGND VPWR VGND sky130_ef_sc_hd__decap_12
XFILLER_0_9_529 VPWR VGND VPWR VGND sky130_ef_sc_hd__decap_12
X_2942_ cpu_inst.regfile_inst.registers\[9\]\[3\] cpu_inst.regfile_inst.registers\[8\]\[3\]
+ _0675_ VGND VGND VPWR VPWR _0907_ sky130_fd_sc_hd__mux2_1
XFILLER_0_84_251 VGND VGND VPWR VPWR sky130_fd_sc_hd__fill_1
XFILLER_0_17_329 VGND VGND VPWR VPWR sky130_fd_sc_hd__decap_6
XFILLER_0_29_167 VGND VGND VPWR VPWR sky130_fd_sc_hd__fill_1
XFILLER_0_26_841 VGND VGND VPWR VPWR sky130_fd_sc_hd__fill_1
X_2873_ _0606_ _0837_ VGND VGND VPWR VPWR _0838_ sky130_fd_sc_hd__or2_1
XTAP_TAPCELL_ROW_100_1794 VGND VPWR sky130_fd_sc_hd__tapvpwrvgnd_1
X_4612_ cpu_inst.regfile_inst.registers\[10\]\[24\] _2252_ VGND VGND VPWR VPWR _2255_
+ sky130_fd_sc_hd__and2_1
XTAP_TAPCELL_ROW_13_493 VGND VPWR sky130_fd_sc_hd__tapvpwrvgnd_1
XFILLER_0_115_559 VGND VGND VPWR VPWR sky130_fd_sc_hd__fill_1
X_4543_ _2219_ VGND VGND VPWR VPWR _0278_ sky130_fd_sc_hd__clkbuf_1
XFILLER_0_53_671 VGND VGND VPWR VPWR sky130_fd_sc_hd__fill_1
XFILLER_0_4_245 VGND VGND VPWR VPWR sky130_fd_sc_hd__decap_6
XFILLER_0_25_373 VPWR VGND VPWR VGND sky130_ef_sc_hd__decap_12
XFILLER_0_40_321 VPWR VGND VPWR VGND sky130_ef_sc_hd__decap_12
XFILLER_0_111_721 VGND VGND VPWR VPWR sky130_fd_sc_hd__decap_6
XFILLER_0_102_209 VPWR VGND VPWR VGND sky130_ef_sc_hd__decap_12
XFILLER_0_4_289 VPWR VGND VPWR VGND sky130_ef_sc_hd__decap_12
XFILLER_0_20_83 VGND VGND VPWR VPWR sky130_fd_sc_hd__fill_1
XTAP_TAPCELL_ROW_133_2293 VGND VPWR sky130_fd_sc_hd__tapvpwrvgnd_1
XFILLER_0_111_765 VPWR VGND VPWR VGND sky130_ef_sc_hd__decap_12
X_4474_ _2184_ VGND VGND VPWR VPWR _0244_ sky130_fd_sc_hd__clkbuf_1
XFILLER_0_40_365 VPWR VGND VPWR VGND sky130_ef_sc_hd__decap_12
XFILLER_0_110_253 VPWR VGND VPWR VGND sky130_ef_sc_hd__decap_12
XFILLER_0_96_65 VPWR VGND VPWR VGND sky130_ef_sc_hd__decap_12
X_3425_ cpu_inst.regfile_inst.registers\[10\]\[16\] cpu_inst.regfile_inst.registers\[11\]\[16\]
+ _0561_ VGND VGND VPWR VPWR _1364_ sky130_fd_sc_hd__mux2_1
XFILLER_0_0_473 VGND VGND VPWR VPWR sky130_fd_sc_hd__decap_3
X_3356_ _1255_ VGND VGND VPWR VPWR _1306_ sky130_fd_sc_hd__clkbuf_4
X_3287_ _1022_ VGND VGND VPWR VPWR _1252_ sky130_fd_sc_hd__buf_4
XFILLER_0_29_81 VPWR VGND VPWR VGND sky130_ef_sc_hd__decap_12
X_5026_ _2502_ VGND VGND VPWR VPWR _0478_ sky130_fd_sc_hd__clkbuf_1
XFILLER_0_31_3 VPWR VGND VPWR VGND sky130_ef_sc_hd__decap_12
XTAP_TAPCELL_ROW_107_1904 VGND VPWR sky130_fd_sc_hd__tapvpwrvgnd_1
XFILLER_0_95_505 VGND VGND VPWR VPWR sky130_fd_sc_hd__fill_2
XTAP_TAPCELL_ROW_49_1033 VGND VPWR sky130_fd_sc_hd__tapvpwrvgnd_1
XFILLER_0_48_421 VPWR VGND VPWR VGND sky130_ef_sc_hd__decap_12
XFILLER_0_138_629 VPWR VGND VPWR VGND sky130_ef_sc_hd__decap_12
XFILLER_0_119_821 VPWR VGND VPWR VGND sky130_ef_sc_hd__decap_12
XFILLER_0_76_763 VGND VGND VPWR VPWR sky130_fd_sc_hd__fill_1
XFILLER_0_75_273 VGND VGND VPWR VPWR sky130_fd_sc_hd__decap_6
XTAP_TAPCELL_ROW_62_1233 VGND VPWR sky130_fd_sc_hd__tapvpwrvgnd_1
XFILLER_0_134_813 VPWR VGND VPWR VGND sky130_ef_sc_hd__decap_12
XFILLER_0_106_515 VGND VGND VPWR VPWR sky130_fd_sc_hd__decap_4
XFILLER_0_90_221 VPWR VGND VPWR VGND sky130_ef_sc_hd__decap_12
XFILLER_0_63_446 VGND VGND VPWR VPWR sky130_fd_sc_hd__fill_2
XFILLER_0_17_841 VGND VGND VPWR VPWR sky130_fd_sc_hd__fill_1
XFILLER_0_35_137 VPWR VGND VPWR VGND sky130_ef_sc_hd__decap_12
XFILLER_0_91_777 VGND VGND VPWR VPWR sky130_fd_sc_hd__fill_1
XFILLER_0_90_265 VPWR VGND VPWR VGND sky130_ef_sc_hd__decap_12
XFILLER_0_63_457 VGND VGND VPWR VPWR sky130_fd_sc_hd__decap_6
XTAP_TAPCELL_ROW_32_780 VGND VPWR sky130_fd_sc_hd__tapvpwrvgnd_1
XFILLER_0_121_529 VPWR VGND VPWR VGND sky130_ef_sc_hd__decap_12
XFILLER_0_114_581 VGND VGND VPWR VPWR sky130_fd_sc_hd__decap_6
XFILLER_0_43_181 VPWR VGND VPWR VGND sky130_ef_sc_hd__decap_12
XFILLER_0_102_754 VGND VGND VPWR VPWR sky130_fd_sc_hd__fill_2
XFILLER_0_102_743 VGND VGND VPWR VPWR sky130_fd_sc_hd__fill_1
XTAP_TAPCELL_ROW_73_1395 VGND VPWR sky130_fd_sc_hd__tapvpwrvgnd_1
XFILLER_0_99_833 VGND VGND VPWR VPWR sky130_fd_sc_hd__decap_6
XFILLER_0_98_321 VPWR VGND VPWR VGND sky130_ef_sc_hd__decap_12
XFILLER_0_98_365 VPWR VGND VPWR VGND sky130_ef_sc_hd__decap_12
XFILLER_0_25_39 VPWR VGND VPWR VGND sky130_ef_sc_hd__decap_12
XFILLER_0_129_629 VPWR VGND VPWR VGND sky130_ef_sc_hd__decap_12
XFILLER_0_132_29 VPWR VGND VPWR VGND sky130_ef_sc_hd__decap_12
XFILLER_0_128_139 VGND VGND VPWR VPWR sky130_fd_sc_hd__fill_1
XFILLER_0_67_785 VGND VGND VPWR VPWR sky130_fd_sc_hd__fill_2
XFILLER_0_66_251 VGND VGND VPWR VPWR sky130_fd_sc_hd__fill_1
XFILLER_0_39_465 VPWR VGND VPWR VGND sky130_ef_sc_hd__decap_12
XFILLER_0_41_27 VPWR VGND VPWR VGND sky130_ef_sc_hd__decap_12
XFILLER_0_137_673 VPWR VGND VPWR VGND sky130_ef_sc_hd__decap_12
XFILLER_0_82_755 VGND VGND VPWR VPWR sky130_fd_sc_hd__fill_1
XFILLER_0_54_435 VGND VGND VPWR VPWR sky130_fd_sc_hd__decap_8
XFILLER_0_124_301 VGND VGND VPWR VPWR sky130_fd_sc_hd__decap_6
XFILLER_0_82_777 VGND VGND VPWR VPWR sky130_fd_sc_hd__decap_8
XFILLER_0_124_345 VPWR VGND VPWR VGND sky130_ef_sc_hd__decap_12
XTAP_TAPCELL_ROW_10_452 VGND VPWR sky130_fd_sc_hd__tapvpwrvgnd_1
XFILLER_0_23_833 VGND VGND VPWR VPWR sky130_fd_sc_hd__decap_6
XFILLER_0_124_389 VPWR VGND VPWR VGND sky130_ef_sc_hd__decap_12
XFILLER_0_2_749 VGND VGND VPWR VPWR sky130_fd_sc_hd__decap_6
XFILLER_0_22_321 VPWR VGND VPWR VGND sky130_ef_sc_hd__decap_12
XFILLER_0_1_237 VPWR VGND VPWR VGND sky130_ef_sc_hd__decap_12
XFILLER_0_22_365 VPWR VGND VPWR VGND sky130_ef_sc_hd__decap_12
XFILLER_0_5_27 VPWR VGND VPWR VGND sky130_ef_sc_hd__decap_12
X_4190_ cpu_inst.regfile_inst.registers\[4\]\[12\] _2035_ VGND VGND VPWR VPWR _2037_
+ sky130_fd_sc_hd__and2_1
X_3210_ _1096_ _0988_ VGND VGND VPWR VPWR _1175_ sky130_fd_sc_hd__xnor2_1
X_3141_ _1104_ _1105_ _0644_ VGND VGND VPWR VPWR _1106_ sky130_fd_sc_hd__mux2_1
X_3072_ _1028_ _1029_ _1032_ _1036_ VGND VGND VPWR VPWR _1037_ sky130_fd_sc_hd__o211a_1
XFILLER_0_106_41 VPWR VGND VPWR VGND sky130_ef_sc_hd__decap_12
XFILLER_0_106_85 VPWR VGND VPWR VGND sky130_ef_sc_hd__decap_12
XTAP_TAPCELL_ROW_102_1823 VGND VPWR sky130_fd_sc_hd__tapvpwrvgnd_1
XFILLER_0_58_752 VGND VGND VPWR VPWR sky130_fd_sc_hd__decap_4
XTAP_TAPCELL_ROW_18_563 VGND VPWR sky130_fd_sc_hd__tapvpwrvgnd_1
XTAP_TAPCELL_ROW_18_574 VGND VPWR sky130_fd_sc_hd__tapvpwrvgnd_1
XTAP_TAPCELL_ROW_102_1834 VGND VPWR sky130_fd_sc_hd__tapvpwrvgnd_1
X_3974_ _0684_ _1879_ _1898_ VGND VGND VPWR VPWR _1899_ sky130_fd_sc_hd__a21o_1
XFILLER_0_73_722 VGND VGND VPWR VPWR sky130_fd_sc_hd__decap_6
XFILLER_0_58_796 VGND VGND VPWR VPWR sky130_fd_sc_hd__decap_6
XFILLER_0_9_337 VPWR VGND VPWR VGND sky130_ef_sc_hd__decap_12
XFILLER_0_134_109 VPWR VGND VPWR VGND sky130_ef_sc_hd__decap_12
XFILLER_0_116_813 VPWR VGND VPWR VGND sky130_ef_sc_hd__decap_12
XFILLER_0_72_221 VPWR VGND VPWR VGND sky130_ef_sc_hd__decap_12
X_2925_ _0665_ _0680_ _0666_ VGND VGND VPWR VPWR _0890_ sky130_fd_sc_hd__o21ai_2
XFILLER_0_57_273 VGND VGND VPWR VPWR sky130_fd_sc_hd__decap_6
XFILLER_0_17_137 VPWR VGND VPWR VGND sky130_ef_sc_hd__decap_12
XTAP_TAPCELL_ROW_135_2322 VGND VPWR sky130_fd_sc_hd__tapvpwrvgnd_1
XFILLER_0_127_161 VGND VGND VPWR VPWR sky130_fd_sc_hd__decap_6
XFILLER_0_73_766 VGND VGND VPWR VPWR sky130_fd_sc_hd__fill_1
XFILLER_0_72_265 VPWR VGND VPWR VGND sky130_ef_sc_hd__decap_12
X_2856_ _0702_ VGND VGND VPWR VPWR _0821_ sky130_fd_sc_hd__clkbuf_4
XFILLER_0_14_811 VGND VGND VPWR VPWR sky130_fd_sc_hd__fill_1
XFILLER_0_26_693 VGND VGND VPWR VPWR sky130_fd_sc_hd__decap_6
XFILLER_0_31_93 VPWR VGND VPWR VGND sky130_ef_sc_hd__decap_12
XFILLER_0_79_3 VPWR VGND VPWR VGND sky130_ef_sc_hd__decap_12
XFILLER_0_25_181 VPWR VGND VPWR VGND sky130_ef_sc_hd__decap_12
X_5575_ clknet_leaf_29_clk _0495_ VGND VGND VPWR VPWR cpu_inst.display_inst.counter\[15\]
+ sky130_fd_sc_hd__dfxtp_1
X_2787_ _0745_ _0746_ _0750_ _0751_ VGND VGND VPWR VPWR _0752_ sky130_fd_sc_hd__o22a_1
X_4526_ cpu_inst.regfile_inst.registers\[11\]\[14\] VGND VGND VPWR VPWR _2211_ sky130_fd_sc_hd__clkbuf_1
XFILLER_0_111_573 VPWR VGND VPWR VGND sky130_ef_sc_hd__decap_12
X_4457_ _1192_ cpu_inst.regfile_inst.registers\[7\]\[12\] _2174_ VGND VGND VPWR VPWR
+ _2176_ sky130_fd_sc_hd__mux2_1
XFILLER_0_40_195 VGND VGND VPWR VPWR sky130_fd_sc_hd__fill_1
X_3408_ _1134_ _1246_ _1345_ _1111_ _1247_ VGND VGND VPWR VPWR _1347_ sky130_fd_sc_hd__o221a_1
XFILLER_0_0_281 VPWR VGND VPWR VGND sky130_ef_sc_hd__decap_12
XTAP_TAPCELL_ROW_113_1996 VGND VPWR sky130_fd_sc_hd__tapvpwrvgnd_1
X_4388_ _2139_ VGND VGND VPWR VPWR _0203_ sky130_fd_sc_hd__clkbuf_1
X_3339_ _1285_ _0647_ _1283_ VGND VGND VPWR VPWR _1294_ sky130_fd_sc_hd__and3_1
XPHY_EDGE_ROW_134_Right_134 VGND VGND VPWR VPWR sky130_fd_sc_hd__decap_3
X_5009_ cpu_inst.regfile_inst.registers\[15\]\[22\] _2491_ VGND VGND VPWR VPWR _2494_
+ sky130_fd_sc_hd__and2_1
XFILLER_0_68_505 VGND VGND VPWR VPWR sky130_fd_sc_hd__fill_2
XFILLER_0_96_825 VPWR VGND VPWR VGND sky130_ef_sc_hd__decap_12
XTAP_TAPCELL_ROW_37_850 VGND VPWR sky130_fd_sc_hd__tapvpwrvgnd_1
XTAP_TAPCELL_ROW_37_861 VGND VPWR sky130_fd_sc_hd__tapvpwrvgnd_1
XFILLER_0_95_335 VGND VGND VPWR VPWR sky130_fd_sc_hd__fill_1
XFILLER_0_49_752 VGND VGND VPWR VPWR sky130_fd_sc_hd__decap_8
XFILLER_0_76_560 VPWR VGND VPWR VGND sky130_ef_sc_hd__decap_12
XFILLER_0_48_251 VGND VGND VPWR VPWR sky130_fd_sc_hd__fill_1
XFILLER_0_119_673 VPWR VGND VPWR VGND sky130_ef_sc_hd__decap_12
XFILLER_0_64_755 VGND VGND VPWR VPWR sky130_fd_sc_hd__fill_1
XFILLER_0_36_413 VGND VGND VPWR VPWR sky130_fd_sc_hd__decap_6
XFILLER_0_106_301 VGND VGND VPWR VPWR sky130_fd_sc_hd__decap_6
XFILLER_0_91_574 VPWR VGND VPWR VGND sky130_ef_sc_hd__decap_12
XFILLER_0_134_643 VGND VGND VPWR VPWR sky130_fd_sc_hd__fill_1
XFILLER_0_122_805 VGND VGND VPWR VPWR sky130_fd_sc_hd__decap_6
XFILLER_0_106_345 VPWR VGND VPWR VGND sky130_ef_sc_hd__decap_12
XFILLER_0_17_671 VGND VGND VPWR VPWR sky130_fd_sc_hd__fill_1
XFILLER_0_106_389 VPWR VGND VPWR VGND sky130_ef_sc_hd__decap_12
XFILLER_0_51_449 VPWR VGND VPWR VGND sky130_ef_sc_hd__decap_12
XFILLER_0_121_337 VPWR VGND VPWR VGND sky130_ef_sc_hd__decap_12
XTAP_TAPCELL_ROW_75_1424 VGND VPWR sky130_fd_sc_hd__tapvpwrvgnd_1
XFILLER_0_20_825 VPWR VGND VPWR VGND sky130_ef_sc_hd__decap_12
XFILLER_0_36_27 VGND VGND VPWR VPWR sky130_fd_sc_hd__fill_1
XPHY_EDGE_ROW_101_Right_101 VGND VGND VPWR VPWR sky130_fd_sc_hd__decap_3
XFILLER_0_87_836 VGND VGND VPWR VPWR sky130_fd_sc_hd__decap_4
XFILLER_0_52_15 VPWR VGND VPWR VGND sky130_ef_sc_hd__decap_12
XFILLER_0_98_195 VGND VGND VPWR VPWR sky130_fd_sc_hd__fill_1
XTAP_TAPCELL_ROW_86_1597 VGND VPWR sky130_fd_sc_hd__tapvpwrvgnd_1
XFILLER_0_86_357 VGND VGND VPWR VPWR sky130_fd_sc_hd__decap_6
XTAP_TAPCELL_ROW_86_1586 VGND VPWR sky130_fd_sc_hd__tapvpwrvgnd_1
XTAP_TAPCELL_ROW_15_522 VGND VPWR sky130_fd_sc_hd__tapvpwrvgnd_1
XFILLER_0_116_109 VPWR VGND VPWR VGND sky130_ef_sc_hd__decap_12
XFILLER_0_54_221 VPWR VGND VPWR VGND sky130_ef_sc_hd__decap_12
XFILLER_0_6_307 VGND VGND VPWR VPWR sky130_fd_sc_hd__fill_1
XFILLER_0_39_273 VGND VGND VPWR VPWR sky130_fd_sc_hd__decap_6
XFILLER_0_109_161 VGND VGND VPWR VPWR sky130_fd_sc_hd__decap_6
XFILLER_0_82_541 VGND VGND VPWR VPWR sky130_fd_sc_hd__decap_6
X_2710_ _0648_ VGND VGND VPWR VPWR _0675_ sky130_fd_sc_hd__buf_4
XFILLER_0_125_665 VGND VGND VPWR VPWR sky130_fd_sc_hd__decap_6
X_3690_ cpu_inst.regfile_inst.registers\[8\]\[23\] _1621_ _0850_ VGND VGND VPWR VPWR
+ _1622_ sky130_fd_sc_hd__mux2_1
XFILLER_0_54_265 VPWR VGND VPWR VGND sky130_ef_sc_hd__decap_12
XFILLER_0_124_153 VPWR VGND VPWR VGND sky130_ef_sc_hd__decap_12
XTAP_TAPCELL_ROW_117_2052 VGND VPWR sky130_fd_sc_hd__tapvpwrvgnd_1
X_2641_ _0569_ _0524_ VGND VGND VPWR VPWR _0606_ sky130_fd_sc_hd__nand2_4
XFILLER_0_2_513 VPWR VGND VPWR VGND sky130_ef_sc_hd__decap_12
XFILLER_0_23_641 VPWR VGND VPWR VGND sky130_ef_sc_hd__decap_12
XFILLER_0_124_197 VPWR VGND VPWR VGND sky130_ef_sc_hd__decap_12
X_5360_ clknet_leaf_8_clk _0280_ VGND VGND VPWR VPWR cpu_inst.regfile_inst.registers\[11\]\[24\]
+ sky130_fd_sc_hd__dfxtp_1
X_2572_ _0516_ VGND VGND VPWR VPWR _0537_ sky130_fd_sc_hd__buf_6
XFILLER_0_2_557 VPWR VGND VPWR VGND sky130_ef_sc_hd__decap_12
XFILLER_0_23_685 VPWR VGND VPWR VGND sky130_ef_sc_hd__decap_12
XTAP_TAPCELL_ROW_130_2252 VGND VPWR sky130_fd_sc_hd__tapvpwrvgnd_1
X_5291_ clknet_leaf_18_clk _0211_ VGND VGND VPWR VPWR cpu_inst.regfile_inst.registers\[1\]\[19\]
+ sky130_fd_sc_hd__dfxtp_1
XFILLER_0_22_195 VGND VGND VPWR VPWR sky130_fd_sc_hd__fill_1
X_4311_ _1168_ cpu_inst.regfile_inst.registers\[5\]\[6\] _2092_ VGND VGND VPWR VPWR
+ _2100_ sky130_fd_sc_hd__mux2_1
XFILLER_0_10_357 VGND VGND VPWR VPWR sky130_fd_sc_hd__decap_6
X_4242_ _2063_ VGND VGND VPWR VPWR _0133_ sky130_fd_sc_hd__clkbuf_1
X_4173_ cpu_inst.regfile_inst.registers\[4\]\[4\] _2024_ VGND VGND VPWR VPWR _2028_
+ sky130_fd_sc_hd__and2_1
XFILLER_0_93_55 VGND VGND VPWR VPWR sky130_fd_sc_hd__fill_1
X_3124_ _0573_ _1084_ _1088_ _1086_ VGND VGND VPWR VPWR _1089_ sky130_fd_sc_hd__o22a_2
XFILLER_0_117_51 VGND VGND VPWR VPWR sky130_fd_sc_hd__decap_4
X_3055_ _0974_ _0987_ _0975_ VGND VGND VPWR VPWR _1020_ sky130_fd_sc_hd__o21a_1
XFILLER_0_77_335 VGND VGND VPWR VPWR sky130_fd_sc_hd__fill_1
XFILLER_0_93_839 VGND VGND VPWR VPWR sky130_fd_sc_hd__fill_1
XFILLER_0_46_711 VGND VGND VPWR VPWR sky130_fd_sc_hd__fill_1
X_3957_ cpu_inst.regfile_inst.registers\[11\]\[30\] cpu_inst.regfile_inst.registers\[10\]\[30\]
+ _1592_ VGND VGND VPWR VPWR _1882_ sky130_fd_sc_hd__mux2_1
XFILLER_0_9_167 VGND VGND VPWR VPWR sky130_fd_sc_hd__fill_1
XFILLER_0_18_413 VGND VGND VPWR VPWR sky130_fd_sc_hd__decap_6
XFILLER_0_46_733 VPWR VGND VPWR VGND sky130_ef_sc_hd__decap_12
XFILLER_0_135_429 VPWR VGND VPWR VGND sky130_ef_sc_hd__decap_12
X_2908_ cpu_inst.regfile_inst.registers\[9\]\[12\] cpu_inst.regfile_inst.registers\[8\]\[12\]
+ _0867_ VGND VGND VPWR VPWR _0873_ sky130_fd_sc_hd__mux2_1
XFILLER_0_73_552 VGND VGND VPWR VPWR sky130_fd_sc_hd__fill_1
XFILLER_0_18_457 VPWR VGND VPWR VGND sky130_ef_sc_hd__decap_12
XFILLER_0_116_643 VGND VGND VPWR VPWR sky130_fd_sc_hd__fill_1
XFILLER_0_104_805 VGND VGND VPWR VPWR sky130_fd_sc_hd__decap_6
X_3888_ cpu_inst.regfile_inst.registers\[24\]\[28\] _1384_ _0700_ _1814_ _0961_ VGND
+ VGND VPWR VPWR _1815_ sky130_fd_sc_hd__o221a_1
XFILLER_0_6_841 VGND VGND VPWR VPWR sky130_fd_sc_hd__fill_1
XFILLER_0_33_405 VPWR VGND VPWR VGND sky130_ef_sc_hd__decap_12
XFILLER_0_5_373 VPWR VGND VPWR VGND sky130_ef_sc_hd__decap_12
XFILLER_0_33_449 VGND VGND VPWR VPWR sky130_fd_sc_hd__decap_8
X_2839_ _0612_ _0803_ VGND VGND VPWR VPWR _0804_ sky130_fd_sc_hd__nand2_1
XFILLER_0_103_337 VPWR VGND VPWR VGND sky130_ef_sc_hd__decap_12
X_5558_ clknet_leaf_3_clk _0478_ VGND VGND VPWR VPWR cpu_inst.regfile_inst.registers\[15\]\[30\]
+ sky130_fd_sc_hd__dfxtp_1
XTAP_TAPCELL_ROW_57_1154 VGND VPWR sky130_fd_sc_hd__tapvpwrvgnd_1
X_4509_ _2202_ VGND VGND VPWR VPWR _0261_ sky130_fd_sc_hd__clkbuf_1
XFILLER_0_130_189 VGND VGND VPWR VPWR sky130_fd_sc_hd__decap_6
X_5489_ clknet_leaf_14_clk _0409_ VGND VGND VPWR VPWR cpu_inst.regfile_inst.registers\[9\]\[25\]
+ sky130_fd_sc_hd__dfxtp_1
XTAP_TAPCELL_ROW_70_1354 VGND VPWR sky130_fd_sc_hd__tapvpwrvgnd_1
XTAP_TAPCELL_ROW_70_1343 VGND VPWR sky130_fd_sc_hd__tapvpwrvgnd_1
Xclkbuf_leaf_38_clk clknet_2_0__leaf_clk VGND VGND VPWR VPWR clknet_leaf_38_clk sky130_fd_sc_hd__clkbuf_8
XFILLER_0_83_305 VPWR VGND VPWR VGND sky130_ef_sc_hd__decap_12
XFILLER_0_68_379 VGND VGND VPWR VPWR sky130_fd_sc_hd__fill_1
XFILLER_0_83_349 VPWR VGND VPWR VGND sky130_ef_sc_hd__decap_12
XFILLER_0_22_29 VPWR VGND VPWR VGND sky130_ef_sc_hd__decap_12
XFILLER_0_64_530 VGND VGND VPWR VPWR sky130_fd_sc_hd__fill_2
XFILLER_0_36_221 VPWR VGND VPWR VGND sky130_ef_sc_hd__decap_12
XFILLER_0_37_777 VGND VGND VPWR VPWR sky130_fd_sc_hd__decap_6
XFILLER_0_36_265 VPWR VGND VPWR VGND sky130_ef_sc_hd__decap_12
XFILLER_0_122_613 VPWR VGND VPWR VGND sky130_ef_sc_hd__decap_12
XFILLER_0_106_153 VPWR VGND VPWR VGND sky130_ef_sc_hd__decap_12
XFILLER_0_122_657 VPWR VGND VPWR VGND sky130_ef_sc_hd__decap_12
XFILLER_0_106_197 VPWR VGND VPWR VGND sky130_ef_sc_hd__decap_12
XFILLER_0_51_279 VGND VGND VPWR VPWR sky130_fd_sc_hd__fill_1
XFILLER_0_121_167 VGND VGND VPWR VPWR sky130_fd_sc_hd__fill_1
XFILLER_0_60_791 VGND VGND VPWR VPWR sky130_fd_sc_hd__decap_8
XFILLER_0_20_699 VGND VGND VPWR VPWR sky130_fd_sc_hd__fill_1
XFILLER_0_47_15 VPWR VGND VPWR VGND sky130_ef_sc_hd__decap_12
XTAP_TAPCELL_ROW_88_1615 VGND VPWR sky130_fd_sc_hd__tapvpwrvgnd_1
XTAP_TAPCELL_ROW_88_1626 VGND VPWR sky130_fd_sc_hd__tapvpwrvgnd_1
Xclkbuf_leaf_29_clk clknet_2_2__leaf_clk VGND VGND VPWR VPWR clknet_leaf_29_clk sky130_fd_sc_hd__clkbuf_8
XFILLER_0_86_121 VPWR VGND VPWR VGND sky130_ef_sc_hd__decap_12
XFILLER_0_63_69 VPWR VGND VPWR VGND sky130_ef_sc_hd__decap_12
XFILLER_0_59_346 VGND VGND VPWR VPWR sky130_fd_sc_hd__fill_2
XFILLER_0_129_223 VGND VGND VPWR VPWR sky130_fd_sc_hd__fill_1
XFILLER_0_87_666 VGND VGND VPWR VPWR sky130_fd_sc_hd__decap_6
XFILLER_0_86_165 VPWR VGND VPWR VGND sky130_ef_sc_hd__decap_12
X_4860_ cpu_inst.regfile_inst.registers\[9\]\[16\] VGND VGND VPWR VPWR _2415_ sky130_fd_sc_hd__clkbuf_1
XFILLER_0_75_839 VGND VGND VPWR VPWR sky130_fd_sc_hd__fill_1
XFILLER_0_47_519 VGND VGND VPWR VPWR sky130_fd_sc_hd__fill_1
XFILLER_0_137_3 VPWR VGND VPWR VGND sky130_ef_sc_hd__decap_12
X_3811_ cpu_inst.regfile_inst.registers\[0\]\[26\] _1667_ _1668_ cpu_inst.regfile_inst.registers\[4\]\[26\]
+ _1560_ VGND VGND VPWR VPWR _1740_ sky130_fd_sc_hd__o221a_1
XFILLER_0_117_429 VPWR VGND VPWR VGND sky130_ef_sc_hd__decap_12
X_4791_ _2380_ VGND VGND VPWR VPWR _0365_ sky130_fd_sc_hd__clkbuf_1
XFILLER_0_28_755 VGND VGND VPWR VPWR sky130_fd_sc_hd__fill_1
X_3742_ _1552_ _1666_ _1669_ _1672_ VGND VGND VPWR VPWR _1673_ sky130_fd_sc_hd__o22a_1
XFILLER_0_82_371 VGND VGND VPWR VPWR sky130_fd_sc_hd__fill_1
XFILLER_0_15_405 VPWR VGND VPWR VGND sky130_ef_sc_hd__decap_12
XFILLER_0_28_799 VGND VGND VPWR VPWR sky130_fd_sc_hd__fill_1
XFILLER_0_125_473 VPWR VGND VPWR VGND sky130_ef_sc_hd__decap_12
XTAP_TAPCELL_ROW_99_1788 VGND VPWR sky130_fd_sc_hd__tapvpwrvgnd_1
X_3673_ _1487_ _1453_ _1153_ VGND VGND VPWR VPWR _1606_ sky130_fd_sc_hd__o21a_1
XFILLER_0_70_533 VGND VGND VPWR VPWR sky130_fd_sc_hd__decap_4
XFILLER_0_15_449 VPWR VGND VPWR VGND sky130_ef_sc_hd__decap_12
X_5412_ clknet_leaf_0_clk _0332_ net2 VGND VGND VPWR VPWR cpu_inst.decoder_inst.current_pc\[12\]
+ sky130_fd_sc_hd__dfrtp_1
XFILLER_0_3_833 VGND VGND VPWR VPWR sky130_fd_sc_hd__decap_6
XFILLER_0_2_321 VPWR VGND VPWR VGND sky130_ef_sc_hd__decap_12
XFILLER_0_30_419 VGND VGND VPWR VPWR sky130_fd_sc_hd__fill_1
X_2624_ _0584_ _0585_ _0587_ _0588_ VGND VGND VPWR VPWR _0589_ sky130_fd_sc_hd__o211a_1
XFILLER_0_100_307 VGND VGND VPWR VPWR sky130_fd_sc_hd__fill_1
XFILLER_0_88_77 VGND VGND VPWR VPWR sky130_fd_sc_hd__decap_6
XFILLER_0_2_365 VPWR VGND VPWR VGND sky130_ef_sc_hd__decap_12
X_5343_ clknet_leaf_34_clk _0263_ VGND VGND VPWR VPWR cpu_inst.regfile_inst.registers\[11\]\[7\]
+ sky130_fd_sc_hd__dfxtp_1
XPHY_EDGE_ROW_120_Left_259 VGND VGND VPWR VPWR sky130_fd_sc_hd__decap_3
XFILLER_0_112_189 VGND VGND VPWR VPWR sky130_fd_sc_hd__decap_6
X_2555_ _0519_ VGND VGND VPWR VPWR _0520_ sky130_fd_sc_hd__buf_2
XFILLER_0_10_121 VPWR VGND VPWR VGND sky130_ef_sc_hd__decap_12
XFILLER_0_10_165 VPWR VGND VPWR VGND sky130_ef_sc_hd__decap_12
X_5274_ clknet_leaf_38_clk _0194_ VGND VGND VPWR VPWR cpu_inst.regfile_inst.registers\[1\]\[2\]
+ sky130_fd_sc_hd__dfxtp_1
XTAP_TAPCELL_ROW_110_1955 VGND VPWR sky130_fd_sc_hd__tapvpwrvgnd_1
XTAP_TAPCELL_ROW_110_1944 VGND VPWR sky130_fd_sc_hd__tapvpwrvgnd_1
X_4225_ cpu_inst.regfile_inst.registers\[4\]\[29\] _2046_ VGND VGND VPWR VPWR _2055_
+ sky130_fd_sc_hd__and2_1
X_4156_ _1867_ cpu_inst.regfile_inst.registers\[25\]\[29\] _2010_ VGND VGND VPWR VPWR
+ _2018_ sky130_fd_sc_hd__mux2_1
XTAP_TAPCELL_ROW_52_1084 VGND VPWR sky130_fd_sc_hd__tapvpwrvgnd_1
XTAP_TAPCELL_ROW_52_1073 VGND VPWR sky130_fd_sc_hd__tapvpwrvgnd_1
XFILLER_0_128_83 VGND VGND VPWR VPWR sky130_fd_sc_hd__fill_1
X_3107_ _1067_ _1071_ _1062_ VGND VGND VPWR VPWR _1072_ sky130_fd_sc_hd__mux2_1
XFILLER_0_37_81 VPWR VGND VPWR VGND sky130_ef_sc_hd__decap_12
X_4087_ _1979_ VGND VGND VPWR VPWR _0062_ sky130_fd_sc_hd__clkbuf_1
X_3038_ _0994_ _1001_ VGND VGND VPWR VPWR _1003_ sky130_fd_sc_hd__nand2_1
XFILLER_0_65_305 VGND VGND VPWR VPWR sky130_fd_sc_hd__decap_6
XFILLER_0_136_749 VGND VGND VPWR VPWR sky130_fd_sc_hd__decap_6
XFILLER_0_81_809 VGND VGND VPWR VPWR sky130_fd_sc_hd__fill_2
X_4989_ _2483_ VGND VGND VPWR VPWR _0460_ sky130_fd_sc_hd__clkbuf_1
XFILLER_0_65_349 VPWR VGND VPWR VGND sky130_ef_sc_hd__decap_12
XFILLER_0_18_221 VPWR VGND VPWR VGND sky130_ef_sc_hd__decap_12
XFILLER_0_19_777 VGND VGND VPWR VPWR sky130_fd_sc_hd__decap_6
XFILLER_0_135_237 VPWR VGND VPWR VGND sky130_ef_sc_hd__decap_12
XFILLER_0_61_511 VGND VGND VPWR VPWR sky130_fd_sc_hd__fill_1
XFILLER_0_18_265 VPWR VGND VPWR VGND sky130_ef_sc_hd__decap_12
XFILLER_0_46_563 VGND VGND VPWR VPWR sky130_fd_sc_hd__decap_4
XFILLER_0_73_393 VGND VGND VPWR VPWR sky130_fd_sc_hd__decap_6
XFILLER_0_61_544 VPWR VGND VPWR VGND sky130_ef_sc_hd__decap_12
XFILLER_0_34_747 VGND VGND VPWR VPWR sky130_fd_sc_hd__decap_8
XFILLER_0_34_769 VPWR VGND VPWR VGND sky130_ef_sc_hd__decap_12
XFILLER_0_6_693 VGND VGND VPWR VPWR sky130_fd_sc_hd__decap_6
XFILLER_0_5_181 VPWR VGND VPWR VGND sky130_ef_sc_hd__decap_12
XFILLER_0_33_279 VGND VGND VPWR VPWR sky130_fd_sc_hd__fill_1
XFILLER_0_103_167 VGND VGND VPWR VPWR sky130_fd_sc_hd__fill_1
XFILLER_0_100_841 VGND VGND VPWR VPWR sky130_fd_sc_hd__fill_1
XTAP_TAPCELL_ROW_6_386 VGND VPWR sky130_fd_sc_hd__tapvpwrvgnd_1
XTAP_TAPCELL_ROW_6_397 VGND VPWR sky130_fd_sc_hd__tapvpwrvgnd_1
XFILLER_0_69_633 VPWR VGND VPWR VGND sky130_ef_sc_hd__decap_12
XFILLER_0_68_121 VPWR VGND VPWR VGND sky130_ef_sc_hd__decap_12
XTAP_TAPCELL_ROW_83_1545 VGND VPWR sky130_fd_sc_hd__tapvpwrvgnd_1
XFILLER_0_68_165 VPWR VGND VPWR VGND sky130_ef_sc_hd__decap_12
XFILLER_0_33_39 VPWR VGND VPWR VGND sky130_ef_sc_hd__decap_12
XFILLER_0_84_625 VGND VGND VPWR VPWR sky130_fd_sc_hd__decap_8
XFILLER_0_83_113 VPWR VGND VPWR VGND sky130_ef_sc_hd__decap_12
XFILLER_0_127_727 VGND VGND VPWR VPWR sky130_fd_sc_hd__fill_1
XTAP_TAPCELL_ROW_25_672 VGND VPWR sky130_fd_sc_hd__tapvpwrvgnd_1
XFILLER_0_122_421 VPWR VGND VPWR VGND sky130_ef_sc_hd__decap_12
XTAP_TAPCELL_ROW_114_2011 VGND VPWR sky130_fd_sc_hd__tapvpwrvgnd_1
XFILLER_0_12_419 VGND VGND VPWR VPWR sky130_fd_sc_hd__fill_1
XFILLER_0_40_717 VGND VGND VPWR VPWR sky130_fd_sc_hd__fill_1
XFILLER_0_0_825 VPWR VGND VPWR VGND sky130_ef_sc_hd__decap_12
X_4010_ _1308_ _1932_ VGND VGND VPWR VPWR _1933_ sky130_fd_sc_hd__nor2_1
XTAP_TAPCELL_ROW_125_2173 VGND VPWR sky130_fd_sc_hd__tapvpwrvgnd_1
X_4912_ _1942_ cpu_inst.regfile_inst.registers\[8\]\[8\] _2436_ VGND VGND VPWR VPWR
+ _2443_ sky130_fd_sc_hd__mux2_1
XFILLER_0_47_305 VPWR VGND VPWR VGND sky130_ef_sc_hd__decap_12
XFILLER_0_114_41 VPWR VGND VPWR VGND sky130_ef_sc_hd__decap_12
XFILLER_0_87_485 VPWR VGND VPWR VGND sky130_ef_sc_hd__decap_12
XFILLER_0_118_749 VGND VGND VPWR VPWR sky130_fd_sc_hd__decap_6
XFILLER_0_114_85 VPWR VGND VPWR VGND sky130_ef_sc_hd__decap_12
X_4843_ _2406_ VGND VGND VPWR VPWR _0391_ sky130_fd_sc_hd__clkbuf_1
XFILLER_0_47_349 VPWR VGND VPWR VGND sky130_ef_sc_hd__decap_12
XFILLER_0_117_237 VPWR VGND VPWR VGND sky130_ef_sc_hd__decap_12
XFILLER_0_16_725 VPWR VGND VPWR VGND sky130_ef_sc_hd__decap_12
X_4774_ cpu_inst.regfile_inst.registers\[0\]\[4\] VGND VGND VPWR VPWR _2372_ sky130_fd_sc_hd__clkbuf_1
X_3725_ _1654_ _1655_ _1312_ VGND VGND VPWR VPWR _1656_ sky130_fd_sc_hd__mux2_1
XFILLER_0_55_393 VGND VGND VPWR VPWR sky130_fd_sc_hd__fill_2
XFILLER_0_16_769 VPWR VGND VPWR VGND sky130_ef_sc_hd__decap_12
XFILLER_0_126_793 VPWR VGND VPWR VGND sky130_ef_sc_hd__decap_12
XFILLER_0_125_281 VPWR VGND VPWR VGND sky130_ef_sc_hd__decap_12
Xclkbuf_leaf_9_clk clknet_2_1__leaf_clk VGND VGND VPWR VPWR clknet_leaf_9_clk sky130_fd_sc_hd__clkbuf_8
X_3656_ cpu_inst.regfile_inst.registers\[0\]\[22\] _1469_ _1470_ cpu_inst.regfile_inst.registers\[4\]\[22\]
+ _0853_ VGND VGND VPWR VPWR _1589_ sky130_fd_sc_hd__o221a_1
XFILLER_0_3_641 VPWR VGND VPWR VGND sky130_ef_sc_hd__decap_12
XFILLER_0_15_279 VGND VGND VPWR VPWR sky130_fd_sc_hd__fill_1
X_3587_ _0686_ _1509_ _1520_ VGND VGND VPWR VPWR _1522_ sky130_fd_sc_hd__and3_1
XFILLER_0_61_3 VPWR VGND VPWR VGND sky130_ef_sc_hd__decap_12
X_2607_ _0510_ _0520_ VGND VGND VPWR VPWR _0572_ sky130_fd_sc_hd__or2_1
XFILLER_0_11_441 VGND VGND VPWR VPWR sky130_fd_sc_hd__decap_6
XFILLER_0_3_685 VPWR VGND VPWR VGND sky130_ef_sc_hd__decap_12
XFILLER_0_101_649 VGND VGND VPWR VPWR sky130_fd_sc_hd__decap_3
X_5326_ clknet_leaf_15_clk _0246_ VGND VGND VPWR VPWR cpu_inst.regfile_inst.registers\[7\]\[22\]
+ sky130_fd_sc_hd__dfxtp_1
X_2538_ cpu_inst.decoder_inst.current_pc\[29\] cpu_inst.decoder_inst.current_pc\[28\]
+ cpu_inst.decoder_inst.current_pc\[31\] cpu_inst.decoder_inst.current_pc\[30\] VGND
+ VGND VPWR VPWR _0503_ sky130_fd_sc_hd__or4_4
XTAP_TAPCELL_ROW_54_1113 VGND VPWR sky130_fd_sc_hd__tapvpwrvgnd_1
XFILLER_0_11_485 VPWR VGND VPWR VGND sky130_ef_sc_hd__decap_12
XFILLER_0_2_195 VGND VGND VPWR VPWR sky130_fd_sc_hd__fill_1
X_5257_ clknet_leaf_25_clk _0177_ VGND VGND VPWR VPWR cpu_inst.regfile_inst.registers\[5\]\[17\]
+ sky130_fd_sc_hd__dfxtp_1
X_4208_ _2023_ VGND VGND VPWR VPWR _2046_ sky130_fd_sc_hd__buf_2
X_5188_ clknet_leaf_20_clk _0108_ VGND VGND VPWR VPWR cpu_inst.regfile_inst.registers\[4\]\[12\]
+ sky130_fd_sc_hd__dfxtp_1
XTAP_TAPCELL_ROW_3_345 VGND VPWR sky130_fd_sc_hd__tapvpwrvgnd_1
XFILLER_0_97_205 VPWR VGND VPWR VGND sky130_ef_sc_hd__decap_12
X_4139_ _1574_ cpu_inst.regfile_inst.registers\[25\]\[21\] _1998_ VGND VGND VPWR VPWR
+ _2009_ sky130_fd_sc_hd__mux2_1
XFILLER_0_97_249 VPWR VGND VPWR VGND sky130_ef_sc_hd__decap_12
XFILLER_0_3_93 VPWR VGND VPWR VGND sky130_ef_sc_hd__decap_12
XFILLER_0_78_474 VGND VGND VPWR VPWR sky130_fd_sc_hd__fill_2
XFILLER_0_65_113 VPWR VGND VPWR VGND sky130_ef_sc_hd__decap_12
XTAP_TAPCELL_ROW_42_929 VGND VPWR sky130_fd_sc_hd__tapvpwrvgnd_1
XFILLER_0_136_513 VPWR VGND VPWR VGND sky130_ef_sc_hd__decap_12
XFILLER_0_109_727 VGND VGND VPWR VPWR sky130_fd_sc_hd__fill_1
XTAP_TAPCELL_ROW_65_1275 VGND VPWR sky130_fd_sc_hd__tapvpwrvgnd_1
XFILLER_0_19_541 VPWR VGND VPWR VGND sky130_ef_sc_hd__decap_12
XFILLER_0_136_557 VPWR VGND VPWR VGND sky130_ef_sc_hd__decap_12
XFILLER_0_81_617 VGND VGND VPWR VPWR sky130_fd_sc_hd__decap_8
XFILLER_0_19_585 VPWR VGND VPWR VGND sky130_ef_sc_hd__decap_12
XTAP_TAPCELL_ROW_22_631 VGND VPWR sky130_fd_sc_hd__tapvpwrvgnd_1
XFILLER_0_104_421 VGND VGND VPWR VPWR sky130_fd_sc_hd__decap_6
XFILLER_0_34_566 VGND VGND VPWR VPWR sky130_fd_sc_hd__decap_3
XFILLER_0_104_465 VGND VGND VPWR VPWR sky130_fd_sc_hd__decap_8
XFILLER_0_21_205 VPWR VGND VPWR VGND sky130_ef_sc_hd__decap_12
XFILLER_0_131_273 VGND VGND VPWR VPWR sky130_fd_sc_hd__decap_6
XFILLER_0_21_249 VPWR VGND VPWR VGND sky130_ef_sc_hd__decap_12
XFILLER_0_44_27 VGND VGND VPWR VPWR sky130_fd_sc_hd__fill_1
XFILLER_0_69_474 VGND VGND VPWR VPWR sky130_fd_sc_hd__fill_1
XFILLER_0_57_636 VGND VGND VPWR VPWR sky130_fd_sc_hd__fill_1
XFILLER_0_57_614 VGND VGND VPWR VPWR sky130_fd_sc_hd__fill_2
XFILLER_0_29_305 VPWR VGND VPWR VGND sky130_ef_sc_hd__decap_12
XFILLER_0_60_15 VPWR VGND VPWR VGND sky130_ef_sc_hd__decap_12
XFILLER_0_57_669 VGND VGND VPWR VPWR sky130_fd_sc_hd__decap_3
XFILLER_0_29_349 VPWR VGND VPWR VGND sky130_ef_sc_hd__decap_12
XFILLER_0_72_639 VGND VGND VPWR VPWR sky130_fd_sc_hd__decap_4
XFILLER_0_71_105 VGND VGND VPWR VPWR sky130_fd_sc_hd__decap_6
XFILLER_0_71_149 VPWR VGND VPWR VGND sky130_ef_sc_hd__decap_12
XFILLER_0_37_393 VPWR VGND VPWR VGND sky130_ef_sc_hd__decap_12
XFILLER_0_108_793 VPWR VGND VPWR VGND sky130_ef_sc_hd__decap_12
XFILLER_0_107_281 VPWR VGND VPWR VGND sky130_ef_sc_hd__decap_12
XTAP_TAPCELL_ROW_96_1736 VGND VPWR sky130_fd_sc_hd__tapvpwrvgnd_1
X_3510_ _1408_ _1445_ _1421_ VGND VGND VPWR VPWR _1447_ sky130_fd_sc_hd__nand3_1
XFILLER_0_52_363 VGND VGND VPWR VPWR sky130_fd_sc_hd__fill_1
XFILLER_0_8_27 VGND VGND VPWR VPWR sky130_fd_sc_hd__fill_1
XFILLER_0_123_741 VPWR VGND VPWR VGND sky130_ef_sc_hd__decap_12
XTAP_TAPCELL_ROW_96_1747 VGND VPWR sky130_fd_sc_hd__tapvpwrvgnd_1
X_4490_ _1833_ cpu_inst.regfile_inst.registers\[7\]\[28\] _2186_ VGND VGND VPWR VPWR
+ _2193_ sky130_fd_sc_hd__mux2_1
XFILLER_0_69_57 VPWR VGND VPWR VGND sky130_ef_sc_hd__decap_12
XFILLER_0_25_588 VGND VGND VPWR VPWR sky130_fd_sc_hd__decap_4
XFILLER_0_123_785 VPWR VGND VPWR VGND sky130_ef_sc_hd__decap_12
XFILLER_0_122_251 VGND VGND VPWR VPWR sky130_fd_sc_hd__fill_1
XFILLER_0_110_413 VGND VGND VPWR VPWR sky130_fd_sc_hd__decap_6
XFILLER_0_100_65 VPWR VGND VPWR VGND sky130_ef_sc_hd__decap_12
X_3441_ _1144_ _1188_ VGND VGND VPWR VPWR _1380_ sky130_fd_sc_hd__nand2_1
XFILLER_0_110_457 VPWR VGND VPWR VGND sky130_ef_sc_hd__decap_12
X_3372_ _1320_ _1321_ _1306_ VGND VGND VPWR VPWR _1322_ sky130_fd_sc_hd__mux2_1
XFILLER_0_21_783 VGND VGND VPWR VPWR sky130_fd_sc_hd__fill_1
X_5111_ clknet_leaf_2_clk _0031_ VGND VGND VPWR VPWR cpu_inst.regfile_inst.registers\[6\]\[31\]
+ sky130_fd_sc_hd__dfxtp_1
XTAP_TAPCELL_ROW_127_2202 VGND VPWR sky130_fd_sc_hd__tapvpwrvgnd_1
X_5042_ _2509_ _2511_ VGND VGND VPWR VPWR _0485_ sky130_fd_sc_hd__nor2_1
XFILLER_0_79_205 VPWR VGND VPWR VGND sky130_ef_sc_hd__decap_12
XFILLER_0_18_83 VGND VGND VPWR VPWR sky130_fd_sc_hd__fill_1
XFILLER_0_79_249 VPWR VGND VPWR VGND sky130_ef_sc_hd__decap_12
XTAP_TAPCELL_ROW_0_304 VGND VPWR sky130_fd_sc_hd__tapvpwrvgnd_1
XFILLER_0_125_51 VGND VGND VPWR VPWR sky130_fd_sc_hd__decap_4
XFILLER_0_88_750 VGND VGND VPWR VPWR sky130_fd_sc_hd__decap_6
XFILLER_0_47_113 VPWR VGND VPWR VGND sky130_ef_sc_hd__decap_12
XFILLER_0_118_513 VPWR VGND VPWR VGND sky130_ef_sc_hd__decap_12
XTAP_TAPCELL_ROW_105_1876 VGND VPWR sky130_fd_sc_hd__tapvpwrvgnd_1
XFILLER_0_87_293 VPWR VGND VPWR VGND sky130_ef_sc_hd__decap_12
XFILLER_0_118_557 VPWR VGND VPWR VGND sky130_ef_sc_hd__decap_12
X_4826_ cpu_inst.regfile_inst.registers\[0\]\[31\] VGND VGND VPWR VPWR _2398_ sky130_fd_sc_hd__clkbuf_1
XFILLER_0_63_639 VGND VGND VPWR VPWR sky130_fd_sc_hd__fill_1
XFILLER_0_63_617 VGND VGND VPWR VPWR sky130_fd_sc_hd__decap_6
XFILLER_0_8_755 VGND VGND VPWR VPWR sky130_fd_sc_hd__fill_1
XTAP_TAPCELL_ROW_138_2375 VGND VPWR sky130_fd_sc_hd__tapvpwrvgnd_1
XTAP_TAPCELL_ROW_138_2364 VGND VPWR sky130_fd_sc_hd__tapvpwrvgnd_1
XFILLER_0_133_505 VPWR VGND VPWR VGND sky130_ef_sc_hd__decap_12
XFILLER_0_90_436 VGND VGND VPWR VPWR sky130_fd_sc_hd__fill_2
Xclone29 _0636_ VGND VGND VPWR VPWR net42 sky130_fd_sc_hd__buf_2
XFILLER_0_56_691 VGND VGND VPWR VPWR sky130_fd_sc_hd__fill_1
XFILLER_0_16_533 VPWR VGND VPWR VGND sky130_ef_sc_hd__decap_12
XTAP_TAPCELL_ROW_138_2386 VGND VPWR sky130_fd_sc_hd__tapvpwrvgnd_1
XFILLER_0_71_650 VGND VGND VPWR VPWR sky130_fd_sc_hd__decap_3
XTAP_TAPCELL_ROW_60_1194 VGND VPWR sky130_fd_sc_hd__tapvpwrvgnd_1
X_4757_ _2293_ _2362_ cpu_inst.decoder_inst.current_pc\[29\] _2289_ VGND VGND VPWR
+ VPWR _0349_ sky130_fd_sc_hd__o2bb2a_1
X_3708_ _1603_ _1639_ _1451_ VGND VGND VPWR VPWR _1640_ sky130_fd_sc_hd__mux2_1
XFILLER_0_71_683 VGND VGND VPWR VPWR sky130_fd_sc_hd__fill_2
X_4688_ cpu_inst.decoder_inst.current_pc\[9\] cpu_inst.decoder_inst.current_pc\[10\]
+ _2308_ VGND VGND VPWR VPWR _2313_ sky130_fd_sc_hd__and3_1
XFILLER_0_31_514 VGND VGND VPWR VPWR sky130_fd_sc_hd__decap_4
XFILLER_0_43_385 VGND VGND VPWR VPWR sky130_fd_sc_hd__decap_6
XFILLER_0_113_273 VGND VGND VPWR VPWR sky130_fd_sc_hd__decap_6
X_3639_ _1570_ _1572_ VGND VGND VPWR VPWR _1573_ sky130_fd_sc_hd__xnor2_1
XTAP_TAPCELL_ROW_8_426 VGND VPWR sky130_fd_sc_hd__tapvpwrvgnd_1
XTAP_TAPCELL_ROW_8_415 VGND VPWR sky130_fd_sc_hd__tapvpwrvgnd_1
XFILLER_0_11_293 VPWR VGND VPWR VGND sky130_ef_sc_hd__decap_12
X_5309_ clknet_leaf_35_clk _0229_ VGND VGND VPWR VPWR cpu_inst.regfile_inst.registers\[7\]\[5\]
+ sky130_fd_sc_hd__dfxtp_1
XTAP_TAPCELL_ROW_67_1304 VGND VPWR sky130_fd_sc_hd__tapvpwrvgnd_1
XTAP_TAPCELL_ROW_27_701 VGND VPWR sky130_fd_sc_hd__tapvpwrvgnd_1
XFILLER_0_86_709 VGND VGND VPWR VPWR sky130_fd_sc_hd__fill_1
XTAP_TAPCELL_ROW_27_712 VGND VPWR sky130_fd_sc_hd__tapvpwrvgnd_1
XFILLER_0_79_794 VGND VGND VPWR VPWR sky130_fd_sc_hd__fill_1
XTAP_TAPCELL_ROW_80_1504 VGND VPWR sky130_fd_sc_hd__tapvpwrvgnd_1
XFILLER_0_66_433 VPWR VGND VPWR VGND sky130_ef_sc_hd__decap_12
XFILLER_0_137_833 VGND VGND VPWR VPWR sky130_fd_sc_hd__decap_6
XFILLER_0_136_321 VPWR VGND VPWR VGND sky130_ef_sc_hd__decap_12
XFILLER_0_66_477 VPWR VGND VPWR VGND sky130_ef_sc_hd__decap_12
XFILLER_0_53_105 VGND VGND VPWR VPWR sky130_fd_sc_hd__decap_6
XFILLER_0_136_365 VPWR VGND VPWR VGND sky130_ef_sc_hd__decap_12
XFILLER_0_19_393 VPWR VGND VPWR VGND sky130_ef_sc_hd__decap_12
XFILLER_0_30_29 VPWR VGND VPWR VGND sky130_ef_sc_hd__decap_12
XFILLER_0_50_801 VGND VGND VPWR VPWR sky130_fd_sc_hd__fill_1
XFILLER_0_53_149 VPWR VGND VPWR VGND sky130_ef_sc_hd__decap_12
XFILLER_0_105_741 VPWR VGND VPWR VGND sky130_ef_sc_hd__decap_12
XFILLER_0_22_525 VGND VGND VPWR VPWR sky130_fd_sc_hd__decap_6
XFILLER_0_34_363 VGND VGND VPWR VPWR sky130_fd_sc_hd__fill_1
XFILLER_0_105_785 VPWR VGND VPWR VGND sky130_ef_sc_hd__decap_12
XFILLER_0_104_251 VGND VGND VPWR VPWR sky130_fd_sc_hd__fill_1
XTAP_TAPCELL_ROW_78_1477 VGND VPWR sky130_fd_sc_hd__tapvpwrvgnd_1
XTAP_TAPCELL_ROW_78_1466 VGND VPWR sky130_fd_sc_hd__tapvpwrvgnd_1
XFILLER_0_61_193 VPWR VGND VPWR VGND sky130_ef_sc_hd__decap_12
XFILLER_0_22_569 VPWR VGND VPWR VGND sky130_ef_sc_hd__decap_12
XFILLER_0_120_755 VGND VGND VPWR VPWR sky130_fd_sc_hd__fill_1
XFILLER_0_39_27 VPWR VGND VPWR VGND sky130_ef_sc_hd__decap_12
XTAP_TAPCELL_ROW_91_1666 VGND VPWR sky130_fd_sc_hd__tapvpwrvgnd_1
XFILLER_0_55_15 VPWR VGND VPWR VGND sky130_ef_sc_hd__decap_12
XTAP_TAPCELL_ROW_122_2132 VGND VPWR sky130_fd_sc_hd__tapvpwrvgnd_1
X_3990_ cpu_inst.regfile_inst.registers\[8\]\[31\] _1739_ VGND VGND VPWR VPWR _1914_
+ sky130_fd_sc_hd__or2_1
XFILLER_0_128_811 VGND VGND VPWR VPWR sky130_fd_sc_hd__fill_1
XFILLER_0_71_69 VPWR VGND VPWR VGND sky130_ef_sc_hd__decap_12
XFILLER_0_69_293 VGND VGND VPWR VPWR sky130_fd_sc_hd__decap_8
XFILLER_0_29_113 VPWR VGND VPWR VGND sky130_ef_sc_hd__decap_12
X_2941_ _0904_ _0905_ _0653_ VGND VGND VPWR VPWR _0906_ sky130_fd_sc_hd__mux2_1
XFILLER_0_45_617 VGND VGND VPWR VPWR sky130_fd_sc_hd__fill_2
XFILLER_0_115_505 VPWR VGND VPWR VGND sky130_ef_sc_hd__decap_12
X_4611_ _2254_ VGND VGND VPWR VPWR _0311_ sky130_fd_sc_hd__clkbuf_1
X_2872_ _0701_ _0829_ _0832_ _0836_ VGND VGND VPWR VPWR _0837_ sky130_fd_sc_hd__o211a_1
XTAP_TAPCELL_ROW_100_1795 VGND VPWR sky130_fd_sc_hd__tapvpwrvgnd_1
XFILLER_0_53_650 VGND VGND VPWR VPWR sky130_fd_sc_hd__decap_6
XTAP_TAPCELL_ROW_13_494 VGND VPWR sky130_fd_sc_hd__tapvpwrvgnd_1
X_4542_ cpu_inst.regfile_inst.registers\[11\]\[22\] VGND VGND VPWR VPWR _2219_ sky130_fd_sc_hd__clkbuf_1
XFILLER_0_13_503 VGND VGND VPWR VPWR sky130_fd_sc_hd__fill_1
XFILLER_0_25_385 VGND VGND VPWR VPWR sky130_fd_sc_hd__decap_6
X_4473_ _1534_ cpu_inst.regfile_inst.registers\[7\]\[20\] _2174_ VGND VGND VPWR VPWR
+ _2184_ sky130_fd_sc_hd__mux2_1
XFILLER_0_40_333 VPWR VGND VPWR VGND sky130_ef_sc_hd__decap_12
XTAP_TAPCELL_ROW_133_2294 VGND VPWR sky130_fd_sc_hd__tapvpwrvgnd_1
XFILLER_0_110_221 VPWR VGND VPWR VGND sky130_ef_sc_hd__decap_12
X_3424_ cpu_inst.regfile_inst.registers\[2\]\[16\] _0848_ _0849_ cpu_inst.regfile_inst.registers\[7\]\[16\]
+ _0850_ VGND VGND VPWR VPWR _1363_ sky130_fd_sc_hd__o221a_1
XFILLER_0_40_377 VPWR VGND VPWR VGND sky130_ef_sc_hd__decap_12
XPHY_EDGE_ROW_115_Right_115 VGND VGND VPWR VPWR sky130_fd_sc_hd__decap_3
XFILLER_0_111_777 VGND VGND VPWR VPWR sky130_fd_sc_hd__decap_6
XFILLER_0_110_265 VPWR VGND VPWR VGND sky130_ef_sc_hd__decap_12
XFILLER_0_96_77 VGND VGND VPWR VPWR sky130_fd_sc_hd__decap_6
X_3355_ _1305_ VGND VGND VPWR VPWR _0004_ sky130_fd_sc_hd__clkbuf_1
X_3286_ _0912_ VGND VGND VPWR VPWR _1251_ sky130_fd_sc_hd__buf_2
XFILLER_0_29_93 VPWR VGND VPWR VGND sky130_ef_sc_hd__decap_12
X_5025_ cpu_inst.regfile_inst.registers\[15\]\[30\] _2468_ VGND VGND VPWR VPWR _2502_
+ sky130_fd_sc_hd__and2_1
XTAP_TAPCELL_ROW_107_1905 VGND VPWR sky130_fd_sc_hd__tapvpwrvgnd_1
XFILLER_0_24_3 VPWR VGND VPWR VGND sky130_ef_sc_hd__decap_12
XFILLER_0_136_83 VGND VGND VPWR VPWR sky130_fd_sc_hd__fill_1
XFILLER_0_45_81 VPWR VGND VPWR VGND sky130_ef_sc_hd__decap_12
XTAP_TAPCELL_ROW_49_1034 VGND VPWR sky130_fd_sc_hd__tapvpwrvgnd_1
XFILLER_0_48_433 VPWR VGND VPWR VGND sky130_ef_sc_hd__decap_12
XFILLER_0_119_833 VGND VGND VPWR VPWR sky130_fd_sc_hd__decap_6
XFILLER_0_118_321 VPWR VGND VPWR VGND sky130_ef_sc_hd__decap_12
XTAP_TAPCELL_ROW_62_1234 VGND VPWR sky130_fd_sc_hd__tapvpwrvgnd_1
XTAP_TAPCELL_ROW_62_1223 VGND VPWR sky130_fd_sc_hd__tapvpwrvgnd_1
XFILLER_0_35_105 VGND VGND VPWR VPWR sky130_fd_sc_hd__decap_6
XFILLER_0_118_365 VPWR VGND VPWR VGND sky130_ef_sc_hd__decap_12
XFILLER_0_91_734 VGND VGND VPWR VPWR sky130_fd_sc_hd__fill_2
XFILLER_0_90_233 VPWR VGND VPWR VGND sky130_ef_sc_hd__decap_12
XFILLER_0_134_825 VPWR VGND VPWR VGND sky130_ef_sc_hd__decap_12
X_4809_ _2389_ VGND VGND VPWR VPWR _0374_ sky130_fd_sc_hd__clkbuf_1
XPHY_EDGE_ROW_17_Right_17 VGND VGND VPWR VPWR sky130_fd_sc_hd__decap_3
XTAP_TAPCELL_ROW_32_781 VGND VPWR sky130_fd_sc_hd__tapvpwrvgnd_1
XFILLER_0_35_149 VPWR VGND VPWR VGND sky130_ef_sc_hd__decap_12
XFILLER_0_133_335 VGND VGND VPWR VPWR sky130_fd_sc_hd__fill_1
XFILLER_0_90_277 VPWR VGND VPWR VGND sky130_ef_sc_hd__decap_12
XFILLER_0_16_363 VGND VGND VPWR VPWR sky130_fd_sc_hd__fill_1
XFILLER_0_9_81 VPWR VGND VPWR VGND sky130_ef_sc_hd__decap_12
XFILLER_0_43_193 VPWR VGND VPWR VGND sky130_ef_sc_hd__decap_12
XFILLER_0_102_766 VPWR VGND VPWR VGND sky130_ef_sc_hd__decap_12
XTAP_TAPCELL_ROW_73_1396 VGND VPWR sky130_fd_sc_hd__tapvpwrvgnd_1
XPHY_EDGE_ROW_26_Right_26 VGND VGND VPWR VPWR sky130_fd_sc_hd__decap_3
XFILLER_0_98_333 VPWR VGND VPWR VGND sky130_ef_sc_hd__decap_12
XFILLER_0_98_377 VPWR VGND VPWR VGND sky130_ef_sc_hd__decap_12
XFILLER_0_137_641 VPWR VGND VPWR VGND sky130_ef_sc_hd__decap_12
XFILLER_0_94_561 VGND VGND VPWR VPWR sky130_fd_sc_hd__fill_2
XFILLER_0_82_701 VGND VGND VPWR VPWR sky130_fd_sc_hd__fill_1
XFILLER_0_39_477 VPWR VGND VPWR VGND sky130_ef_sc_hd__decap_12
XFILLER_0_41_39 VPWR VGND VPWR VGND sky130_ef_sc_hd__decap_12
XFILLER_0_54_425 VGND VGND VPWR VPWR sky130_fd_sc_hd__fill_2
XPHY_EDGE_ROW_35_Right_35 VGND VGND VPWR VPWR sky130_fd_sc_hd__decap_3
XFILLER_0_137_685 VPWR VGND VPWR VGND sky130_ef_sc_hd__decap_12
XFILLER_0_136_195 VGND VGND VPWR VPWR sky130_fd_sc_hd__fill_1
XFILLER_0_124_357 VGND VGND VPWR VPWR sky130_fd_sc_hd__decap_6
XTAP_TAPCELL_ROW_10_453 VGND VPWR sky130_fd_sc_hd__tapvpwrvgnd_1
XFILLER_0_1_205 VPWR VGND VPWR VGND sky130_ef_sc_hd__decap_12
XFILLER_0_22_333 VPWR VGND VPWR VGND sky130_ef_sc_hd__decap_12
XFILLER_0_1_249 VPWR VGND VPWR VGND sky130_ef_sc_hd__decap_12
XFILLER_0_22_377 VPWR VGND VPWR VGND sky130_ef_sc_hd__decap_12
XFILLER_0_5_39 VPWR VGND VPWR VGND sky130_ef_sc_hd__decap_12
XPHY_EDGE_ROW_44_Right_44 VGND VGND VPWR VPWR sky130_fd_sc_hd__decap_3
X_3140_ _1076_ _1079_ _1057_ VGND VGND VPWR VPWR _1105_ sky130_fd_sc_hd__mux2_1
X_3071_ cpu_inst.regfile_inst.registers\[15\]\[13\] _0729_ _1035_ _0844_ VGND VGND
+ VPWR VPWR _1036_ sky130_fd_sc_hd__a211o_1
XFILLER_0_106_53 VPWR VGND VPWR VGND sky130_ef_sc_hd__decap_12
XFILLER_0_106_97 VPWR VGND VPWR VGND sky130_ef_sc_hd__decap_12
XFILLER_0_9_305 VPWR VGND VPWR VGND sky130_ef_sc_hd__decap_12
XFILLER_0_15_51 VGND VGND VPWR VPWR sky130_fd_sc_hd__decap_4
XTAP_TAPCELL_ROW_18_564 VGND VPWR sky130_fd_sc_hd__tapvpwrvgnd_1
XTAP_TAPCELL_ROW_18_575 VGND VPWR sky130_fd_sc_hd__tapvpwrvgnd_1
XTAP_TAPCELL_ROW_102_1835 VGND VPWR sky130_fd_sc_hd__tapvpwrvgnd_1
XTAP_TAPCELL_ROW_102_1824 VGND VPWR sky130_fd_sc_hd__tapvpwrvgnd_1
XFILLER_0_85_561 VGND VGND VPWR VPWR sky130_fd_sc_hd__decap_3
X_3973_ _1896_ _1897_ _1224_ VGND VGND VPWR VPWR _1898_ sky130_fd_sc_hd__and3b_1
XPHY_EDGE_ROW_53_Right_53 VGND VGND VPWR VPWR sky130_fd_sc_hd__decap_3
XFILLER_0_9_349 VPWR VGND VPWR VGND sky130_ef_sc_hd__decap_12
XFILLER_0_122_41 VPWR VGND VPWR VGND sky130_ef_sc_hd__decap_12
XFILLER_0_85_583 VGND VGND VPWR VPWR sky130_fd_sc_hd__decap_3
X_2924_ _0880_ _0888_ VGND VGND VPWR VPWR _0889_ sky130_fd_sc_hd__or2_1
XFILLER_0_17_105 VGND VGND VPWR VPWR sky130_fd_sc_hd__decap_6
XTAP_TAPCELL_ROW_135_2323 VGND VPWR sky130_fd_sc_hd__tapvpwrvgnd_1
XFILLER_0_116_825 VPWR VGND VPWR VGND sky130_ef_sc_hd__decap_12
XFILLER_0_72_233 VPWR VGND VPWR VGND sky130_ef_sc_hd__decap_12
XFILLER_0_17_149 VPWR VGND VPWR VGND sky130_ef_sc_hd__decap_12
X_2855_ _0593_ VGND VGND VPWR VPWR _0820_ sky130_fd_sc_hd__clkbuf_4
XFILLER_0_122_85 VPWR VGND VPWR VGND sky130_ef_sc_hd__decap_12
XFILLER_0_115_335 VGND VGND VPWR VPWR sky130_fd_sc_hd__fill_1
XFILLER_0_72_277 VPWR VGND VPWR VGND sky130_ef_sc_hd__decap_12
X_5574_ clknet_leaf_30_clk _0494_ VGND VGND VPWR VPWR cpu_inst.display_inst.counter\[14\]
+ sky130_fd_sc_hd__dfxtp_1
XFILLER_0_131_839 VGND VGND VPWR VPWR sky130_fd_sc_hd__fill_1
X_4525_ _2210_ VGND VGND VPWR VPWR _0269_ sky130_fd_sc_hd__clkbuf_1
XFILLER_0_25_193 VPWR VGND VPWR VGND sky130_ef_sc_hd__decap_12
X_2786_ cpu_inst.regfile_inst.registers\[2\]\[3\] _0627_ _0603_ cpu_inst.regfile_inst.registers\[7\]\[3\]
+ _0613_ VGND VGND VPWR VPWR _0751_ sky130_fd_sc_hd__o221a_1
XFILLER_0_40_141 VPWR VGND VPWR VGND sky130_ef_sc_hd__decap_12
XFILLER_0_111_541 VPWR VGND VPWR VGND sky130_ef_sc_hd__decap_12
XPHY_EDGE_ROW_62_Right_62 VGND VGND VPWR VPWR sky130_fd_sc_hd__decap_3
X_4456_ _2175_ VGND VGND VPWR VPWR _0235_ sky130_fd_sc_hd__clkbuf_1
XFILLER_0_111_585 VPWR VGND VPWR VGND sky130_ef_sc_hd__decap_12
X_3407_ _1019_ _1021_ _1025_ _1047_ _1345_ VGND VGND VPWR VPWR _1346_ sky130_fd_sc_hd__a2111o_1
XFILLER_0_1_783 VGND VGND VPWR VPWR sky130_fd_sc_hd__fill_1
X_4387_ cpu_inst.regfile_inst.registers\[1\]\[11\] VGND VGND VPWR VPWR _2139_ sky130_fd_sc_hd__clkbuf_1
XTAP_TAPCELL_ROW_113_1997 VGND VPWR sky130_fd_sc_hd__tapvpwrvgnd_1
X_3338_ _0555_ _0854_ VGND VGND VPWR VPWR _1293_ sky130_fd_sc_hd__and2_1
XFILLER_0_0_293 VPWR VGND VPWR VGND sky130_ef_sc_hd__decap_12
X_3269_ _0844_ _1229_ _1230_ _1233_ VGND VGND VPWR VPWR _1234_ sky130_fd_sc_hd__o22a_1
X_5008_ _2493_ VGND VGND VPWR VPWR _0469_ sky130_fd_sc_hd__clkbuf_1
XFILLER_0_96_837 VGND VGND VPWR VPWR sky130_fd_sc_hd__decap_4
XTAP_TAPCELL_ROW_37_851 VGND VPWR sky130_fd_sc_hd__tapvpwrvgnd_1
XFILLER_0_138_405 VPWR VGND VPWR VGND sky130_ef_sc_hd__decap_12
XPHY_EDGE_ROW_71_Right_71 VGND VGND VPWR VPWR sky130_fd_sc_hd__decap_3
XTAP_TAPCELL_ROW_37_862 VGND VPWR sky130_fd_sc_hd__tapvpwrvgnd_1
XFILLER_0_49_742 VGND VGND VPWR VPWR sky130_fd_sc_hd__decap_3
XFILLER_0_138_449 VPWR VGND VPWR VGND sky130_ef_sc_hd__decap_12
XFILLER_0_76_572 VGND VGND VPWR VPWR sky130_fd_sc_hd__fill_2
XFILLER_0_119_641 VPWR VGND VPWR VGND sky130_ef_sc_hd__decap_12
XFILLER_0_119_685 VPWR VGND VPWR VGND sky130_ef_sc_hd__decap_12
XFILLER_0_118_195 VGND VGND VPWR VPWR sky130_fd_sc_hd__fill_1
XFILLER_0_106_357 VGND VGND VPWR VPWR sky130_fd_sc_hd__decap_6
XFILLER_0_91_586 VGND VGND VPWR VPWR sky130_fd_sc_hd__decap_8
XFILLER_0_51_439 VGND VGND VPWR VPWR sky130_fd_sc_hd__decap_8
XFILLER_0_134_699 VGND VGND VPWR VPWR sky130_fd_sc_hd__fill_1
XFILLER_0_121_305 VPWR VGND VPWR VGND sky130_ef_sc_hd__decap_12
XFILLER_0_121_349 VPWR VGND VPWR VGND sky130_ef_sc_hd__decap_12
XPHY_EDGE_ROW_80_Right_80 VGND VGND VPWR VPWR sky130_fd_sc_hd__decap_3
XTAP_TAPCELL_ROW_75_1425 VGND VPWR sky130_fd_sc_hd__tapvpwrvgnd_1
XPHY_EDGE_ROW_15_Left_154 VGND VGND VPWR VPWR sky130_fd_sc_hd__decap_3
XFILLER_0_20_837 VGND VGND VPWR VPWR sky130_fd_sc_hd__decap_4
XFILLER_0_98_141 VPWR VGND VPWR VGND sky130_ef_sc_hd__decap_12
XPHY_EDGE_ROW_24_Left_163 VGND VGND VPWR VPWR sky130_fd_sc_hd__decap_3
XFILLER_0_59_517 VGND VGND VPWR VPWR sky130_fd_sc_hd__decap_3
XFILLER_0_129_405 VPWR VGND VPWR VGND sky130_ef_sc_hd__decap_12
XTAP_TAPCELL_ROW_86_1587 VGND VPWR sky130_fd_sc_hd__tapvpwrvgnd_1
XFILLER_0_52_27 VGND VGND VPWR VPWR sky130_fd_sc_hd__fill_1
XFILLER_0_129_449 VPWR VGND VPWR VGND sky130_ef_sc_hd__decap_12
XFILLER_0_67_561 VPWR VGND VPWR VGND sky130_ef_sc_hd__decap_12
XFILLER_0_67_550 VGND VGND VPWR VPWR sky130_fd_sc_hd__decap_4
XTAP_TAPCELL_ROW_15_523 VGND VPWR sky130_fd_sc_hd__tapvpwrvgnd_1
XFILLER_0_7_809 VPWR VGND VPWR VGND sky130_ef_sc_hd__decap_12
XFILLER_0_54_233 VPWR VGND VPWR VGND sky130_ef_sc_hd__decap_12
XFILLER_0_15_609 VGND VGND VPWR VPWR sky130_fd_sc_hd__decap_6
XFILLER_0_27_447 VGND VGND VPWR VPWR sky130_fd_sc_hd__fill_1
XFILLER_0_124_121 VPWR VGND VPWR VGND sky130_ef_sc_hd__decap_12
XFILLER_0_70_715 VGND VGND VPWR VPWR sky130_fd_sc_hd__fill_1
XFILLER_0_54_277 VPWR VGND VPWR VGND sky130_ef_sc_hd__decap_12
X_2640_ _0593_ _0597_ _0604_ VGND VGND VPWR VPWR _0605_ sky130_fd_sc_hd__o21a_1
XFILLER_0_124_165 VPWR VGND VPWR VGND sky130_ef_sc_hd__decap_12
XTAP_TAPCELL_ROW_117_2053 VGND VPWR sky130_fd_sc_hd__tapvpwrvgnd_1
XFILLER_0_113_839 VGND VGND VPWR VPWR sky130_fd_sc_hd__fill_1
XPHY_EDGE_ROW_33_Left_172 VGND VGND VPWR VPWR sky130_fd_sc_hd__decap_3
X_2571_ _0535_ VGND VGND VPWR VPWR _0536_ sky130_fd_sc_hd__buf_6
XFILLER_0_2_525 VGND VGND VPWR VPWR sky130_fd_sc_hd__decap_6
XFILLER_0_22_141 VPWR VGND VPWR VGND sky130_ef_sc_hd__decap_12
XFILLER_0_23_653 VPWR VGND VPWR VGND sky130_ef_sc_hd__decap_12
XTAP_TAPCELL_ROW_130_2253 VGND VPWR sky130_fd_sc_hd__tapvpwrvgnd_1
X_5290_ clknet_leaf_20_clk _0210_ VGND VGND VPWR VPWR cpu_inst.regfile_inst.registers\[1\]\[18\]
+ sky130_fd_sc_hd__dfxtp_1
XFILLER_0_2_569 VPWR VGND VPWR VGND sky130_ef_sc_hd__decap_12
XFILLER_0_23_697 VPWR VGND VPWR VGND sky130_ef_sc_hd__decap_12
X_4310_ _2099_ VGND VGND VPWR VPWR _0165_ sky130_fd_sc_hd__clkbuf_1
XFILLER_0_77_57 VPWR VGND VPWR VGND sky130_ef_sc_hd__decap_12
X_4241_ cpu_inst.regfile_inst.registers\[24\]\[5\] VGND VGND VPWR VPWR _2063_ sky130_fd_sc_hd__clkbuf_1
X_4172_ _2027_ VGND VGND VPWR VPWR _0099_ sky130_fd_sc_hd__clkbuf_1
X_3123_ _1087_ VGND VGND VPWR VPWR _1088_ sky130_fd_sc_hd__buf_4
XPHY_EDGE_ROW_42_Left_181 VGND VGND VPWR VPWR sky130_fd_sc_hd__decap_3
X_3054_ _0950_ _0960_ _0989_ _1018_ _1017_ VGND VGND VPWR VPWR _1019_ sky130_fd_sc_hd__a2111o_1
XFILLER_0_26_83 VGND VGND VPWR VPWR sky130_fd_sc_hd__fill_1
XTAP_TAPCELL_ROW_34_810 VGND VPWR sky130_fd_sc_hd__tapvpwrvgnd_1
XFILLER_0_133_51 VGND VGND VPWR VPWR sky130_fd_sc_hd__decap_4
XFILLER_0_58_561 VGND VGND VPWR VPWR sky130_fd_sc_hd__fill_1
XFILLER_0_9_113 VPWR VGND VPWR VGND sky130_ef_sc_hd__decap_12
XFILLER_0_46_701 VGND VGND VPWR VPWR sky130_fd_sc_hd__fill_1
X_3956_ cpu_inst.regfile_inst.registers\[2\]\[30\] _1804_ _1805_ cpu_inst.regfile_inst.registers\[7\]\[30\]
+ VGND VGND VPWR VPWR _1881_ sky130_fd_sc_hd__o22a_1
XFILLER_0_46_745 VGND VGND VPWR VPWR sky130_fd_sc_hd__fill_1
X_2907_ _0868_ _0869_ _0871_ VGND VGND VPWR VPWR _0872_ sky130_fd_sc_hd__mux2_1
XFILLER_0_18_469 VGND VGND VPWR VPWR sky130_fd_sc_hd__decap_6
X_3887_ _1709_ _1806_ _1809_ _1813_ VGND VGND VPWR VPWR _1814_ sky130_fd_sc_hd__o211a_1
XFILLER_0_91_3 VPWR VGND VPWR VGND sky130_ef_sc_hd__decap_12
XFILLER_0_73_586 VGND VGND VPWR VPWR sky130_fd_sc_hd__decap_8
XFILLER_0_33_417 VPWR VGND VPWR VGND sky130_ef_sc_hd__decap_12
XPHY_EDGE_ROW_51_Left_190 VGND VGND VPWR VPWR sky130_fd_sc_hd__decap_3
XFILLER_0_116_699 VGND VGND VPWR VPWR sky130_fd_sc_hd__fill_1
XFILLER_0_103_305 VPWR VGND VPWR VGND sky130_ef_sc_hd__decap_12
X_2838_ _0731_ _0800_ _0802_ _0701_ VGND VGND VPWR VPWR _0803_ sky130_fd_sc_hd__o211ai_1
XFILLER_0_103_349 VPWR VGND VPWR VGND sky130_ef_sc_hd__decap_12
X_5557_ clknet_leaf_3_clk _0477_ VGND VGND VPWR VPWR cpu_inst.regfile_inst.registers\[15\]\[29\]
+ sky130_fd_sc_hd__dfxtp_1
XFILLER_0_5_385 VGND VGND VPWR VPWR sky130_fd_sc_hd__decap_6
X_2769_ _0725_ _0727_ _0733_ VGND VGND VPWR VPWR _0734_ sky130_fd_sc_hd__or3_1
X_5488_ clknet_leaf_9_clk _0408_ VGND VGND VPWR VPWR cpu_inst.regfile_inst.registers\[9\]\[24\]
+ sky130_fd_sc_hd__dfxtp_1
XTAP_TAPCELL_ROW_57_1155 VGND VPWR sky130_fd_sc_hd__tapvpwrvgnd_1
X_4508_ cpu_inst.regfile_inst.registers\[11\]\[5\] VGND VGND VPWR VPWR _2202_ sky130_fd_sc_hd__clkbuf_1
X_4439_ _1196_ cpu_inst.regfile_inst.registers\[7\]\[4\] _2161_ VGND VGND VPWR VPWR
+ _2166_ sky130_fd_sc_hd__mux2_1
XFILLER_0_111_393 VPWR VGND VPWR VGND sky130_ef_sc_hd__decap_12
XTAP_TAPCELL_ROW_70_1355 VGND VPWR sky130_fd_sc_hd__tapvpwrvgnd_1
XTAP_TAPCELL_ROW_70_1344 VGND VPWR sky130_fd_sc_hd__tapvpwrvgnd_1
XFILLER_0_96_634 VGND VGND VPWR VPWR sky130_fd_sc_hd__decap_8
XFILLER_0_95_111 VGND VGND VPWR VPWR sky130_fd_sc_hd__fill_1
XFILLER_0_49_561 VPWR VGND VPWR VGND sky130_ef_sc_hd__decap_12
XFILLER_0_83_317 VPWR VGND VPWR VGND sky130_ef_sc_hd__decap_12
XFILLER_0_126_419 VGND VGND VPWR VPWR sky130_fd_sc_hd__fill_1
XFILLER_0_36_233 VPWR VGND VPWR VGND sky130_ef_sc_hd__decap_12
XFILLER_0_106_121 VPWR VGND VPWR VGND sky130_ef_sc_hd__decap_12
XFILLER_0_91_361 VPWR VGND VPWR VGND sky130_ef_sc_hd__decap_12
XFILLER_0_36_277 VPWR VGND VPWR VGND sky130_ef_sc_hd__decap_12
XFILLER_0_106_165 VPWR VGND VPWR VGND sky130_ef_sc_hd__decap_12
XFILLER_0_51_225 VPWR VGND VPWR VGND sky130_ef_sc_hd__decap_12
XFILLER_0_122_625 VPWR VGND VPWR VGND sky130_ef_sc_hd__decap_12
XFILLER_0_121_113 VPWR VGND VPWR VGND sky130_ef_sc_hd__decap_12
XFILLER_0_20_601 VPWR VGND VPWR VGND sky130_ef_sc_hd__decap_12
XFILLER_0_122_669 VPWR VGND VPWR VGND sky130_ef_sc_hd__decap_12
XFILLER_0_20_645 VPWR VGND VPWR VGND sky130_ef_sc_hd__decap_12
XFILLER_0_138_29 VPWR VGND VPWR VGND sky130_ef_sc_hd__decap_12
XFILLER_0_47_27 VPWR VGND VPWR VGND sky130_ef_sc_hd__decap_12
XTAP_TAPCELL_ROW_88_1616 VGND VPWR sky130_fd_sc_hd__tapvpwrvgnd_1
XTAP_TAPCELL_ROW_88_1627 VGND VPWR sky130_fd_sc_hd__tapvpwrvgnd_1
XFILLER_0_63_15 VPWR VGND VPWR VGND sky130_ef_sc_hd__decap_12
XFILLER_0_2_29 VPWR VGND VPWR VGND sky130_ef_sc_hd__decap_12
XFILLER_0_86_133 VGND VGND VPWR VPWR sky130_fd_sc_hd__decap_6
XFILLER_0_28_701 VPWR VGND VPWR VGND sky130_ef_sc_hd__decap_12
X_3810_ _1557_ VGND VGND VPWR VPWR _1739_ sky130_fd_sc_hd__buf_2
XFILLER_0_86_177 VPWR VGND VPWR VGND sky130_ef_sc_hd__decap_12
X_4790_ cpu_inst.regfile_inst.registers\[0\]\[13\] VGND VGND VPWR VPWR _2380_ sky130_fd_sc_hd__clkbuf_1
XFILLER_0_129_279 VGND VGND VPWR VPWR sky130_fd_sc_hd__fill_1
X_3741_ cpu_inst.regfile_inst.registers\[0\]\[24\] _0615_ _1670_ _1560_ _1671_ VGND
+ VGND VPWR VPWR _1672_ sky130_fd_sc_hd__o221a_1
XFILLER_0_7_617 VPWR VGND VPWR VGND sky130_ef_sc_hd__decap_12
XFILLER_0_12_41 VPWR VGND VPWR VGND sky130_ef_sc_hd__decap_12
XFILLER_0_15_417 VPWR VGND VPWR VGND sky130_ef_sc_hd__decap_12
XFILLER_0_125_441 VGND VGND VPWR VPWR sky130_fd_sc_hd__decap_6
XTAP_TAPCELL_ROW_99_1778 VGND VPWR sky130_fd_sc_hd__tapvpwrvgnd_1
X_3672_ _1503_ _1604_ _1255_ VGND VGND VPWR VPWR _1605_ sky130_fd_sc_hd__mux2_1
XFILLER_0_12_85 VPWR VGND VPWR VGND sky130_ef_sc_hd__decap_12
XFILLER_0_125_485 VPWR VGND VPWR VGND sky130_ef_sc_hd__decap_12
XTAP_TAPCELL_ROW_99_1789 VGND VPWR sky130_fd_sc_hd__tapvpwrvgnd_1
XFILLER_0_70_589 VGND VGND VPWR VPWR sky130_fd_sc_hd__decap_6
X_5411_ clknet_leaf_0_clk _0331_ net2 VGND VGND VPWR VPWR cpu_inst.decoder_inst.current_pc\[11\]
+ sky130_fd_sc_hd__dfrtp_1
X_2623_ _0565_ _0536_ _0545_ _0555_ VGND VGND VPWR VPWR _0588_ sky130_fd_sc_hd__and4_4
XFILLER_0_101_809 VPWR VGND VPWR VGND sky130_ef_sc_hd__decap_12
X_2554_ cpu_inst.decoder_inst.current_pc\[5\] cpu_inst.decoder_inst.current_pc\[7\]
+ cpu_inst.decoder_inst.current_pc\[6\] cpu_inst.decoder_inst.current_pc\[4\] VGND
+ VGND VPWR VPWR _0519_ sky130_fd_sc_hd__or4b_1
XFILLER_0_2_333 VPWR VGND VPWR VGND sky130_ef_sc_hd__decap_12
XFILLER_0_23_461 VPWR VGND VPWR VGND sky130_ef_sc_hd__decap_12
X_5342_ clknet_leaf_38_clk _0262_ VGND VGND VPWR VPWR cpu_inst.regfile_inst.registers\[11\]\[6\]
+ sky130_fd_sc_hd__dfxtp_1
XFILLER_0_10_133 VGND VGND VPWR VPWR sky130_fd_sc_hd__decap_6
XFILLER_0_2_377 VPWR VGND VPWR VGND sky130_ef_sc_hd__decap_12
XFILLER_0_10_177 VPWR VGND VPWR VGND sky130_ef_sc_hd__decap_12
X_5273_ clknet_leaf_39_clk _0193_ VGND VGND VPWR VPWR cpu_inst.regfile_inst.registers\[1\]\[1\]
+ sky130_fd_sc_hd__dfxtp_1
XTAP_TAPCELL_ROW_110_1956 VGND VPWR sky130_fd_sc_hd__tapvpwrvgnd_1
XTAP_TAPCELL_ROW_110_1945 VGND VPWR sky130_fd_sc_hd__tapvpwrvgnd_1
X_4224_ _2054_ VGND VGND VPWR VPWR _0124_ sky130_fd_sc_hd__clkbuf_1
X_4155_ _2017_ VGND VGND VPWR VPWR _0092_ sky130_fd_sc_hd__clkbuf_1
XTAP_TAPCELL_ROW_52_1085 VGND VPWR sky130_fd_sc_hd__tapvpwrvgnd_1
XTAP_TAPCELL_ROW_52_1074 VGND VPWR sky130_fd_sc_hd__tapvpwrvgnd_1
X_3106_ _1068_ _1070_ _1060_ VGND VGND VPWR VPWR _1071_ sky130_fd_sc_hd__mux2_1
XFILLER_0_37_93 VPWR VGND VPWR VGND sky130_ef_sc_hd__decap_12
X_4086_ cpu_inst.regfile_inst.registers\[2\]\[30\] VGND VGND VPWR VPWR _1979_ sky130_fd_sc_hd__clkbuf_1
XFILLER_0_78_645 VGND VGND VPWR VPWR sky130_fd_sc_hd__decap_3
XFILLER_0_77_111 VGND VGND VPWR VPWR sky130_fd_sc_hd__fill_1
X_3037_ _1001_ _0994_ VGND VGND VPWR VPWR _1002_ sky130_fd_sc_hd__nor2_1
XFILLER_0_66_818 VPWR VGND VPWR VGND sky130_ef_sc_hd__decap_12
XFILLER_0_53_81 VPWR VGND VPWR VGND sky130_ef_sc_hd__decap_12
XFILLER_0_135_205 VPWR VGND VPWR VGND sky130_ef_sc_hd__decap_12
XFILLER_0_108_419 VGND VGND VPWR VPWR sky130_fd_sc_hd__fill_1
X_4988_ cpu_inst.regfile_inst.registers\[15\]\[12\] _2480_ VGND VGND VPWR VPWR _2483_
+ sky130_fd_sc_hd__and2_1
XFILLER_0_74_840 VGND VGND VPWR VPWR sky130_fd_sc_hd__fill_2
XFILLER_0_18_233 VPWR VGND VPWR VGND sky130_ef_sc_hd__decap_12
XFILLER_0_46_531 VGND VGND VPWR VPWR sky130_fd_sc_hd__fill_1
XFILLER_0_46_542 VGND VGND VPWR VPWR sky130_fd_sc_hd__fill_2
XFILLER_0_135_249 VPWR VGND VPWR VGND sky130_ef_sc_hd__decap_12
X_3939_ _1306_ _1787_ _1864_ _1487_ VGND VGND VPWR VPWR _1865_ sky130_fd_sc_hd__o211a_1
XFILLER_0_80_309 VPWR VGND VPWR VGND sky130_ef_sc_hd__decap_12
XFILLER_0_73_350 VPWR VGND VPWR VGND sky130_ef_sc_hd__decap_12
XFILLER_0_18_277 VPWR VGND VPWR VGND sky130_ef_sc_hd__decap_12
XFILLER_0_33_225 VPWR VGND VPWR VGND sky130_ef_sc_hd__decap_12
XFILLER_0_103_113 VPWR VGND VPWR VGND sky130_ef_sc_hd__decap_12
XFILLER_0_61_556 VGND VGND VPWR VPWR sky130_fd_sc_hd__decap_4
XFILLER_0_5_193 VPWR VGND VPWR VGND sky130_ef_sc_hd__decap_12
XTAP_TAPCELL_ROW_6_387 VGND VPWR sky130_fd_sc_hd__tapvpwrvgnd_1
XTAP_TAPCELL_ROW_83_1546 VGND VPWR sky130_fd_sc_hd__tapvpwrvgnd_1
XFILLER_0_69_656 VGND VGND VPWR VPWR sky130_fd_sc_hd__decap_4
XFILLER_0_68_133 VGND VGND VPWR VPWR sky130_fd_sc_hd__decap_6
XFILLER_0_96_475 VGND VGND VPWR VPWR sky130_fd_sc_hd__fill_1
XFILLER_0_68_177 VPWR VGND VPWR VGND sky130_ef_sc_hd__decap_12
XFILLER_0_83_125 VPWR VGND VPWR VGND sky130_ef_sc_hd__decap_12
XTAP_TAPCELL_ROW_25_673 VGND VPWR sky130_fd_sc_hd__tapvpwrvgnd_1
XFILLER_0_49_391 VGND VGND VPWR VPWR sky130_fd_sc_hd__fill_1
XFILLER_0_83_169 VPWR VGND VPWR VGND sky130_ef_sc_hd__decap_12
XFILLER_0_107_441 VGND VGND VPWR VPWR sky130_fd_sc_hd__decap_6
XFILLER_0_135_783 VGND VGND VPWR VPWR sky130_fd_sc_hd__fill_1
XTAP_TAPCELL_ROW_114_2012 VGND VPWR sky130_fd_sc_hd__tapvpwrvgnd_1
XFILLER_0_52_556 VGND VGND VPWR VPWR sky130_fd_sc_hd__fill_1
XFILLER_0_122_433 VPWR VGND VPWR VGND sky130_ef_sc_hd__decap_12
XFILLER_0_122_477 VPWR VGND VPWR VGND sky130_ef_sc_hd__decap_12
XFILLER_0_58_15 VPWR VGND VPWR VGND sky130_ef_sc_hd__decap_12
XFILLER_0_0_837 VGND VGND VPWR VPWR sky130_fd_sc_hd__decap_3
XFILLER_0_20_475 VGND VGND VPWR VPWR sky130_fd_sc_hd__fill_1
XTAP_TAPCELL_ROW_125_2174 VGND VPWR sky130_fd_sc_hd__tapvpwrvgnd_1
XFILLER_0_59_111 VGND VGND VPWR VPWR sky130_fd_sc_hd__fill_1
X_4911_ _2442_ VGND VGND VPWR VPWR _0423_ sky130_fd_sc_hd__clkbuf_1
XFILLER_0_87_497 VGND VGND VPWR VPWR sky130_fd_sc_hd__decap_4
XTAP_TAPCELL_ROW_44_960 VGND VPWR sky130_fd_sc_hd__tapvpwrvgnd_1
XFILLER_0_47_317 VPWR VGND VPWR VGND sky130_ef_sc_hd__decap_12
XFILLER_0_117_205 VPWR VGND VPWR VGND sky130_ef_sc_hd__decap_12
XFILLER_0_114_53 VPWR VGND VPWR VGND sky130_ef_sc_hd__decap_12
XFILLER_0_23_51 VGND VGND VPWR VPWR sky130_fd_sc_hd__decap_4
X_4842_ cpu_inst.regfile_inst.registers\[9\]\[7\] VGND VGND VPWR VPWR _2406_ sky130_fd_sc_hd__clkbuf_1
XFILLER_0_117_249 VPWR VGND VPWR VGND sky130_ef_sc_hd__decap_12
XFILLER_0_114_97 VPWR VGND VPWR VGND sky130_ef_sc_hd__decap_12
XFILLER_0_7_447 VGND VGND VPWR VPWR sky130_fd_sc_hd__fill_1
X_4773_ _2371_ VGND VGND VPWR VPWR _0356_ sky130_fd_sc_hd__clkbuf_1
XFILLER_0_133_709 VPWR VGND VPWR VGND sky130_ef_sc_hd__decap_12
X_3724_ cpu_inst.regfile_inst.registers\[7\]\[24\] cpu_inst.regfile_inst.registers\[6\]\[24\]
+ _1540_ VGND VGND VPWR VPWR _1655_ sky130_fd_sc_hd__mux2_1
XFILLER_0_99_55 VGND VGND VPWR VPWR sky130_fd_sc_hd__fill_1
XFILLER_0_71_832 VGND VGND VPWR VPWR sky130_fd_sc_hd__decap_8
XFILLER_0_15_225 VPWR VGND VPWR VGND sky130_ef_sc_hd__decap_12
XFILLER_0_16_737 VPWR VGND VPWR VGND sky130_ef_sc_hd__decap_12
XFILLER_0_43_512 VGND VGND VPWR VPWR sky130_fd_sc_hd__decap_6
XFILLER_0_130_41 VPWR VGND VPWR VGND sky130_ef_sc_hd__decap_12
X_3655_ cpu_inst.regfile_inst.registers\[2\]\[22\] _1469_ _1470_ cpu_inst.regfile_inst.registers\[7\]\[22\]
+ VGND VGND VPWR VPWR _1588_ sky130_fd_sc_hd__o22a_1
XFILLER_0_130_85 VPWR VGND VPWR VGND sky130_ef_sc_hd__decap_12
XFILLER_0_125_293 VPWR VGND VPWR VGND sky130_ef_sc_hd__decap_12
XFILLER_0_101_606 VGND VGND VPWR VPWR sky130_fd_sc_hd__fill_1
XFILLER_0_3_653 VPWR VGND VPWR VGND sky130_ef_sc_hd__decap_12
XFILLER_0_24_781 VPWR VGND VPWR VGND sky130_ef_sc_hd__decap_12
XFILLER_0_31_729 VPWR VGND VPWR VGND sky130_ef_sc_hd__decap_12
X_2606_ _0528_ _0570_ VGND VGND VPWR VPWR _0571_ sky130_fd_sc_hd__nor2_2
X_3586_ _0686_ _1509_ _1520_ VGND VGND VPWR VPWR _1521_ sky130_fd_sc_hd__a21oi_1
XFILLER_0_3_697 VPWR VGND VPWR VGND sky130_ef_sc_hd__decap_12
XFILLER_0_2_141 VPWR VGND VPWR VGND sky130_ef_sc_hd__decap_12
X_5325_ clknet_leaf_16_clk _0245_ VGND VGND VPWR VPWR cpu_inst.regfile_inst.registers\[7\]\[21\]
+ sky130_fd_sc_hd__dfxtp_1
X_2537_ cpu_inst.decoder_inst.current_pc\[22\] cpu_inst.decoder_inst.current_pc\[20\]
+ cpu_inst.decoder_inst.current_pc\[23\] cpu_inst.decoder_inst.current_pc\[21\] VGND
+ VGND VPWR VPWR _0502_ sky130_fd_sc_hd__or4_4
XTAP_TAPCELL_ROW_54_1114 VGND VPWR sky130_fd_sc_hd__tapvpwrvgnd_1
XTAP_TAPCELL_ROW_54_1103 VGND VPWR sky130_fd_sc_hd__tapvpwrvgnd_1
X_5256_ clknet_leaf_23_clk _0176_ VGND VGND VPWR VPWR cpu_inst.regfile_inst.registers\[5\]\[16\]
+ sky130_fd_sc_hd__dfxtp_1
XFILLER_0_54_3 VPWR VGND VPWR VGND sky130_ef_sc_hd__decap_12
XFILLER_0_11_497 VGND VGND VPWR VPWR sky130_fd_sc_hd__decap_6
X_4207_ _2045_ VGND VGND VPWR VPWR _0116_ sky130_fd_sc_hd__clkbuf_1
X_5187_ clknet_leaf_28_clk _0107_ VGND VGND VPWR VPWR cpu_inst.regfile_inst.registers\[4\]\[11\]
+ sky130_fd_sc_hd__dfxtp_1
XFILLER_0_97_217 VGND VGND VPWR VPWR sky130_fd_sc_hd__decap_6
X_4138_ _2008_ VGND VGND VPWR VPWR _0084_ sky130_fd_sc_hd__clkbuf_1
XTAP_TAPCELL_ROW_3_346 VGND VPWR sky130_fd_sc_hd__tapvpwrvgnd_1
X_4069_ _1970_ VGND VGND VPWR VPWR _0053_ sky130_fd_sc_hd__clkbuf_1
XFILLER_0_78_486 VPWR VGND VPWR VGND sky130_ef_sc_hd__decap_12
XFILLER_0_136_525 VGND VGND VPWR VPWR sky130_fd_sc_hd__decap_6
XTAP_TAPCELL_ROW_65_1276 VGND VPWR sky130_fd_sc_hd__tapvpwrvgnd_1
XFILLER_0_65_125 VPWR VGND VPWR VGND sky130_ef_sc_hd__decap_12
XFILLER_0_65_169 VPWR VGND VPWR VGND sky130_ef_sc_hd__decap_12
XFILLER_0_19_553 VGND VGND VPWR VPWR sky130_fd_sc_hd__decap_6
XTAP_TAPCELL_ROW_22_632 VGND VPWR sky130_fd_sc_hd__tapvpwrvgnd_1
XFILLER_0_136_569 VPWR VGND VPWR VGND sky130_ef_sc_hd__decap_12
XFILLER_0_80_139 VGND VGND VPWR VPWR sky130_fd_sc_hd__fill_1
XFILLER_0_62_832 VGND VGND VPWR VPWR sky130_fd_sc_hd__decap_8
XFILLER_0_19_597 VPWR VGND VPWR VGND sky130_ef_sc_hd__decap_12
XPHY_EDGE_ROW_129_Right_129 VGND VGND VPWR VPWR sky130_fd_sc_hd__decap_3
XFILLER_0_117_783 VGND VGND VPWR VPWR sky130_fd_sc_hd__fill_1
XFILLER_0_61_397 VGND VGND VPWR VPWR sky130_fd_sc_hd__decap_8
XFILLER_0_21_217 VGND VGND VPWR VPWR sky130_fd_sc_hd__decap_6
XFILLER_0_34_589 VGND VGND VPWR VPWR sky130_fd_sc_hd__fill_1
XFILLER_0_104_477 VGND VGND VPWR VPWR sky130_fd_sc_hd__decap_4
XFILLER_0_30_740 VPWR VGND VPWR VGND sky130_ef_sc_hd__decap_12
XFILLER_0_100_650 VGND VGND VPWR VPWR sky130_fd_sc_hd__decap_4
XFILLER_0_28_29 VPWR VGND VPWR VGND sky130_ef_sc_hd__decap_12
XFILLER_0_100_694 VGND VGND VPWR VPWR sky130_fd_sc_hd__decap_6
XFILLER_0_100_672 VGND VGND VPWR VPWR sky130_fd_sc_hd__decap_6
XFILLER_0_97_751 VGND VGND VPWR VPWR sky130_fd_sc_hd__decap_8
XFILLER_0_29_317 VPWR VGND VPWR VGND sky130_ef_sc_hd__decap_12
XFILLER_0_127_503 VGND VGND VPWR VPWR sky130_fd_sc_hd__fill_1
XFILLER_0_60_27 VGND VGND VPWR VPWR sky130_fd_sc_hd__fill_1
XTAP_TAPCELL_ROW_120_2093 VGND VPWR sky130_fd_sc_hd__tapvpwrvgnd_1
XFILLER_0_37_361 VPWR VGND VPWR VGND sky130_ef_sc_hd__decap_12
XFILLER_0_44_309 VPWR VGND VPWR VGND sky130_ef_sc_hd__decap_12
XFILLER_0_115_709 VPWR VGND VPWR VGND sky130_ef_sc_hd__decap_12
XPHY_EDGE_ROW_7_Left_146 VGND VGND VPWR VPWR sky130_fd_sc_hd__decap_3
XFILLER_0_123_753 VPWR VGND VPWR VGND sky130_ef_sc_hd__decap_12
XFILLER_0_107_293 VPWR VGND VPWR VGND sky130_ef_sc_hd__decap_12
XTAP_TAPCELL_ROW_96_1737 VGND VPWR sky130_fd_sc_hd__tapvpwrvgnd_1
XFILLER_0_13_729 VPWR VGND VPWR VGND sky130_ef_sc_hd__decap_12
XFILLER_0_123_797 VPWR VGND VPWR VGND sky130_ef_sc_hd__decap_12
X_3440_ _1146_ _1378_ _1255_ VGND VGND VPWR VPWR _1379_ sky130_fd_sc_hd__mux2_1
XFILLER_0_69_69 VPWR VGND VPWR VGND sky130_ef_sc_hd__decap_12
XFILLER_0_0_601 VPWR VGND VPWR VGND sky130_ef_sc_hd__decap_12
XFILLER_0_100_77 VGND VGND VPWR VPWR sky130_fd_sc_hd__decap_6
X_3371_ _0935_ _0888_ _1317_ VGND VGND VPWR VPWR _1321_ sky130_fd_sc_hd__mux2_1
XFILLER_0_0_645 VPWR VGND VPWR VGND sky130_ef_sc_hd__decap_12
XFILLER_0_110_469 VGND VGND VPWR VPWR sky130_fd_sc_hd__decap_6
X_5110_ clknet_leaf_2_clk _0030_ VGND VGND VPWR VPWR cpu_inst.regfile_inst.registers\[6\]\[30\]
+ sky130_fd_sc_hd__dfxtp_1
XTAP_TAPCELL_ROW_127_2203 VGND VPWR sky130_fd_sc_hd__tapvpwrvgnd_1
XFILLER_0_85_57 VPWR VGND VPWR VGND sky130_ef_sc_hd__decap_12
X_5041_ _2270_ _2510_ VGND VGND VPWR VPWR _2511_ sky130_fd_sc_hd__nand2_1
XFILLER_0_79_217 VGND VGND VPWR VPWR sky130_fd_sc_hd__decap_6
XTAP_TAPCELL_ROW_0_305 VGND VPWR sky130_fd_sc_hd__tapvpwrvgnd_1
XFILLER_0_94_209 VPWR VGND VPWR VGND sky130_ef_sc_hd__decap_12
XFILLER_0_88_773 VGND VGND VPWR VPWR sky130_fd_sc_hd__decap_4
XFILLER_0_87_261 VPWR VGND VPWR VGND sky130_ef_sc_hd__decap_12
XTAP_TAPCELL_ROW_105_1877 VGND VPWR sky130_fd_sc_hd__tapvpwrvgnd_1
XFILLER_0_75_445 VGND VGND VPWR VPWR sky130_fd_sc_hd__decap_3
XFILLER_0_8_701 VPWR VGND VPWR VGND sky130_ef_sc_hd__decap_12
XFILLER_0_34_83 VGND VGND VPWR VPWR sky130_fd_sc_hd__fill_1
XFILLER_0_47_125 VPWR VGND VPWR VGND sky130_ef_sc_hd__decap_12
XFILLER_0_118_525 VGND VGND VPWR VPWR sky130_fd_sc_hd__decap_6
X_4825_ _2397_ VGND VGND VPWR VPWR _0382_ sky130_fd_sc_hd__clkbuf_1
XFILLER_0_16_501 VPWR VGND VPWR VGND sky130_ef_sc_hd__decap_12
XFILLER_0_47_169 VPWR VGND VPWR VGND sky130_ef_sc_hd__decap_12
XTAP_TAPCELL_ROW_138_2365 VGND VPWR sky130_fd_sc_hd__tapvpwrvgnd_1
XFILLER_0_133_517 VPWR VGND VPWR VGND sky130_ef_sc_hd__decap_12
XFILLER_0_118_569 VPWR VGND VPWR VGND sky130_ef_sc_hd__decap_12
XFILLER_0_62_139 VGND VGND VPWR VPWR sky130_fd_sc_hd__fill_1
XFILLER_0_44_821 VGND VGND VPWR VPWR sky130_fd_sc_hd__decap_3
XTAP_TAPCELL_ROW_138_2387 VGND VPWR sky130_fd_sc_hd__tapvpwrvgnd_1
XTAP_TAPCELL_ROW_138_2376 VGND VPWR sky130_fd_sc_hd__tapvpwrvgnd_1
XTAP_TAPCELL_ROW_60_1195 VGND VPWR sky130_fd_sc_hd__tapvpwrvgnd_1
X_4756_ cpu_inst.decoder_inst.current_pc\[29\] _2359_ VGND VGND VPWR VPWR _2362_ sky130_fd_sc_hd__xnor2_1
XFILLER_0_16_545 VPWR VGND VPWR VGND sky130_ef_sc_hd__decap_12
X_3707_ _1638_ VGND VGND VPWR VPWR _1639_ sky130_fd_sc_hd__inv_2
X_4687_ net37 _2308_ cpu_inst.decoder_inst.current_pc\[10\] VGND VGND VPWR VPWR _2312_
+ sky130_fd_sc_hd__a21oi_1
XFILLER_0_16_589 VPWR VGND VPWR VGND sky130_ef_sc_hd__decap_12
XFILLER_0_101_414 VGND VGND VPWR VPWR sky130_fd_sc_hd__decap_3
X_3638_ _1524_ _1532_ _1571_ VGND VGND VPWR VPWR _1572_ sky130_fd_sc_hd__o21ai_1
XFILLER_0_3_461 VPWR VGND VPWR VGND sky130_ef_sc_hd__decap_12
XFILLER_0_31_537 VGND VGND VPWR VPWR sky130_fd_sc_hd__decap_4
XFILLER_0_31_559 VGND VGND VPWR VPWR sky130_fd_sc_hd__fill_1
XFILLER_0_101_447 VGND VGND VPWR VPWR sky130_fd_sc_hd__fill_1
X_3569_ _1452_ _1503_ _1255_ VGND VGND VPWR VPWR _1504_ sky130_fd_sc_hd__mux2_1
XTAP_TAPCELL_ROW_8_427 VGND VPWR sky130_fd_sc_hd__tapvpwrvgnd_1
XTAP_TAPCELL_ROW_8_416 VGND VPWR sky130_fd_sc_hd__tapvpwrvgnd_1
XFILLER_0_101_458 VPWR VGND VPWR VGND sky130_ef_sc_hd__decap_12
XFILLER_0_11_261 VPWR VGND VPWR VGND sky130_ef_sc_hd__decap_12
X_5308_ clknet_leaf_33_clk _0228_ VGND VGND VPWR VPWR cpu_inst.regfile_inst.registers\[7\]\[4\]
+ sky130_fd_sc_hd__dfxtp_1
X_5239_ clknet_leaf_2_clk _0159_ VGND VGND VPWR VPWR cpu_inst.regfile_inst.registers\[24\]\[31\]
+ sky130_fd_sc_hd__dfxtp_1
XTAP_TAPCELL_ROW_67_1305 VGND VPWR sky130_fd_sc_hd__tapvpwrvgnd_1
XTAP_TAPCELL_ROW_27_702 VGND VPWR sky130_fd_sc_hd__tapvpwrvgnd_1
XFILLER_0_39_615 VGND VGND VPWR VPWR sky130_fd_sc_hd__fill_1
XFILLER_0_109_503 VGND VGND VPWR VPWR sky130_fd_sc_hd__fill_1
XTAP_TAPCELL_ROW_80_1505 VGND VPWR sky130_fd_sc_hd__tapvpwrvgnd_1
XFILLER_0_66_445 VGND VGND VPWR VPWR sky130_fd_sc_hd__decap_6
XFILLER_0_136_333 VPWR VGND VPWR VGND sky130_ef_sc_hd__decap_12
XFILLER_0_66_489 VGND VGND VPWR VPWR sky130_fd_sc_hd__decap_8
XFILLER_0_26_309 VPWR VGND VPWR VGND sky130_ef_sc_hd__decap_12
XFILLER_0_19_361 VPWR VGND VPWR VGND sky130_ef_sc_hd__decap_12
XFILLER_0_136_377 VPWR VGND VPWR VGND sky130_ef_sc_hd__decap_12
XFILLER_0_105_753 VPWR VGND VPWR VGND sky130_ef_sc_hd__decap_12
XFILLER_0_61_161 VGND VGND VPWR VPWR sky130_fd_sc_hd__decap_6
XFILLER_0_120_701 VPWR VGND VPWR VGND sky130_ef_sc_hd__decap_12
XFILLER_0_105_797 VPWR VGND VPWR VGND sky130_ef_sc_hd__decap_12
XTAP_TAPCELL_ROW_78_1467 VGND VPWR sky130_fd_sc_hd__tapvpwrvgnd_1
XFILLER_0_39_39 VPWR VGND VPWR VGND sky130_ef_sc_hd__decap_12
XTAP_TAPCELL_ROW_91_1667 VGND VPWR sky130_fd_sc_hd__tapvpwrvgnd_1
XFILLER_0_55_27 VPWR VGND VPWR VGND sky130_ef_sc_hd__decap_12
XTAP_TAPCELL_ROW_122_2133 VGND VPWR sky130_fd_sc_hd__tapvpwrvgnd_1
XFILLER_0_89_559 VGND VGND VPWR VPWR sky130_fd_sc_hd__fill_1
XFILLER_0_76_209 VPWR VGND VPWR VGND sky130_ef_sc_hd__decap_12
XFILLER_0_71_15 VPWR VGND VPWR VGND sky130_ef_sc_hd__decap_12
XFILLER_0_69_261 VPWR VGND VPWR VGND sky130_ef_sc_hd__decap_12
XFILLER_0_29_125 VPWR VGND VPWR VGND sky130_ef_sc_hd__decap_12
X_2940_ cpu_inst.regfile_inst.registers\[7\]\[3\] cpu_inst.regfile_inst.registers\[6\]\[3\]
+ _0675_ VGND VGND VPWR VPWR _0905_ sky130_fd_sc_hd__mux2_1
XFILLER_0_84_253 VPWR VGND VPWR VGND sky130_ef_sc_hd__decap_12
XFILLER_0_29_169 VPWR VGND VPWR VGND sky130_ef_sc_hd__decap_12
X_2871_ cpu_inst.regfile_inst.registers\[15\]\[8\] _0729_ _0835_ _0714_ VGND VGND
+ VPWR VPWR _0836_ sky130_fd_sc_hd__a211o_1
X_4610_ cpu_inst.regfile_inst.registers\[10\]\[23\] _2252_ VGND VGND VPWR VPWR _2254_
+ sky130_fd_sc_hd__and2_1
XFILLER_0_72_415 VGND VGND VPWR VPWR sky130_fd_sc_hd__decap_4
XFILLER_0_44_139 VGND VGND VPWR VPWR sky130_fd_sc_hd__fill_1
XFILLER_0_115_517 VPWR VGND VPWR VGND sky130_ef_sc_hd__decap_12
XFILLER_0_112_3 VPWR VGND VPWR VGND sky130_ef_sc_hd__decap_12
XTAP_TAPCELL_ROW_100_1796 VGND VPWR sky130_fd_sc_hd__tapvpwrvgnd_1
X_4541_ _2218_ VGND VGND VPWR VPWR _0277_ sky130_fd_sc_hd__clkbuf_1
XFILLER_0_53_695 VGND VGND VPWR VPWR sky130_fd_sc_hd__fill_1
XFILLER_0_53_673 VGND VGND VPWR VPWR sky130_fd_sc_hd__decap_4
XTAP_TAPCELL_ROW_13_495 VGND VPWR sky130_fd_sc_hd__tapvpwrvgnd_1
XFILLER_0_20_41 VPWR VGND VPWR VGND sky130_ef_sc_hd__decap_12
XFILLER_0_40_301 VGND VGND VPWR VPWR sky130_fd_sc_hd__decap_6
XFILLER_0_41_824 VGND VGND VPWR VPWR sky130_fd_sc_hd__fill_2
XFILLER_0_123_561 VPWR VGND VPWR VGND sky130_ef_sc_hd__decap_12
X_4472_ _2183_ VGND VGND VPWR VPWR _0243_ sky130_fd_sc_hd__clkbuf_1
XFILLER_0_13_559 VGND VGND VPWR VPWR sky130_fd_sc_hd__fill_1
XFILLER_0_20_85 VPWR VGND VPWR VGND sky130_ef_sc_hd__decap_12
XFILLER_0_40_345 VPWR VGND VPWR VGND sky130_ef_sc_hd__decap_12
XTAP_TAPCELL_ROW_133_2295 VGND VPWR sky130_fd_sc_hd__tapvpwrvgnd_1
X_3423_ _0853_ _1360_ _1361_ VGND VGND VPWR VPWR _1362_ sky130_fd_sc_hd__o21a_1
XFILLER_0_110_233 VPWR VGND VPWR VGND sky130_ef_sc_hd__decap_12
XFILLER_0_40_389 VPWR VGND VPWR VGND sky130_ef_sc_hd__decap_12
XFILLER_0_110_277 VPWR VGND VPWR VGND sky130_ef_sc_hd__decap_12
X_3354_ _1196_ cpu_inst.regfile_inst.registers\[6\]\[4\] _1300_ VGND VGND VPWR VPWR
+ _1305_ sky130_fd_sc_hd__mux2_1
X_3285_ _1134_ _1136_ _1248_ VGND VGND VPWR VPWR _1250_ sky130_fd_sc_hd__a21o_1
X_5024_ _2501_ VGND VGND VPWR VPWR _0477_ sky130_fd_sc_hd__clkbuf_1
XTAP_TAPCELL_ROW_107_1906 VGND VPWR sky130_fd_sc_hd__tapvpwrvgnd_1
XFILLER_0_17_3 VPWR VGND VPWR VGND sky130_ef_sc_hd__decap_12
XTAP_TAPCELL_ROW_49_1035 VGND VPWR sky130_fd_sc_hd__tapvpwrvgnd_1
XFILLER_0_45_93 VPWR VGND VPWR VGND sky130_ef_sc_hd__decap_12
XFILLER_0_76_754 VGND VGND VPWR VPWR sky130_fd_sc_hd__fill_2
XFILLER_0_48_445 VGND VGND VPWR VPWR sky130_fd_sc_hd__decap_4
XTAP_TAPCELL_ROW_62_1235 VGND VPWR sky130_fd_sc_hd__tapvpwrvgnd_1
XTAP_TAPCELL_ROW_62_1224 VGND VPWR sky130_fd_sc_hd__tapvpwrvgnd_1
XFILLER_0_8_531 VGND VGND VPWR VPWR sky130_fd_sc_hd__fill_1
XFILLER_0_118_333 VPWR VGND VPWR VGND sky130_ef_sc_hd__decap_12
XFILLER_0_61_81 VPWR VGND VPWR VGND sky130_ef_sc_hd__decap_12
XFILLER_0_17_821 VPWR VGND VPWR VGND sky130_ef_sc_hd__decap_12
XFILLER_0_134_837 VGND VGND VPWR VPWR sky130_fd_sc_hd__fill_2
XFILLER_0_118_377 VPWR VGND VPWR VGND sky130_ef_sc_hd__decap_12
X_4808_ cpu_inst.regfile_inst.registers\[0\]\[22\] VGND VGND VPWR VPWR _2389_ sky130_fd_sc_hd__clkbuf_1
XFILLER_0_90_245 VGND VGND VPWR VPWR sky130_fd_sc_hd__decap_6
XTAP_TAPCELL_ROW_32_782 VGND VPWR sky130_fd_sc_hd__tapvpwrvgnd_1
XFILLER_0_90_289 VPWR VGND VPWR VGND sky130_ef_sc_hd__decap_12
X_4739_ _2349_ _0685_ _2284_ VGND VGND VPWR VPWR _2350_ sky130_fd_sc_hd__or3b_1
XFILLER_0_43_161 VGND VGND VPWR VPWR sky130_fd_sc_hd__decap_6
XFILLER_0_50_109 VPWR VGND VPWR VGND sky130_ef_sc_hd__decap_12
XFILLER_0_9_93 VPWR VGND VPWR VGND sky130_ef_sc_hd__decap_12
XFILLER_0_4_781 VPWR VGND VPWR VGND sky130_ef_sc_hd__decap_12
XFILLER_0_102_778 VPWR VGND VPWR VGND sky130_ef_sc_hd__decap_12
XPHY_EDGE_ROW_79_Left_218 VGND VGND VPWR VPWR sky130_fd_sc_hd__decap_3
XFILLER_0_12_581 VGND VGND VPWR VPWR sky130_fd_sc_hd__decap_6
XTAP_TAPCELL_ROW_73_1397 VGND VPWR sky130_fd_sc_hd__tapvpwrvgnd_1
XFILLER_0_98_301 VGND VGND VPWR VPWR sky130_fd_sc_hd__decap_6
XFILLER_0_98_345 VPWR VGND VPWR VGND sky130_ef_sc_hd__decap_12
XFILLER_0_98_389 VPWR VGND VPWR VGND sky130_ef_sc_hd__decap_12
XFILLER_0_86_518 VGND VGND VPWR VPWR sky130_fd_sc_hd__fill_1
XFILLER_0_79_570 VGND VGND VPWR VPWR sky130_fd_sc_hd__fill_1
XFILLER_0_58_209 VPWR VGND VPWR VGND sky130_ef_sc_hd__decap_12
XFILLER_0_129_609 VGND VGND VPWR VPWR sky130_fd_sc_hd__decap_6
XPHY_EDGE_ROW_88_Left_227 VGND VGND VPWR VPWR sky130_fd_sc_hd__decap_3
XFILLER_0_79_592 VGND VGND VPWR VPWR sky130_fd_sc_hd__fill_1
XFILLER_0_82_713 VGND VGND VPWR VPWR sky130_fd_sc_hd__decap_8
XFILLER_0_66_253 VPWR VGND VPWR VGND sky130_ef_sc_hd__decap_12
XFILLER_0_137_653 VPWR VGND VPWR VGND sky130_ef_sc_hd__decap_12
XFILLER_0_136_141 VPWR VGND VPWR VGND sky130_ef_sc_hd__decap_12
XFILLER_0_81_223 VGND VGND VPWR VPWR sky130_fd_sc_hd__fill_1
XFILLER_0_39_489 VGND VGND VPWR VPWR sky130_fd_sc_hd__decap_4
XFILLER_0_137_697 VPWR VGND VPWR VGND sky130_ef_sc_hd__decap_12
XFILLER_0_82_757 VGND VGND VPWR VPWR sky130_fd_sc_hd__fill_1
XFILLER_0_26_139 VGND VGND VPWR VPWR sky130_fd_sc_hd__fill_1
XTAP_TAPCELL_ROW_10_443 VGND VPWR sky130_fd_sc_hd__tapvpwrvgnd_1
XFILLER_0_22_301 VGND VGND VPWR VPWR sky130_fd_sc_hd__decap_6
XFILLER_0_105_561 VGND VGND VPWR VPWR sky130_fd_sc_hd__decap_8
XTAP_TAPCELL_ROW_10_454 VGND VPWR sky130_fd_sc_hd__tapvpwrvgnd_1
XFILLER_0_50_643 VGND VGND VPWR VPWR sky130_fd_sc_hd__fill_1
XFILLER_0_120_531 VGND VGND VPWR VPWR sky130_fd_sc_hd__fill_1
XPHY_EDGE_ROW_97_Left_236 VGND VGND VPWR VPWR sky130_fd_sc_hd__decap_3
XFILLER_0_1_217 VGND VGND VPWR VPWR sky130_fd_sc_hd__decap_6
XFILLER_0_22_345 VPWR VGND VPWR VGND sky130_ef_sc_hd__decap_12
XFILLER_0_22_389 VPWR VGND VPWR VGND sky130_ef_sc_hd__decap_12
XFILLER_0_66_15 VPWR VGND VPWR VGND sky130_ef_sc_hd__decap_12
X_3070_ _0701_ _1033_ _1034_ _0720_ VGND VGND VPWR VPWR _1035_ sky130_fd_sc_hd__o211a_1
XFILLER_0_106_65 VPWR VGND VPWR VGND sky130_ef_sc_hd__decap_12
XTAP_TAPCELL_ROW_18_565 VGND VPWR sky130_fd_sc_hd__tapvpwrvgnd_1
XTAP_TAPCELL_ROW_18_576 VGND VPWR sky130_fd_sc_hd__tapvpwrvgnd_1
XTAP_TAPCELL_ROW_102_1836 VGND VPWR sky130_fd_sc_hd__tapvpwrvgnd_1
XTAP_TAPCELL_ROW_102_1825 VGND VPWR sky130_fd_sc_hd__tapvpwrvgnd_1
X_3972_ _1856_ _1860_ _1861_ _1895_ VGND VGND VPWR VPWR _1897_ sky130_fd_sc_hd__or4_1
XFILLER_0_58_787 VGND VGND VPWR VPWR sky130_fd_sc_hd__decap_3
XFILLER_0_9_317 VPWR VGND VPWR VGND sky130_ef_sc_hd__decap_12
XFILLER_0_85_595 VGND VGND VPWR VPWR sky130_fd_sc_hd__decap_4
X_2923_ cpu_inst.regfile_inst.registers\[25\]\[4\] _0569_ _0694_ _0887_ VGND VGND
+ VPWR VPWR _0888_ sky130_fd_sc_hd__o211a_1
XFILLER_0_57_297 VGND VGND VPWR VPWR sky130_fd_sc_hd__fill_1
XFILLER_0_45_415 VPWR VGND VPWR VGND sky130_ef_sc_hd__decap_12
XFILLER_0_122_53 VPWR VGND VPWR VGND sky130_ef_sc_hd__decap_12
XFILLER_0_116_837 VGND VGND VPWR VPWR sky130_fd_sc_hd__decap_4
XFILLER_0_72_245 VGND VGND VPWR VPWR sky130_fd_sc_hd__decap_6
XFILLER_0_31_51 VGND VGND VPWR VPWR sky130_fd_sc_hd__decap_4
X_2854_ _0725_ _0817_ _0818_ VGND VGND VPWR VPWR _0819_ sky130_fd_sc_hd__or3_1
XTAP_TAPCELL_ROW_135_2324 VGND VPWR sky130_fd_sc_hd__tapvpwrvgnd_1
XFILLER_0_122_97 VPWR VGND VPWR VGND sky130_ef_sc_hd__decap_12
XFILLER_0_72_289 VPWR VGND VPWR VGND sky130_ef_sc_hd__decap_12
XFILLER_0_14_813 VPWR VGND VPWR VGND sky130_ef_sc_hd__decap_12
XFILLER_0_25_161 VGND VGND VPWR VPWR sky130_fd_sc_hd__decap_6
XFILLER_0_32_109 VPWR VGND VPWR VGND sky130_ef_sc_hd__decap_12
X_2785_ _0705_ _0747_ _0748_ _0749_ VGND VGND VPWR VPWR _0750_ sky130_fd_sc_hd__o211a_1
X_5573_ clknet_leaf_30_clk _0493_ VGND VGND VPWR VPWR cpu_inst.display_inst.counter\[13\]
+ sky130_fd_sc_hd__dfxtp_1
X_4524_ cpu_inst.regfile_inst.registers\[11\]\[13\] VGND VGND VPWR VPWR _2210_ sky130_fd_sc_hd__clkbuf_1
XFILLER_0_53_492 VGND VGND VPWR VPWR sky130_fd_sc_hd__fill_1
XFILLER_0_40_153 VPWR VGND VPWR VGND sky130_ef_sc_hd__decap_12
XFILLER_0_123_391 VGND VGND VPWR VPWR sky130_fd_sc_hd__fill_1
XFILLER_0_111_553 VGND VGND VPWR VPWR sky130_fd_sc_hd__decap_6
X_4455_ _1215_ cpu_inst.regfile_inst.registers\[7\]\[11\] _2174_ VGND VGND VPWR VPWR
+ _2175_ sky130_fd_sc_hd__mux2_1
XFILLER_0_111_597 VPWR VGND VPWR VGND sky130_ef_sc_hd__decap_12
X_3406_ _1135_ _1248_ VGND VGND VPWR VPWR _1345_ sky130_fd_sc_hd__or2_1
X_4386_ _2138_ VGND VGND VPWR VPWR _0202_ sky130_fd_sc_hd__clkbuf_1
XFILLER_0_40_197 VPWR VGND VPWR VGND sky130_ef_sc_hd__decap_12
XTAP_TAPCELL_ROW_113_1998 VGND VPWR sky130_fd_sc_hd__tapvpwrvgnd_1
X_3337_ _0512_ _1288_ _1291_ VGND VGND VPWR VPWR _1292_ sky130_fd_sc_hd__or3b_1
X_3268_ cpu_inst.regfile_inst.registers\[0\]\[15\] _0615_ _1231_ _0853_ _1232_ VGND
+ VGND VPWR VPWR _1233_ sky130_fd_sc_hd__o221a_1
X_5007_ cpu_inst.regfile_inst.registers\[15\]\[21\] _2491_ VGND VGND VPWR VPWR _2493_
+ sky130_fd_sc_hd__and2_1
X_3199_ _1053_ _1159_ _1160_ _1163_ _0683_ VGND VGND VPWR VPWR _1164_ sky130_fd_sc_hd__a32o_2
XTAP_TAPCELL_ROW_37_852 VGND VPWR sky130_fd_sc_hd__tapvpwrvgnd_1
XFILLER_0_138_417 VGND VGND VPWR VPWR sky130_fd_sc_hd__decap_3
XFILLER_0_95_337 VPWR VGND VPWR VGND sky130_ef_sc_hd__decap_12
XFILLER_0_48_253 VPWR VGND VPWR VGND sky130_ef_sc_hd__decap_12
XFILLER_0_119_653 VPWR VGND VPWR VGND sky130_ef_sc_hd__decap_12
XFILLER_0_118_141 VPWR VGND VPWR VGND sky130_ef_sc_hd__decap_12
XFILLER_0_134_601 VPWR VGND VPWR VGND sky130_ef_sc_hd__decap_12
XFILLER_0_119_697 VPWR VGND VPWR VGND sky130_ef_sc_hd__decap_12
XFILLER_0_63_223 VGND VGND VPWR VPWR sky130_fd_sc_hd__fill_1
XFILLER_0_134_645 VPWR VGND VPWR VGND sky130_ef_sc_hd__decap_12
XFILLER_0_133_111 VGND VGND VPWR VPWR sky130_fd_sc_hd__fill_1
XFILLER_0_17_673 VPWR VGND VPWR VGND sky130_ef_sc_hd__decap_12
XFILLER_0_121_317 VPWR VGND VPWR VGND sky130_ef_sc_hd__decap_12
XTAP_TAPCELL_ROW_75_1426 VGND VPWR sky130_fd_sc_hd__tapvpwrvgnd_1
XFILLER_0_20_805 VGND VGND VPWR VPWR sky130_fd_sc_hd__decap_6
XFILLER_0_102_531 VGND VGND VPWR VPWR sky130_fd_sc_hd__fill_1
XFILLER_0_6_3 VPWR VGND VPWR VGND sky130_ef_sc_hd__decap_12
XFILLER_0_36_29 VPWR VGND VPWR VGND sky130_ef_sc_hd__decap_12
XFILLER_0_98_153 VPWR VGND VPWR VGND sky130_ef_sc_hd__decap_12
XFILLER_0_59_529 VGND VGND VPWR VPWR sky130_fd_sc_hd__decap_6
XFILLER_0_129_417 VPWR VGND VPWR VGND sky130_ef_sc_hd__decap_12
XFILLER_0_98_197 VPWR VGND VPWR VGND sky130_ef_sc_hd__decap_12
XTAP_TAPCELL_ROW_86_1588 VGND VPWR sky130_fd_sc_hd__tapvpwrvgnd_1
XTAP_TAPCELL_ROW_15_524 VGND VPWR sky130_fd_sc_hd__tapvpwrvgnd_1
XFILLER_0_67_573 VGND VGND VPWR VPWR sky130_fd_sc_hd__fill_1
XFILLER_0_55_713 VGND VGND VPWR VPWR sky130_fd_sc_hd__fill_1
XFILLER_0_137_461 VPWR VGND VPWR VGND sky130_ef_sc_hd__decap_12
XFILLER_0_54_245 VGND VGND VPWR VPWR sky130_fd_sc_hd__decap_6
XFILLER_0_6_309 VPWR VGND VPWR VGND sky130_ef_sc_hd__decap_12
XFILLER_0_124_133 VGND VGND VPWR VPWR sky130_fd_sc_hd__decap_6
XFILLER_0_54_289 VPWR VGND VPWR VGND sky130_ef_sc_hd__decap_12
XFILLER_0_14_109 VPWR VGND VPWR VGND sky130_ef_sc_hd__decap_12
XTAP_TAPCELL_ROW_117_2054 VGND VPWR sky130_fd_sc_hd__tapvpwrvgnd_1
XFILLER_0_124_177 VPWR VGND VPWR VGND sky130_ef_sc_hd__decap_12
X_2570_ _0516_ _0518_ _0534_ VGND VGND VPWR VPWR _0535_ sky130_fd_sc_hd__or3_4
XFILLER_0_22_153 VPWR VGND VPWR VGND sky130_ef_sc_hd__decap_12
XFILLER_0_23_665 VGND VGND VPWR VPWR sky130_fd_sc_hd__decap_6
XFILLER_0_50_462 VGND VGND VPWR VPWR sky130_fd_sc_hd__fill_1
XTAP_TAPCELL_ROW_130_2243 VGND VPWR sky130_fd_sc_hd__tapvpwrvgnd_1
XFILLER_0_105_391 VGND VGND VPWR VPWR sky130_fd_sc_hd__fill_1
XTAP_TAPCELL_ROW_130_2254 VGND VPWR sky130_fd_sc_hd__tapvpwrvgnd_1
XFILLER_0_77_69 VPWR VGND VPWR VGND sky130_ef_sc_hd__decap_12
XFILLER_0_22_197 VPWR VGND VPWR VGND sky130_ef_sc_hd__decap_12
X_4240_ _2062_ VGND VGND VPWR VPWR _0132_ sky130_fd_sc_hd__clkbuf_1
X_4171_ cpu_inst.regfile_inst.registers\[4\]\[3\] _2024_ VGND VGND VPWR VPWR _2027_
+ sky130_fd_sc_hd__and2_1
X_3122_ _0682_ _0685_ VGND VGND VPWR VPWR _1087_ sky130_fd_sc_hd__or2_1
XFILLER_0_93_57 VPWR VGND VPWR VGND sky130_ef_sc_hd__decap_12
X_3053_ _0952_ _0959_ VGND VGND VPWR VPWR _1018_ sky130_fd_sc_hd__and2_1
XFILLER_0_77_337 VPWR VGND VPWR VGND sky130_ef_sc_hd__decap_12
XFILLER_0_92_307 VGND VGND VPWR VPWR sky130_fd_sc_hd__fill_1
XFILLER_0_9_125 VPWR VGND VPWR VGND sky130_ef_sc_hd__decap_12
XTAP_TAPCELL_ROW_34_811 VGND VPWR sky130_fd_sc_hd__tapvpwrvgnd_1
X_3955_ _0686_ _1852_ _1842_ VGND VGND VPWR VPWR _1880_ sky130_fd_sc_hd__a21o_1
XFILLER_0_73_521 VPWR VGND VPWR VGND sky130_ef_sc_hd__decap_12
XFILLER_0_116_601 VPWR VGND VPWR VGND sky130_ef_sc_hd__decap_12
X_2906_ _0870_ VGND VGND VPWR VPWR _0871_ sky130_fd_sc_hd__buf_4
XFILLER_0_9_169 VPWR VGND VPWR VGND sky130_ef_sc_hd__decap_12
XFILLER_0_42_83 VGND VGND VPWR VPWR sky130_fd_sc_hd__fill_1
XFILLER_0_45_223 VGND VGND VPWR VPWR sky130_fd_sc_hd__fill_1
XFILLER_0_116_645 VPWR VGND VPWR VGND sky130_ef_sc_hd__decap_12
XFILLER_0_115_111 VGND VGND VPWR VPWR sky130_fd_sc_hd__fill_1
X_3886_ cpu_inst.regfile_inst.registers\[15\]\[28\] _0729_ _1812_ _1552_ VGND VGND
+ VPWR VPWR _1813_ sky130_fd_sc_hd__a211o_1
XFILLER_0_61_727 VGND VGND VPWR VPWR sky130_fd_sc_hd__fill_1
XFILLER_0_131_615 VGND VGND VPWR VPWR sky130_fd_sc_hd__fill_1
XFILLER_0_84_3 VPWR VGND VPWR VGND sky130_ef_sc_hd__decap_12
XFILLER_0_33_429 VPWR VGND VPWR VGND sky130_ef_sc_hd__decap_12
X_2837_ cpu_inst.regfile_inst.registers\[4\]\[5\] _0622_ _0571_ _0801_ VGND VGND VPWR
+ VPWR _0802_ sky130_fd_sc_hd__o22a_1
XFILLER_0_103_317 VPWR VGND VPWR VGND sky130_ef_sc_hd__decap_12
X_5556_ clknet_leaf_7_clk _0476_ VGND VGND VPWR VPWR cpu_inst.regfile_inst.registers\[15\]\[28\]
+ sky130_fd_sc_hd__dfxtp_1
X_2768_ cpu_inst.regfile_inst.registers\[1\]\[11\] _0726_ _0730_ cpu_inst.regfile_inst.registers\[5\]\[11\]
+ _0732_ VGND VGND VPWR VPWR _0733_ sky130_fd_sc_hd__o221a_1
XFILLER_0_14_643 VGND VGND VPWR VPWR sky130_fd_sc_hd__fill_1
XFILLER_0_41_440 VGND VGND VPWR VPWR sky130_fd_sc_hd__fill_1
X_5487_ clknet_leaf_14_clk _0407_ VGND VGND VPWR VPWR cpu_inst.regfile_inst.registers\[9\]\[23\]
+ sky130_fd_sc_hd__dfxtp_1
X_2699_ cpu_inst.regfile_inst.registers\[25\]\[1\] _0569_ _0661_ _0663_ VGND VGND
+ VPWR VPWR _0664_ sky130_fd_sc_hd__o211ai_2
X_4507_ _2201_ VGND VGND VPWR VPWR _0260_ sky130_fd_sc_hd__clkbuf_1
XFILLER_0_111_361 VPWR VGND VPWR VGND sky130_ef_sc_hd__decap_12
XTAP_TAPCELL_ROW_57_1156 VGND VPWR sky130_fd_sc_hd__tapvpwrvgnd_1
X_4438_ _2165_ VGND VGND VPWR VPWR _0227_ sky130_fd_sc_hd__clkbuf_1
XFILLER_0_6_83 VGND VGND VPWR VPWR sky130_fd_sc_hd__fill_1
XTAP_TAPCELL_ROW_70_1356 VGND VPWR sky130_fd_sc_hd__tapvpwrvgnd_1
XTAP_TAPCELL_ROW_70_1345 VGND VPWR sky130_fd_sc_hd__tapvpwrvgnd_1
X_4369_ cpu_inst.regfile_inst.registers\[1\]\[2\] VGND VGND VPWR VPWR _2130_ sky130_fd_sc_hd__clkbuf_1
XFILLER_0_96_657 VGND VGND VPWR VPWR sky130_fd_sc_hd__fill_2
XFILLER_0_138_225 VPWR VGND VPWR VGND sky130_ef_sc_hd__decap_12
XFILLER_0_95_167 VGND VGND VPWR VPWR sky130_fd_sc_hd__fill_1
XFILLER_0_83_329 VGND VGND VPWR VPWR sky130_fd_sc_hd__decap_6
XFILLER_0_49_573 VPWR VGND VPWR VGND sky130_ef_sc_hd__decap_12
XFILLER_0_119_461 VPWR VGND VPWR VGND sky130_ef_sc_hd__decap_12
XFILLER_0_92_841 VGND VGND VPWR VPWR sky130_fd_sc_hd__fill_1
XFILLER_0_36_245 VGND VGND VPWR VPWR sky130_fd_sc_hd__decap_6
XFILLER_0_91_373 VGND VGND VPWR VPWR sky130_fd_sc_hd__decap_3
XFILLER_0_64_576 VPWR VGND VPWR VGND sky130_ef_sc_hd__decap_12
XFILLER_0_106_133 VGND VGND VPWR VPWR sky130_fd_sc_hd__decap_6
XFILLER_0_36_289 VPWR VGND VPWR VGND sky130_ef_sc_hd__decap_12
XFILLER_0_51_237 VPWR VGND VPWR VGND sky130_ef_sc_hd__decap_12
XFILLER_0_134_475 VGND VGND VPWR VPWR sky130_fd_sc_hd__fill_1
XFILLER_0_122_637 VGND VGND VPWR VPWR sky130_fd_sc_hd__decap_6
XFILLER_0_121_125 VPWR VGND VPWR VGND sky130_ef_sc_hd__decap_12
XFILLER_0_106_177 VPWR VGND VPWR VGND sky130_ef_sc_hd__decap_12
XTAP_TAPCELL_ROW_20_593 VGND VPWR sky130_fd_sc_hd__tapvpwrvgnd_1
XFILLER_0_20_613 VPWR VGND VPWR VGND sky130_ef_sc_hd__decap_12
XFILLER_0_130_681 VPWR VGND VPWR VGND sky130_ef_sc_hd__decap_12
XFILLER_0_121_169 VPWR VGND VPWR VGND sky130_ef_sc_hd__decap_12
XFILLER_0_20_657 VPWR VGND VPWR VGND sky130_ef_sc_hd__decap_12
XFILLER_0_32_495 VGND VGND VPWR VPWR sky130_fd_sc_hd__fill_2
XFILLER_0_47_39 VPWR VGND VPWR VGND sky130_ef_sc_hd__decap_12
XTAP_TAPCELL_ROW_88_1617 VGND VPWR sky130_fd_sc_hd__tapvpwrvgnd_1
XFILLER_0_63_27 VPWR VGND VPWR VGND sky130_ef_sc_hd__decap_12
XFILLER_0_129_225 VPWR VGND VPWR VGND sky130_ef_sc_hd__decap_12
XFILLER_0_86_189 VGND VGND VPWR VPWR sky130_fd_sc_hd__decap_6
XFILLER_0_74_307 VGND VGND VPWR VPWR sky130_fd_sc_hd__fill_1
XFILLER_0_28_713 VPWR VGND VPWR VGND sky130_ef_sc_hd__decap_12
XFILLER_0_138_781 VGND VGND VPWR VPWR sky130_fd_sc_hd__decap_3
X_3740_ cpu_inst.regfile_inst.registers\[4\]\[24\] _0854_ _1028_ VGND VGND VPWR VPWR
+ _1671_ sky130_fd_sc_hd__o21a_1
XFILLER_0_83_841 VGND VGND VPWR VPWR sky130_fd_sc_hd__fill_1
XFILLER_0_67_381 VGND VGND VPWR VPWR sky130_fd_sc_hd__fill_2
XFILLER_0_55_521 VGND VGND VPWR VPWR sky130_fd_sc_hd__fill_1
XFILLER_0_7_629 VPWR VGND VPWR VGND sky130_ef_sc_hd__decap_12
XFILLER_0_27_223 VGND VGND VPWR VPWR sky130_fd_sc_hd__fill_1
XFILLER_0_28_757 VPWR VGND VPWR VGND sky130_ef_sc_hd__decap_12
XFILLER_0_103_55 VGND VGND VPWR VPWR sky130_fd_sc_hd__fill_1
XFILLER_0_12_53 VPWR VGND VPWR VGND sky130_ef_sc_hd__decap_12
XFILLER_0_6_139 VGND VGND VPWR VPWR sky130_fd_sc_hd__fill_1
XTAP_TAPCELL_ROW_99_1779 VGND VPWR sky130_fd_sc_hd__tapvpwrvgnd_1
X_3671_ _1544_ _1603_ _1451_ VGND VGND VPWR VPWR _1604_ sky130_fd_sc_hd__mux2_1
XFILLER_0_12_97 VPWR VGND VPWR VGND sky130_ef_sc_hd__decap_12
XFILLER_0_15_429 VPWR VGND VPWR VGND sky130_ef_sc_hd__decap_12
XFILLER_0_125_497 VGND VGND VPWR VPWR sky130_fd_sc_hd__decap_6
XFILLER_0_113_615 VGND VGND VPWR VPWR sky130_fd_sc_hd__fill_1
X_5410_ clknet_leaf_4_clk _0330_ net2 VGND VGND VPWR VPWR cpu_inst.decoder_inst.current_pc\[10\]
+ sky130_fd_sc_hd__dfrtp_1
XFILLER_0_70_557 VPWR VGND VPWR VGND sky130_ef_sc_hd__decap_12
XFILLER_0_2_301 VGND VGND VPWR VPWR sky130_fd_sc_hd__decap_6
X_2622_ cpu_inst.regfile_inst.registers\[8\]\[0\] _0586_ VGND VGND VPWR VPWR _0587_
+ sky130_fd_sc_hd__or2_1
X_2553_ _0517_ VGND VGND VPWR VPWR _0518_ sky130_fd_sc_hd__buf_2
XFILLER_0_2_345 VPWR VGND VPWR VGND sky130_ef_sc_hd__decap_12
XFILLER_0_23_473 VPWR VGND VPWR VGND sky130_ef_sc_hd__decap_12
X_5341_ clknet_leaf_35_clk _0261_ VGND VGND VPWR VPWR cpu_inst.regfile_inst.registers\[11\]\[5\]
+ sky130_fd_sc_hd__dfxtp_1
XFILLER_0_51_782 VGND VGND VPWR VPWR sky130_fd_sc_hd__fill_2
XFILLER_0_100_309 VPWR VGND VPWR VGND sky130_ef_sc_hd__decap_12
XFILLER_0_2_389 VPWR VGND VPWR VGND sky130_ef_sc_hd__decap_12
X_5272_ clknet_leaf_41_clk _0192_ VGND VGND VPWR VPWR cpu_inst.regfile_inst.registers\[1\]\[0\]
+ sky130_fd_sc_hd__dfxtp_1
XTAP_TAPCELL_ROW_110_1957 VGND VPWR sky130_fd_sc_hd__tapvpwrvgnd_1
XTAP_TAPCELL_ROW_110_1946 VGND VPWR sky130_fd_sc_hd__tapvpwrvgnd_1
X_4223_ cpu_inst.regfile_inst.registers\[4\]\[28\] _2046_ VGND VGND VPWR VPWR _2054_
+ sky130_fd_sc_hd__and2_1
XFILLER_0_10_189 VGND VGND VPWR VPWR sky130_fd_sc_hd__decap_6
XFILLER_0_128_41 VPWR VGND VPWR VGND sky130_ef_sc_hd__decap_12
X_4154_ _1833_ cpu_inst.regfile_inst.registers\[25\]\[28\] _2010_ VGND VGND VPWR VPWR
+ _2017_ sky130_fd_sc_hd__mux2_1
XTAP_TAPCELL_ROW_52_1075 VGND VPWR sky130_fd_sc_hd__tapvpwrvgnd_1
XFILLER_0_128_85 VPWR VGND VPWR VGND sky130_ef_sc_hd__decap_12
X_4085_ _1978_ VGND VGND VPWR VPWR _0061_ sky130_fd_sc_hd__clkbuf_1
X_3105_ cpu_inst.regfile_inst.registers\[25\]\[13\] _1022_ _1069_ _1045_ VGND VGND
+ VPWR VPWR _1070_ sky130_fd_sc_hd__o211ai_1
XTAP_TAPCELL_ROW_52_1086 VGND VPWR sky130_fd_sc_hd__tapvpwrvgnd_1
X_3036_ cpu_inst.regfile_inst.registers\[25\]\[11\] _0692_ _0694_ _1000_ VGND VGND
+ VPWR VPWR _1001_ sky130_fd_sc_hd__o211a_1
XFILLER_0_66_808 VGND VGND VPWR VPWR sky130_fd_sc_hd__fill_1
XFILLER_0_77_167 VGND VGND VPWR VPWR sky130_fd_sc_hd__fill_1
XFILLER_0_53_93 VPWR VGND VPWR VGND sky130_ef_sc_hd__decap_12
XFILLER_0_135_217 VGND VGND VPWR VPWR sky130_fd_sc_hd__decap_6
XFILLER_0_93_649 VGND VGND VPWR VPWR sky130_fd_sc_hd__decap_8
X_4987_ _2482_ VGND VGND VPWR VPWR _0459_ sky130_fd_sc_hd__clkbuf_1
X_3938_ _1176_ _1863_ VGND VGND VPWR VPWR _1864_ sky130_fd_sc_hd__or2_1
XFILLER_0_73_362 VPWR VGND VPWR VGND sky130_ef_sc_hd__decap_12
XFILLER_0_61_502 VGND VGND VPWR VPWR sky130_fd_sc_hd__fill_2
XFILLER_0_18_245 VGND VGND VPWR VPWR sky130_fd_sc_hd__decap_6
XFILLER_0_46_587 VGND VGND VPWR VPWR sky130_fd_sc_hd__fill_1
X_3869_ _1794_ _1795_ _1313_ VGND VGND VPWR VPWR _1796_ sky130_fd_sc_hd__mux2_1
XFILLER_0_18_289 VPWR VGND VPWR VGND sky130_ef_sc_hd__decap_12
XFILLER_0_33_237 VPWR VGND VPWR VGND sky130_ef_sc_hd__decap_12
XFILLER_0_116_475 VGND VGND VPWR VPWR sky130_fd_sc_hd__fill_1
XFILLER_0_5_161 VGND VGND VPWR VPWR sky130_fd_sc_hd__decap_6
XFILLER_0_103_125 VPWR VGND VPWR VGND sky130_ef_sc_hd__decap_12
X_5539_ clknet_leaf_28_clk _0459_ VGND VGND VPWR VPWR cpu_inst.regfile_inst.registers\[15\]\[11\]
+ sky130_fd_sc_hd__dfxtp_1
XFILLER_0_103_169 VPWR VGND VPWR VGND sky130_ef_sc_hd__decap_12
XFILLER_0_41_281 VPWR VGND VPWR VGND sky130_ef_sc_hd__decap_12
XFILLER_0_112_681 VPWR VGND VPWR VGND sky130_ef_sc_hd__decap_12
XTAP_TAPCELL_ROW_6_388 VGND VPWR sky130_fd_sc_hd__tapvpwrvgnd_1
XFILLER_0_69_679 VGND VGND VPWR VPWR sky130_fd_sc_hd__decap_8
XTAP_TAPCELL_ROW_83_1547 VGND VPWR sky130_fd_sc_hd__tapvpwrvgnd_1
XFILLER_0_68_189 VGND VGND VPWR VPWR sky130_fd_sc_hd__decap_6
XFILLER_0_127_729 VPWR VGND VPWR VGND sky130_ef_sc_hd__decap_12
XFILLER_0_83_137 VPWR VGND VPWR VGND sky130_ef_sc_hd__decap_12
XFILLER_0_65_841 VGND VGND VPWR VPWR sky130_fd_sc_hd__fill_1
XTAP_TAPCELL_ROW_25_674 VGND VPWR sky130_fd_sc_hd__tapvpwrvgnd_1
XFILLER_0_37_521 VGND VGND VPWR VPWR sky130_fd_sc_hd__decap_8
XFILLER_0_80_800 VPWR VGND VPWR VGND sky130_ef_sc_hd__decap_12
XFILLER_0_91_181 VPWR VGND VPWR VGND sky130_ef_sc_hd__decap_12
XFILLER_0_25_727 VGND VGND VPWR VPWR sky130_fd_sc_hd__fill_1
XFILLER_0_122_401 VPWR VGND VPWR VGND sky130_ef_sc_hd__decap_12
XTAP_TAPCELL_ROW_114_2013 VGND VPWR sky130_fd_sc_hd__tapvpwrvgnd_1
XFILLER_0_122_445 VPWR VGND VPWR VGND sky130_ef_sc_hd__decap_12
XFILLER_0_122_489 VPWR VGND VPWR VGND sky130_ef_sc_hd__decap_12
XFILLER_0_58_27 VGND VGND VPWR VPWR sky130_fd_sc_hd__fill_1
XFILLER_0_20_421 VPWR VGND VPWR VGND sky130_ef_sc_hd__decap_12
XFILLER_0_74_15 VPWR VGND VPWR VGND sky130_ef_sc_hd__decap_12
XTAP_TAPCELL_ROW_125_2175 VGND VPWR sky130_fd_sc_hd__tapvpwrvgnd_1
XFILLER_0_99_281 VPWR VGND VPWR VGND sky130_ef_sc_hd__decap_12
X_4910_ _1223_ cpu_inst.regfile_inst.registers\[8\]\[7\] _2432_ VGND VGND VPWR VPWR
+ _2442_ sky130_fd_sc_hd__mux2_1
XFILLER_0_59_167 VGND VGND VPWR VPWR sky130_fd_sc_hd__fill_1
XFILLER_0_47_329 VGND VGND VPWR VPWR sky130_fd_sc_hd__decap_6
X_4841_ _2405_ VGND VGND VPWR VPWR _0390_ sky130_fd_sc_hd__clkbuf_1
XFILLER_0_114_65 VPWR VGND VPWR VGND sky130_ef_sc_hd__decap_12
XTAP_TAPCELL_ROW_44_961 VGND VPWR sky130_fd_sc_hd__tapvpwrvgnd_1
XFILLER_0_117_217 VGND VGND VPWR VPWR sky130_fd_sc_hd__decap_6
XFILLER_0_90_608 VGND VGND VPWR VPWR sky130_fd_sc_hd__decap_8
X_4772_ cpu_inst.regfile_inst.registers\[0\]\[3\] VGND VGND VPWR VPWR _2371_ sky130_fd_sc_hd__clkbuf_1
XFILLER_0_132_209 VPWR VGND VPWR VGND sky130_ef_sc_hd__decap_12
X_3723_ cpu_inst.regfile_inst.registers\[5\]\[24\] cpu_inst.regfile_inst.registers\[4\]\[24\]
+ _1540_ VGND VGND VPWR VPWR _1654_ sky130_fd_sc_hd__mux2_1
XFILLER_0_16_749 VGND VGND VPWR VPWR sky130_fd_sc_hd__decap_6
XFILLER_0_43_535 VGND VGND VPWR VPWR sky130_fd_sc_hd__fill_1
XFILLER_0_130_53 VPWR VGND VPWR VGND sky130_ef_sc_hd__decap_12
XFILLER_0_125_261 VPWR VGND VPWR VGND sky130_ef_sc_hd__decap_12
X_3654_ _1295_ _1586_ VGND VGND VPWR VPWR _1587_ sky130_fd_sc_hd__or2_1
XFILLER_0_70_354 VGND VGND VPWR VPWR sky130_fd_sc_hd__decap_3
XFILLER_0_15_237 VPWR VGND VPWR VGND sky130_ef_sc_hd__decap_12
XFILLER_0_31_719 VGND VGND VPWR VPWR sky130_fd_sc_hd__decap_8
XFILLER_0_130_97 VPWR VGND VPWR VGND sky130_ef_sc_hd__decap_12
X_2605_ _0567_ _0555_ _0536_ _0569_ VGND VGND VPWR VPWR _0570_ sky130_fd_sc_hd__nand4_2
X_3585_ cpu_inst.regfile_inst.registers\[24\]\[20\] _0698_ _0699_ _1519_ VGND VGND
+ VPWR VPWR _1520_ sky130_fd_sc_hd__o211a_1
XFILLER_0_3_665 VGND VGND VPWR VPWR sky130_fd_sc_hd__decap_6
XFILLER_0_2_153 VPWR VGND VPWR VGND sky130_ef_sc_hd__decap_12
XFILLER_0_23_281 VPWR VGND VPWR VGND sky130_ef_sc_hd__decap_12
XFILLER_0_24_793 VPWR VGND VPWR VGND sky130_ef_sc_hd__decap_12
XFILLER_0_100_139 VGND VGND VPWR VPWR sky130_fd_sc_hd__fill_1
X_5324_ clknet_leaf_19_clk _0244_ VGND VGND VPWR VPWR cpu_inst.regfile_inst.registers\[7\]\[20\]
+ sky130_fd_sc_hd__dfxtp_1
X_2536_ cpu_inst.decoder_inst.current_pc\[17\] cpu_inst.decoder_inst.current_pc\[16\]
+ cpu_inst.decoder_inst.current_pc\[19\] cpu_inst.decoder_inst.current_pc\[18\] VGND
+ VGND VPWR VPWR _0501_ sky130_fd_sc_hd__or4_4
XTAP_TAPCELL_ROW_54_1115 VGND VPWR sky130_fd_sc_hd__tapvpwrvgnd_1
XTAP_TAPCELL_ROW_54_1104 VGND VPWR sky130_fd_sc_hd__tapvpwrvgnd_1
XFILLER_0_2_197 VPWR VGND VPWR VGND sky130_ef_sc_hd__decap_12
X_5255_ clknet_leaf_21_clk _0175_ VGND VGND VPWR VPWR cpu_inst.regfile_inst.registers\[5\]\[15\]
+ sky130_fd_sc_hd__dfxtp_1
X_4206_ cpu_inst.regfile_inst.registers\[4\]\[20\] _2035_ VGND VGND VPWR VPWR _2045_
+ sky130_fd_sc_hd__and2_1
XFILLER_0_47_3 VPWR VGND VPWR VGND sky130_ef_sc_hd__decap_12
X_5186_ clknet_leaf_32_clk _0106_ VGND VGND VPWR VPWR cpu_inst.regfile_inst.registers\[4\]\[10\]
+ sky130_fd_sc_hd__dfxtp_1
XFILLER_0_98_719 VGND VGND VPWR VPWR sky130_fd_sc_hd__decap_3
X_4137_ _1534_ cpu_inst.regfile_inst.registers\[25\]\[20\] _1998_ VGND VGND VPWR VPWR
+ _2008_ sky130_fd_sc_hd__mux2_1
XTAP_TAPCELL_ROW_3_347 VGND VPWR sky130_fd_sc_hd__tapvpwrvgnd_1
XFILLER_0_3_51 VGND VGND VPWR VPWR sky130_fd_sc_hd__decap_4
X_4068_ cpu_inst.regfile_inst.registers\[2\]\[21\] VGND VGND VPWR VPWR _1970_ sky130_fd_sc_hd__clkbuf_1
XFILLER_0_78_421 VGND VGND VPWR VPWR sky130_fd_sc_hd__decap_6
X_3019_ _0863_ _0981_ _0983_ _0875_ VGND VGND VPWR VPWR _0984_ sky130_fd_sc_hd__o22a_1
XFILLER_0_78_498 VPWR VGND VPWR VGND sky130_ef_sc_hd__decap_12
XFILLER_0_66_616 VPWR VGND VPWR VGND sky130_ef_sc_hd__decap_12
XFILLER_0_38_307 VGND VGND VPWR VPWR sky130_fd_sc_hd__fill_1
XFILLER_0_109_729 VPWR VGND VPWR VGND sky130_ef_sc_hd__decap_12
XFILLER_0_93_457 VGND VGND VPWR VPWR sky130_fd_sc_hd__fill_1
XTAP_TAPCELL_ROW_65_1277 VGND VPWR sky130_fd_sc_hd__tapvpwrvgnd_1
XFILLER_0_65_137 VPWR VGND VPWR VGND sky130_ef_sc_hd__decap_12
XFILLER_0_47_841 VGND VGND VPWR VPWR sky130_fd_sc_hd__fill_1
XFILLER_0_93_479 VPWR VGND VPWR VGND sky130_ef_sc_hd__decap_12
XFILLER_0_62_811 VGND VGND VPWR VPWR sky130_fd_sc_hd__fill_1
XTAP_TAPCELL_ROW_22_633 VGND VPWR sky130_fd_sc_hd__tapvpwrvgnd_1
XFILLER_0_104_401 VPWR VGND VPWR VGND sky130_ef_sc_hd__decap_12
XFILLER_0_73_181 VPWR VGND VPWR VGND sky130_ef_sc_hd__decap_12
XFILLER_0_30_752 VGND VGND VPWR VPWR sky130_fd_sc_hd__decap_4
XFILLER_0_44_29 VPWR VGND VPWR VGND sky130_ef_sc_hd__decap_12
XFILLER_0_97_741 VGND VGND VPWR VPWR sky130_fd_sc_hd__fill_1
XFILLER_0_96_251 VGND VGND VPWR VPWR sky130_fd_sc_hd__fill_1
XFILLER_0_57_649 VPWR VGND VPWR VGND sky130_ef_sc_hd__decap_12
XFILLER_0_29_329 VGND VGND VPWR VPWR sky130_fd_sc_hd__decap_6
XTAP_TAPCELL_ROW_120_2094 VGND VPWR sky130_fd_sc_hd__tapvpwrvgnd_1
XTAP_TAPCELL_ROW_41_920 VGND VPWR sky130_fd_sc_hd__tapvpwrvgnd_1
XFILLER_0_127_559 VGND VGND VPWR VPWR sky130_fd_sc_hd__fill_1
XFILLER_0_25_535 VGND VGND VPWR VPWR sky130_fd_sc_hd__decap_4
XFILLER_0_37_373 VPWR VGND VPWR VGND sky130_ef_sc_hd__decap_12
XFILLER_0_123_721 VGND VGND VPWR VPWR sky130_fd_sc_hd__decap_6
XFILLER_0_114_209 VPWR VGND VPWR VGND sky130_ef_sc_hd__decap_12
XFILLER_0_107_261 VPWR VGND VPWR VGND sky130_ef_sc_hd__decap_12
XFILLER_0_52_321 VPWR VGND VPWR VGND sky130_ef_sc_hd__decap_12
XFILLER_0_8_29 VPWR VGND VPWR VGND sky130_ef_sc_hd__decap_12
XTAP_TAPCELL_ROW_96_1738 VGND VPWR sky130_fd_sc_hd__tapvpwrvgnd_1
XFILLER_0_52_365 VGND VGND VPWR VPWR sky130_fd_sc_hd__decap_3
XFILLER_0_123_765 VPWR VGND VPWR VGND sky130_ef_sc_hd__decap_12
XFILLER_0_122_253 VPWR VGND VPWR VGND sky130_ef_sc_hd__decap_12
XFILLER_0_0_613 VGND VGND VPWR VPWR sky130_fd_sc_hd__decap_3
XFILLER_0_21_741 VPWR VGND VPWR VGND sky130_ef_sc_hd__decap_12
X_3370_ _1319_ _0899_ _1317_ VGND VGND VPWR VPWR _1320_ sky130_fd_sc_hd__mux2_1
XFILLER_0_20_251 VGND VGND VPWR VPWR sky130_fd_sc_hd__fill_1
XFILLER_0_0_657 VPWR VGND VPWR VGND sky130_ef_sc_hd__decap_12
XFILLER_0_21_785 VPWR VGND VPWR VGND sky130_ef_sc_hd__decap_12
XTAP_TAPCELL_ROW_127_2204 VGND VPWR sky130_fd_sc_hd__tapvpwrvgnd_1
X_5040_ cpu_inst.display_inst.counter\[3\] cpu_inst.display_inst.counter\[4\] _2505_
+ cpu_inst.display_inst.counter\[5\] VGND VGND VPWR VPWR _2510_ sky130_fd_sc_hd__a31o_1
XFILLER_0_85_69 VPWR VGND VPWR VGND sky130_ef_sc_hd__decap_12
XFILLER_0_18_41 VPWR VGND VPWR VGND sky130_ef_sc_hd__decap_12
XPHY_EDGE_ROW_108_Left_247 VGND VGND VPWR VPWR sky130_fd_sc_hd__decap_3
XFILLER_0_18_85 VPWR VGND VPWR VGND sky130_ef_sc_hd__decap_12
XTAP_TAPCELL_ROW_0_306 VGND VPWR sky130_fd_sc_hd__tapvpwrvgnd_1
XFILLER_0_87_273 VGND VGND VPWR VPWR sky130_fd_sc_hd__decap_6
XTAP_TAPCELL_ROW_105_1878 VGND VPWR sky130_fd_sc_hd__tapvpwrvgnd_1
XFILLER_0_8_713 VPWR VGND VPWR VGND sky130_ef_sc_hd__decap_12
XFILLER_0_29_841 VGND VGND VPWR VPWR sky130_fd_sc_hd__fill_1
XFILLER_0_47_137 VPWR VGND VPWR VGND sky130_ef_sc_hd__decap_12
X_4824_ cpu_inst.regfile_inst.registers\[0\]\[30\] VGND VGND VPWR VPWR _2397_ sky130_fd_sc_hd__clkbuf_1
XFILLER_0_7_223 VGND VGND VPWR VPWR sky130_fd_sc_hd__fill_1
XTAP_TAPCELL_ROW_138_2366 VGND VPWR sky130_fd_sc_hd__tapvpwrvgnd_1
XPHY_EDGE_ROW_117_Left_256 VGND VGND VPWR VPWR sky130_fd_sc_hd__decap_3
X_4755_ _2293_ _2361_ cpu_inst.decoder_inst.current_pc\[28\] _2289_ VGND VGND VPWR
+ VPWR _0348_ sky130_fd_sc_hd__o2bb2a_1
XFILLER_0_8_757 VPWR VGND VPWR VGND sky130_ef_sc_hd__decap_12
XFILLER_0_16_513 VPWR VGND VPWR VGND sky130_ef_sc_hd__decap_12
XTAP_TAPCELL_ROW_138_2388 VGND VPWR sky130_fd_sc_hd__tapvpwrvgnd_1
XTAP_TAPCELL_ROW_138_2377 VGND VPWR sky130_fd_sc_hd__tapvpwrvgnd_1
XFILLER_0_133_529 VPWR VGND VPWR VGND sky130_ef_sc_hd__decap_12
XFILLER_0_126_581 VGND VGND VPWR VPWR sky130_fd_sc_hd__decap_6
X_3706_ cpu_inst.regfile_inst.registers\[25\]\[23\] _1252_ _1449_ _1617_ VGND VGND
+ VPWR VPWR _1638_ sky130_fd_sc_hd__o211a_1
XFILLER_0_55_181 VPWR VGND VPWR VGND sky130_ef_sc_hd__decap_12
XFILLER_0_16_557 VPWR VGND VPWR VGND sky130_ef_sc_hd__decap_12
XFILLER_0_50_83 VGND VGND VPWR VPWR sky130_fd_sc_hd__fill_1
X_4686_ _1295_ _2288_ cpu_inst.decoder_inst.current_pc\[10\] VGND VGND VPWR VPWR _2311_
+ sky130_fd_sc_hd__a21oi_1
XTAP_TAPCELL_ROW_60_1196 VGND VPWR sky130_fd_sc_hd__tapvpwrvgnd_1
X_3637_ _1507_ _1523_ VGND VGND VPWR VPWR _1571_ sky130_fd_sc_hd__nand2_1
XFILLER_0_70_195 VGND VGND VPWR VPWR sky130_fd_sc_hd__fill_1
X_3568_ _1488_ _1502_ _1451_ VGND VGND VPWR VPWR _1503_ sky130_fd_sc_hd__mux2_1
XTAP_TAPCELL_ROW_8_417 VGND VPWR sky130_fd_sc_hd__tapvpwrvgnd_1
XFILLER_0_3_473 VPWR VGND VPWR VGND sky130_ef_sc_hd__decap_12
XFILLER_0_59_81 VPWR VGND VPWR VGND sky130_ef_sc_hd__decap_12
XFILLER_0_11_273 VGND VGND VPWR VPWR sky130_fd_sc_hd__decap_6
X_5307_ clknet_leaf_39_clk _0227_ VGND VGND VPWR VPWR cpu_inst.regfile_inst.registers\[7\]\[3\]
+ sky130_fd_sc_hd__dfxtp_1
X_3499_ cpu_inst.regfile_inst.registers\[4\]\[18\] _0854_ _0701_ VGND VGND VPWR VPWR
+ _1436_ sky130_fd_sc_hd__o21a_1
XPHY_EDGE_ROW_126_Left_265 VGND VGND VPWR VPWR sky130_fd_sc_hd__decap_3
X_5238_ clknet_leaf_2_clk _0158_ VGND VGND VPWR VPWR cpu_inst.regfile_inst.registers\[24\]\[30\]
+ sky130_fd_sc_hd__dfxtp_1
X_5169_ clknet_leaf_14_clk _0089_ VGND VGND VPWR VPWR cpu_inst.regfile_inst.registers\[25\]\[25\]
+ sky130_fd_sc_hd__dfxtp_1
XTAP_TAPCELL_ROW_67_1306 VGND VPWR sky130_fd_sc_hd__tapvpwrvgnd_1
XTAP_TAPCELL_ROW_27_703 VGND VPWR sky130_fd_sc_hd__tapvpwrvgnd_1
XFILLER_0_78_251 VGND VGND VPWR VPWR sky130_fd_sc_hd__fill_1
XFILLER_0_94_755 VGND VGND VPWR VPWR sky130_fd_sc_hd__fill_1
XTAP_TAPCELL_ROW_80_1506 VGND VPWR sky130_fd_sc_hd__tapvpwrvgnd_1
XFILLER_0_136_301 VGND VGND VPWR VPWR sky130_fd_sc_hd__decap_6
XPHY_EDGE_ROW_135_Left_274 VGND VGND VPWR VPWR sky130_fd_sc_hd__decap_3
XFILLER_0_66_468 VGND VGND VPWR VPWR sky130_fd_sc_hd__decap_8
XFILLER_0_136_345 VPWR VGND VPWR VGND sky130_ef_sc_hd__decap_12
XFILLER_0_109_559 VGND VGND VPWR VPWR sky130_fd_sc_hd__fill_1
XFILLER_0_19_373 VPWR VGND VPWR VGND sky130_ef_sc_hd__decap_12
XFILLER_0_47_682 VGND VGND VPWR VPWR sky130_fd_sc_hd__fill_1
XFILLER_0_136_389 VPWR VGND VPWR VGND sky130_ef_sc_hd__decap_12
XFILLER_0_74_490 VPWR VGND VPWR VGND sky130_ef_sc_hd__decap_12
XFILLER_0_34_321 VPWR VGND VPWR VGND sky130_ef_sc_hd__decap_12
XFILLER_0_34_365 VPWR VGND VPWR VGND sky130_ef_sc_hd__decap_12
XFILLER_0_120_713 VPWR VGND VPWR VGND sky130_ef_sc_hd__decap_12
XFILLER_0_105_765 VPWR VGND VPWR VGND sky130_ef_sc_hd__decap_12
XFILLER_0_104_253 VPWR VGND VPWR VGND sky130_ef_sc_hd__decap_12
XTAP_TAPCELL_ROW_78_1468 VGND VPWR sky130_fd_sc_hd__tapvpwrvgnd_1
XFILLER_0_120_757 VPWR VGND VPWR VGND sky130_ef_sc_hd__decap_12
XFILLER_0_30_560 VGND VGND VPWR VPWR sky130_fd_sc_hd__decap_4
XTAP_TAPCELL_ROW_91_1668 VGND VPWR sky130_fd_sc_hd__tapvpwrvgnd_1
XFILLER_0_100_481 VGND VGND VPWR VPWR sky130_fd_sc_hd__fill_1
XFILLER_0_89_505 VGND VGND VPWR VPWR sky130_fd_sc_hd__decap_4
XFILLER_0_55_39 VPWR VGND VPWR VGND sky130_ef_sc_hd__decap_12
XTAP_TAPCELL_ROW_122_2134 VGND VPWR sky130_fd_sc_hd__tapvpwrvgnd_1
XTAP_TAPCELL_ROW_122_2123 VGND VPWR sky130_fd_sc_hd__tapvpwrvgnd_1
XFILLER_0_97_571 VGND VGND VPWR VPWR sky130_fd_sc_hd__decap_3
XFILLER_0_71_27 VPWR VGND VPWR VGND sky130_ef_sc_hd__decap_12
XFILLER_0_128_813 VPWR VGND VPWR VGND sky130_ef_sc_hd__decap_12
XFILLER_0_84_221 VPWR VGND VPWR VGND sky130_ef_sc_hd__decap_12
XFILLER_0_69_273 VGND VGND VPWR VPWR sky130_fd_sc_hd__decap_6
XFILLER_0_29_137 VPWR VGND VPWR VGND sky130_ef_sc_hd__decap_12
XFILLER_0_84_265 VPWR VGND VPWR VGND sky130_ef_sc_hd__decap_12
X_2870_ _0584_ _0833_ _0834_ _0623_ VGND VGND VPWR VPWR _0835_ sky130_fd_sc_hd__o211a_1
XFILLER_0_26_811 VGND VGND VPWR VPWR sky130_fd_sc_hd__fill_1
XFILLER_0_115_529 VPWR VGND VPWR VGND sky130_ef_sc_hd__decap_12
XFILLER_0_5_727 VGND VGND VPWR VPWR sky130_fd_sc_hd__fill_1
XFILLER_0_37_181 VPWR VGND VPWR VGND sky130_ef_sc_hd__decap_12
XFILLER_0_111_55 VGND VGND VPWR VPWR sky130_fd_sc_hd__fill_1
XFILLER_0_105_3 VPWR VGND VPWR VGND sky130_ef_sc_hd__decap_12
X_4540_ cpu_inst.regfile_inst.registers\[11\]\[21\] VGND VGND VPWR VPWR _2218_ sky130_fd_sc_hd__clkbuf_1
XTAP_TAPCELL_ROW_100_1797 VGND VPWR sky130_fd_sc_hd__tapvpwrvgnd_1
Xclkbuf_leaf_10_clk clknet_2_1__leaf_clk VGND VGND VPWR VPWR clknet_leaf_10_clk sky130_fd_sc_hd__clkbuf_8
XFILLER_0_13_505 VPWR VGND VPWR VGND sky130_ef_sc_hd__decap_12
XTAP_TAPCELL_ROW_13_496 VGND VPWR sky130_fd_sc_hd__tapvpwrvgnd_1
XFILLER_0_123_573 VPWR VGND VPWR VGND sky130_ef_sc_hd__decap_12
X_4471_ _1493_ cpu_inst.regfile_inst.registers\[7\]\[19\] _2174_ VGND VGND VPWR VPWR
+ _2183_ sky130_fd_sc_hd__mux2_1
XFILLER_0_20_53 VPWR VGND VPWR VGND sky130_ef_sc_hd__decap_12
XFILLER_0_52_195 VGND VGND VPWR VPWR sky130_fd_sc_hd__fill_1
XTAP_TAPCELL_ROW_133_2296 VGND VPWR sky130_fd_sc_hd__tapvpwrvgnd_1
X_3422_ cpu_inst.regfile_inst.registers\[4\]\[16\] _0854_ _0615_ cpu_inst.regfile_inst.registers\[0\]\[16\]
+ _0735_ VGND VGND VPWR VPWR _1361_ sky130_fd_sc_hd__o221a_1
XFILLER_0_0_421 VPWR VGND VPWR VGND sky130_ef_sc_hd__decap_12
XFILLER_0_20_97 VPWR VGND VPWR VGND sky130_ef_sc_hd__decap_12
XFILLER_0_40_357 VGND VGND VPWR VPWR sky130_fd_sc_hd__decap_6
XFILLER_0_110_245 VGND VGND VPWR VPWR sky130_fd_sc_hd__decap_6
XFILLER_0_110_289 VPWR VGND VPWR VGND sky130_ef_sc_hd__decap_12
XFILLER_0_29_51 VGND VGND VPWR VPWR sky130_fd_sc_hd__decap_4
X_3353_ _1304_ VGND VGND VPWR VPWR _0003_ sky130_fd_sc_hd__clkbuf_1
X_3284_ _1134_ _1136_ _1248_ VGND VGND VPWR VPWR _1249_ sky130_fd_sc_hd__nand3_1
X_5023_ cpu_inst.regfile_inst.registers\[15\]\[29\] _2491_ VGND VGND VPWR VPWR _2501_
+ sky130_fd_sc_hd__and2_1
XFILLER_0_136_41 VPWR VGND VPWR VGND sky130_ef_sc_hd__decap_12
XTAP_TAPCELL_ROW_107_1907 VGND VPWR sky130_fd_sc_hd__tapvpwrvgnd_1
XFILLER_0_136_85 VPWR VGND VPWR VGND sky130_ef_sc_hd__decap_12
XFILLER_0_48_402 VPWR VGND VPWR VGND sky130_ef_sc_hd__decap_12
XTAP_TAPCELL_ROW_49_1036 VGND VPWR sky130_fd_sc_hd__tapvpwrvgnd_1
XFILLER_0_0_41 VPWR VGND VPWR VGND sky130_ef_sc_hd__decap_12
XFILLER_0_118_301 VGND VGND VPWR VPWR sky130_fd_sc_hd__decap_6
XTAP_TAPCELL_ROW_62_1236 VGND VPWR sky130_fd_sc_hd__tapvpwrvgnd_1
XTAP_TAPCELL_ROW_62_1225 VGND VPWR sky130_fd_sc_hd__tapvpwrvgnd_1
XFILLER_0_0_85 VPWR VGND VPWR VGND sky130_ef_sc_hd__decap_12
XFILLER_0_134_805 VGND VGND VPWR VPWR sky130_fd_sc_hd__decap_6
XFILLER_0_118_345 VPWR VGND VPWR VGND sky130_ef_sc_hd__decap_12
X_4807_ _2388_ VGND VGND VPWR VPWR _0373_ sky130_fd_sc_hd__clkbuf_1
XFILLER_0_61_93 VPWR VGND VPWR VGND sky130_ef_sc_hd__decap_12
XPHY_EDGE_ROW_3_Right_3 VGND VGND VPWR VPWR sky130_fd_sc_hd__decap_3
XFILLER_0_17_833 VGND VGND VPWR VPWR sky130_fd_sc_hd__decap_4
XFILLER_0_118_389 VPWR VGND VPWR VGND sky130_ef_sc_hd__decap_12
X_2999_ _0816_ _0963_ _0514_ VGND VGND VPWR VPWR _0964_ sky130_fd_sc_hd__a21oi_2
XFILLER_0_8_587 VGND VGND VPWR VPWR sky130_fd_sc_hd__fill_1
XFILLER_0_16_321 VPWR VGND VPWR VGND sky130_ef_sc_hd__decap_12
XTAP_TAPCELL_ROW_32_783 VGND VPWR sky130_fd_sc_hd__tapvpwrvgnd_1
XFILLER_0_44_652 VGND VGND VPWR VPWR sky130_fd_sc_hd__fill_2
XFILLER_0_133_337 VPWR VGND VPWR VGND sky130_ef_sc_hd__decap_12
X_4738_ cpu_inst.decoder_inst.current_pc\[24\] _2345_ VGND VGND VPWR VPWR _2349_ sky130_fd_sc_hd__xor2_1
XFILLER_0_16_365 VPWR VGND VPWR VGND sky130_ef_sc_hd__decap_12
X_4669_ cpu_inst.decoder_inst.current_pc\[5\] _2295_ VGND VGND VPWR VPWR _2299_ sky130_fd_sc_hd__and2_1
XFILLER_0_31_335 VGND VGND VPWR VPWR sky130_fd_sc_hd__fill_1
XFILLER_0_102_735 VGND VGND VPWR VPWR sky130_fd_sc_hd__decap_8
XFILLER_0_4_793 VPWR VGND VPWR VGND sky130_ef_sc_hd__decap_12
XFILLER_0_3_281 VPWR VGND VPWR VGND sky130_ef_sc_hd__decap_12
XFILLER_0_102_757 VGND VGND VPWR VPWR sky130_fd_sc_hd__decap_6
XFILLER_0_101_223 VGND VGND VPWR VPWR sky130_fd_sc_hd__fill_1
XTAP_TAPCELL_ROW_73_1398 VGND VPWR sky130_fd_sc_hd__tapvpwrvgnd_1
XFILLER_0_98_357 VGND VGND VPWR VPWR sky130_fd_sc_hd__decap_6
XFILLER_0_128_109 VPWR VGND VPWR VGND sky130_ef_sc_hd__decap_12
XFILLER_0_66_221 VPWR VGND VPWR VGND sky130_ef_sc_hd__decap_12
XFILLER_0_137_665 VGND VGND VPWR VPWR sky130_fd_sc_hd__decap_6
XFILLER_0_66_265 VPWR VGND VPWR VGND sky130_ef_sc_hd__decap_12
XFILLER_0_136_153 VPWR VGND VPWR VGND sky130_ef_sc_hd__decap_12
XFILLER_0_54_449 VPWR VGND VPWR VGND sky130_ef_sc_hd__decap_12
XFILLER_0_19_181 VPWR VGND VPWR VGND sky130_ef_sc_hd__decap_12
XFILLER_0_136_197 VPWR VGND VPWR VGND sky130_ef_sc_hd__decap_12
XFILLER_0_81_279 VGND VGND VPWR VPWR sky130_fd_sc_hd__fill_1
XFILLER_0_35_652 VPWR VGND VPWR VGND sky130_ef_sc_hd__decap_12
XFILLER_0_62_493 VGND VGND VPWR VPWR sky130_fd_sc_hd__fill_1
XTAP_TAPCELL_ROW_10_455 VGND VPWR sky130_fd_sc_hd__tapvpwrvgnd_1
XTAP_TAPCELL_ROW_10_444 VGND VPWR sky130_fd_sc_hd__tapvpwrvgnd_1
XFILLER_0_34_195 VGND VGND VPWR VPWR sky130_fd_sc_hd__fill_1
XFILLER_0_22_357 VGND VGND VPWR VPWR sky130_fd_sc_hd__decap_6
XFILLER_0_50_666 VPWR VGND VPWR VGND sky130_ef_sc_hd__decap_12
XFILLER_0_120_587 VGND VGND VPWR VPWR sky130_fd_sc_hd__fill_1
XFILLER_0_66_27 VGND VGND VPWR VPWR sky130_fd_sc_hd__fill_1
XFILLER_0_89_335 VGND VGND VPWR VPWR sky130_fd_sc_hd__fill_1
XFILLER_0_82_15 VPWR VGND VPWR VGND sky130_ef_sc_hd__decap_12
XFILLER_0_106_77 VGND VGND VPWR VPWR sky130_fd_sc_hd__decap_6
X_3971_ _1856_ _1860_ _1861_ _1895_ VGND VGND VPWR VPWR _1896_ sky130_fd_sc_hd__o31a_1
XTAP_TAPCELL_ROW_18_566 VGND VPWR sky130_fd_sc_hd__tapvpwrvgnd_1
XTAP_TAPCELL_ROW_18_577 VGND VPWR sky130_fd_sc_hd__tapvpwrvgnd_1
XTAP_TAPCELL_ROW_102_1837 VGND VPWR sky130_fd_sc_hd__tapvpwrvgnd_1
XTAP_TAPCELL_ROW_102_1826 VGND VPWR sky130_fd_sc_hd__tapvpwrvgnd_1
XFILLER_0_9_329 VGND VGND VPWR VPWR sky130_fd_sc_hd__decap_6
X_2922_ _0863_ _0884_ _0886_ _0875_ VGND VGND VPWR VPWR _0887_ sky130_fd_sc_hd__o22a_1
XFILLER_0_128_643 VGND VGND VPWR VPWR sky130_fd_sc_hd__fill_1
XFILLER_0_116_805 VGND VGND VPWR VPWR sky130_fd_sc_hd__decap_6
XFILLER_0_45_405 VGND VGND VPWR VPWR sky130_fd_sc_hd__decap_4
XFILLER_0_45_427 VPWR VGND VPWR VGND sky130_ef_sc_hd__decap_12
XFILLER_0_122_65 VPWR VGND VPWR VGND sky130_ef_sc_hd__decap_12
XFILLER_0_45_449 VGND VGND VPWR VPWR sky130_fd_sc_hd__fill_1
X_2853_ cpu_inst.regfile_inst.registers\[1\]\[9\] _0726_ _0703_ cpu_inst.regfile_inst.registers\[5\]\[9\]
+ _0561_ VGND VGND VPWR VPWR _0818_ sky130_fd_sc_hd__o221a_1
XTAP_TAPCELL_ROW_135_2325 VGND VPWR sky130_fd_sc_hd__tapvpwrvgnd_1
XFILLER_0_115_337 VPWR VGND VPWR VGND sky130_ef_sc_hd__decap_12
XFILLER_0_14_825 VPWR VGND VPWR VGND sky130_ef_sc_hd__decap_12
X_2784_ cpu_inst.regfile_inst.registers\[4\]\[3\] _0622_ _0584_ VGND VGND VPWR VPWR
+ _0749_ sky130_fd_sc_hd__o21a_1
X_5572_ clknet_leaf_30_clk _0492_ VGND VGND VPWR VPWR cpu_inst.display_inst.counter\[12\]
+ sky130_fd_sc_hd__dfxtp_1
XFILLER_0_130_307 VGND VGND VPWR VPWR sky130_fd_sc_hd__fill_1
X_4523_ _2209_ VGND VGND VPWR VPWR _0268_ sky130_fd_sc_hd__clkbuf_1
XFILLER_0_13_335 VGND VGND VPWR VPWR sky130_fd_sc_hd__fill_1
XFILLER_0_40_121 VPWR VGND VPWR VGND sky130_ef_sc_hd__decap_12
X_4454_ _2160_ VGND VGND VPWR VPWR _2174_ sky130_fd_sc_hd__buf_4
XFILLER_0_1_741 VPWR VGND VPWR VGND sky130_ef_sc_hd__decap_12
XFILLER_0_40_165 VPWR VGND VPWR VGND sky130_ef_sc_hd__decap_12
X_3405_ _1344_ VGND VGND VPWR VPWR _0015_ sky130_fd_sc_hd__clkbuf_1
XFILLER_0_1_785 VPWR VGND VPWR VGND sky130_ef_sc_hd__decap_12
X_4385_ cpu_inst.regfile_inst.registers\[1\]\[10\] VGND VGND VPWR VPWR _2138_ sky130_fd_sc_hd__clkbuf_1
XTAP_TAPCELL_ROW_113_1999 VGND VPWR sky130_fd_sc_hd__tapvpwrvgnd_1
XTAP_TAPCELL_ROW_113_1988 VGND VPWR sky130_fd_sc_hd__tapvpwrvgnd_1
X_3336_ _0710_ _1290_ _1284_ _1286_ VGND VGND VPWR VPWR _1291_ sky130_fd_sc_hd__or4_1
X_5006_ _2492_ VGND VGND VPWR VPWR _0468_ sky130_fd_sc_hd__clkbuf_1
X_3267_ cpu_inst.regfile_inst.registers\[4\]\[15\] _0854_ _0735_ VGND VGND VPWR VPWR
+ _1232_ sky130_fd_sc_hd__o21a_1
XFILLER_0_96_806 VGND VGND VPWR VPWR sky130_fd_sc_hd__decap_6
X_3198_ _0756_ _1107_ _1162_ VGND VGND VPWR VPWR _1163_ sky130_fd_sc_hd__a21o_1
XFILLER_0_95_305 VPWR VGND VPWR VGND sky130_ef_sc_hd__decap_12
XFILLER_0_95_349 VPWR VGND VPWR VGND sky130_ef_sc_hd__decap_12
XTAP_TAPCELL_ROW_37_853 VGND VPWR sky130_fd_sc_hd__tapvpwrvgnd_1
XFILLER_0_76_530 VGND VGND VPWR VPWR sky130_fd_sc_hd__fill_2
XFILLER_0_48_221 VPWR VGND VPWR VGND sky130_ef_sc_hd__decap_12
XFILLER_0_91_500 VGND VGND VPWR VPWR sky130_fd_sc_hd__decap_4
XFILLER_0_9_841 VGND VGND VPWR VPWR sky130_fd_sc_hd__fill_1
XFILLER_0_48_265 VPWR VGND VPWR VGND sky130_ef_sc_hd__decap_12
XFILLER_0_134_613 VPWR VGND VPWR VGND sky130_ef_sc_hd__decap_12
XFILLER_0_119_665 VGND VGND VPWR VPWR sky130_fd_sc_hd__decap_6
XFILLER_0_118_153 VPWR VGND VPWR VGND sky130_ef_sc_hd__decap_12
XFILLER_0_64_769 VGND VGND VPWR VPWR sky130_fd_sc_hd__decap_4
XFILLER_0_17_641 VPWR VGND VPWR VGND sky130_ef_sc_hd__decap_12
XFILLER_0_134_657 VPWR VGND VPWR VGND sky130_ef_sc_hd__decap_12
XFILLER_0_118_197 VPWR VGND VPWR VGND sky130_ef_sc_hd__decap_12
XFILLER_0_63_279 VGND VGND VPWR VPWR sky130_fd_sc_hd__fill_1
XFILLER_0_133_167 VGND VGND VPWR VPWR sky130_fd_sc_hd__fill_1
XFILLER_0_17_685 VPWR VGND VPWR VGND sky130_ef_sc_hd__decap_12
XFILLER_0_121_329 VGND VGND VPWR VPWR sky130_fd_sc_hd__decap_6
XTAP_TAPCELL_ROW_75_1427 VGND VPWR sky130_fd_sc_hd__tapvpwrvgnd_1
XFILLER_0_16_195 VGND VGND VPWR VPWR sky130_fd_sc_hd__fill_1
XFILLER_0_130_841 VGND VGND VPWR VPWR sky130_fd_sc_hd__fill_1
XFILLER_0_102_543 VGND VGND VPWR VPWR sky130_fd_sc_hd__decap_4
XFILLER_0_98_121 VPWR VGND VPWR VGND sky130_ef_sc_hd__decap_12
XFILLER_0_98_165 VPWR VGND VPWR VGND sky130_ef_sc_hd__decap_12
XTAP_TAPCELL_ROW_86_1589 VGND VPWR sky130_fd_sc_hd__tapvpwrvgnd_1
XFILLER_0_52_29 VPWR VGND VPWR VGND sky130_ef_sc_hd__decap_12
XFILLER_0_129_429 VPWR VGND VPWR VGND sky130_ef_sc_hd__decap_12
XTAP_TAPCELL_ROW_15_525 VGND VPWR sky130_fd_sc_hd__tapvpwrvgnd_1
XFILLER_0_27_405 VPWR VGND VPWR VGND sky130_ef_sc_hd__decap_12
XFILLER_0_137_473 VPWR VGND VPWR VGND sky130_ef_sc_hd__decap_12
XFILLER_0_94_393 VGND VGND VPWR VPWR sky130_fd_sc_hd__fill_1
XFILLER_0_82_533 VGND VGND VPWR VPWR sky130_fd_sc_hd__fill_1
XFILLER_0_27_449 VPWR VGND VPWR VGND sky130_ef_sc_hd__decap_12
XTAP_TAPCELL_ROW_117_2055 VGND VPWR sky130_fd_sc_hd__tapvpwrvgnd_1
XFILLER_0_112_307 VGND VGND VPWR VPWR sky130_fd_sc_hd__fill_1
XFILLER_0_124_189 VGND VGND VPWR VPWR sky130_fd_sc_hd__decap_6
XFILLER_0_22_121 VPWR VGND VPWR VGND sky130_ef_sc_hd__decap_12
XFILLER_0_50_441 VGND VGND VPWR VPWR sky130_fd_sc_hd__fill_2
XTAP_TAPCELL_ROW_130_2244 VGND VPWR sky130_fd_sc_hd__tapvpwrvgnd_1
XFILLER_0_121_841 VGND VGND VPWR VPWR sky130_fd_sc_hd__fill_1
XFILLER_0_77_15 VPWR VGND VPWR VGND sky130_ef_sc_hd__decap_12
XFILLER_0_11_839 VGND VGND VPWR VPWR sky130_fd_sc_hd__fill_1
XFILLER_0_22_165 VPWR VGND VPWR VGND sky130_ef_sc_hd__decap_12
XTAP_TAPCELL_ROW_130_2255 VGND VPWR sky130_fd_sc_hd__tapvpwrvgnd_1
X_4170_ _2021_ _0540_ _1990_ cpu_inst.regfile_inst.registers\[4\]\[2\] VGND VGND VPWR
+ VPWR _0098_ sky130_fd_sc_hd__a31o_1
X_3121_ _0920_ _1085_ VGND VGND VPWR VPWR _1086_ sky130_fd_sc_hd__xnor2_1
XFILLER_0_93_69 VPWR VGND VPWR VGND sky130_ef_sc_hd__decap_12
X_3052_ _1004_ _1016_ VGND VGND VPWR VPWR _1017_ sky130_fd_sc_hd__or2_4
XFILLER_0_26_41 VPWR VGND VPWR VGND sky130_ef_sc_hd__decap_12
XFILLER_0_77_305 VPWR VGND VPWR VGND sky130_ef_sc_hd__decap_12
XFILLER_0_26_85 VPWR VGND VPWR VGND sky130_ef_sc_hd__decap_12
XFILLER_0_77_349 VPWR VGND VPWR VGND sky130_ef_sc_hd__decap_12
XTAP_TAPCELL_ROW_34_812 VGND VPWR sky130_fd_sc_hd__tapvpwrvgnd_1
X_3954_ _1448_ _1756_ _1878_ _1208_ VGND VGND VPWR VPWR _1879_ sky130_fd_sc_hd__a211o_1
XFILLER_0_73_500 VGND VGND VPWR VPWR sky130_fd_sc_hd__fill_1
XFILLER_0_58_585 VGND VGND VPWR VPWR sky130_fd_sc_hd__decap_3
XFILLER_0_9_137 VPWR VGND VPWR VGND sky130_ef_sc_hd__decap_12
XFILLER_0_116_613 VPWR VGND VPWR VGND sky130_ef_sc_hd__decap_12
X_3885_ _1709_ _1810_ _1811_ _1555_ VGND VGND VPWR VPWR _1812_ sky130_fd_sc_hd__o211a_1
XFILLER_0_73_533 VGND VGND VPWR VPWR sky130_fd_sc_hd__fill_1
XFILLER_0_6_811 VGND VGND VPWR VPWR sky130_fd_sc_hd__fill_1
X_2905_ _0653_ VGND VGND VPWR VPWR _0870_ sky130_fd_sc_hd__clkbuf_4
XFILLER_0_45_279 VGND VGND VPWR VPWR sky130_fd_sc_hd__fill_1
X_2836_ cpu_inst.regfile_inst.registers\[8\]\[5\] cpu_inst.regfile_inst.registers\[15\]\[5\]
+ _0728_ VGND VGND VPWR VPWR _0801_ sky130_fd_sc_hd__mux2_1
XFILLER_0_116_657 VPWR VGND VPWR VGND sky130_ef_sc_hd__decap_12
XFILLER_0_115_167 VGND VGND VPWR VPWR sky130_fd_sc_hd__fill_1
XFILLER_0_103_329 VGND VGND VPWR VPWR sky130_fd_sc_hd__decap_6
X_5555_ clknet_leaf_8_clk _0475_ VGND VGND VPWR VPWR cpu_inst.regfile_inst.registers\[15\]\[27\]
+ sky130_fd_sc_hd__dfxtp_1
X_2767_ _0731_ VGND VGND VPWR VPWR _0732_ sky130_fd_sc_hd__inv_2
XFILLER_0_112_841 VGND VGND VPWR VPWR sky130_fd_sc_hd__fill_1
X_5486_ clknet_leaf_16_clk _0406_ VGND VGND VPWR VPWR cpu_inst.regfile_inst.registers\[9\]\[22\]
+ sky130_fd_sc_hd__dfxtp_1
XFILLER_0_77_3 VPWR VGND VPWR VGND sky130_ef_sc_hd__decap_12
X_2698_ _0662_ _0651_ _0658_ net19 VGND VGND VPWR VPWR _0663_ sky130_fd_sc_hd__or4b_2
XFILLER_0_14_699 VGND VGND VPWR VPWR sky130_fd_sc_hd__fill_1
X_4506_ cpu_inst.regfile_inst.registers\[11\]\[4\] VGND VGND VPWR VPWR _2201_ sky130_fd_sc_hd__clkbuf_1
XTAP_TAPCELL_ROW_57_1157 VGND VPWR sky130_fd_sc_hd__tapvpwrvgnd_1
X_4437_ _1205_ cpu_inst.regfile_inst.registers\[7\]\[3\] _2161_ VGND VGND VPWR VPWR
+ _2165_ sky130_fd_sc_hd__mux2_1
XFILLER_0_111_373 VPWR VGND VPWR VGND sky130_ef_sc_hd__decap_12
XTAP_TAPCELL_ROW_70_1357 VGND VPWR sky130_fd_sc_hd__tapvpwrvgnd_1
XTAP_TAPCELL_ROW_70_1346 VGND VPWR sky130_fd_sc_hd__tapvpwrvgnd_1
XFILLER_0_67_81 VPWR VGND VPWR VGND sky130_ef_sc_hd__decap_12
X_4368_ _2129_ VGND VGND VPWR VPWR _0193_ sky130_fd_sc_hd__clkbuf_1
X_3319_ _1262_ _1269_ VGND VGND VPWR VPWR _1279_ sky130_fd_sc_hd__nor2_1
X_4299_ _2093_ VGND VGND VPWR VPWR _0160_ sky130_fd_sc_hd__clkbuf_1
XFILLER_0_96_625 VGND VGND VPWR VPWR sky130_fd_sc_hd__decap_6
XFILLER_0_95_113 VPWR VGND VPWR VGND sky130_ef_sc_hd__decap_12
XFILLER_0_138_237 VPWR VGND VPWR VGND sky130_ef_sc_hd__decap_12
XFILLER_0_64_511 VGND VGND VPWR VPWR sky130_fd_sc_hd__fill_1
XFILLER_0_49_585 VGND VGND VPWR VPWR sky130_fd_sc_hd__decap_4
XFILLER_0_119_473 VPWR VGND VPWR VGND sky130_ef_sc_hd__decap_12
XFILLER_0_64_533 VPWR VGND VPWR VGND sky130_ef_sc_hd__decap_12
XFILLER_0_9_671 VGND VGND VPWR VPWR sky130_fd_sc_hd__fill_1
XFILLER_0_49_596 VGND VGND VPWR VPWR sky130_fd_sc_hd__fill_1
XFILLER_0_134_421 VPWR VGND VPWR VGND sky130_ef_sc_hd__decap_12
XFILLER_0_52_706 VGND VGND VPWR VPWR sky130_fd_sc_hd__fill_1
XFILLER_0_24_419 VGND VGND VPWR VPWR sky130_fd_sc_hd__fill_1
XFILLER_0_51_205 VPWR VGND VPWR VGND sky130_ef_sc_hd__decap_12
XFILLER_0_106_189 VGND VGND VPWR VPWR sky130_fd_sc_hd__decap_6
XFILLER_0_51_249 VPWR VGND VPWR VGND sky130_ef_sc_hd__decap_12
XFILLER_0_121_137 VPWR VGND VPWR VGND sky130_ef_sc_hd__decap_12
XFILLER_0_103_841 VGND VGND VPWR VPWR sky130_fd_sc_hd__fill_1
XFILLER_0_60_772 VGND VGND VPWR VPWR sky130_fd_sc_hd__decap_3
XTAP_TAPCELL_ROW_20_594 VGND VPWR sky130_fd_sc_hd__tapvpwrvgnd_1
XFILLER_0_20_625 VPWR VGND VPWR VGND sky130_ef_sc_hd__decap_12
XFILLER_0_130_693 VGND VGND VPWR VPWR sky130_fd_sc_hd__decap_6
XFILLER_0_20_669 VPWR VGND VPWR VGND sky130_ef_sc_hd__decap_12
XTAP_TAPCELL_ROW_88_1618 VGND VPWR sky130_fd_sc_hd__tapvpwrvgnd_1
XFILLER_0_63_39 VPWR VGND VPWR VGND sky130_ef_sc_hd__decap_12
XFILLER_0_129_237 VPWR VGND VPWR VGND sky130_ef_sc_hd__decap_12
XFILLER_0_28_725 VPWR VGND VPWR VGND sky130_ef_sc_hd__decap_12
XFILLER_0_137_281 VPWR VGND VPWR VGND sky130_ef_sc_hd__decap_12
XFILLER_0_82_363 VGND VGND VPWR VPWR sky130_fd_sc_hd__fill_1
XFILLER_0_28_769 VPWR VGND VPWR VGND sky130_ef_sc_hd__decap_12
X_3670_ cpu_inst.regfile_inst.registers\[25\]\[22\] _1252_ _1069_ _1583_ VGND VGND
+ VPWR VPWR _1603_ sky130_fd_sc_hd__o211ai_2
XFILLER_0_70_525 VGND VGND VPWR VPWR sky130_fd_sc_hd__decap_6
XFILLER_0_12_65 VPWR VGND VPWR VGND sky130_ef_sc_hd__decap_12
XFILLER_0_27_279 VGND VGND VPWR VPWR sky130_fd_sc_hd__fill_1
XFILLER_0_70_569 VGND VGND VPWR VPWR sky130_fd_sc_hd__decap_8
XFILLER_0_70_547 VGND VGND VPWR VPWR sky130_fd_sc_hd__fill_1
XFILLER_0_23_441 VGND VGND VPWR VPWR sky130_fd_sc_hd__decap_6
X_2621_ _0574_ net35 _0582_ VGND VGND VPWR VPWR _0586_ sky130_fd_sc_hd__or3_4
X_2552_ _0506_ _0507_ VGND VGND VPWR VPWR _0517_ sky130_fd_sc_hd__or2_4
XFILLER_0_2_357 VGND VGND VPWR VPWR sky130_fd_sc_hd__decap_6
XFILLER_0_23_485 VPWR VGND VPWR VGND sky130_ef_sc_hd__decap_12
X_5340_ clknet_leaf_39_clk _0260_ VGND VGND VPWR VPWR cpu_inst.regfile_inst.registers\[11\]\[4\]
+ sky130_fd_sc_hd__dfxtp_1
XFILLER_0_121_671 VGND VGND VPWR VPWR sky130_fd_sc_hd__fill_1
X_5271_ clknet_leaf_2_clk _0191_ VGND VGND VPWR VPWR cpu_inst.regfile_inst.registers\[5\]\[31\]
+ sky130_fd_sc_hd__dfxtp_1
X_4222_ _2053_ VGND VGND VPWR VPWR _0123_ sky130_fd_sc_hd__clkbuf_1
XTAP_TAPCELL_ROW_110_1947 VGND VPWR sky130_fd_sc_hd__tapvpwrvgnd_1
XFILLER_0_128_53 VPWR VGND VPWR VGND sky130_ef_sc_hd__decap_12
X_4153_ _2016_ VGND VGND VPWR VPWR _0091_ sky130_fd_sc_hd__clkbuf_1
XFILLER_0_37_51 VGND VGND VPWR VPWR sky130_fd_sc_hd__decap_4
XTAP_TAPCELL_ROW_52_1076 VGND VPWR sky130_fd_sc_hd__tapvpwrvgnd_1
XFILLER_0_128_97 VPWR VGND VPWR VGND sky130_ef_sc_hd__decap_12
X_4084_ cpu_inst.regfile_inst.registers\[2\]\[29\] VGND VGND VPWR VPWR _1978_ sky130_fd_sc_hd__clkbuf_1
X_3104_ _0921_ VGND VGND VPWR VPWR _1069_ sky130_fd_sc_hd__buf_4
XTAP_TAPCELL_ROW_52_1087 VGND VPWR sky130_fd_sc_hd__tapvpwrvgnd_1
X_3035_ _0863_ _0997_ _0999_ _0875_ VGND VGND VPWR VPWR _1000_ sky130_fd_sc_hd__o22a_1
XFILLER_0_78_625 VPWR VGND VPWR VGND sky130_ef_sc_hd__decap_12
XFILLER_0_78_614 VGND VGND VPWR VPWR sky130_fd_sc_hd__decap_3
XFILLER_0_77_113 VPWR VGND VPWR VGND sky130_ef_sc_hd__decap_12
X_4986_ cpu_inst.regfile_inst.registers\[15\]\[11\] _2480_ VGND VGND VPWR VPWR _2482_
+ sky130_fd_sc_hd__and2_1
X_3937_ _1841_ _1801_ _1317_ VGND VGND VPWR VPWR _1863_ sky130_fd_sc_hd__mux2_1
XFILLER_0_116_421 VPWR VGND VPWR VGND sky130_ef_sc_hd__decap_12
X_3868_ cpu_inst.regfile_inst.registers\[7\]\[28\] cpu_inst.regfile_inst.registers\[6\]\[28\]
+ _1657_ VGND VGND VPWR VPWR _1795_ sky130_fd_sc_hd__mux2_1
XFILLER_0_73_374 VPWR VGND VPWR VGND sky130_ef_sc_hd__decap_12
XFILLER_0_33_205 VPWR VGND VPWR VGND sky130_ef_sc_hd__decap_12
X_3799_ _1661_ _1677_ _1721_ _1720_ _1707_ VGND VGND VPWR VPWR _1728_ sky130_fd_sc_hd__o32a_1
XFILLER_0_33_249 VPWR VGND VPWR VGND sky130_ef_sc_hd__decap_12
X_2819_ cpu_inst.regfile_inst.registers\[2\]\[7\] _0627_ _0603_ cpu_inst.regfile_inst.registers\[7\]\[7\]
+ VGND VGND VPWR VPWR _0784_ sky130_fd_sc_hd__o22a_1
XFILLER_0_103_137 VPWR VGND VPWR VGND sky130_ef_sc_hd__decap_12
X_5538_ clknet_leaf_32_clk _0458_ VGND VGND VPWR VPWR cpu_inst.regfile_inst.registers\[15\]\[10\]
+ sky130_fd_sc_hd__dfxtp_1
XFILLER_0_41_293 VPWR VGND VPWR VGND sky130_ef_sc_hd__decap_12
XFILLER_0_112_693 VGND VGND VPWR VPWR sky130_fd_sc_hd__decap_6
XFILLER_0_111_181 VPWR VGND VPWR VGND sky130_ef_sc_hd__decap_12
X_5469_ clknet_leaf_35_clk _0389_ VGND VGND VPWR VPWR cpu_inst.regfile_inst.registers\[9\]\[5\]
+ sky130_fd_sc_hd__dfxtp_1
XTAP_TAPCELL_ROW_6_389 VGND VPWR sky130_fd_sc_hd__tapvpwrvgnd_1
XFILLER_0_96_477 VGND VGND VPWR VPWR sky130_fd_sc_hd__decap_3
XTAP_TAPCELL_ROW_83_1548 VGND VPWR sky130_fd_sc_hd__tapvpwrvgnd_1
XFILLER_0_83_105 VGND VGND VPWR VPWR sky130_fd_sc_hd__decap_6
XFILLER_0_83_149 VPWR VGND VPWR VGND sky130_ef_sc_hd__decap_12
XTAP_TAPCELL_ROW_25_675 VGND VPWR sky130_fd_sc_hd__tapvpwrvgnd_1
XFILLER_0_49_393 VGND VGND VPWR VPWR sky130_fd_sc_hd__decap_8
XFILLER_0_119_281 VPWR VGND VPWR VGND sky130_ef_sc_hd__decap_12
XFILLER_0_64_352 VGND VGND VPWR VPWR sky130_fd_sc_hd__decap_6
XFILLER_0_52_503 VGND VGND VPWR VPWR sky130_fd_sc_hd__decap_6
XFILLER_0_135_741 VPWR VGND VPWR VGND sky130_ef_sc_hd__decap_12
XFILLER_0_107_454 VPWR VGND VPWR VGND sky130_ef_sc_hd__decap_12
XFILLER_0_37_599 VGND VGND VPWR VPWR sky130_fd_sc_hd__fill_1
XFILLER_0_135_785 VPWR VGND VPWR VGND sky130_ef_sc_hd__decap_12
XFILLER_0_134_251 VGND VGND VPWR VPWR sky130_fd_sc_hd__fill_1
XFILLER_0_122_413 VGND VGND VPWR VPWR sky130_fd_sc_hd__decap_6
XTAP_TAPCELL_ROW_114_2014 VGND VPWR sky130_fd_sc_hd__tapvpwrvgnd_1
XTAP_TAPCELL_ROW_114_2003 VGND VPWR sky130_fd_sc_hd__tapvpwrvgnd_1
XFILLER_0_107_476 VPWR VGND VPWR VGND sky130_ef_sc_hd__decap_12
XFILLER_0_91_193 VPWR VGND VPWR VGND sky130_ef_sc_hd__decap_12
XFILLER_0_122_457 VPWR VGND VPWR VGND sky130_ef_sc_hd__decap_12
XFILLER_0_33_783 VGND VGND VPWR VPWR sky130_fd_sc_hd__fill_1
XFILLER_0_20_433 VPWR VGND VPWR VGND sky130_ef_sc_hd__decap_12
XFILLER_0_20_477 VPWR VGND VPWR VGND sky130_ef_sc_hd__decap_12
XFILLER_0_74_27 VGND VGND VPWR VPWR sky130_fd_sc_hd__fill_1
XTAP_TAPCELL_ROW_125_2176 VGND VPWR sky130_fd_sc_hd__tapvpwrvgnd_1
XFILLER_0_59_113 VPWR VGND VPWR VGND sky130_ef_sc_hd__decap_12
XFILLER_0_99_293 VPWR VGND VPWR VGND sky130_ef_sc_hd__decap_12
XFILLER_0_90_15 VPWR VGND VPWR VGND sky130_ef_sc_hd__decap_12
XFILLER_0_87_455 VGND VGND VPWR VPWR sky130_fd_sc_hd__decap_3
XFILLER_0_48_809 VGND VGND VPWR VPWR sky130_fd_sc_hd__decap_3
X_4840_ cpu_inst.regfile_inst.registers\[9\]\[6\] VGND VGND VPWR VPWR _2405_ sky130_fd_sc_hd__clkbuf_1
XFILLER_0_135_3 VPWR VGND VPWR VGND sky130_ef_sc_hd__decap_12
XFILLER_0_114_77 VGND VGND VPWR VPWR sky130_fd_sc_hd__decap_6
XFILLER_0_68_680 VPWR VGND VPWR VGND sky130_ef_sc_hd__decap_12
XFILLER_0_56_820 VPWR VGND VPWR VGND sky130_ef_sc_hd__decap_12
XFILLER_0_7_405 VPWR VGND VPWR VGND sky130_ef_sc_hd__decap_12
XFILLER_0_28_533 VGND VGND VPWR VPWR sky130_fd_sc_hd__fill_1
XTAP_TAPCELL_ROW_44_962 VGND VPWR sky130_fd_sc_hd__tapvpwrvgnd_1
XFILLER_0_71_801 VPWR VGND VPWR VGND sky130_ef_sc_hd__decap_12
XFILLER_0_7_449 VPWR VGND VPWR VGND sky130_ef_sc_hd__decap_12
X_4771_ _2370_ VGND VGND VPWR VPWR _0355_ sky130_fd_sc_hd__clkbuf_1
X_3722_ _1618_ _1632_ _1646_ _1650_ _1652_ VGND VGND VPWR VPWR _1653_ sky130_fd_sc_hd__a221oi_2
XFILLER_0_83_694 VGND VGND VPWR VPWR sky130_fd_sc_hd__decap_3
XFILLER_0_15_205 VPWR VGND VPWR VGND sky130_ef_sc_hd__decap_12
XFILLER_0_43_503 VGND VGND VPWR VPWR sky130_fd_sc_hd__fill_1
XFILLER_0_125_273 VGND VGND VPWR VPWR sky130_fd_sc_hd__decap_6
XFILLER_0_99_57 VPWR VGND VPWR VGND sky130_ef_sc_hd__decap_12
X_3653_ _1359_ _1508_ _1585_ VGND VGND VPWR VPWR _1586_ sky130_fd_sc_hd__and3_1
XFILLER_0_15_249 VPWR VGND VPWR VGND sky130_ef_sc_hd__decap_12
XFILLER_0_130_65 VPWR VGND VPWR VGND sky130_ef_sc_hd__decap_12
X_2604_ _0568_ VGND VGND VPWR VPWR _0569_ sky130_fd_sc_hd__buf_6
XFILLER_0_2_121 VPWR VGND VPWR VGND sky130_ef_sc_hd__decap_12
X_5323_ clknet_leaf_18_clk _0243_ VGND VGND VPWR VPWR cpu_inst.regfile_inst.registers\[7\]\[19\]
+ sky130_fd_sc_hd__dfxtp_1
X_3584_ _0700_ _1518_ VGND VGND VPWR VPWR _1519_ sky130_fd_sc_hd__or2_1
XFILLER_0_2_165 VPWR VGND VPWR VGND sky130_ef_sc_hd__decap_12
XFILLER_0_23_293 VPWR VGND VPWR VGND sky130_ef_sc_hd__decap_12
X_2535_ _0500_ VGND VGND VPWR VPWR net3 sky130_fd_sc_hd__inv_2
XTAP_TAPCELL_ROW_54_1116 VGND VPWR sky130_fd_sc_hd__tapvpwrvgnd_1
XTAP_TAPCELL_ROW_54_1105 VGND VPWR sky130_fd_sc_hd__tapvpwrvgnd_1
X_5254_ clknet_leaf_28_clk _0174_ VGND VGND VPWR VPWR cpu_inst.regfile_inst.registers\[5\]\[14\]
+ sky130_fd_sc_hd__dfxtp_1
X_4205_ _2044_ VGND VGND VPWR VPWR _0115_ sky130_fd_sc_hd__clkbuf_1
X_5185_ clknet_leaf_29_clk _0105_ VGND VGND VPWR VPWR cpu_inst.regfile_inst.registers\[4\]\[9\]
+ sky130_fd_sc_hd__dfxtp_1
XFILLER_0_48_83 VGND VGND VPWR VPWR sky130_fd_sc_hd__fill_1
X_4136_ _2007_ VGND VGND VPWR VPWR _0083_ sky130_fd_sc_hd__clkbuf_1
XTAP_TAPCELL_ROW_3_348 VGND VPWR sky130_fd_sc_hd__tapvpwrvgnd_1
X_4067_ _1969_ VGND VGND VPWR VPWR _0052_ sky130_fd_sc_hd__clkbuf_1
XFILLER_0_78_455 VGND VGND VPWR VPWR sky130_fd_sc_hd__decap_8
X_3018_ _0982_ cpu_inst.regfile_inst.registers\[10\]\[8\] _0883_ VGND VGND VPWR VPWR
+ _0983_ sky130_fd_sc_hd__mux2_1
XFILLER_0_78_477 VGND VGND VPWR VPWR sky130_fd_sc_hd__decap_4
XFILLER_0_78_466 VGND VGND VPWR VPWR sky130_fd_sc_hd__decap_8
XFILLER_0_66_628 VPWR VGND VPWR VGND sky130_ef_sc_hd__decap_12
XFILLER_0_65_105 VGND VGND VPWR VPWR sky130_fd_sc_hd__decap_6
XTAP_TAPCELL_ROW_65_1278 VGND VPWR sky130_fd_sc_hd__tapvpwrvgnd_1
XFILLER_0_81_609 VGND VGND VPWR VPWR sky130_fd_sc_hd__decap_6
XFILLER_0_65_149 VPWR VGND VPWR VGND sky130_ef_sc_hd__decap_12
XTAP_TAPCELL_ROW_22_623 VGND VPWR sky130_fd_sc_hd__tapvpwrvgnd_1
XTAP_TAPCELL_ROW_22_634 VGND VPWR sky130_fd_sc_hd__tapvpwrvgnd_1
X_4969_ cpu_inst.regfile_inst.registers\[15\]\[3\] _2469_ VGND VGND VPWR VPWR _2473_
+ sky130_fd_sc_hd__or2b_1
XFILLER_0_117_741 VPWR VGND VPWR VGND sky130_ef_sc_hd__decap_12
XFILLER_0_46_363 VGND VGND VPWR VPWR sky130_fd_sc_hd__fill_1
XFILLER_0_117_785 VPWR VGND VPWR VGND sky130_ef_sc_hd__decap_12
XFILLER_0_116_251 VGND VGND VPWR VPWR sky130_fd_sc_hd__fill_1
XFILLER_0_104_413 VGND VGND VPWR VPWR sky130_fd_sc_hd__decap_6
XFILLER_0_73_193 VPWR VGND VPWR VGND sky130_ef_sc_hd__decap_12
XFILLER_0_34_536 VGND VGND VPWR VPWR sky130_fd_sc_hd__fill_2
XFILLER_0_132_755 VGND VGND VPWR VPWR sky130_fd_sc_hd__fill_1
XFILLER_0_61_388 VGND VGND VPWR VPWR sky130_fd_sc_hd__decap_4
XFILLER_0_15_783 VGND VGND VPWR VPWR sky130_fd_sc_hd__fill_1
XPHY_EDGE_ROW_110_Right_110 VGND VGND VPWR VPWR sky130_fd_sc_hd__decap_3
XFILLER_0_69_411 VPWR VGND VPWR VGND sky130_ef_sc_hd__decap_12
XFILLER_0_69_488 VPWR VGND VPWR VGND sky130_ef_sc_hd__decap_12
XFILLER_0_57_617 VGND VGND VPWR VPWR sky130_fd_sc_hd__fill_2
XFILLER_0_127_505 VPWR VGND VPWR VGND sky130_ef_sc_hd__decap_12
XTAP_TAPCELL_ROW_120_2095 VGND VPWR sky130_fd_sc_hd__tapvpwrvgnd_1
XFILLER_0_60_29 VPWR VGND VPWR VGND sky130_ef_sc_hd__decap_12
XTAP_TAPCELL_ROW_41_910 VGND VPWR sky130_fd_sc_hd__tapvpwrvgnd_1
XTAP_TAPCELL_ROW_41_921 VGND VPWR sky130_fd_sc_hd__tapvpwrvgnd_1
XFILLER_0_53_812 VPWR VGND VPWR VGND sky130_ef_sc_hd__decap_12
XFILLER_0_25_503 VGND VGND VPWR VPWR sky130_fd_sc_hd__fill_1
XFILLER_0_25_525 VGND VGND VPWR VPWR sky130_fd_sc_hd__fill_1
XFILLER_0_37_385 VGND VGND VPWR VPWR sky130_fd_sc_hd__decap_6
XFILLER_0_92_491 VGND VGND VPWR VPWR sky130_fd_sc_hd__fill_1
XFILLER_0_80_642 VGND VGND VPWR VPWR sky130_fd_sc_hd__fill_2
XFILLER_0_52_333 VPWR VGND VPWR VGND sky130_ef_sc_hd__decap_12
XFILLER_0_4_419 VGND VGND VPWR VPWR sky130_fd_sc_hd__fill_1
XFILLER_0_13_709 VPWR VGND VPWR VGND sky130_ef_sc_hd__decap_12
XFILLER_0_25_558 VGND VGND VPWR VPWR sky130_fd_sc_hd__fill_2
XFILLER_0_122_221 VPWR VGND VPWR VGND sky130_ef_sc_hd__decap_12
XFILLER_0_107_273 VGND VGND VPWR VPWR sky130_fd_sc_hd__decap_6
XTAP_TAPCELL_ROW_96_1739 VGND VPWR sky130_fd_sc_hd__tapvpwrvgnd_1
XFILLER_0_123_777 VGND VGND VPWR VPWR sky130_fd_sc_hd__decap_6
XFILLER_0_122_265 VPWR VGND VPWR VGND sky130_ef_sc_hd__decap_12
XFILLER_0_52_399 VPWR VGND VPWR VGND sky130_ef_sc_hd__decap_12
XFILLER_0_21_753 VPWR VGND VPWR VGND sky130_ef_sc_hd__decap_12
XFILLER_0_85_15 VPWR VGND VPWR VGND sky130_ef_sc_hd__decap_12
XFILLER_0_0_669 VGND VGND VPWR VPWR sky130_fd_sc_hd__decap_3
XFILLER_0_21_797 VPWR VGND VPWR VGND sky130_ef_sc_hd__decap_12
XTAP_TAPCELL_ROW_127_2205 VGND VPWR sky130_fd_sc_hd__tapvpwrvgnd_1
XFILLER_0_109_55 VGND VGND VPWR VPWR sky130_fd_sc_hd__fill_1
XFILLER_0_18_53 VPWR VGND VPWR VGND sky130_ef_sc_hd__decap_12
XTAP_TAPCELL_ROW_0_307 VGND VPWR sky130_fd_sc_hd__tapvpwrvgnd_1
XFILLER_0_18_97 VPWR VGND VPWR VGND sky130_ef_sc_hd__decap_12
XFILLER_0_34_41 VPWR VGND VPWR VGND sky130_ef_sc_hd__decap_12
XTAP_TAPCELL_ROW_105_1879 VGND VPWR sky130_fd_sc_hd__tapvpwrvgnd_1
XTAP_TAPCELL_ROW_105_1868 VGND VPWR sky130_fd_sc_hd__tapvpwrvgnd_1
XFILLER_0_34_85 VPWR VGND VPWR VGND sky130_ef_sc_hd__decap_12
XFILLER_0_47_105 VGND VGND VPWR VPWR sky130_fd_sc_hd__decap_6
X_4823_ _2396_ VGND VGND VPWR VPWR _0381_ sky130_fd_sc_hd__clkbuf_1
XFILLER_0_8_725 VPWR VGND VPWR VGND sky130_ef_sc_hd__decap_12
XFILLER_0_47_149 VPWR VGND VPWR VGND sky130_ef_sc_hd__decap_12
XFILLER_0_90_428 VGND VGND VPWR VPWR sky130_fd_sc_hd__decap_8
X_4754_ _2359_ _2360_ VGND VGND VPWR VPWR _2361_ sky130_fd_sc_hd__or2_1
XFILLER_0_8_769 VPWR VGND VPWR VGND sky130_ef_sc_hd__decap_12
XFILLER_0_16_525 VGND VGND VPWR VPWR sky130_fd_sc_hd__decap_6
XFILLER_0_28_363 VGND VGND VPWR VPWR sky130_fd_sc_hd__fill_1
XTAP_TAPCELL_ROW_138_2389 VGND VPWR sky130_fd_sc_hd__tapvpwrvgnd_1
XTAP_TAPCELL_ROW_138_2378 VGND VPWR sky130_fd_sc_hd__tapvpwrvgnd_1
XTAP_TAPCELL_ROW_138_2367 VGND VPWR sky130_fd_sc_hd__tapvpwrvgnd_1
X_3705_ _1251_ _1490_ VGND VGND VPWR VPWR _1637_ sky130_fd_sc_hd__nor2_1
XFILLER_0_55_193 VPWR VGND VPWR VGND sky130_ef_sc_hd__decap_12
XFILLER_0_7_279 VGND VGND VPWR VPWR sky130_fd_sc_hd__fill_1
XFILLER_0_114_755 VGND VGND VPWR VPWR sky130_fd_sc_hd__fill_1
XFILLER_0_70_141 VPWR VGND VPWR VGND sky130_ef_sc_hd__decap_12
X_4685_ _2310_ VGND VGND VPWR VPWR _0329_ sky130_fd_sc_hd__clkbuf_1
XTAP_TAPCELL_ROW_60_1197 VGND VPWR sky130_fd_sc_hd__tapvpwrvgnd_1
XFILLER_0_16_569 VPWR VGND VPWR VGND sky130_ef_sc_hd__decap_12
XFILLER_0_101_405 VGND VGND VPWR VPWR sky130_fd_sc_hd__decap_6
X_3636_ _1568_ _1569_ VGND VGND VPWR VPWR _1570_ sky130_fd_sc_hd__or2_1
XFILLER_0_3_441 VGND VGND VPWR VPWR sky130_fd_sc_hd__decap_6
X_3567_ _1501_ VGND VGND VPWR VPWR _1502_ sky130_fd_sc_hd__inv_2
XTAP_TAPCELL_ROW_8_418 VGND VPWR sky130_fd_sc_hd__tapvpwrvgnd_1
XFILLER_0_3_485 VPWR VGND VPWR VGND sky130_ef_sc_hd__decap_12
XFILLER_0_101_449 VGND VGND VPWR VPWR sky130_fd_sc_hd__fill_2
XFILLER_0_59_93 VPWR VGND VPWR VGND sky130_ef_sc_hd__decap_12
X_5306_ clknet_leaf_38_clk _0226_ VGND VGND VPWR VPWR cpu_inst.regfile_inst.registers\[7\]\[2\]
+ sky130_fd_sc_hd__dfxtp_1
X_3498_ cpu_inst.regfile_inst.registers\[1\]\[18\] _0820_ _0821_ cpu_inst.regfile_inst.registers\[5\]\[18\]
+ VGND VGND VPWR VPWR _1435_ sky130_fd_sc_hd__o22a_1
X_5237_ clknet_leaf_2_clk _0157_ VGND VGND VPWR VPWR cpu_inst.regfile_inst.registers\[24\]\[29\]
+ sky130_fd_sc_hd__dfxtp_1
X_5168_ clknet_leaf_10_clk _0088_ VGND VGND VPWR VPWR cpu_inst.regfile_inst.registers\[25\]\[24\]
+ sky130_fd_sc_hd__dfxtp_1
XFILLER_0_75_81 VPWR VGND VPWR VGND sky130_ef_sc_hd__decap_12
XFILLER_0_98_528 VGND VGND VPWR VPWR sky130_fd_sc_hd__decap_4
X_5099_ clknet_leaf_17_clk _0019_ VGND VGND VPWR VPWR cpu_inst.regfile_inst.registers\[6\]\[19\]
+ sky130_fd_sc_hd__dfxtp_1
XTAP_TAPCELL_ROW_67_1307 VGND VPWR sky130_fd_sc_hd__tapvpwrvgnd_1
X_4119_ _1215_ cpu_inst.regfile_inst.registers\[25\]\[11\] _1998_ VGND VGND VPWR VPWR
+ _1999_ sky130_fd_sc_hd__mux2_1
XTAP_TAPCELL_ROW_27_704 VGND VPWR sky130_fd_sc_hd__tapvpwrvgnd_1
XFILLER_0_94_701 VGND VGND VPWR VPWR sky130_fd_sc_hd__decap_6
XFILLER_0_79_764 VGND VGND VPWR VPWR sky130_fd_sc_hd__decap_3
XFILLER_0_109_505 VPWR VGND VPWR VGND sky130_ef_sc_hd__decap_12
XTAP_TAPCELL_ROW_80_1507 VGND VPWR sky130_fd_sc_hd__tapvpwrvgnd_1
XFILLER_0_94_789 VGND VGND VPWR VPWR sky130_fd_sc_hd__fill_1
XFILLER_0_136_357 VGND VGND VPWR VPWR sky130_fd_sc_hd__decap_6
XFILLER_0_35_812 VGND VGND VPWR VPWR sky130_fd_sc_hd__fill_2
XFILLER_0_62_642 VGND VGND VPWR VPWR sky130_fd_sc_hd__fill_2
XFILLER_0_19_385 VGND VGND VPWR VPWR sky130_fd_sc_hd__decap_6
XFILLER_0_34_333 VPWR VGND VPWR VGND sky130_ef_sc_hd__decap_12
XFILLER_0_104_221 VPWR VGND VPWR VGND sky130_ef_sc_hd__decap_12
XFILLER_0_34_377 VPWR VGND VPWR VGND sky130_ef_sc_hd__decap_12
XFILLER_0_105_777 VGND VGND VPWR VPWR sky130_fd_sc_hd__decap_6
XTAP_TAPCELL_ROW_78_1469 VGND VPWR sky130_fd_sc_hd__tapvpwrvgnd_1
XFILLER_0_62_697 VGND VGND VPWR VPWR sky130_fd_sc_hd__decap_3
XFILLER_0_120_725 VPWR VGND VPWR VGND sky130_ef_sc_hd__decap_12
XFILLER_0_104_265 VPWR VGND VPWR VGND sky130_ef_sc_hd__decap_12
XFILLER_0_120_769 VPWR VGND VPWR VGND sky130_ef_sc_hd__decap_12
XFILLER_0_30_583 VGND VGND VPWR VPWR sky130_fd_sc_hd__decap_4
XFILLER_0_100_471 VGND VGND VPWR VPWR sky130_fd_sc_hd__decap_4
XFILLER_0_100_460 VGND VGND VPWR VPWR sky130_fd_sc_hd__decap_8
XTAP_TAPCELL_ROW_91_1669 VGND VPWR sky130_fd_sc_hd__tapvpwrvgnd_1
XTAP_TAPCELL_ROW_91_1658 VGND VPWR sky130_fd_sc_hd__tapvpwrvgnd_1
XTAP_TAPCELL_ROW_122_2124 VGND VPWR sky130_fd_sc_hd__tapvpwrvgnd_1
XTAP_TAPCELL_ROW_122_2135 VGND VPWR sky130_fd_sc_hd__tapvpwrvgnd_1
XFILLER_0_57_403 VGND VGND VPWR VPWR sky130_fd_sc_hd__decap_4
XFILLER_0_71_39 VPWR VGND VPWR VGND sky130_ef_sc_hd__decap_12
XFILLER_0_29_105 VGND VGND VPWR VPWR sky130_fd_sc_hd__decap_6
XFILLER_0_128_825 VPWR VGND VPWR VGND sky130_ef_sc_hd__decap_12
XFILLER_0_85_767 VGND VGND VPWR VPWR sky130_fd_sc_hd__decap_4
XFILLER_0_84_233 VPWR VGND VPWR VGND sky130_ef_sc_hd__decap_12
XFILLER_0_29_149 VPWR VGND VPWR VGND sky130_ef_sc_hd__decap_12
XFILLER_0_127_335 VGND VGND VPWR VPWR sky130_fd_sc_hd__fill_1
XFILLER_0_84_277 VPWR VGND VPWR VGND sky130_ef_sc_hd__decap_12
XFILLER_0_26_823 VPWR VGND VPWR VGND sky130_ef_sc_hd__decap_12
XFILLER_0_38_672 VGND VGND VPWR VPWR sky130_fd_sc_hd__fill_2
XFILLER_0_37_193 VPWR VGND VPWR VGND sky130_ef_sc_hd__decap_12
XFILLER_0_38_694 VGND VGND VPWR VPWR sky130_fd_sc_hd__decap_6
XTAP_TAPCELL_ROW_100_1798 VGND VPWR sky130_fd_sc_hd__tapvpwrvgnd_1
XFILLER_0_13_517 VPWR VGND VPWR VGND sky130_ef_sc_hd__decap_12
XTAP_TAPCELL_ROW_13_497 VGND VPWR sky130_fd_sc_hd__tapvpwrvgnd_1
XFILLER_0_52_141 VPWR VGND VPWR VGND sky130_ef_sc_hd__decap_12
XFILLER_0_123_541 VPWR VGND VPWR VGND sky130_ef_sc_hd__decap_12
X_4470_ _2182_ VGND VGND VPWR VPWR _0242_ sky130_fd_sc_hd__clkbuf_1
XFILLER_0_20_65 VPWR VGND VPWR VGND sky130_ef_sc_hd__decap_12
XFILLER_0_123_585 VPWR VGND VPWR VGND sky130_ef_sc_hd__decap_12
X_3421_ cpu_inst.regfile_inst.registers\[1\]\[16\] _0820_ _0821_ cpu_inst.regfile_inst.registers\[5\]\[16\]
+ VGND VGND VPWR VPWR _1360_ sky130_fd_sc_hd__o22a_1
XTAP_TAPCELL_ROW_133_2297 VGND VPWR sky130_fd_sc_hd__tapvpwrvgnd_1
XFILLER_0_0_433 VPWR VGND VPWR VGND sky130_ef_sc_hd__decap_12
XFILLER_0_21_561 VPWR VGND VPWR VGND sky130_ef_sc_hd__decap_12
X_3352_ _1205_ cpu_inst.regfile_inst.registers\[6\]\[3\] _1300_ VGND VGND VPWR VPWR
+ _1304_ sky130_fd_sc_hd__mux2_1
XFILLER_0_0_477 VPWR VGND VPWR VGND sky130_ef_sc_hd__decap_12
X_3283_ _1246_ _1247_ VGND VGND VPWR VPWR _1248_ sky130_fd_sc_hd__or2b_1
X_5022_ _2500_ VGND VGND VPWR VPWR _0476_ sky130_fd_sc_hd__clkbuf_1
XFILLER_0_136_53 VPWR VGND VPWR VGND sky130_ef_sc_hd__decap_12
XTAP_TAPCELL_ROW_107_1908 VGND VPWR sky130_fd_sc_hd__tapvpwrvgnd_1
XFILLER_0_45_51 VGND VGND VPWR VPWR sky130_fd_sc_hd__decap_4
XFILLER_0_136_97 VPWR VGND VPWR VGND sky130_ef_sc_hd__decap_12
XTAP_TAPCELL_ROW_49_1037 VGND VPWR sky130_fd_sc_hd__tapvpwrvgnd_1
XFILLER_0_48_414 VGND VGND VPWR VPWR sky130_fd_sc_hd__decap_6
XTAP_TAPCELL_ROW_62_1237 VGND VPWR sky130_fd_sc_hd__tapvpwrvgnd_1
XTAP_TAPCELL_ROW_62_1226 VGND VPWR sky130_fd_sc_hd__tapvpwrvgnd_1
XFILLER_0_0_53 VGND VGND VPWR VPWR sky130_fd_sc_hd__decap_3
XFILLER_0_118_357 VGND VGND VPWR VPWR sky130_fd_sc_hd__decap_6
X_4806_ cpu_inst.regfile_inst.registers\[0\]\[21\] VGND VGND VPWR VPWR _2388_ sky130_fd_sc_hd__clkbuf_1
XFILLER_0_8_533 VPWR VGND VPWR VGND sky130_ef_sc_hd__decap_12
XFILLER_0_0_97 VPWR VGND VPWR VGND sky130_ef_sc_hd__decap_12
XFILLER_0_133_305 VPWR VGND VPWR VGND sky130_ef_sc_hd__decap_12
XFILLER_0_106_519 VGND VGND VPWR VPWR sky130_fd_sc_hd__fill_1
X_2998_ _0962_ VGND VGND VPWR VPWR _0963_ sky130_fd_sc_hd__inv_2
XFILLER_0_16_333 VPWR VGND VPWR VGND sky130_ef_sc_hd__decap_12
XTAP_TAPCELL_ROW_32_773 VGND VPWR sky130_fd_sc_hd__tapvpwrvgnd_1
XTAP_TAPCELL_ROW_32_784 VGND VPWR sky130_fd_sc_hd__tapvpwrvgnd_1
XFILLER_0_133_349 VPWR VGND VPWR VGND sky130_ef_sc_hd__decap_12
X_4737_ cpu_inst.decoder_inst.current_pc\[23\] _1288_ _2297_ _2348_ VGND VGND VPWR
+ VPWR _0343_ sky130_fd_sc_hd__a22o_1
XFILLER_0_9_51 VGND VGND VPWR VPWR sky130_fd_sc_hd__decap_4
XFILLER_0_71_472 VGND VGND VPWR VPWR sky130_fd_sc_hd__fill_1
X_4668_ cpu_inst.decoder_inst.current_pc\[5\] _2288_ VGND VGND VPWR VPWR _2298_ sky130_fd_sc_hd__nor2_1
XFILLER_0_16_377 VPWR VGND VPWR VGND sky130_ef_sc_hd__decap_12
X_3619_ cpu_inst.regfile_inst.registers\[11\]\[21\] cpu_inst.regfile_inst.registers\[10\]\[21\]
+ _0731_ VGND VGND VPWR VPWR _1553_ sky130_fd_sc_hd__mux2_1
X_4599_ cpu_inst.regfile_inst.registers\[10\]\[18\] _2241_ VGND VGND VPWR VPWR _2248_
+ sky130_fd_sc_hd__and2_1
XFILLER_0_3_293 VPWR VGND VPWR VGND sky130_ef_sc_hd__decap_12
XFILLER_0_101_279 VGND VGND VPWR VPWR sky130_fd_sc_hd__fill_1
XTAP_TAPCELL_ROW_73_1399 VGND VPWR sky130_fd_sc_hd__tapvpwrvgnd_1
XTAP_TAPCELL_ROW_73_1388 VGND VPWR sky130_fd_sc_hd__tapvpwrvgnd_1
XFILLER_0_79_561 VGND VGND VPWR VPWR sky130_fd_sc_hd__fill_2
XFILLER_0_79_550 VGND VGND VPWR VPWR sky130_fd_sc_hd__fill_1
XFILLER_0_67_723 VGND VGND VPWR VPWR sky130_fd_sc_hd__decap_4
XFILLER_0_94_531 VGND VGND VPWR VPWR sky130_fd_sc_hd__fill_1
XFILLER_0_67_756 VGND VGND VPWR VPWR sky130_fd_sc_hd__fill_2
XFILLER_0_66_233 VPWR VGND VPWR VGND sky130_ef_sc_hd__decap_12
XFILLER_0_136_121 VPWR VGND VPWR VGND sky130_ef_sc_hd__decap_12
XFILLER_0_109_335 VGND VGND VPWR VPWR sky130_fd_sc_hd__fill_1
XFILLER_0_66_277 VPWR VGND VPWR VGND sky130_ef_sc_hd__decap_12
XFILLER_0_136_165 VPWR VGND VPWR VGND sky130_ef_sc_hd__decap_12
XFILLER_0_125_839 VGND VGND VPWR VPWR sky130_fd_sc_hd__fill_1
XFILLER_0_81_225 VPWR VGND VPWR VGND sky130_ef_sc_hd__decap_12
XFILLER_0_19_193 VPWR VGND VPWR VGND sky130_ef_sc_hd__decap_12
XFILLER_0_62_461 VGND VGND VPWR VPWR sky130_fd_sc_hd__fill_1
XFILLER_0_34_141 VPWR VGND VPWR VGND sky130_ef_sc_hd__decap_12
XFILLER_0_35_664 VGND VGND VPWR VPWR sky130_fd_sc_hd__decap_4
XFILLER_0_62_483 VGND VGND VPWR VPWR sky130_fd_sc_hd__fill_1
XTAP_TAPCELL_ROW_10_456 VGND VPWR sky130_fd_sc_hd__tapvpwrvgnd_1
XTAP_TAPCELL_ROW_10_445 VGND VPWR sky130_fd_sc_hd__tapvpwrvgnd_1
XFILLER_0_50_623 VGND VGND VPWR VPWR sky130_fd_sc_hd__decap_4
XFILLER_0_50_678 VGND VGND VPWR VPWR sky130_fd_sc_hd__decap_3
XFILLER_0_120_533 VPWR VGND VPWR VGND sky130_ef_sc_hd__decap_12
XPHY_EDGE_ROW_13_Right_13 VGND VGND VPWR VPWR sky130_fd_sc_hd__decap_3
XFILLER_0_82_27 VGND VGND VPWR VPWR sky130_fd_sc_hd__fill_1
XFILLER_0_58_701 VGND VGND VPWR VPWR sky130_fd_sc_hd__decap_8
X_3970_ _1893_ _1894_ VGND VGND VPWR VPWR _1895_ sky130_fd_sc_hd__nor2_1
XTAP_TAPCELL_ROW_18_567 VGND VPWR sky130_fd_sc_hd__tapvpwrvgnd_1
XTAP_TAPCELL_ROW_102_1827 VGND VPWR sky130_fd_sc_hd__tapvpwrvgnd_1
XFILLER_0_97_391 VGND VGND VPWR VPWR sky130_fd_sc_hd__fill_1
X_2921_ _0885_ cpu_inst.regfile_inst.registers\[10\]\[4\] _0883_ VGND VGND VPWR VPWR
+ _0886_ sky130_fd_sc_hd__mux2_1
XFILLER_0_85_575 VGND VGND VPWR VPWR sky130_fd_sc_hd__decap_8
XFILLER_0_73_715 VGND VGND VPWR VPWR sky130_fd_sc_hd__decap_4
XFILLER_0_115_305 VPWR VGND VPWR VGND sky130_ef_sc_hd__decap_12
XFILLER_0_5_503 VGND VGND VPWR VPWR sky130_fd_sc_hd__fill_1
X_2852_ cpu_inst.regfile_inst.registers\[0\]\[9\] _0726_ _0703_ cpu_inst.regfile_inst.registers\[4\]\[9\]
+ _0705_ VGND VGND VPWR VPWR _0817_ sky130_fd_sc_hd__o221a_1
XTAP_TAPCELL_ROW_135_2326 VGND VPWR sky130_fd_sc_hd__tapvpwrvgnd_1
XFILLER_0_128_699 VGND VGND VPWR VPWR sky130_fd_sc_hd__fill_1
XFILLER_0_122_77 VGND VGND VPWR VPWR sky130_fd_sc_hd__decap_6
XFILLER_0_115_349 VPWR VGND VPWR VGND sky130_ef_sc_hd__decap_12
XFILLER_0_53_461 VGND VGND VPWR VPWR sky130_fd_sc_hd__decap_4
XPHY_EDGE_ROW_22_Right_22 VGND VGND VPWR VPWR sky130_fd_sc_hd__decap_3
X_2783_ cpu_inst.regfile_inst.registers\[0\]\[3\] _0561_ _0592_ VGND VGND VPWR VPWR
+ _0748_ sky130_fd_sc_hd__or3_1
X_5571_ clknet_leaf_30_clk _0491_ VGND VGND VPWR VPWR cpu_inst.display_inst.counter\[11\]
+ sky130_fd_sc_hd__dfxtp_1
XFILLER_0_131_809 VPWR VGND VPWR VGND sky130_ef_sc_hd__decap_12
X_4522_ cpu_inst.regfile_inst.registers\[11\]\[12\] VGND VGND VPWR VPWR _2209_ sky130_fd_sc_hd__clkbuf_1
XFILLER_0_14_837 VGND VGND VPWR VPWR sky130_fd_sc_hd__decap_4
X_4453_ _2173_ VGND VGND VPWR VPWR _0234_ sky130_fd_sc_hd__clkbuf_1
XFILLER_0_40_133 VGND VGND VPWR VPWR sky130_fd_sc_hd__decap_6
XFILLER_0_41_645 VGND VGND VPWR VPWR sky130_fd_sc_hd__decap_3
XFILLER_0_123_393 VPWR VGND VPWR VGND sky130_ef_sc_hd__decap_12
X_3404_ _1260_ cpu_inst.regfile_inst.registers\[6\]\[15\] _1339_ VGND VGND VPWR VPWR
+ _1344_ sky130_fd_sc_hd__mux2_1
XFILLER_0_1_753 VPWR VGND VPWR VGND sky130_ef_sc_hd__decap_12
XFILLER_0_40_177 VPWR VGND VPWR VGND sky130_ef_sc_hd__decap_12
XFILLER_0_21_391 VGND VGND VPWR VPWR sky130_fd_sc_hd__fill_1
X_4384_ _2137_ VGND VGND VPWR VPWR _0201_ sky130_fd_sc_hd__clkbuf_1
XTAP_TAPCELL_ROW_113_1989 VGND VPWR sky130_fd_sc_hd__tapvpwrvgnd_1
XFILLER_0_1_797 VPWR VGND VPWR VGND sky130_ef_sc_hd__decap_12
X_3335_ _0574_ _1289_ _0555_ _0532_ VGND VGND VPWR VPWR _1290_ sky130_fd_sc_hd__or4bb_2
X_3266_ cpu_inst.regfile_inst.registers\[1\]\[15\] _0820_ _0821_ cpu_inst.regfile_inst.registers\[5\]\[15\]
+ VGND VGND VPWR VPWR _1231_ sky130_fd_sc_hd__o22a_1
XPHY_EDGE_ROW_31_Right_31 VGND VGND VPWR VPWR sky130_fd_sc_hd__decap_3
X_5005_ cpu_inst.regfile_inst.registers\[15\]\[20\] _2491_ VGND VGND VPWR VPWR _2492_
+ sky130_fd_sc_hd__and2_1
XFILLER_0_56_83 VGND VGND VPWR VPWR sky130_fd_sc_hd__fill_1
X_3197_ _1144_ _1151_ _1161_ _0911_ VGND VGND VPWR VPWR _1162_ sky130_fd_sc_hd__o211a_1
XFILLER_0_22_3 VPWR VGND VPWR VGND sky130_ef_sc_hd__decap_12
XFILLER_0_95_317 VPWR VGND VPWR VGND sky130_ef_sc_hd__decap_12
XTAP_TAPCELL_ROW_37_854 VGND VPWR sky130_fd_sc_hd__tapvpwrvgnd_1
XFILLER_0_76_542 VPWR VGND VPWR VGND sky130_ef_sc_hd__decap_12
XFILLER_0_48_233 VPWR VGND VPWR VGND sky130_ef_sc_hd__decap_12
XFILLER_0_118_121 VPWR VGND VPWR VGND sky130_ef_sc_hd__decap_12
XFILLER_0_64_737 VGND VGND VPWR VPWR sky130_fd_sc_hd__decap_3
XFILLER_0_48_277 VPWR VGND VPWR VGND sky130_ef_sc_hd__decap_12
XFILLER_0_118_165 VPWR VGND VPWR VGND sky130_ef_sc_hd__decap_12
XFILLER_0_63_225 VPWR VGND VPWR VGND sky130_ef_sc_hd__decap_12
XFILLER_0_8_363 VGND VGND VPWR VPWR sky130_fd_sc_hd__fill_1
XFILLER_0_29_491 VGND VGND VPWR VPWR sky130_fd_sc_hd__decap_4
XPHY_EDGE_ROW_40_Right_40 VGND VGND VPWR VPWR sky130_fd_sc_hd__decap_3
XFILLER_0_134_625 VPWR VGND VPWR VGND sky130_ef_sc_hd__decap_12
XFILLER_0_133_113 VPWR VGND VPWR VGND sky130_ef_sc_hd__decap_12
XFILLER_0_107_839 VGND VGND VPWR VPWR sky130_fd_sc_hd__fill_1
XFILLER_0_16_141 VPWR VGND VPWR VGND sky130_ef_sc_hd__decap_12
XFILLER_0_17_653 VPWR VGND VPWR VGND sky130_ef_sc_hd__decap_12
XFILLER_0_134_669 VPWR VGND VPWR VGND sky130_ef_sc_hd__decap_12
XFILLER_0_72_781 VPWR VGND VPWR VGND sky130_ef_sc_hd__decap_12
XFILLER_0_17_697 VPWR VGND VPWR VGND sky130_ef_sc_hd__decap_12
XFILLER_0_31_111 VGND VGND VPWR VPWR sky130_fd_sc_hd__fill_1
XFILLER_0_102_533 VGND VGND VPWR VPWR sky130_fd_sc_hd__decap_4
XTAP_TAPCELL_ROW_75_1428 VGND VPWR sky130_fd_sc_hd__tapvpwrvgnd_1
XFILLER_0_99_623 VGND VGND VPWR VPWR sky130_fd_sc_hd__decap_6
XFILLER_0_99_689 VGND VGND VPWR VPWR sky130_fd_sc_hd__fill_2
XFILLER_0_98_133 VGND VGND VPWR VPWR sky130_fd_sc_hd__decap_6
XFILLER_0_98_177 VPWR VGND VPWR VGND sky130_ef_sc_hd__decap_12
XTAP_TAPCELL_ROW_15_526 VGND VPWR sky130_fd_sc_hd__tapvpwrvgnd_1
XFILLER_0_67_586 VPWR VGND VPWR VGND sky130_ef_sc_hd__decap_12
XFILLER_0_55_704 VGND VGND VPWR VPWR sky130_fd_sc_hd__fill_2
XFILLER_0_27_417 VPWR VGND VPWR VGND sky130_ef_sc_hd__decap_12
XFILLER_0_137_441 VGND VGND VPWR VPWR sky130_fd_sc_hd__decap_6
XFILLER_0_137_485 VPWR VGND VPWR VGND sky130_ef_sc_hd__decap_12
XTAP_TAPCELL_ROW_117_2056 VGND VPWR sky130_fd_sc_hd__tapvpwrvgnd_1
XFILLER_0_113_809 VPWR VGND VPWR VGND sky130_ef_sc_hd__decap_12
XFILLER_0_63_781 VGND VGND VPWR VPWR sky130_fd_sc_hd__decap_3
XFILLER_0_22_133 VGND VGND VPWR VPWR sky130_fd_sc_hd__decap_6
XFILLER_0_105_393 VPWR VGND VPWR VGND sky130_ef_sc_hd__decap_12
XFILLER_0_77_27 VPWR VGND VPWR VGND sky130_ef_sc_hd__decap_12
XFILLER_0_22_177 VPWR VGND VPWR VGND sky130_ef_sc_hd__decap_12
XFILLER_0_50_486 VGND VGND VPWR VPWR sky130_fd_sc_hd__decap_6
XTAP_TAPCELL_ROW_130_2256 VGND VPWR sky130_fd_sc_hd__tapvpwrvgnd_1
XTAP_TAPCELL_ROW_130_2245 VGND VPWR sky130_fd_sc_hd__tapvpwrvgnd_1
XFILLER_0_120_363 VGND VGND VPWR VPWR sky130_fd_sc_hd__fill_1
XFILLER_0_50_497 VGND VGND VPWR VPWR sky130_fd_sc_hd__decap_6
X_3120_ _0936_ _0934_ VGND VGND VPWR VPWR _1085_ sky130_fd_sc_hd__or2b_1
XFILLER_0_93_15 VPWR VGND VPWR VGND sky130_ef_sc_hd__decap_12
XFILLER_0_117_55 VGND VGND VPWR VPWR sky130_fd_sc_hd__fill_1
XFILLER_0_89_111 VGND VGND VPWR VPWR sky130_fd_sc_hd__fill_1
X_3051_ _1014_ _1015_ VGND VGND VPWR VPWR _1016_ sky130_fd_sc_hd__nand2_1
XFILLER_0_26_53 VPWR VGND VPWR VGND sky130_ef_sc_hd__decap_12
XFILLER_0_77_317 VPWR VGND VPWR VGND sky130_ef_sc_hd__decap_12
XPHY_EDGE_ROW_11_Left_150 VGND VGND VPWR VPWR sky130_fd_sc_hd__decap_3
XFILLER_0_26_97 VPWR VGND VPWR VGND sky130_ef_sc_hd__decap_12
XFILLER_0_86_840 VGND VGND VPWR VPWR sky130_fd_sc_hd__fill_2
XFILLER_0_58_531 VGND VGND VPWR VPWR sky130_fd_sc_hd__fill_1
XFILLER_0_9_105 VGND VGND VPWR VPWR sky130_fd_sc_hd__decap_6
XTAP_TAPCELL_ROW_34_813 VGND VPWR sky130_fd_sc_hd__tapvpwrvgnd_1
XFILLER_0_92_309 VPWR VGND VPWR VGND sky130_ef_sc_hd__decap_12
XFILLER_0_85_361 VPWR VGND VPWR VGND sky130_ef_sc_hd__decap_12
X_3953_ _1306_ _1828_ _1877_ _1487_ VGND VGND VPWR VPWR _1878_ sky130_fd_sc_hd__o211a_1
XFILLER_0_9_149 VPWR VGND VPWR VGND sky130_ef_sc_hd__decap_12
XFILLER_0_42_41 VPWR VGND VPWR VGND sky130_ef_sc_hd__decap_12
X_3884_ cpu_inst.regfile_inst.registers\[8\]\[28\] _1739_ VGND VGND VPWR VPWR _1811_
+ sky130_fd_sc_hd__or2_1
X_2904_ cpu_inst.regfile_inst.registers\[7\]\[12\] cpu_inst.regfile_inst.registers\[6\]\[12\]
+ _0867_ VGND VGND VPWR VPWR _0869_ sky130_fd_sc_hd__mux2_1
XFILLER_0_42_85 VPWR VGND VPWR VGND sky130_ef_sc_hd__decap_12
XFILLER_0_45_225 VPWR VGND VPWR VGND sky130_ef_sc_hd__decap_12
XFILLER_0_116_625 VPWR VGND VPWR VGND sky130_ef_sc_hd__decap_12
XFILLER_0_115_113 VPWR VGND VPWR VGND sky130_ef_sc_hd__decap_12
X_2835_ cpu_inst.regfile_inst.registers\[1\]\[5\] _0593_ _0702_ cpu_inst.regfile_inst.registers\[5\]\[5\]
+ VGND VGND VPWR VPWR _0800_ sky130_fd_sc_hd__o22a_1
XFILLER_0_116_669 VPWR VGND VPWR VGND sky130_ef_sc_hd__decap_12
XFILLER_0_61_729 VGND VGND VPWR VPWR sky130_fd_sc_hd__decap_3
XFILLER_0_14_601 VPWR VGND VPWR VGND sky130_ef_sc_hd__decap_12
XFILLER_0_131_617 VPWR VGND VPWR VGND sky130_ef_sc_hd__decap_12
X_5554_ clknet_leaf_8_clk _0474_ VGND VGND VPWR VPWR cpu_inst.regfile_inst.registers\[15\]\[26\]
+ sky130_fd_sc_hd__dfxtp_1
XFILLER_0_13_111 VGND VGND VPWR VPWR sky130_fd_sc_hd__fill_1
XFILLER_0_14_645 VPWR VGND VPWR VGND sky130_ef_sc_hd__decap_12
X_2766_ _0620_ VGND VGND VPWR VPWR _0731_ sky130_fd_sc_hd__buf_4
X_5485_ clknet_leaf_18_clk _0405_ VGND VGND VPWR VPWR cpu_inst.regfile_inst.registers\[9\]\[21\]
+ sky130_fd_sc_hd__dfxtp_1
X_2697_ _0578_ _0514_ VGND VGND VPWR VPWR _0662_ sky130_fd_sc_hd__or2_1
XFILLER_0_41_453 VGND VGND VPWR VPWR sky130_fd_sc_hd__fill_1
X_4505_ _2200_ VGND VGND VPWR VPWR _0259_ sky130_fd_sc_hd__clkbuf_1
XTAP_TAPCELL_ROW_57_1158 VGND VPWR sky130_fd_sc_hd__tapvpwrvgnd_1
XFILLER_0_6_41 VPWR VGND VPWR VGND sky130_ef_sc_hd__decap_12
XFILLER_0_1_561 VPWR VGND VPWR VGND sky130_ef_sc_hd__decap_12
X_4436_ _2164_ VGND VGND VPWR VPWR _0226_ sky130_fd_sc_hd__clkbuf_1
XFILLER_0_111_385 VGND VGND VPWR VPWR sky130_fd_sc_hd__decap_6
X_4367_ cpu_inst.regfile_inst.registers\[1\]\[1\] VGND VGND VPWR VPWR _2129_ sky130_fd_sc_hd__clkbuf_1
X_3318_ _1278_ _1199_ _1265_ _1274_ VGND VGND VPWR VPWR net11 sky130_fd_sc_hd__o22ai_1
XTAP_TAPCELL_ROW_70_1347 VGND VPWR sky130_fd_sc_hd__tapvpwrvgnd_1
XFILLER_0_67_93 VPWR VGND VPWR VGND sky130_ef_sc_hd__decap_12
XFILLER_0_6_85 VPWR VGND VPWR VGND sky130_ef_sc_hd__decap_12
X_4298_ _1174_ cpu_inst.regfile_inst.registers\[5\]\[0\] _2092_ VGND VGND VPWR VPWR
+ _2093_ sky130_fd_sc_hd__mux2_1
X_3249_ _1208_ _1213_ _0683_ VGND VGND VPWR VPWR _1214_ sky130_fd_sc_hd__o21ai_2
XFILLER_0_83_81 VPWR VGND VPWR VGND sky130_ef_sc_hd__decap_12
XFILLER_0_68_317 VGND VGND VPWR VPWR sky130_fd_sc_hd__fill_1
XFILLER_0_95_125 VPWR VGND VPWR VGND sky130_ef_sc_hd__decap_12
XFILLER_0_49_531 VGND VGND VPWR VPWR sky130_fd_sc_hd__fill_1
XFILLER_0_49_542 VGND VGND VPWR VPWR sky130_fd_sc_hd__fill_2
XFILLER_0_138_249 VGND VGND VPWR VPWR sky130_fd_sc_hd__decap_3
XFILLER_0_95_169 VPWR VGND VPWR VGND sky130_ef_sc_hd__decap_12
XFILLER_0_119_441 VGND VGND VPWR VPWR sky130_fd_sc_hd__decap_6
XFILLER_0_64_545 VGND VGND VPWR VPWR sky130_fd_sc_hd__decap_4
XFILLER_0_119_485 VPWR VGND VPWR VGND sky130_ef_sc_hd__decap_12
XFILLER_0_134_433 VPWR VGND VPWR VGND sky130_ef_sc_hd__decap_12
XFILLER_0_64_589 VPWR VGND VPWR VGND sky130_ef_sc_hd__decap_12
XFILLER_0_17_461 VPWR VGND VPWR VGND sky130_ef_sc_hd__decap_12
XFILLER_0_51_217 VGND VGND VPWR VPWR sky130_fd_sc_hd__decap_6
XFILLER_0_134_477 VPWR VGND VPWR VGND sky130_ef_sc_hd__decap_12
XFILLER_0_121_105 VGND VGND VPWR VPWR sky130_fd_sc_hd__decap_6
XFILLER_0_121_149 VPWR VGND VPWR VGND sky130_ef_sc_hd__decap_12
XTAP_TAPCELL_ROW_20_595 VGND VPWR sky130_fd_sc_hd__tapvpwrvgnd_1
XFILLER_0_102_363 VGND VGND VPWR VPWR sky130_fd_sc_hd__fill_1
XFILLER_0_20_637 VGND VGND VPWR VPWR sky130_fd_sc_hd__decap_6
XFILLER_0_99_431 VGND VGND VPWR VPWR sky130_fd_sc_hd__decap_8
XTAP_TAPCELL_ROW_88_1619 VGND VPWR sky130_fd_sc_hd__tapvpwrvgnd_1
XFILLER_0_87_615 VGND VGND VPWR VPWR sky130_fd_sc_hd__fill_1
XFILLER_0_129_205 VPWR VGND VPWR VGND sky130_ef_sc_hd__decap_12
XFILLER_0_87_659 VGND VGND VPWR VPWR sky130_fd_sc_hd__fill_1
XFILLER_0_129_249 VPWR VGND VPWR VGND sky130_ef_sc_hd__decap_12
XFILLER_0_95_670 VGND VGND VPWR VPWR sky130_fd_sc_hd__fill_2
XFILLER_0_74_309 VPWR VGND VPWR VGND sky130_ef_sc_hd__decap_12
XFILLER_0_7_609 VGND VGND VPWR VPWR sky130_fd_sc_hd__decap_6
XFILLER_0_27_225 VPWR VGND VPWR VGND sky130_ef_sc_hd__decap_12
XFILLER_0_28_737 VPWR VGND VPWR VGND sky130_ef_sc_hd__decap_12
XFILLER_0_103_57 VPWR VGND VPWR VGND sky130_ef_sc_hd__decap_12
XFILLER_0_137_293 VPWR VGND VPWR VGND sky130_ef_sc_hd__decap_12
XFILLER_0_12_77 VGND VGND VPWR VPWR sky130_fd_sc_hd__decap_6
X_2620_ cpu_inst.regfile_inst.registers\[10\]\[0\] cpu_inst.regfile_inst.registers\[11\]\[0\]
+ _0560_ VGND VGND VPWR VPWR _0585_ sky130_fd_sc_hd__mux2_2
XPHY_EDGE_ROW_124_Right_124 VGND VGND VPWR VPWR sky130_fd_sc_hd__decap_3
XFILLER_0_113_617 VPWR VGND VPWR VGND sky130_ef_sc_hd__decap_12
XFILLER_0_88_15 VPWR VGND VPWR VGND sky130_ef_sc_hd__decap_12
X_2551_ _0515_ VGND VGND VPWR VPWR _0516_ sky130_fd_sc_hd__buf_6
XFILLER_0_11_615 VGND VGND VPWR VPWR sky130_fd_sc_hd__fill_1
X_5270_ clknet_leaf_2_clk _0190_ VGND VGND VPWR VPWR cpu_inst.regfile_inst.registers\[5\]\[30\]
+ sky130_fd_sc_hd__dfxtp_1
XFILLER_0_23_497 VGND VGND VPWR VPWR sky130_fd_sc_hd__decap_6
X_4221_ cpu_inst.regfile_inst.registers\[4\]\[27\] _2046_ VGND VGND VPWR VPWR _2053_
+ sky130_fd_sc_hd__and2_1
XTAP_TAPCELL_ROW_110_1948 VGND VPWR sky130_fd_sc_hd__tapvpwrvgnd_1
X_4152_ _1792_ cpu_inst.regfile_inst.registers\[25\]\[27\] _2010_ VGND VGND VPWR VPWR
+ _2016_ sky130_fd_sc_hd__mux2_1
XFILLER_0_128_65 VPWR VGND VPWR VGND sky130_ef_sc_hd__decap_12
X_4083_ _1977_ VGND VGND VPWR VPWR _0060_ sky130_fd_sc_hd__clkbuf_1
X_3103_ _1023_ VGND VGND VPWR VPWR _1068_ sky130_fd_sc_hd__inv_2
XTAP_TAPCELL_ROW_52_1077 VGND VPWR sky130_fd_sc_hd__tapvpwrvgnd_1
X_3034_ _0998_ cpu_inst.regfile_inst.registers\[10\]\[11\] _0870_ VGND VGND VPWR VPWR
+ _0999_ sky130_fd_sc_hd__mux2_1
XFILLER_0_78_637 VGND VGND VPWR VPWR sky130_fd_sc_hd__decap_3
XFILLER_0_77_125 VPWR VGND VPWR VGND sky130_ef_sc_hd__decap_12
XFILLER_0_53_51 VGND VGND VPWR VPWR sky130_fd_sc_hd__decap_4
XFILLER_0_77_169 VPWR VGND VPWR VGND sky130_ef_sc_hd__decap_12
X_4985_ _2481_ VGND VGND VPWR VPWR _0458_ sky130_fd_sc_hd__clkbuf_1
XFILLER_0_46_501 VGND VGND VPWR VPWR sky130_fd_sc_hd__decap_4
XFILLER_0_92_139 VGND VGND VPWR VPWR sky130_fd_sc_hd__fill_1
X_3936_ _1088_ _1860_ _1861_ VGND VGND VPWR VPWR _1862_ sky130_fd_sc_hd__or3_1
XFILLER_0_129_783 VGND VGND VPWR VPWR sky130_fd_sc_hd__fill_1
XFILLER_0_46_556 VGND VGND VPWR VPWR sky130_fd_sc_hd__fill_1
XFILLER_0_116_433 VPWR VGND VPWR VGND sky130_ef_sc_hd__decap_12
X_3867_ cpu_inst.regfile_inst.registers\[5\]\[28\] cpu_inst.regfile_inst.registers\[4\]\[28\]
+ _1657_ VGND VGND VPWR VPWR _1794_ sky130_fd_sc_hd__mux2_1
XFILLER_0_33_217 VGND VGND VPWR VPWR sky130_fd_sc_hd__decap_6
XFILLER_0_46_589 VGND VGND VPWR VPWR sky130_fd_sc_hd__fill_1
XFILLER_0_116_477 VPWR VGND VPWR VGND sky130_ef_sc_hd__decap_12
XFILLER_0_103_105 VGND VGND VPWR VPWR sky130_fd_sc_hd__decap_6
X_3798_ _1727_ VGND VGND VPWR VPWR _0025_ sky130_fd_sc_hd__clkbuf_1
X_2818_ cpu_inst.regfile_inst.registers\[24\]\[7\] _0524_ VGND VGND VPWR VPWR _0783_
+ sky130_fd_sc_hd__or2_1
XFILLER_0_131_447 VGND VGND VPWR VPWR sky130_fd_sc_hd__fill_1
XFILLER_0_14_475 VGND VGND VPWR VPWR sky130_fd_sc_hd__fill_1
X_2749_ _0571_ VGND VGND VPWR VPWR _0714_ sky130_fd_sc_hd__clkbuf_4
X_5537_ clknet_leaf_35_clk _0457_ VGND VGND VPWR VPWR cpu_inst.regfile_inst.registers\[15\]\[9\]
+ sky130_fd_sc_hd__dfxtp_1
XFILLER_0_103_149 VPWR VGND VPWR VGND sky130_ef_sc_hd__decap_12
XFILLER_0_41_261 VPWR VGND VPWR VGND sky130_ef_sc_hd__decap_12
X_5468_ clknet_leaf_38_clk _0388_ VGND VGND VPWR VPWR cpu_inst.regfile_inst.registers\[9\]\[4\]
+ sky130_fd_sc_hd__dfxtp_1
XFILLER_0_111_193 VPWR VGND VPWR VGND sky130_ef_sc_hd__decap_12
X_4419_ cpu_inst.regfile_inst.registers\[1\]\[27\] VGND VGND VPWR VPWR _2155_ sky130_fd_sc_hd__clkbuf_1
X_5399_ clknet_leaf_4_clk _0319_ VGND VGND VPWR VPWR cpu_inst.regfile_inst.registers\[10\]\[31\]
+ sky130_fd_sc_hd__dfxtp_1
XFILLER_0_10_681 VPWR VGND VPWR VGND sky130_ef_sc_hd__decap_12
XFILLER_0_1_391 VGND VGND VPWR VPWR sky130_fd_sc_hd__fill_1
XFILLER_0_69_604 VGND VGND VPWR VPWR sky130_fd_sc_hd__decap_3
XTAP_TAPCELL_ROW_83_1549 VGND VPWR sky130_fd_sc_hd__tapvpwrvgnd_1
XTAP_TAPCELL_ROW_83_1538 VGND VPWR sky130_fd_sc_hd__tapvpwrvgnd_1
XFILLER_0_56_309 VGND VGND VPWR VPWR sky130_fd_sc_hd__fill_2
XFILLER_0_49_361 VPWR VGND VPWR VGND sky130_ef_sc_hd__decap_12
XFILLER_0_127_709 VPWR VGND VPWR VGND sky130_ef_sc_hd__decap_12
XTAP_TAPCELL_ROW_25_676 VGND VPWR sky130_fd_sc_hd__tapvpwrvgnd_1
XFILLER_0_37_512 VGND VGND VPWR VPWR sky130_fd_sc_hd__decap_3
XFILLER_0_135_753 VPWR VGND VPWR VGND sky130_ef_sc_hd__decap_12
XFILLER_0_119_293 VPWR VGND VPWR VGND sky130_ef_sc_hd__decap_12
XFILLER_0_91_161 VGND VGND VPWR VPWR sky130_fd_sc_hd__decap_6
XFILLER_0_18_781 VPWR VGND VPWR VGND sky130_ef_sc_hd__decap_12
XFILLER_0_25_729 VPWR VGND VPWR VGND sky130_ef_sc_hd__decap_12
XFILLER_0_135_797 VPWR VGND VPWR VGND sky130_ef_sc_hd__decap_12
XTAP_TAPCELL_ROW_114_2004 VGND VPWR sky130_fd_sc_hd__tapvpwrvgnd_1
XFILLER_0_107_488 VPWR VGND VPWR VGND sky130_ef_sc_hd__decap_12
XFILLER_0_107_466 VGND VGND VPWR VPWR sky130_fd_sc_hd__decap_6
XTAP_TAPCELL_ROW_114_2015 VGND VPWR sky130_fd_sc_hd__tapvpwrvgnd_1
XTAP_TAPCELL_ROW_98_1770 VGND VPWR sky130_fd_sc_hd__tapvpwrvgnd_1
XFILLER_0_122_469 VGND VGND VPWR VPWR sky130_fd_sc_hd__decap_6
XFILLER_0_58_29 VPWR VGND VPWR VGND sky130_ef_sc_hd__decap_12
XFILLER_0_20_401 VPWR VGND VPWR VGND sky130_ef_sc_hd__decap_12
XFILLER_0_20_445 VPWR VGND VPWR VGND sky130_ef_sc_hd__decap_12
XFILLER_0_20_489 VPWR VGND VPWR VGND sky130_ef_sc_hd__decap_12
XTAP_TAPCELL_ROW_125_2177 VGND VPWR sky130_fd_sc_hd__tapvpwrvgnd_1
XFILLER_0_99_261 VPWR VGND VPWR VGND sky130_ef_sc_hd__decap_12
XFILLER_0_90_27 VGND VGND VPWR VPWR sky130_fd_sc_hd__fill_1
XFILLER_0_59_125 VPWR VGND VPWR VGND sky130_ef_sc_hd__decap_12
XFILLER_0_59_169 VPWR VGND VPWR VGND sky130_ef_sc_hd__decap_12
XFILLER_0_74_139 VGND VGND VPWR VPWR sky130_fd_sc_hd__fill_1
XFILLER_0_56_832 VGND VGND VPWR VPWR sky130_fd_sc_hd__fill_2
XTAP_TAPCELL_ROW_44_963 VGND VPWR sky130_fd_sc_hd__tapvpwrvgnd_1
XFILLER_0_128_3 VPWR VGND VPWR VGND sky130_ef_sc_hd__decap_12
XFILLER_0_7_417 VPWR VGND VPWR VGND sky130_ef_sc_hd__decap_12
XFILLER_0_28_556 VGND VGND VPWR VPWR sky130_fd_sc_hd__decap_6
X_4770_ cpu_inst.regfile_inst.registers\[0\]\[2\] VGND VGND VPWR VPWR _2370_ sky130_fd_sc_hd__clkbuf_1
X_3721_ _1599_ _1651_ _1584_ VGND VGND VPWR VPWR _1652_ sky130_fd_sc_hd__and3b_1
XFILLER_0_71_813 VPWR VGND VPWR VGND sky130_ef_sc_hd__decap_12
XFILLER_0_55_386 VGND VGND VPWR VPWR sky130_fd_sc_hd__decap_6
XFILLER_0_15_217 VGND VGND VPWR VPWR sky130_fd_sc_hd__decap_6
XFILLER_0_99_69 VPWR VGND VPWR VGND sky130_ef_sc_hd__decap_12
X_3652_ _1520_ _1565_ VGND VGND VPWR VPWR _1585_ sky130_fd_sc_hd__nor2_1
XFILLER_0_43_559 VGND VGND VPWR VPWR sky130_fd_sc_hd__fill_1
XFILLER_0_130_77 VGND VGND VPWR VPWR sky130_fd_sc_hd__decap_6
XFILLER_0_113_447 VGND VGND VPWR VPWR sky130_fd_sc_hd__fill_1
X_3583_ _1028_ _1510_ _1513_ _1517_ VGND VGND VPWR VPWR _1518_ sky130_fd_sc_hd__o211a_1
X_2603_ _0515_ _0517_ _0554_ _0551_ VGND VGND VPWR VPWR _0568_ sky130_fd_sc_hd__or4_4
XFILLER_0_30_209 VPWR VGND VPWR VGND sky130_ef_sc_hd__decap_12
X_5322_ clknet_leaf_20_clk _0242_ VGND VGND VPWR VPWR cpu_inst.regfile_inst.registers\[7\]\[18\]
+ sky130_fd_sc_hd__dfxtp_1
X_2534_ cpu_inst.display_inst.digit_select\[0\] cpu_inst.display_inst.digit_select\[1\]
+ VGND VGND VPWR VPWR _0500_ sky130_fd_sc_hd__nor2_1
XFILLER_0_2_133 VGND VGND VPWR VPWR sky130_fd_sc_hd__decap_6
XFILLER_0_23_261 VPWR VGND VPWR VGND sky130_ef_sc_hd__decap_12
XTAP_TAPCELL_ROW_54_1117 VGND VPWR sky130_fd_sc_hd__tapvpwrvgnd_1
XTAP_TAPCELL_ROW_54_1106 VGND VPWR sky130_fd_sc_hd__tapvpwrvgnd_1
XFILLER_0_2_177 VPWR VGND VPWR VGND sky130_ef_sc_hd__decap_12
X_5253_ clknet_leaf_26_clk _0173_ VGND VGND VPWR VPWR cpu_inst.regfile_inst.registers\[5\]\[13\]
+ sky130_fd_sc_hd__dfxtp_1
X_4204_ cpu_inst.regfile_inst.registers\[4\]\[19\] _2035_ VGND VGND VPWR VPWR _2044_
+ sky130_fd_sc_hd__and2_1
X_5184_ clknet_leaf_33_clk _0104_ VGND VGND VPWR VPWR cpu_inst.regfile_inst.registers\[4\]\[8\]
+ sky130_fd_sc_hd__dfxtp_1
X_4135_ _1493_ cpu_inst.regfile_inst.registers\[25\]\[19\] _1998_ VGND VGND VPWR VPWR
+ _2007_ sky130_fd_sc_hd__mux2_1
XTAP_TAPCELL_ROW_3_349 VGND VPWR sky130_fd_sc_hd__tapvpwrvgnd_1
XTAP_TAPCELL_ROW_3_338 VGND VPWR sky130_fd_sc_hd__tapvpwrvgnd_1
X_4066_ cpu_inst.regfile_inst.registers\[2\]\[20\] VGND VGND VPWR VPWR _1969_ sky130_fd_sc_hd__clkbuf_1
XFILLER_0_64_83 VGND VGND VPWR VPWR sky130_fd_sc_hd__fill_1
X_3017_ cpu_inst.regfile_inst.registers\[9\]\[8\] cpu_inst.regfile_inst.registers\[8\]\[8\]
+ _0865_ VGND VGND VPWR VPWR _0982_ sky130_fd_sc_hd__mux2_1
XFILLER_0_38_309 VPWR VGND VPWR VGND sky130_ef_sc_hd__decap_12
XFILLER_0_109_709 VPWR VGND VPWR VGND sky130_ef_sc_hd__decap_12
XTAP_TAPCELL_ROW_65_1279 VGND VPWR sky130_fd_sc_hd__tapvpwrvgnd_1
XTAP_TAPCELL_ROW_65_1268 VGND VPWR sky130_fd_sc_hd__tapvpwrvgnd_1
XFILLER_0_59_670 VGND VGND VPWR VPWR sky130_fd_sc_hd__fill_2
XTAP_TAPCELL_ROW_22_624 VGND VPWR sky130_fd_sc_hd__tapvpwrvgnd_1
XTAP_TAPCELL_ROW_22_635 VGND VPWR sky130_fd_sc_hd__tapvpwrvgnd_1
X_4968_ _2472_ VGND VGND VPWR VPWR _0450_ sky130_fd_sc_hd__clkbuf_1
XFILLER_0_117_753 VPWR VGND VPWR VGND sky130_ef_sc_hd__decap_12
X_3919_ cpu_inst.regfile_inst.registers\[15\]\[29\] _1844_ _1555_ VGND VGND VPWR VPWR
+ _1845_ sky130_fd_sc_hd__mux2_1
XFILLER_0_80_109 VPWR VGND VPWR VGND sky130_ef_sc_hd__decap_12
XFILLER_0_73_161 VGND VGND VPWR VPWR sky130_fd_sc_hd__decap_6
X_4899_ _2435_ VGND VGND VPWR VPWR _2436_ sky130_fd_sc_hd__buf_4
XFILLER_0_132_701 VPWR VGND VPWR VGND sky130_ef_sc_hd__decap_12
XFILLER_0_117_797 VPWR VGND VPWR VGND sky130_ef_sc_hd__decap_12
XFILLER_0_88_209 VPWR VGND VPWR VGND sky130_ef_sc_hd__decap_12
XFILLER_0_69_423 VGND VGND VPWR VPWR sky130_fd_sc_hd__decap_6
XFILLER_0_96_253 VPWR VGND VPWR VGND sky130_ef_sc_hd__decap_12
XPHY_EDGE_ROW_69_Right_69 VGND VGND VPWR VPWR sky130_fd_sc_hd__decap_3
XFILLER_0_127_517 VPWR VGND VPWR VGND sky130_ef_sc_hd__decap_12
XTAP_TAPCELL_ROW_120_2096 VGND VPWR sky130_fd_sc_hd__tapvpwrvgnd_1
XFILLER_0_56_139 VGND VGND VPWR VPWR sky130_fd_sc_hd__fill_1
XTAP_TAPCELL_ROW_41_911 VGND VPWR sky130_fd_sc_hd__tapvpwrvgnd_1
XTAP_TAPCELL_ROW_41_922 VGND VPWR sky130_fd_sc_hd__tapvpwrvgnd_1
XFILLER_0_53_824 VPWR VGND VPWR VGND sky130_ef_sc_hd__decap_12
XFILLER_0_52_301 VGND VGND VPWR VPWR sky130_fd_sc_hd__decap_6
XFILLER_0_135_561 VPWR VGND VPWR VGND sky130_ef_sc_hd__decap_12
XFILLER_0_52_345 VPWR VGND VPWR VGND sky130_ef_sc_hd__decap_12
XFILLER_0_80_687 VGND VGND VPWR VPWR sky130_fd_sc_hd__decap_6
XFILLER_0_80_665 VPWR VGND VPWR VGND sky130_ef_sc_hd__decap_12
XFILLER_0_12_209 VPWR VGND VPWR VGND sky130_ef_sc_hd__decap_12
XFILLER_0_40_507 VGND VGND VPWR VPWR sky130_fd_sc_hd__decap_4
XFILLER_0_122_233 VPWR VGND VPWR VGND sky130_ef_sc_hd__decap_12
XFILLER_0_52_389 VGND VGND VPWR VPWR sky130_fd_sc_hd__decap_4
XFILLER_0_21_721 VGND VGND VPWR VPWR sky130_fd_sc_hd__decap_6
XFILLER_0_40_529 VGND VGND VPWR VPWR sky130_fd_sc_hd__decap_3
XFILLER_0_122_277 VPWR VGND VPWR VGND sky130_ef_sc_hd__decap_12
XPHY_EDGE_ROW_78_Right_78 VGND VGND VPWR VPWR sky130_fd_sc_hd__decap_3
XFILLER_0_21_765 VPWR VGND VPWR VGND sky130_ef_sc_hd__decap_12
XFILLER_0_20_253 VPWR VGND VPWR VGND sky130_ef_sc_hd__decap_12
XFILLER_0_85_27 VPWR VGND VPWR VGND sky130_ef_sc_hd__decap_12
XTAP_TAPCELL_ROW_127_2206 VGND VPWR sky130_fd_sc_hd__tapvpwrvgnd_1
XFILLER_0_18_65 VPWR VGND VPWR VGND sky130_ef_sc_hd__decap_12
XFILLER_0_125_55 VGND VGND VPWR VPWR sky130_fd_sc_hd__fill_1
XPHY_EDGE_ROW_87_Right_87 VGND VGND VPWR VPWR sky130_fd_sc_hd__decap_3
XFILLER_0_34_53 VPWR VGND VPWR VGND sky130_ef_sc_hd__decap_12
XTAP_TAPCELL_ROW_105_1869 VGND VPWR sky130_fd_sc_hd__tapvpwrvgnd_1
XFILLER_0_34_97 VPWR VGND VPWR VGND sky130_ef_sc_hd__decap_12
X_4822_ cpu_inst.regfile_inst.registers\[0\]\[29\] VGND VGND VPWR VPWR _2396_ sky130_fd_sc_hd__clkbuf_1
XFILLER_0_8_737 VPWR VGND VPWR VGND sky130_ef_sc_hd__decap_12
XFILLER_0_90_418 VGND VGND VPWR VPWR sky130_fd_sc_hd__fill_2
XFILLER_0_62_109 VPWR VGND VPWR VGND sky130_ef_sc_hd__decap_12
X_4753_ cpu_inst.decoder_inst.current_pc\[27\] _2355_ cpu_inst.decoder_inst.current_pc\[28\]
+ VGND VGND VPWR VPWR _2360_ sky130_fd_sc_hd__a21oi_1
XFILLER_0_55_161 VGND VGND VPWR VPWR sky130_fd_sc_hd__decap_6
XFILLER_0_7_225 VPWR VGND VPWR VGND sky130_ef_sc_hd__decap_12
XFILLER_0_44_813 VGND VGND VPWR VPWR sky130_fd_sc_hd__decap_8
XFILLER_0_50_41 VPWR VGND VPWR VGND sky130_ef_sc_hd__decap_12
XTAP_TAPCELL_ROW_138_2379 VGND VPWR sky130_fd_sc_hd__tapvpwrvgnd_1
XTAP_TAPCELL_ROW_138_2368 VGND VPWR sky130_fd_sc_hd__tapvpwrvgnd_1
XFILLER_0_114_701 VPWR VGND VPWR VGND sky130_ef_sc_hd__decap_12
X_3704_ _1635_ _1634_ VGND VGND VPWR VPWR _1636_ sky130_fd_sc_hd__nor2_1
XFILLER_0_50_85 VPWR VGND VPWR VGND sky130_ef_sc_hd__decap_12
XFILLER_0_70_153 VPWR VGND VPWR VGND sky130_ef_sc_hd__decap_12
X_4684_ cpu_inst.decoder_inst.current_pc\[9\] _2309_ _2285_ VGND VGND VPWR VPWR _2310_
+ sky130_fd_sc_hd__mux2_1
XTAP_TAPCELL_ROW_60_1198 VGND VPWR sky130_fd_sc_hd__tapvpwrvgnd_1
XFILLER_0_31_518 VGND VGND VPWR VPWR sky130_fd_sc_hd__fill_1
XPHY_EDGE_ROW_96_Right_96 VGND VGND VPWR VPWR sky130_fd_sc_hd__decap_3
X_3635_ _1544_ _1567_ VGND VGND VPWR VPWR _1569_ sky130_fd_sc_hd__nor2_1
XFILLER_0_70_197 VPWR VGND VPWR VGND sky130_ef_sc_hd__decap_12
X_3566_ cpu_inst.regfile_inst.registers\[25\]\[20\] _1022_ _1069_ _1500_ VGND VGND
+ VPWR VPWR _1501_ sky130_fd_sc_hd__o211a_1
XTAP_TAPCELL_ROW_8_419 VGND VPWR sky130_fd_sc_hd__tapvpwrvgnd_1
XFILLER_0_3_497 VGND VGND VPWR VPWR sky130_fd_sc_hd__decap_6
X_3497_ cpu_inst.regfile_inst.registers\[2\]\[18\] _0848_ _0849_ cpu_inst.regfile_inst.registers\[7\]\[18\]
+ _0850_ VGND VGND VPWR VPWR _1434_ sky130_fd_sc_hd__o221a_1
X_5305_ clknet_leaf_40_clk _0225_ VGND VGND VPWR VPWR cpu_inst.regfile_inst.registers\[7\]\[1\]
+ sky130_fd_sc_hd__dfxtp_1
X_5236_ clknet_leaf_7_clk _0156_ VGND VGND VPWR VPWR cpu_inst.regfile_inst.registers\[24\]\[28\]
+ sky130_fd_sc_hd__dfxtp_1
XFILLER_0_52_3 VPWR VGND VPWR VGND sky130_ef_sc_hd__decap_12
X_5167_ clknet_leaf_13_clk _0087_ VGND VGND VPWR VPWR cpu_inst.regfile_inst.registers\[25\]\[23\]
+ sky130_fd_sc_hd__dfxtp_1
X_5098_ clknet_leaf_20_clk _0018_ VGND VGND VPWR VPWR cpu_inst.regfile_inst.registers\[6\]\[18\]
+ sky130_fd_sc_hd__dfxtp_1
XFILLER_0_75_93 VPWR VGND VPWR VGND sky130_ef_sc_hd__decap_12
X_4118_ _1981_ VGND VGND VPWR VPWR _1998_ sky130_fd_sc_hd__buf_4
XPHY_EDGE_ROW_3_Left_142 VGND VGND VPWR VPWR sky130_fd_sc_hd__decap_3
XTAP_TAPCELL_ROW_67_1308 VGND VPWR sky130_fd_sc_hd__tapvpwrvgnd_1
Xclone4 _0515_ VGND VGND VPWR VPWR net17 sky130_fd_sc_hd__buf_2
XTAP_TAPCELL_ROW_27_705 VGND VPWR sky130_fd_sc_hd__tapvpwrvgnd_1
X_4049_ _1960_ VGND VGND VPWR VPWR _0043_ sky130_fd_sc_hd__clkbuf_1
XFILLER_0_78_253 VPWR VGND VPWR VGND sky130_ef_sc_hd__decap_12
XFILLER_0_93_223 VGND VGND VPWR VPWR sky130_fd_sc_hd__fill_1
XFILLER_0_91_81 VPWR VGND VPWR VGND sky130_ef_sc_hd__decap_12
XFILLER_0_109_517 VPWR VGND VPWR VGND sky130_ef_sc_hd__decap_12
XFILLER_0_94_768 VGND VGND VPWR VPWR sky130_fd_sc_hd__decap_4
XFILLER_0_94_757 VGND VGND VPWR VPWR sky130_fd_sc_hd__fill_2
XFILLER_0_38_139 VGND VGND VPWR VPWR sky130_fd_sc_hd__fill_1
XFILLER_0_34_301 VGND VGND VPWR VPWR sky130_fd_sc_hd__decap_6
XFILLER_0_117_561 VPWR VGND VPWR VGND sky130_ef_sc_hd__decap_12
XFILLER_0_35_835 VGND VGND VPWR VPWR sky130_fd_sc_hd__decap_4
XFILLER_0_132_531 VGND VGND VPWR VPWR sky130_fd_sc_hd__fill_1
XFILLER_0_62_665 VPWR VGND VPWR VGND sky130_ef_sc_hd__decap_12
XFILLER_0_34_345 VPWR VGND VPWR VGND sky130_ef_sc_hd__decap_12
XPHY_EDGE_ROW_49_Left_188 VGND VGND VPWR VPWR sky130_fd_sc_hd__decap_3
XFILLER_0_50_816 VPWR VGND VPWR VGND sky130_ef_sc_hd__decap_12
XFILLER_0_104_233 VPWR VGND VPWR VGND sky130_ef_sc_hd__decap_12
XFILLER_0_34_389 VPWR VGND VPWR VGND sky130_ef_sc_hd__decap_12
XFILLER_0_120_737 VPWR VGND VPWR VGND sky130_ef_sc_hd__decap_12
XFILLER_0_104_277 VPWR VGND VPWR VGND sky130_ef_sc_hd__decap_12
XTAP_TAPCELL_ROW_91_1659 VGND VPWR sky130_fd_sc_hd__tapvpwrvgnd_1
XPHY_EDGE_ROW_58_Left_197 VGND VGND VPWR VPWR sky130_fd_sc_hd__decap_3
XTAP_TAPCELL_ROW_122_2125 VGND VPWR sky130_fd_sc_hd__tapvpwrvgnd_1
XTAP_TAPCELL_ROW_122_2136 VGND VPWR sky130_fd_sc_hd__tapvpwrvgnd_1
XFILLER_0_85_724 VGND VGND VPWR VPWR sky130_fd_sc_hd__decap_4
XFILLER_0_128_837 VGND VGND VPWR VPWR sky130_fd_sc_hd__decap_4
XFILLER_0_84_245 VGND VGND VPWR VPWR sky130_fd_sc_hd__decap_6
XFILLER_0_84_289 VPWR VGND VPWR VGND sky130_ef_sc_hd__decap_12
XFILLER_0_26_813 VGND VGND VPWR VPWR sky130_fd_sc_hd__decap_6
XFILLER_0_44_109 VPWR VGND VPWR VGND sky130_ef_sc_hd__decap_12
XFILLER_0_5_729 VPWR VGND VPWR VGND sky130_ef_sc_hd__decap_12
XFILLER_0_26_835 VGND VGND VPWR VPWR sky130_fd_sc_hd__decap_6
XFILLER_0_37_161 VGND VGND VPWR VPWR sky130_fd_sc_hd__decap_6
XTAP_TAPCELL_ROW_100_1799 VGND VPWR sky130_fd_sc_hd__tapvpwrvgnd_1
XTAP_TAPCELL_ROW_13_498 VGND VPWR sky130_fd_sc_hd__tapvpwrvgnd_1
XFILLER_0_52_153 VPWR VGND VPWR VGND sky130_ef_sc_hd__decap_12
XFILLER_0_135_391 VGND VGND VPWR VPWR sky130_fd_sc_hd__fill_1
XFILLER_0_123_553 VGND VGND VPWR VPWR sky130_fd_sc_hd__decap_6
XFILLER_0_111_57 VPWR VGND VPWR VGND sky130_ef_sc_hd__decap_12
XFILLER_0_13_529 VPWR VGND VPWR VGND sky130_ef_sc_hd__decap_12
XFILLER_0_20_77 VGND VGND VPWR VPWR sky130_fd_sc_hd__decap_6
XFILLER_0_123_597 VPWR VGND VPWR VGND sky130_ef_sc_hd__decap_12
XFILLER_0_96_15 VPWR VGND VPWR VGND sky130_ef_sc_hd__decap_12
X_3420_ _0841_ _1112_ _1358_ VGND VGND VPWR VPWR _1359_ sky130_fd_sc_hd__and3_2
XFILLER_0_52_197 VPWR VGND VPWR VGND sky130_ef_sc_hd__decap_12
XTAP_TAPCELL_ROW_133_2298 VGND VPWR sky130_fd_sc_hd__tapvpwrvgnd_1
XFILLER_0_0_445 VGND VGND VPWR VPWR sky130_fd_sc_hd__decap_3
XFILLER_0_21_573 VPWR VGND VPWR VGND sky130_ef_sc_hd__decap_12
X_3351_ _1303_ VGND VGND VPWR VPWR _0002_ sky130_fd_sc_hd__clkbuf_1
XFILLER_0_0_489 VPWR VGND VPWR VGND sky130_ef_sc_hd__decap_12
X_3282_ _1238_ _1245_ VGND VGND VPWR VPWR _1247_ sky130_fd_sc_hd__nand2_1
X_5021_ cpu_inst.regfile_inst.registers\[15\]\[28\] _2491_ VGND VGND VPWR VPWR _2500_
+ sky130_fd_sc_hd__and2_1
XFILLER_0_136_65 VPWR VGND VPWR VGND sky130_ef_sc_hd__decap_12
XTAP_TAPCELL_ROW_107_1909 VGND VPWR sky130_fd_sc_hd__tapvpwrvgnd_1
XFILLER_0_88_551 VGND VGND VPWR VPWR sky130_fd_sc_hd__fill_1
XTAP_TAPCELL_ROW_49_1038 VGND VPWR sky130_fd_sc_hd__tapvpwrvgnd_1
XFILLER_0_76_757 VGND VGND VPWR VPWR sky130_fd_sc_hd__decap_6
XFILLER_0_76_746 VGND VGND VPWR VPWR sky130_fd_sc_hd__decap_8
XFILLER_0_75_223 VGND VGND VPWR VPWR sky130_fd_sc_hd__fill_1
XTAP_TAPCELL_ROW_62_1227 VGND VPWR sky130_fd_sc_hd__tapvpwrvgnd_1
XFILLER_0_61_51 VGND VGND VPWR VPWR sky130_fd_sc_hd__decap_4
XFILLER_0_8_501 VPWR VGND VPWR VGND sky130_ef_sc_hd__decap_12
XFILLER_0_91_727 VGND VGND VPWR VPWR sky130_fd_sc_hd__fill_1
X_4805_ _2387_ VGND VGND VPWR VPWR _0372_ sky130_fd_sc_hd__clkbuf_1
XFILLER_0_8_545 VPWR VGND VPWR VGND sky130_ef_sc_hd__decap_12
XFILLER_0_29_673 VGND VGND VPWR VPWR sky130_fd_sc_hd__decap_4
X_2997_ cpu_inst.regfile_inst.registers\[24\]\[8\] _0697_ _0961_ _0838_ VGND VGND
+ VPWR VPWR _0962_ sky130_fd_sc_hd__o211a_1
XFILLER_0_8_589 VPWR VGND VPWR VGND sky130_ef_sc_hd__decap_12
XFILLER_0_16_301 VGND VGND VPWR VPWR sky130_fd_sc_hd__decap_6
XTAP_TAPCELL_ROW_32_774 VGND VPWR sky130_fd_sc_hd__tapvpwrvgnd_1
XTAP_TAPCELL_ROW_32_785 VGND VPWR sky130_fd_sc_hd__tapvpwrvgnd_1
XFILLER_0_133_317 VPWR VGND VPWR VGND sky130_ef_sc_hd__decap_12
XFILLER_0_71_440 VGND VGND VPWR VPWR sky130_fd_sc_hd__decap_4
X_4736_ _2347_ _0685_ _2284_ VGND VGND VPWR VPWR _2348_ sky130_fd_sc_hd__or3b_1
XFILLER_0_16_345 VPWR VGND VPWR VGND sky130_ef_sc_hd__decap_12
XFILLER_0_114_531 VGND VGND VPWR VPWR sky130_fd_sc_hd__fill_1
X_4667_ _0843_ _1288_ VGND VGND VPWR VPWR _2297_ sky130_fd_sc_hd__nor2_1
XFILLER_0_16_389 VPWR VGND VPWR VGND sky130_ef_sc_hd__decap_12
XFILLER_0_32_838 VGND VGND VPWR VPWR sky130_fd_sc_hd__decap_4
XFILLER_0_102_726 VGND VGND VPWR VPWR sky130_fd_sc_hd__decap_6
XFILLER_0_102_704 VGND VGND VPWR VPWR sky130_fd_sc_hd__decap_6
X_3618_ _0844_ VGND VGND VPWR VPWR _1552_ sky130_fd_sc_hd__clkbuf_4
XFILLER_0_3_261 VPWR VGND VPWR VGND sky130_ef_sc_hd__decap_12
XFILLER_0_31_337 VPWR VGND VPWR VGND sky130_ef_sc_hd__decap_12
XFILLER_0_101_225 VPWR VGND VPWR VGND sky130_ef_sc_hd__decap_12
X_4598_ _2247_ VGND VGND VPWR VPWR _0305_ sky130_fd_sc_hd__clkbuf_1
X_3549_ _1458_ _1446_ _1484_ VGND VGND VPWR VPWR _1485_ sky130_fd_sc_hd__a21o_1
XFILLER_0_110_781 VPWR VGND VPWR VGND sky130_ef_sc_hd__decap_12
XTAP_TAPCELL_ROW_73_1389 VGND VPWR sky130_fd_sc_hd__tapvpwrvgnd_1
X_5219_ clknet_leaf_25_clk _0139_ VGND VGND VPWR VPWR cpu_inst.regfile_inst.registers\[24\]\[11\]
+ sky130_fd_sc_hd__dfxtp_1
XFILLER_0_79_584 VGND VGND VPWR VPWR sky130_fd_sc_hd__decap_8
XFILLER_0_66_245 VGND VGND VPWR VPWR sky130_fd_sc_hd__decap_6
XFILLER_0_136_133 VGND VGND VPWR VPWR sky130_fd_sc_hd__decap_6
XFILLER_0_54_407 VPWR VGND VPWR VGND sky130_ef_sc_hd__decap_12
XFILLER_0_26_109 VPWR VGND VPWR VGND sky130_ef_sc_hd__decap_12
XFILLER_0_94_598 VGND VGND VPWR VPWR sky130_fd_sc_hd__decap_8
XFILLER_0_81_237 VPWR VGND VPWR VGND sky130_ef_sc_hd__decap_12
XFILLER_0_66_289 VPWR VGND VPWR VGND sky130_ef_sc_hd__decap_12
XFILLER_0_19_161 VGND VGND VPWR VPWR sky130_fd_sc_hd__decap_6
XFILLER_0_136_177 VPWR VGND VPWR VGND sky130_ef_sc_hd__decap_12
XFILLER_0_62_440 VPWR VGND VPWR VGND sky130_ef_sc_hd__decap_12
XFILLER_0_117_391 VGND VGND VPWR VPWR sky130_fd_sc_hd__fill_1
XTAP_TAPCELL_ROW_10_457 VGND VPWR sky130_fd_sc_hd__tapvpwrvgnd_1
XTAP_TAPCELL_ROW_10_446 VGND VPWR sky130_fd_sc_hd__tapvpwrvgnd_1
XFILLER_0_34_153 VPWR VGND VPWR VGND sky130_ef_sc_hd__decap_12
XFILLER_0_120_501 VPWR VGND VPWR VGND sky130_ef_sc_hd__decap_12
XFILLER_0_34_197 VPWR VGND VPWR VGND sky130_ef_sc_hd__decap_12
XFILLER_0_120_545 VPWR VGND VPWR VGND sky130_ef_sc_hd__decap_12
XFILLER_0_120_589 VPWR VGND VPWR VGND sky130_ef_sc_hd__decap_12
XFILLER_0_66_29 VPWR VGND VPWR VGND sky130_ef_sc_hd__decap_12
XPHY_EDGE_ROW_66_Left_205 VGND VGND VPWR VPWR sky130_fd_sc_hd__decap_3
XFILLER_0_89_337 VPWR VGND VPWR VGND sky130_ef_sc_hd__decap_12
Xclkbuf_2_3__f_clk clknet_0_clk VGND VGND VPWR VPWR clknet_2_3__leaf_clk sky130_fd_sc_hd__clkbuf_16
XFILLER_0_58_724 VPWR VGND VPWR VGND sky130_ef_sc_hd__decap_12
XFILLER_0_15_55 VGND VGND VPWR VPWR sky130_fd_sc_hd__fill_1
XTAP_TAPCELL_ROW_18_568 VGND VPWR sky130_fd_sc_hd__tapvpwrvgnd_1
XFILLER_0_128_601 VPWR VGND VPWR VGND sky130_ef_sc_hd__decap_12
XTAP_TAPCELL_ROW_102_1828 VGND VPWR sky130_fd_sc_hd__tapvpwrvgnd_1
XFILLER_0_85_532 VPWR VGND VPWR VGND sky130_ef_sc_hd__decap_12
XFILLER_0_57_223 VGND VGND VPWR VPWR sky130_fd_sc_hd__fill_1
X_2920_ cpu_inst.regfile_inst.registers\[9\]\[4\] cpu_inst.regfile_inst.registers\[8\]\[4\]
+ _0865_ VGND VGND VPWR VPWR _0885_ sky130_fd_sc_hd__mux2_1
XFILLER_0_128_645 VPWR VGND VPWR VGND sky130_ef_sc_hd__decap_12
XFILLER_0_127_111 VGND VGND VPWR VPWR sky130_fd_sc_hd__fill_1
XPHY_EDGE_ROW_75_Left_214 VGND VGND VPWR VPWR sky130_fd_sc_hd__decap_3
XFILLER_0_58_779 VGND VGND VPWR VPWR sky130_fd_sc_hd__decap_8
X_2851_ _0815_ _0771_ VGND VGND VPWR VPWR _0816_ sky130_fd_sc_hd__nor2_8
XTAP_TAPCELL_ROW_135_2327 VGND VPWR sky130_fd_sc_hd__tapvpwrvgnd_1
XFILLER_0_115_317 VPWR VGND VPWR VGND sky130_ef_sc_hd__decap_12
XFILLER_0_110_3 VPWR VGND VPWR VGND sky130_ef_sc_hd__decap_12
XFILLER_0_14_805 VGND VGND VPWR VPWR sky130_fd_sc_hd__decap_6
XFILLER_0_26_643 VGND VGND VPWR VPWR sky130_fd_sc_hd__fill_1
X_2782_ cpu_inst.regfile_inst.registers\[1\]\[3\] _0592_ _0602_ cpu_inst.regfile_inst.registers\[5\]\[3\]
+ VGND VGND VPWR VPWR _0747_ sky130_fd_sc_hd__o22a_1
X_5570_ clknet_leaf_30_clk _0490_ VGND VGND VPWR VPWR cpu_inst.display_inst.counter\[10\]
+ sky130_fd_sc_hd__dfxtp_1
XFILLER_0_5_559 VGND VGND VPWR VPWR sky130_fd_sc_hd__fill_1
X_4521_ _2208_ VGND VGND VPWR VPWR _0267_ sky130_fd_sc_hd__clkbuf_1
XFILLER_0_41_613 VGND VGND VPWR VPWR sky130_fd_sc_hd__decap_3
XFILLER_0_130_309 VPWR VGND VPWR VGND sky130_ef_sc_hd__decap_12
XFILLER_0_123_361 VPWR VGND VPWR VGND sky130_ef_sc_hd__decap_12
XFILLER_0_13_337 VPWR VGND VPWR VGND sky130_ef_sc_hd__decap_12
X_4452_ _1164_ cpu_inst.regfile_inst.registers\[7\]\[10\] _2161_ VGND VGND VPWR VPWR
+ _2173_ sky130_fd_sc_hd__mux2_1
XFILLER_0_41_657 VGND VGND VPWR VPWR sky130_fd_sc_hd__fill_1
X_3403_ _1343_ VGND VGND VPWR VPWR _0014_ sky130_fd_sc_hd__clkbuf_1
XFILLER_0_1_721 VGND VGND VPWR VPWR sky130_fd_sc_hd__decap_6
XPHY_EDGE_ROW_84_Left_223 VGND VGND VPWR VPWR sky130_fd_sc_hd__decap_3
XFILLER_0_0_253 VPWR VGND VPWR VGND sky130_ef_sc_hd__decap_12
XFILLER_0_1_765 VPWR VGND VPWR VGND sky130_ef_sc_hd__decap_12
XFILLER_0_40_189 VGND VGND VPWR VPWR sky130_fd_sc_hd__decap_6
X_4383_ cpu_inst.regfile_inst.registers\[1\]\[9\] VGND VGND VPWR VPWR _2137_ sky130_fd_sc_hd__clkbuf_1
X_3334_ _0550_ _0552_ VGND VGND VPWR VPWR _1289_ sky130_fd_sc_hd__nand2_1
X_3265_ cpu_inst.regfile_inst.registers\[2\]\[15\] _0848_ _0849_ cpu_inst.regfile_inst.registers\[7\]\[15\]
+ _0850_ VGND VGND VPWR VPWR _1230_ sky130_fd_sc_hd__o221a_1
X_5004_ _2468_ VGND VGND VPWR VPWR _2491_ sky130_fd_sc_hd__clkbuf_4
X_3196_ _1144_ _1141_ VGND VGND VPWR VPWR _1161_ sky130_fd_sc_hd__nand2_1
XFILLER_0_15_3 VPWR VGND VPWR VGND sky130_ef_sc_hd__decap_12
XFILLER_0_95_329 VGND VGND VPWR VPWR sky130_fd_sc_hd__decap_6
XTAP_TAPCELL_ROW_37_855 VGND VPWR sky130_fd_sc_hd__tapvpwrvgnd_1
XPHY_EDGE_ROW_138_Right_138 VGND VGND VPWR VPWR sky130_fd_sc_hd__decap_3
XPHY_EDGE_ROW_93_Left_232 VGND VGND VPWR VPWR sky130_fd_sc_hd__decap_3
XFILLER_0_72_83 VGND VGND VPWR VPWR sky130_fd_sc_hd__fill_1
XFILLER_0_48_245 VGND VGND VPWR VPWR sky130_fd_sc_hd__decap_6
XFILLER_0_9_821 VPWR VGND VPWR VGND sky130_ef_sc_hd__decap_12
XFILLER_0_118_133 VGND VGND VPWR VPWR sky130_fd_sc_hd__decap_6
XFILLER_0_63_237 VPWR VGND VPWR VGND sky130_ef_sc_hd__decap_12
XFILLER_0_48_289 VPWR VGND VPWR VGND sky130_ef_sc_hd__decap_12
XFILLER_0_134_637 VGND VGND VPWR VPWR sky130_fd_sc_hd__decap_6
XFILLER_0_118_177 VPWR VGND VPWR VGND sky130_ef_sc_hd__decap_12
XFILLER_0_72_760 VGND VGND VPWR VPWR sky130_fd_sc_hd__fill_2
XFILLER_0_17_665 VGND VGND VPWR VPWR sky130_fd_sc_hd__decap_6
XFILLER_0_44_440 VGND VGND VPWR VPWR sky130_fd_sc_hd__decap_4
XFILLER_0_133_125 VPWR VGND VPWR VGND sky130_ef_sc_hd__decap_12
X_4719_ _2334_ _2335_ VGND VGND VPWR VPWR _2336_ sky130_fd_sc_hd__nor2_1
XFILLER_0_16_153 VPWR VGND VPWR VGND sky130_ef_sc_hd__decap_12
XFILLER_0_44_473 VGND VGND VPWR VPWR sky130_fd_sc_hd__decap_3
XFILLER_0_133_169 VPWR VGND VPWR VGND sky130_ef_sc_hd__decap_12
XTAP_TAPCELL_ROW_75_1418 VGND VPWR sky130_fd_sc_hd__tapvpwrvgnd_1
XFILLER_0_71_281 VPWR VGND VPWR VGND sky130_ef_sc_hd__decap_12
XFILLER_0_16_197 VPWR VGND VPWR VGND sky130_ef_sc_hd__decap_12
XTAP_TAPCELL_ROW_75_1429 VGND VPWR sky130_fd_sc_hd__tapvpwrvgnd_1
XFILLER_0_4_581 VGND VGND VPWR VPWR sky130_fd_sc_hd__decap_6
XFILLER_0_31_167 VGND VGND VPWR VPWR sky130_fd_sc_hd__fill_1
XFILLER_0_102_589 VGND VGND VPWR VPWR sky130_fd_sc_hd__decap_3
XFILLER_0_98_189 VGND VGND VPWR VPWR sky130_fd_sc_hd__decap_6
XFILLER_0_86_307 VGND VGND VPWR VPWR sky130_fd_sc_hd__fill_1
XPHY_EDGE_ROW_105_Right_105 VGND VGND VPWR VPWR sky130_fd_sc_hd__decap_3
XFILLER_0_95_841 VGND VGND VPWR VPWR sky130_fd_sc_hd__fill_1
XFILLER_0_39_223 VGND VGND VPWR VPWR sky130_fd_sc_hd__fill_1
XFILLER_0_109_111 VGND VGND VPWR VPWR sky130_fd_sc_hd__fill_1
XFILLER_0_67_554 VGND VGND VPWR VPWR sky130_fd_sc_hd__fill_1
XTAP_TAPCELL_ROW_15_527 VGND VPWR sky130_fd_sc_hd__tapvpwrvgnd_1
XFILLER_0_55_738 VGND VGND VPWR VPWR sky130_fd_sc_hd__fill_1
XFILLER_0_27_429 VPWR VGND VPWR VGND sky130_ef_sc_hd__decap_12
XFILLER_0_137_497 VGND VGND VPWR VPWR sky130_fd_sc_hd__decap_6
XFILLER_0_125_615 VGND VGND VPWR VPWR sky130_fd_sc_hd__fill_1
XTAP_TAPCELL_ROW_117_2057 VGND VPWR sky130_fd_sc_hd__tapvpwrvgnd_1
XFILLER_0_63_793 VPWR VGND VPWR VGND sky130_ef_sc_hd__decap_12
XFILLER_0_112_309 VPWR VGND VPWR VGND sky130_ef_sc_hd__decap_12
XFILLER_0_105_361 VPWR VGND VPWR VGND sky130_ef_sc_hd__decap_12
XFILLER_0_50_421 VGND VGND VPWR VPWR sky130_fd_sc_hd__fill_2
XFILLER_0_121_821 VPWR VGND VPWR VGND sky130_ef_sc_hd__decap_12
XFILLER_0_10_307 VGND VGND VPWR VPWR sky130_fd_sc_hd__fill_1
XTAP_TAPCELL_ROW_130_2257 VGND VPWR sky130_fd_sc_hd__tapvpwrvgnd_1
XTAP_TAPCELL_ROW_130_2246 VGND VPWR sky130_fd_sc_hd__tapvpwrvgnd_1
XFILLER_0_77_39 VPWR VGND VPWR VGND sky130_ef_sc_hd__decap_12
XFILLER_0_22_189 VGND VGND VPWR VPWR sky130_fd_sc_hd__decap_6
XFILLER_0_93_27 VPWR VGND VPWR VGND sky130_ef_sc_hd__decap_12
X_3050_ _1006_ _1013_ VGND VGND VPWR VPWR _1015_ sky130_fd_sc_hd__nand2_1
XFILLER_0_78_808 VGND VGND VPWR VPWR sky130_fd_sc_hd__decap_4
XFILLER_0_26_65 VPWR VGND VPWR VGND sky130_ef_sc_hd__decap_12
XFILLER_0_89_167 VGND VGND VPWR VPWR sky130_fd_sc_hd__fill_1
XFILLER_0_77_329 VGND VGND VPWR VPWR sky130_fd_sc_hd__decap_6
XTAP_TAPCELL_ROW_34_803 VGND VPWR sky130_fd_sc_hd__tapvpwrvgnd_1
XTAP_TAPCELL_ROW_34_814 VGND VPWR sky130_fd_sc_hd__tapvpwrvgnd_1
XFILLER_0_133_55 VGND VGND VPWR VPWR sky130_fd_sc_hd__fill_1
X_3952_ _1176_ _1876_ VGND VGND VPWR VPWR _1877_ sky130_fd_sc_hd__or2_1
XFILLER_0_42_53 VPWR VGND VPWR VGND sky130_ef_sc_hd__decap_12
X_3883_ cpu_inst.regfile_inst.registers\[11\]\[28\] cpu_inst.regfile_inst.registers\[10\]\[28\]
+ _1592_ VGND VGND VPWR VPWR _1810_ sky130_fd_sc_hd__mux2_1
XFILLER_0_85_373 VGND VGND VPWR VPWR sky130_fd_sc_hd__decap_6
X_2903_ cpu_inst.regfile_inst.registers\[5\]\[12\] cpu_inst.regfile_inst.registers\[4\]\[12\]
+ _0867_ VGND VGND VPWR VPWR _0868_ sky130_fd_sc_hd__mux2_1
XFILLER_0_45_237 VPWR VGND VPWR VGND sky130_ef_sc_hd__decap_12
XFILLER_0_128_475 VGND VGND VPWR VPWR sky130_fd_sc_hd__fill_1
XFILLER_0_116_637 VGND VGND VPWR VPWR sky130_fd_sc_hd__decap_6
XFILLER_0_6_813 VPWR VGND VPWR VGND sky130_ef_sc_hd__decap_12
XFILLER_0_42_97 VPWR VGND VPWR VGND sky130_ef_sc_hd__decap_12
X_2834_ _0714_ _0797_ _0798_ VGND VGND VPWR VPWR _0799_ sky130_fd_sc_hd__o21a_1
XFILLER_0_115_125 VPWR VGND VPWR VGND sky130_ef_sc_hd__decap_12
X_5553_ clknet_leaf_9_clk _0473_ VGND VGND VPWR VPWR cpu_inst.regfile_inst.registers\[15\]\[25\]
+ sky130_fd_sc_hd__dfxtp_1
XFILLER_0_14_613 VPWR VGND VPWR VGND sky130_ef_sc_hd__decap_12
XFILLER_0_131_629 VPWR VGND VPWR VGND sky130_ef_sc_hd__decap_12
XFILLER_0_115_169 VPWR VGND VPWR VGND sky130_ef_sc_hd__decap_12
XFILLER_0_53_281 VPWR VGND VPWR VGND sky130_ef_sc_hd__decap_12
XFILLER_0_14_657 VPWR VGND VPWR VGND sky130_ef_sc_hd__decap_12
X_4504_ cpu_inst.regfile_inst.registers\[11\]\[3\] VGND VGND VPWR VPWR _2200_ sky130_fd_sc_hd__clkbuf_1
X_2765_ _0714_ _0729_ VGND VGND VPWR VPWR _0730_ sky130_fd_sc_hd__nand2_1
XFILLER_0_130_139 VGND VGND VPWR VPWR sky130_fd_sc_hd__fill_1
XFILLER_0_124_681 VPWR VGND VPWR VGND sky130_ef_sc_hd__decap_12
X_5484_ clknet_leaf_17_clk _0404_ VGND VGND VPWR VPWR cpu_inst.regfile_inst.registers\[9\]\[20\]
+ sky130_fd_sc_hd__dfxtp_1
XFILLER_0_13_167 VGND VGND VPWR VPWR sky130_fd_sc_hd__fill_1
X_2696_ _0654_ _0658_ _0660_ _0657_ VGND VGND VPWR VPWR _0661_ sky130_fd_sc_hd__o22a_1
XTAP_TAPCELL_ROW_57_1159 VGND VPWR sky130_fd_sc_hd__tapvpwrvgnd_1
XTAP_TAPCELL_ROW_57_1148 VGND VPWR sky130_fd_sc_hd__tapvpwrvgnd_1
X_4435_ _1110_ cpu_inst.regfile_inst.registers\[7\]\[2\] _2161_ VGND VGND VPWR VPWR
+ _2164_ sky130_fd_sc_hd__mux2_1
XFILLER_0_10_841 VGND VGND VPWR VPWR sky130_fd_sc_hd__fill_1
XFILLER_0_6_53 VPWR VGND VPWR VGND sky130_ef_sc_hd__decap_12
XFILLER_0_1_573 VPWR VGND VPWR VGND sky130_ef_sc_hd__decap_12
X_4366_ _2128_ VGND VGND VPWR VPWR _0192_ sky130_fd_sc_hd__clkbuf_1
X_3317_ _1102_ _1172_ VGND VGND VPWR VPWR _1278_ sky130_fd_sc_hd__nand2_1
XTAP_TAPCELL_ROW_70_1348 VGND VPWR sky130_fd_sc_hd__tapvpwrvgnd_1
XFILLER_0_6_97 VPWR VGND VPWR VGND sky130_ef_sc_hd__decap_12
X_4297_ _2091_ VGND VGND VPWR VPWR _2092_ sky130_fd_sc_hd__buf_4
X_3248_ _1211_ _1212_ _0912_ VGND VGND VPWR VPWR _1213_ sky130_fd_sc_hd__mux2_1
X_3179_ _1055_ VGND VGND VPWR VPWR _1144_ sky130_fd_sc_hd__buf_2
Xrebuffer20 net34 VGND VGND VPWR VPWR net33 sky130_fd_sc_hd__dlygate4sd1_1
XFILLER_0_83_93 VPWR VGND VPWR VGND sky130_ef_sc_hd__decap_12
XFILLER_0_68_307 VGND VGND VPWR VPWR sky130_fd_sc_hd__fill_1
XFILLER_0_95_137 VPWR VGND VPWR VGND sky130_ef_sc_hd__decap_12
XFILLER_0_77_841 VGND VGND VPWR VPWR sky130_fd_sc_hd__fill_1
XFILLER_0_92_811 VGND VGND VPWR VPWR sky130_fd_sc_hd__fill_1
XTAP_TAPCELL_ROW_85_1580 VGND VPWR sky130_fd_sc_hd__tapvpwrvgnd_1
XFILLER_0_37_727 VGND VGND VPWR VPWR sky130_fd_sc_hd__fill_1
XFILLER_0_134_401 VPWR VGND VPWR VGND sky130_ef_sc_hd__decap_12
XFILLER_0_119_497 VGND VGND VPWR VPWR sky130_fd_sc_hd__decap_6
XFILLER_0_64_568 VGND VGND VPWR VPWR sky130_fd_sc_hd__fill_1
XFILLER_0_9_673 VPWR VGND VPWR VGND sky130_ef_sc_hd__decap_12
XFILLER_0_134_445 VPWR VGND VPWR VGND sky130_ef_sc_hd__decap_12
XFILLER_0_17_473 VPWR VGND VPWR VGND sky130_ef_sc_hd__decap_12
XFILLER_0_134_489 VPWR VGND VPWR VGND sky130_ef_sc_hd__decap_12
XFILLER_0_32_421 VPWR VGND VPWR VGND sky130_ef_sc_hd__decap_12
XFILLER_0_103_821 VPWR VGND VPWR VGND sky130_ef_sc_hd__decap_12
XTAP_TAPCELL_ROW_20_596 VGND VPWR sky130_fd_sc_hd__tapvpwrvgnd_1
XFILLER_0_4_3 VPWR VGND VPWR VGND sky130_ef_sc_hd__decap_12
XFILLER_0_99_487 VGND VGND VPWR VPWR sky130_fd_sc_hd__fill_1
XFILLER_0_87_638 VGND VGND VPWR VPWR sky130_fd_sc_hd__fill_2
XFILLER_0_129_217 VGND VGND VPWR VPWR sky130_fd_sc_hd__decap_6
XFILLER_0_82_321 VPWR VGND VPWR VGND sky130_ef_sc_hd__decap_12
XFILLER_0_28_749 VGND VGND VPWR VPWR sky130_fd_sc_hd__decap_6
XFILLER_0_137_261 VPWR VGND VPWR VGND sky130_ef_sc_hd__decap_12
XFILLER_0_6_109 VPWR VGND VPWR VGND sky130_ef_sc_hd__decap_12
XFILLER_0_27_237 VPWR VGND VPWR VGND sky130_ef_sc_hd__decap_12
XFILLER_0_103_69 VPWR VGND VPWR VGND sky130_ef_sc_hd__decap_12
XFILLER_0_82_365 VGND VGND VPWR VPWR sky130_fd_sc_hd__decap_6
XFILLER_0_70_505 VGND VGND VPWR VPWR sky130_fd_sc_hd__fill_2
XFILLER_0_113_629 VPWR VGND VPWR VGND sky130_ef_sc_hd__decap_12
XFILLER_0_106_670 VGND VGND VPWR VPWR sky130_fd_sc_hd__decap_8
XFILLER_0_88_27 VGND VGND VPWR VPWR sky130_fd_sc_hd__fill_1
XFILLER_0_63_590 VGND VGND VPWR VPWR sky130_fd_sc_hd__decap_8
XFILLER_0_35_281 VPWR VGND VPWR VGND sky130_ef_sc_hd__decap_12
XFILLER_0_112_139 VGND VGND VPWR VPWR sky130_fd_sc_hd__fill_1
X_2550_ _0504_ _0502_ _0503_ _0501_ VGND VGND VPWR VPWR _0515_ sky130_fd_sc_hd__or4_4
XFILLER_0_50_251 VGND VGND VPWR VPWR sky130_fd_sc_hd__fill_1
XFILLER_0_51_774 VGND VGND VPWR VPWR sky130_fd_sc_hd__fill_2
XFILLER_0_121_673 VPWR VGND VPWR VGND sky130_ef_sc_hd__decap_12
X_4220_ _2052_ VGND VGND VPWR VPWR _0122_ sky130_fd_sc_hd__clkbuf_1
XTAP_TAPCELL_ROW_110_1949 VGND VPWR sky130_fd_sc_hd__tapvpwrvgnd_1
X_4151_ _2015_ VGND VGND VPWR VPWR _0090_ sky130_fd_sc_hd__clkbuf_1
XFILLER_0_128_77 VGND VGND VPWR VPWR sky130_fd_sc_hd__decap_6
X_4082_ cpu_inst.regfile_inst.registers\[2\]\[28\] VGND VGND VPWR VPWR _1977_ sky130_fd_sc_hd__clkbuf_1
X_3102_ _1066_ VGND VGND VPWR VPWR _1067_ sky130_fd_sc_hd__inv_2
XTAP_TAPCELL_ROW_52_1078 VGND VPWR sky130_fd_sc_hd__tapvpwrvgnd_1
X_3033_ cpu_inst.regfile_inst.registers\[9\]\[11\] cpu_inst.regfile_inst.registers\[8\]\[11\]
+ _0922_ VGND VGND VPWR VPWR _0998_ sky130_fd_sc_hd__mux2_1
XFILLER_0_77_137 VPWR VGND VPWR VGND sky130_ef_sc_hd__decap_12
XFILLER_0_59_841 VGND VGND VPWR VPWR sky130_fd_sc_hd__fill_1
X_4984_ cpu_inst.regfile_inst.registers\[15\]\[10\] _2480_ VGND VGND VPWR VPWR _2481_
+ sky130_fd_sc_hd__and2_1
X_3935_ _1818_ _1857_ VGND VGND VPWR VPWR _1861_ sky130_fd_sc_hd__and2_1
XFILLER_0_74_822 VGND VGND VPWR VPWR sky130_fd_sc_hd__fill_1
XFILLER_0_19_727 VGND VGND VPWR VPWR sky130_fd_sc_hd__fill_1
XFILLER_0_116_401 VPWR VGND VPWR VGND sky130_ef_sc_hd__decap_12
XFILLER_0_85_181 VPWR VGND VPWR VGND sky130_ef_sc_hd__decap_12
XFILLER_0_116_445 VPWR VGND VPWR VGND sky130_ef_sc_hd__decap_12
X_3866_ _1793_ VGND VGND VPWR VPWR _0027_ sky130_fd_sc_hd__clkbuf_1
XFILLER_0_61_505 VGND VGND VPWR VPWR sky130_fd_sc_hd__decap_6
XFILLER_0_6_643 VGND VGND VPWR VPWR sky130_fd_sc_hd__fill_1
XFILLER_0_46_579 VGND VGND VPWR VPWR sky130_fd_sc_hd__fill_1
XFILLER_0_116_489 VPWR VGND VPWR VGND sky130_ef_sc_hd__decap_12
XFILLER_0_104_629 VGND VGND VPWR VPWR sky130_fd_sc_hd__decap_4
X_3797_ _1726_ cpu_inst.regfile_inst.registers\[6\]\[25\] _1609_ VGND VGND VPWR VPWR
+ _1727_ sky130_fd_sc_hd__mux2_1
XFILLER_0_82_3 VPWR VGND VPWR VGND sky130_ef_sc_hd__decap_12
X_2817_ _0780_ _0636_ _0781_ _0639_ VGND VGND VPWR VPWR _0782_ sky130_fd_sc_hd__a31o_1
XFILLER_0_14_421 VPWR VGND VPWR VGND sky130_ef_sc_hd__decap_12
X_2748_ _0584_ _0711_ _0712_ net23 VGND VGND VPWR VPWR _0713_ sky130_fd_sc_hd__o211a_1
X_5536_ clknet_leaf_35_clk _0456_ VGND VGND VPWR VPWR cpu_inst.regfile_inst.registers\[15\]\[8\]
+ sky130_fd_sc_hd__dfxtp_1
X_5467_ clknet_leaf_37_clk _0387_ VGND VGND VPWR VPWR cpu_inst.regfile_inst.registers\[9\]\[3\]
+ sky130_fd_sc_hd__dfxtp_1
XFILLER_0_41_273 VGND VGND VPWR VPWR sky130_fd_sc_hd__decap_6
XFILLER_0_111_161 VGND VGND VPWR VPWR sky130_fd_sc_hd__decap_6
X_4418_ _2154_ VGND VGND VPWR VPWR _0218_ sky130_fd_sc_hd__clkbuf_1
XFILLER_0_100_813 VPWR VGND VPWR VGND sky130_ef_sc_hd__decap_12
X_2679_ _0637_ net41 _0641_ _0643_ VGND VGND VPWR VPWR _0644_ sky130_fd_sc_hd__a31oi_4
X_5398_ clknet_leaf_4_clk _0318_ VGND VGND VPWR VPWR cpu_inst.regfile_inst.registers\[10\]\[30\]
+ sky130_fd_sc_hd__dfxtp_1
X_4349_ _1692_ cpu_inst.regfile_inst.registers\[5\]\[24\] _2117_ VGND VGND VPWR VPWR
+ _2120_ sky130_fd_sc_hd__mux2_1
XFILLER_0_10_693 VGND VGND VPWR VPWR sky130_fd_sc_hd__decap_6
XTAP_TAPCELL_ROW_83_1539 VGND VPWR sky130_fd_sc_hd__tapvpwrvgnd_1
XFILLER_0_77_693 VGND VGND VPWR VPWR sky130_fd_sc_hd__fill_2
XFILLER_0_65_833 VGND VGND VPWR VPWR sky130_fd_sc_hd__decap_6
XFILLER_0_49_373 VPWR VGND VPWR VGND sky130_ef_sc_hd__decap_12
XFILLER_0_135_721 VGND VGND VPWR VPWR sky130_fd_sc_hd__decap_6
XFILLER_0_126_209 VPWR VGND VPWR VGND sky130_ef_sc_hd__decap_12
XFILLER_0_119_261 VPWR VGND VPWR VGND sky130_ef_sc_hd__decap_12
XTAP_TAPCELL_ROW_25_677 VGND VPWR sky130_fd_sc_hd__tapvpwrvgnd_1
XFILLER_0_37_557 VGND VGND VPWR VPWR sky130_fd_sc_hd__decap_3
XFILLER_0_64_376 VGND VGND VPWR VPWR sky130_fd_sc_hd__decap_6
XPHY_EDGE_ROW_30_Left_169 VGND VGND VPWR VPWR sky130_fd_sc_hd__decap_3
XFILLER_0_135_765 VPWR VGND VPWR VGND sky130_ef_sc_hd__decap_12
XFILLER_0_134_253 VPWR VGND VPWR VGND sky130_ef_sc_hd__decap_12
XTAP_TAPCELL_ROW_114_2005 VGND VPWR sky130_fd_sc_hd__tapvpwrvgnd_1
XFILLER_0_52_549 VGND VGND VPWR VPWR sky130_fd_sc_hd__fill_1
XFILLER_0_17_281 VPWR VGND VPWR VGND sky130_ef_sc_hd__decap_12
XFILLER_0_18_793 VPWR VGND VPWR VGND sky130_ef_sc_hd__decap_12
XFILLER_0_33_741 VPWR VGND VPWR VGND sky130_ef_sc_hd__decap_12
XTAP_TAPCELL_ROW_114_2016 VGND VPWR sky130_fd_sc_hd__tapvpwrvgnd_1
XTAP_TAPCELL_ROW_98_1771 VGND VPWR sky130_fd_sc_hd__tapvpwrvgnd_1
XFILLER_0_32_251 VGND VGND VPWR VPWR sky130_fd_sc_hd__fill_1
XFILLER_0_60_582 VGND VGND VPWR VPWR sky130_fd_sc_hd__decap_6
XFILLER_0_20_413 VGND VGND VPWR VPWR sky130_fd_sc_hd__decap_6
XFILLER_0_33_785 VPWR VGND VPWR VGND sky130_ef_sc_hd__decap_12
XFILLER_0_20_457 VPWR VGND VPWR VGND sky130_ef_sc_hd__decap_12
XFILLER_0_74_29 VPWR VGND VPWR VGND sky130_ef_sc_hd__decap_12
XTAP_TAPCELL_ROW_5_380 VGND VPWR sky130_fd_sc_hd__tapvpwrvgnd_1
XFILLER_0_99_273 VGND VGND VPWR VPWR sky130_fd_sc_hd__decap_6
XTAP_TAPCELL_ROW_125_2178 VGND VPWR sky130_fd_sc_hd__tapvpwrvgnd_1
XFILLER_0_59_137 VPWR VGND VPWR VGND sky130_ef_sc_hd__decap_12
XFILLER_0_23_55 VGND VGND VPWR VPWR sky130_fd_sc_hd__fill_1
XTAP_TAPCELL_ROW_44_953 VGND VPWR sky130_fd_sc_hd__tapvpwrvgnd_1
XTAP_TAPCELL_ROW_44_964 VGND VPWR sky130_fd_sc_hd__tapvpwrvgnd_1
X_3720_ _1618_ _1632_ VGND VGND VPWR VPWR _1651_ sky130_fd_sc_hd__or2_1
XFILLER_0_83_652 VPWR VGND VPWR VGND sky130_ef_sc_hd__decap_12
XFILLER_0_67_181 VPWR VGND VPWR VGND sky130_ef_sc_hd__decap_12
XFILLER_0_7_429 VPWR VGND VPWR VGND sky130_ef_sc_hd__decap_12
XFILLER_0_99_15 VPWR VGND VPWR VGND sky130_ef_sc_hd__decap_12
XFILLER_0_71_825 VGND VGND VPWR VPWR sky130_fd_sc_hd__fill_1
Xclkbuf_leaf_40_clk clknet_2_0__leaf_clk VGND VGND VPWR VPWR clknet_leaf_40_clk sky130_fd_sc_hd__clkbuf_8
XFILLER_0_43_505 VGND VGND VPWR VPWR sky130_fd_sc_hd__fill_2
X_3651_ cpu_inst.regfile_inst.registers\[25\]\[22\] _0693_ _0695_ _1583_ VGND VGND
+ VPWR VPWR _1584_ sky130_fd_sc_hd__o211a_1
XFILLER_0_82_195 VGND VGND VPWR VPWR sky130_fd_sc_hd__fill_1
X_3582_ cpu_inst.regfile_inst.registers\[15\]\[20\] _0729_ _1516_ _0844_ VGND VGND
+ VPWR VPWR _1517_ sky130_fd_sc_hd__a211o_1
X_2602_ net17 _0518_ _0554_ _0549_ VGND VGND VPWR VPWR _0567_ sky130_fd_sc_hd__or4_4
X_5321_ clknet_leaf_25_clk _0241_ VGND VGND VPWR VPWR cpu_inst.regfile_inst.registers\[7\]\[17\]
+ sky130_fd_sc_hd__dfxtp_1
XFILLER_0_23_273 VGND VGND VPWR VPWR sky130_fd_sc_hd__decap_6
XFILLER_0_100_109 VPWR VGND VPWR VGND sky130_ef_sc_hd__decap_12
XTAP_TAPCELL_ROW_54_1107 VGND VPWR sky130_fd_sc_hd__tapvpwrvgnd_1
XFILLER_0_2_189 VGND VGND VPWR VPWR sky130_fd_sc_hd__decap_6
X_5252_ clknet_leaf_21_clk _0172_ VGND VGND VPWR VPWR cpu_inst.regfile_inst.registers\[5\]\[12\]
+ sky130_fd_sc_hd__dfxtp_1
XFILLER_0_48_41 VPWR VGND VPWR VGND sky130_ef_sc_hd__decap_12
X_4203_ _2043_ VGND VGND VPWR VPWR _0114_ sky130_fd_sc_hd__clkbuf_1
X_5183_ clknet_leaf_34_clk _0103_ VGND VGND VPWR VPWR cpu_inst.regfile_inst.registers\[4\]\[7\]
+ sky130_fd_sc_hd__dfxtp_1
XFILLER_0_48_85 VPWR VGND VPWR VGND sky130_ef_sc_hd__decap_12
X_4134_ _2006_ VGND VGND VPWR VPWR _0082_ sky130_fd_sc_hd__clkbuf_1
XTAP_TAPCELL_ROW_3_339 VGND VPWR sky130_fd_sc_hd__tapvpwrvgnd_1
X_4065_ _1968_ VGND VGND VPWR VPWR _0051_ sky130_fd_sc_hd__clkbuf_1
X_3016_ _0979_ _0980_ _0883_ VGND VGND VPWR VPWR _0981_ sky130_fd_sc_hd__mux2_1
XTAP_TAPCELL_ROW_65_1269 VGND VPWR sky130_fd_sc_hd__tapvpwrvgnd_1
XFILLER_0_47_811 VPWR VGND VPWR VGND sky130_ef_sc_hd__decap_12
XFILLER_0_108_209 VPWR VGND VPWR VGND sky130_ef_sc_hd__decap_12
XFILLER_0_80_83 VGND VGND VPWR VPWR sky130_fd_sc_hd__fill_1
XFILLER_0_74_641 VGND VGND VPWR VPWR sky130_fd_sc_hd__decap_3
XTAP_TAPCELL_ROW_22_625 VGND VPWR sky130_fd_sc_hd__tapvpwrvgnd_1
XFILLER_0_46_321 VPWR VGND VPWR VGND sky130_ef_sc_hd__decap_12
X_4967_ cpu_inst.regfile_inst.registers\[15\]\[2\] _2469_ VGND VGND VPWR VPWR _2472_
+ sky130_fd_sc_hd__or2b_1
XFILLER_0_117_721 VGND VGND VPWR VPWR sky130_fd_sc_hd__decap_6
X_3918_ cpu_inst.regfile_inst.registers\[8\]\[29\] _1843_ _1739_ VGND VGND VPWR VPWR
+ _1844_ sky130_fd_sc_hd__mux2_1
X_4898_ _0543_ _1328_ VGND VGND VPWR VPWR _2435_ sky130_fd_sc_hd__or2_1
XTAP_TAPCELL_ROW_22_636 VGND VPWR sky130_fd_sc_hd__tapvpwrvgnd_1
Xclkbuf_leaf_31_clk clknet_2_2__leaf_clk VGND VGND VPWR VPWR clknet_leaf_31_clk sky130_fd_sc_hd__clkbuf_8
XFILLER_0_46_365 VPWR VGND VPWR VGND sky130_ef_sc_hd__decap_12
XFILLER_0_132_713 VPWR VGND VPWR VGND sky130_ef_sc_hd__decap_12
XFILLER_0_117_765 VPWR VGND VPWR VGND sky130_ef_sc_hd__decap_12
XFILLER_0_116_253 VPWR VGND VPWR VGND sky130_ef_sc_hd__decap_12
X_3849_ _1709_ _1773_ _1776_ _1552_ VGND VGND VPWR VPWR _1777_ sky130_fd_sc_hd__o22a_1
XFILLER_0_61_324 VPWR VGND VPWR VGND sky130_ef_sc_hd__decap_12
XFILLER_0_131_223 VGND VGND VPWR VPWR sky130_fd_sc_hd__fill_1
XFILLER_0_15_741 VPWR VGND VPWR VGND sky130_ef_sc_hd__decap_12
XFILLER_0_132_757 VPWR VGND VPWR VGND sky130_ef_sc_hd__decap_12
X_5519_ clknet_leaf_13_clk _0439_ VGND VGND VPWR VPWR cpu_inst.regfile_inst.registers\[8\]\[23\]
+ sky130_fd_sc_hd__dfxtp_1
XFILLER_0_89_81 VPWR VGND VPWR VGND sky130_ef_sc_hd__decap_12
XFILLER_0_14_251 VGND VGND VPWR VPWR sky130_fd_sc_hd__fill_1
XFILLER_0_15_785 VPWR VGND VPWR VGND sky130_ef_sc_hd__decap_12
XFILLER_0_100_621 VPWR VGND VPWR VGND sky130_ef_sc_hd__decap_12
XFILLER_0_100_643 VGND VGND VPWR VPWR sky130_fd_sc_hd__fill_1
XTAP_TAPCELL_ROW_93_1690 VGND VPWR sky130_fd_sc_hd__tapvpwrvgnd_1
XFILLER_0_96_221 VPWR VGND VPWR VGND sky130_ef_sc_hd__decap_12
XFILLER_0_97_777 VGND VGND VPWR VPWR sky130_fd_sc_hd__fill_2
XFILLER_0_96_265 VPWR VGND VPWR VGND sky130_ef_sc_hd__decap_12
XFILLER_0_127_529 VPWR VGND VPWR VGND sky130_ef_sc_hd__decap_12
XTAP_TAPCELL_ROW_120_2097 VGND VPWR sky130_fd_sc_hd__tapvpwrvgnd_1
XTAP_TAPCELL_ROW_41_912 VGND VPWR sky130_fd_sc_hd__tapvpwrvgnd_1
XFILLER_0_49_181 VPWR VGND VPWR VGND sky130_ef_sc_hd__decap_12
Xclkbuf_leaf_22_clk clknet_2_3__leaf_clk VGND VGND VPWR VPWR clknet_leaf_22_clk sky130_fd_sc_hd__clkbuf_8
XFILLER_0_25_505 VPWR VGND VPWR VGND sky130_ef_sc_hd__decap_12
XFILLER_0_64_195 VGND VGND VPWR VPWR sky130_fd_sc_hd__fill_1
XFILLER_0_53_836 VGND VGND VPWR VPWR sky130_fd_sc_hd__decap_4
XFILLER_0_135_573 VPWR VGND VPWR VGND sky130_ef_sc_hd__decap_12
XFILLER_0_80_677 VGND VGND VPWR VPWR sky130_fd_sc_hd__decap_3
XFILLER_0_52_357 VGND VGND VPWR VPWR sky130_fd_sc_hd__decap_6
XFILLER_0_122_245 VGND VGND VPWR VPWR sky130_fd_sc_hd__decap_6
XFILLER_0_100_15 VPWR VGND VPWR VGND sky130_ef_sc_hd__decap_12
XFILLER_0_122_289 VPWR VGND VPWR VGND sky130_ef_sc_hd__decap_12
XFILLER_0_20_221 VPWR VGND VPWR VGND sky130_ef_sc_hd__decap_12
XFILLER_0_20_265 VPWR VGND VPWR VGND sky130_ef_sc_hd__decap_12
XFILLER_0_21_777 VGND VGND VPWR VPWR sky130_fd_sc_hd__decap_6
XFILLER_0_85_39 VPWR VGND VPWR VGND sky130_ef_sc_hd__decap_12
XTAP_TAPCELL_ROW_127_2207 VGND VPWR sky130_fd_sc_hd__tapvpwrvgnd_1
XFILLER_0_109_57 VPWR VGND VPWR VGND sky130_ef_sc_hd__decap_12
XFILLER_0_18_77 VGND VGND VPWR VPWR sky130_fd_sc_hd__decap_6
XTAP_TAPCELL_ROW_109_1940 VGND VPWR sky130_fd_sc_hd__tapvpwrvgnd_1
XFILLER_0_88_777 VGND VGND VPWR VPWR sky130_fd_sc_hd__fill_1
X_4821_ _2395_ VGND VGND VPWR VPWR _0380_ sky130_fd_sc_hd__clkbuf_1
XFILLER_0_34_65 VPWR VGND VPWR VGND sky130_ef_sc_hd__decap_12
XFILLER_0_75_449 VGND VGND VPWR VPWR sky130_fd_sc_hd__fill_2
XFILLER_0_28_321 VPWR VGND VPWR VGND sky130_ef_sc_hd__decap_12
Xclkbuf_leaf_13_clk clknet_2_3__leaf_clk VGND VGND VPWR VPWR clknet_leaf_13_clk sky130_fd_sc_hd__clkbuf_8
X_4752_ cpu_inst.decoder_inst.current_pc\[27\] cpu_inst.decoder_inst.current_pc\[28\]
+ _2355_ VGND VGND VPWR VPWR _2359_ sky130_fd_sc_hd__and3_1
XFILLER_0_8_749 VGND VGND VPWR VPWR sky130_fd_sc_hd__decap_6
XFILLER_0_7_237 VPWR VGND VPWR VGND sky130_ef_sc_hd__decap_12
XFILLER_0_28_365 VPWR VGND VPWR VGND sky130_ef_sc_hd__decap_12
XTAP_TAPCELL_ROW_138_2369 VGND VPWR sky130_fd_sc_hd__tapvpwrvgnd_1
X_3703_ _1601_ _1611_ _1633_ VGND VGND VPWR VPWR _1635_ sky130_fd_sc_hd__a21oi_1
XFILLER_0_83_471 VPWR VGND VPWR VGND sky130_ef_sc_hd__decap_12
XFILLER_0_70_121 VPWR VGND VPWR VGND sky130_ef_sc_hd__decap_12
X_4683_ net37 _2308_ VGND VGND VPWR VPWR _2309_ sky130_fd_sc_hd__xor2_1
XFILLER_0_43_335 VGND VGND VPWR VPWR sky130_fd_sc_hd__fill_1
XFILLER_0_50_53 VPWR VGND VPWR VGND sky130_ef_sc_hd__decap_12
XFILLER_0_114_713 VPWR VGND VPWR VGND sky130_ef_sc_hd__decap_12
X_3634_ _1549_ _1567_ VGND VGND VPWR VPWR _1568_ sky130_fd_sc_hd__and2_1
XTAP_TAPCELL_ROW_60_1199 VGND VPWR sky130_fd_sc_hd__tapvpwrvgnd_1
XFILLER_0_50_97 VPWR VGND VPWR VGND sky130_ef_sc_hd__decap_12
XFILLER_0_114_757 VPWR VGND VPWR VGND sky130_ef_sc_hd__decap_12
XFILLER_0_113_223 VGND VGND VPWR VPWR sky130_fd_sc_hd__fill_1
XFILLER_0_70_165 VPWR VGND VPWR VGND sky130_ef_sc_hd__decap_12
X_3565_ _0864_ _1497_ _1499_ _0876_ VGND VGND VPWR VPWR _1500_ sky130_fd_sc_hd__o22a_1
XFILLER_0_59_51 VGND VGND VPWR VPWR sky130_fd_sc_hd__decap_4
XFILLER_0_12_755 VGND VGND VPWR VPWR sky130_fd_sc_hd__fill_1
X_3496_ cpu_inst.regfile_inst.registers\[15\]\[18\] _1432_ _0721_ VGND VGND VPWR VPWR
+ _1433_ sky130_fd_sc_hd__mux2_1
X_5304_ clknet_leaf_40_clk _0224_ VGND VGND VPWR VPWR cpu_inst.regfile_inst.registers\[7\]\[0\]
+ sky130_fd_sc_hd__dfxtp_1
X_5235_ clknet_leaf_10_clk _0155_ VGND VGND VPWR VPWR cpu_inst.regfile_inst.registers\[24\]\[27\]
+ sky130_fd_sc_hd__dfxtp_1
XFILLER_0_45_3 VPWR VGND VPWR VGND sky130_ef_sc_hd__decap_12
X_5166_ clknet_leaf_13_clk _0086_ VGND VGND VPWR VPWR cpu_inst.regfile_inst.registers\[25\]\[22\]
+ sky130_fd_sc_hd__dfxtp_1
XFILLER_0_98_508 VGND VGND VPWR VPWR sky130_fd_sc_hd__decap_4
X_4117_ _1997_ VGND VGND VPWR VPWR _0074_ sky130_fd_sc_hd__clkbuf_1
X_5097_ clknet_leaf_25_clk _0017_ VGND VGND VPWR VPWR cpu_inst.regfile_inst.registers\[6\]\[17\]
+ sky130_fd_sc_hd__dfxtp_1
XFILLER_0_78_221 VPWR VGND VPWR VGND sky130_ef_sc_hd__decap_12
XTAP_TAPCELL_ROW_67_1309 VGND VPWR sky130_fd_sc_hd__tapvpwrvgnd_1
XTAP_TAPCELL_ROW_27_706 VGND VPWR sky130_fd_sc_hd__tapvpwrvgnd_1
X_4048_ cpu_inst.regfile_inst.registers\[2\]\[11\] VGND VGND VPWR VPWR _1960_ sky130_fd_sc_hd__clkbuf_1
XFILLER_0_91_93 VPWR VGND VPWR VGND sky130_ef_sc_hd__decap_12
XFILLER_0_78_265 VPWR VGND VPWR VGND sky130_ef_sc_hd__decap_12
XFILLER_0_66_416 VGND VGND VPWR VPWR sky130_fd_sc_hd__decap_4
XFILLER_0_109_529 VPWR VGND VPWR VGND sky130_ef_sc_hd__decap_12
XFILLER_0_94_747 VGND VGND VPWR VPWR sky130_fd_sc_hd__decap_8
XFILLER_0_93_279 VGND VGND VPWR VPWR sky130_fd_sc_hd__fill_1
XFILLER_0_117_573 VPWR VGND VPWR VGND sky130_ef_sc_hd__decap_12
XFILLER_0_62_677 VGND VGND VPWR VPWR sky130_fd_sc_hd__fill_1
XFILLER_0_34_357 VGND VGND VPWR VPWR sky130_fd_sc_hd__decap_6
XFILLER_0_46_195 VGND VGND VPWR VPWR sky130_fd_sc_hd__fill_1
XFILLER_0_104_245 VGND VGND VPWR VPWR sky130_fd_sc_hd__decap_6
XPHY_EDGE_ROW_104_Left_243 VGND VGND VPWR VPWR sky130_fd_sc_hd__decap_3
XTAP_TAPCELL_ROW_95_1730 VGND VPWR sky130_fd_sc_hd__tapvpwrvgnd_1
XFILLER_0_50_828 VPWR VGND VPWR VGND sky130_ef_sc_hd__decap_12
XFILLER_0_132_587 VGND VGND VPWR VPWR sky130_fd_sc_hd__fill_1
XFILLER_0_104_289 VPWR VGND VPWR VGND sky130_ef_sc_hd__decap_12
XFILLER_0_120_749 VGND VGND VPWR VPWR sky130_fd_sc_hd__decap_6
XFILLER_0_100_495 VGND VGND VPWR VPWR sky130_fd_sc_hd__fill_2
XPHY_EDGE_ROW_113_Left_252 VGND VGND VPWR VPWR sky130_fd_sc_hd__decap_3
XFILLER_0_89_519 VGND VGND VPWR VPWR sky130_fd_sc_hd__decap_8
XTAP_TAPCELL_ROW_122_2137 VGND VPWR sky130_fd_sc_hd__tapvpwrvgnd_1
XTAP_TAPCELL_ROW_122_2126 VGND VPWR sky130_fd_sc_hd__tapvpwrvgnd_1
XFILLER_0_97_541 VGND VGND VPWR VPWR sky130_fd_sc_hd__decap_8
XFILLER_0_128_805 VGND VGND VPWR VPWR sky130_fd_sc_hd__decap_6
XFILLER_0_57_416 VPWR VGND VPWR VGND sky130_ef_sc_hd__decap_12
XFILLER_0_57_449 VGND VGND VPWR VPWR sky130_fd_sc_hd__decap_8
XFILLER_0_127_337 VPWR VGND VPWR VGND sky130_ef_sc_hd__decap_12
XFILLER_0_72_419 VGND VGND VPWR VPWR sky130_fd_sc_hd__fill_1
XFILLER_0_65_460 VGND VGND VPWR VPWR sky130_fd_sc_hd__decap_3
XPHY_EDGE_ROW_122_Left_261 VGND VGND VPWR VPWR sky130_fd_sc_hd__decap_3
XFILLER_0_108_562 VGND VGND VPWR VPWR sky130_fd_sc_hd__fill_1
XFILLER_0_65_482 VGND VGND VPWR VPWR sky130_fd_sc_hd__fill_1
XTAP_TAPCELL_ROW_13_488 VGND VPWR sky130_fd_sc_hd__tapvpwrvgnd_1
XTAP_TAPCELL_ROW_13_499 VGND VPWR sky130_fd_sc_hd__tapvpwrvgnd_1
XFILLER_0_25_335 VGND VGND VPWR VPWR sky130_fd_sc_hd__fill_1
XFILLER_0_52_121 VPWR VGND VPWR VGND sky130_ef_sc_hd__decap_12
XFILLER_0_111_69 VPWR VGND VPWR VGND sky130_ef_sc_hd__decap_12
XFILLER_0_80_485 VGND VGND VPWR VPWR sky130_fd_sc_hd__fill_2
XFILLER_0_41_839 VGND VGND VPWR VPWR sky130_fd_sc_hd__fill_1
XFILLER_0_52_165 VPWR VGND VPWR VGND sky130_ef_sc_hd__decap_12
XFILLER_0_111_727 VGND VGND VPWR VPWR sky130_fd_sc_hd__fill_1
XFILLER_0_21_541 VPWR VGND VPWR VGND sky130_ef_sc_hd__decap_12
XTAP_TAPCELL_ROW_133_2299 VGND VPWR sky130_fd_sc_hd__tapvpwrvgnd_1
XTAP_TAPCELL_ROW_133_2288 VGND VPWR sky130_fd_sc_hd__tapvpwrvgnd_1
XFILLER_0_96_27 VGND VGND VPWR VPWR sky130_fd_sc_hd__fill_1
X_3350_ _1110_ cpu_inst.regfile_inst.registers\[6\]\[2\] _1300_ VGND VGND VPWR VPWR
+ _1303_ sky130_fd_sc_hd__mux2_1
XFILLER_0_21_585 VPWR VGND VPWR VGND sky130_ef_sc_hd__decap_12
X_5020_ _2499_ VGND VGND VPWR VPWR _0475_ sky130_fd_sc_hd__clkbuf_1
X_3281_ _1238_ _1245_ VGND VGND VPWR VPWR _1246_ sky130_fd_sc_hd__nor2_1
XPHY_EDGE_ROW_131_Left_270 VGND VGND VPWR VPWR sky130_fd_sc_hd__decap_3
Xclkbuf_leaf_2_clk clknet_2_1__leaf_clk VGND VGND VPWR VPWR clknet_leaf_2_clk sky130_fd_sc_hd__clkbuf_8
XPHY_EDGE_ROW_119_Right_119 VGND VGND VPWR VPWR sky130_fd_sc_hd__decap_3
XFILLER_0_136_77 VGND VGND VPWR VPWR sky130_fd_sc_hd__decap_6
XTAP_TAPCELL_ROW_49_1028 VGND VPWR sky130_fd_sc_hd__tapvpwrvgnd_1
XTAP_TAPCELL_ROW_49_1039 VGND VPWR sky130_fd_sc_hd__tapvpwrvgnd_1
XFILLER_0_76_736 VGND VGND VPWR VPWR sky130_fd_sc_hd__fill_2
XTAP_TAPCELL_ROW_62_1228 VGND VPWR sky130_fd_sc_hd__tapvpwrvgnd_1
XFILLER_0_8_513 VPWR VGND VPWR VGND sky130_ef_sc_hd__decap_12
X_4804_ cpu_inst.regfile_inst.registers\[0\]\[20\] VGND VGND VPWR VPWR _2387_ sky130_fd_sc_hd__clkbuf_1
XFILLER_0_75_279 VGND VGND VPWR VPWR sky130_fd_sc_hd__fill_1
X_2996_ _0610_ _0859_ VGND VGND VPWR VPWR _0961_ sky130_fd_sc_hd__or2_4
X_4735_ _2345_ _2346_ VGND VGND VPWR VPWR _2347_ sky130_fd_sc_hd__nor2_1
XFILLER_0_8_557 VPWR VGND VPWR VGND sky130_ef_sc_hd__decap_12
XTAP_TAPCELL_ROW_32_775 VGND VPWR sky130_fd_sc_hd__tapvpwrvgnd_1
XFILLER_0_133_329 VGND VGND VPWR VPWR sky130_fd_sc_hd__decap_6
XFILLER_0_16_357 VGND VGND VPWR VPWR sky130_fd_sc_hd__decap_6
XFILLER_0_28_195 VGND VGND VPWR VPWR sky130_fd_sc_hd__fill_1
XTAP_TAPCELL_ROW_32_786 VGND VPWR sky130_fd_sc_hd__tapvpwrvgnd_1
X_4666_ _2293_ _2296_ cpu_inst.decoder_inst.current_pc\[4\] _2289_ VGND VGND VPWR
+ VPWR _0324_ sky130_fd_sc_hd__o2bb2a_1
XFILLER_0_31_305 VPWR VGND VPWR VGND sky130_ef_sc_hd__decap_12
XFILLER_0_44_699 VGND VGND VPWR VPWR sky130_fd_sc_hd__fill_1
XFILLER_0_114_587 VGND VGND VPWR VPWR sky130_fd_sc_hd__fill_1
X_3617_ _1509_ _1550_ _0686_ VGND VGND VPWR VPWR _1551_ sky130_fd_sc_hd__o21a_1
X_4597_ cpu_inst.regfile_inst.registers\[10\]\[17\] _2241_ VGND VGND VPWR VPWR _2247_
+ sky130_fd_sc_hd__and2_1
XFILLER_0_31_349 VPWR VGND VPWR VGND sky130_ef_sc_hd__decap_12
XFILLER_0_101_237 VPWR VGND VPWR VGND sky130_ef_sc_hd__decap_12
X_3548_ _1482_ _1483_ VGND VGND VPWR VPWR _1484_ sky130_fd_sc_hd__or2b_1
XTAP_TAPCELL_ROW_77_1460 VGND VPWR sky130_fd_sc_hd__tapvpwrvgnd_1
XFILLER_0_3_273 VGND VGND VPWR VPWR sky130_fd_sc_hd__decap_6
XFILLER_0_110_793 VPWR VGND VPWR VGND sky130_ef_sc_hd__decap_12
X_3479_ _0756_ _1415_ _1416_ _0682_ VGND VGND VPWR VPWR _1417_ sky130_fd_sc_hd__o31a_1
X_5218_ clknet_leaf_25_clk _0138_ VGND VGND VPWR VPWR cpu_inst.regfile_inst.registers\[24\]\[10\]
+ sky130_fd_sc_hd__dfxtp_1
X_5149_ clknet_leaf_24_clk _0069_ VGND VGND VPWR VPWR cpu_inst.regfile_inst.registers\[25\]\[5\]
+ sky130_fd_sc_hd__dfxtp_1
XFILLER_0_99_839 VGND VGND VPWR VPWR sky130_fd_sc_hd__fill_1
XFILLER_0_94_511 VGND VGND VPWR VPWR sky130_fd_sc_hd__decap_3
XFILLER_0_79_574 VGND VGND VPWR VPWR sky130_fd_sc_hd__decap_3
XFILLER_0_39_405 VPWR VGND VPWR VGND sky130_ef_sc_hd__decap_12
XFILLER_0_94_544 VGND VGND VPWR VPWR sky130_fd_sc_hd__fill_1
XFILLER_0_109_337 VPWR VGND VPWR VGND sky130_ef_sc_hd__decap_12
XFILLER_0_81_205 VPWR VGND VPWR VGND sky130_ef_sc_hd__decap_12
XFILLER_0_54_419 VGND VGND VPWR VPWR sky130_fd_sc_hd__fill_1
XFILLER_0_47_460 VGND VGND VPWR VPWR sky130_fd_sc_hd__fill_1
XFILLER_0_136_189 VGND VGND VPWR VPWR sky130_fd_sc_hd__decap_6
XFILLER_0_124_307 VGND VGND VPWR VPWR sky130_fd_sc_hd__fill_1
XFILLER_0_81_249 VPWR VGND VPWR VGND sky130_ef_sc_hd__decap_12
XFILLER_0_62_452 VGND VGND VPWR VPWR sky130_fd_sc_hd__decap_6
XFILLER_0_34_121 VPWR VGND VPWR VGND sky130_ef_sc_hd__decap_12
XFILLER_0_133_841 VGND VGND VPWR VPWR sky130_fd_sc_hd__fill_1
XFILLER_0_105_554 VGND VGND VPWR VPWR sky130_fd_sc_hd__decap_6
XTAP_TAPCELL_ROW_10_447 VGND VPWR sky130_fd_sc_hd__tapvpwrvgnd_1
XFILLER_0_23_839 VGND VGND VPWR VPWR sky130_fd_sc_hd__fill_1
XFILLER_0_34_165 VPWR VGND VPWR VGND sky130_ef_sc_hd__decap_12
XFILLER_0_120_513 VPWR VGND VPWR VGND sky130_ef_sc_hd__decap_12
XFILLER_0_120_557 VPWR VGND VPWR VGND sky130_ef_sc_hd__decap_12
XFILLER_0_89_305 VPWR VGND VPWR VGND sky130_ef_sc_hd__decap_12
XFILLER_0_82_29 VPWR VGND VPWR VGND sky130_ef_sc_hd__decap_12
XFILLER_0_89_349 VPWR VGND VPWR VGND sky130_ef_sc_hd__decap_12
XFILLER_0_128_613 VPWR VGND VPWR VGND sky130_ef_sc_hd__decap_12
XTAP_TAPCELL_ROW_102_1829 VGND VPWR sky130_fd_sc_hd__tapvpwrvgnd_1
XFILLER_0_97_393 VGND VGND VPWR VPWR sky130_fd_sc_hd__decap_8
XFILLER_0_85_544 VGND VGND VPWR VPWR sky130_fd_sc_hd__fill_1
XFILLER_0_58_736 VGND VGND VPWR VPWR sky130_fd_sc_hd__fill_1
XTAP_TAPCELL_ROW_18_569 VGND VPWR sky130_fd_sc_hd__tapvpwrvgnd_1
XFILLER_0_57_279 VGND VGND VPWR VPWR sky130_fd_sc_hd__fill_1
X_2850_ _0782_ _0795_ _0805_ _0814_ VGND VGND VPWR VPWR _0815_ sky130_fd_sc_hd__or4b_4
XFILLER_0_128_657 VPWR VGND VPWR VGND sky130_ef_sc_hd__decap_12
XFILLER_0_85_599 VGND VGND VPWR VPWR sky130_fd_sc_hd__fill_1
XFILLER_0_5_505 VPWR VGND VPWR VGND sky130_ef_sc_hd__decap_12
XTAP_TAPCELL_ROW_135_2328 VGND VPWR sky130_fd_sc_hd__tapvpwrvgnd_1
XFILLER_0_127_167 VGND VGND VPWR VPWR sky130_fd_sc_hd__fill_1
XFILLER_0_115_329 VGND VGND VPWR VPWR sky130_fd_sc_hd__decap_6
XFILLER_0_31_55 VGND VGND VPWR VPWR sky130_fd_sc_hd__fill_1
X_2781_ cpu_inst.regfile_inst.registers\[15\]\[3\] _0710_ _0571_ VGND VGND VPWR VPWR
+ _0746_ sky130_fd_sc_hd__a21o_1
XFILLER_0_124_841 VGND VGND VPWR VPWR sky130_fd_sc_hd__fill_1
XFILLER_0_81_783 VGND VGND VPWR VPWR sky130_fd_sc_hd__fill_1
XFILLER_0_13_305 VPWR VGND VPWR VGND sky130_ef_sc_hd__decap_12
XFILLER_0_26_699 VGND VGND VPWR VPWR sky130_fd_sc_hd__fill_1
X_4520_ cpu_inst.regfile_inst.registers\[11\]\[11\] VGND VGND VPWR VPWR _2208_ sky130_fd_sc_hd__clkbuf_1
XFILLER_0_103_3 VPWR VGND VPWR VGND sky130_ef_sc_hd__decap_12
XFILLER_0_13_349 VPWR VGND VPWR VGND sky130_ef_sc_hd__decap_12
X_4451_ _2172_ VGND VGND VPWR VPWR _0233_ sky130_fd_sc_hd__clkbuf_1
XFILLER_0_123_373 VPWR VGND VPWR VGND sky130_ef_sc_hd__decap_12
X_3402_ _1156_ cpu_inst.regfile_inst.registers\[6\]\[14\] _1339_ VGND VGND VPWR VPWR
+ _1343_ sky130_fd_sc_hd__mux2_1
XFILLER_0_0_221 VGND VGND VPWR VPWR sky130_fd_sc_hd__decap_3
XTAP_TAPCELL_ROW_59_1190 VGND VPWR sky130_fd_sc_hd__tapvpwrvgnd_1
XFILLER_0_1_777 VGND VGND VPWR VPWR sky130_fd_sc_hd__decap_6
X_4382_ _2136_ VGND VGND VPWR VPWR _0200_ sky130_fd_sc_hd__clkbuf_1
X_3333_ _1287_ VGND VGND VPWR VPWR _1288_ sky130_fd_sc_hd__buf_2
XFILLER_0_0_265 VPWR VGND VPWR VGND sky130_ef_sc_hd__decap_12
XFILLER_0_21_393 VPWR VGND VPWR VGND sky130_ef_sc_hd__decap_12
X_3264_ cpu_inst.regfile_inst.registers\[15\]\[15\] _1228_ _0721_ VGND VGND VPWR VPWR
+ _1229_ sky130_fd_sc_hd__mux2_1
XFILLER_0_56_41 VPWR VGND VPWR VGND sky130_ef_sc_hd__decap_12
XPHY_EDGE_ROW_7_Right_7 VGND VGND VPWR VPWR sky130_fd_sc_hd__decap_3
X_5003_ _2490_ VGND VGND VPWR VPWR _0467_ sky130_fd_sc_hd__clkbuf_1
X_3195_ _1016_ _1020_ _1158_ VGND VGND VPWR VPWR _1160_ sky130_fd_sc_hd__nand3_1
XFILLER_0_56_85 VPWR VGND VPWR VGND sky130_ef_sc_hd__decap_12
XFILLER_0_76_500 VGND VGND VPWR VPWR sky130_fd_sc_hd__fill_2
XTAP_TAPCELL_ROW_37_856 VGND VPWR sky130_fd_sc_hd__tapvpwrvgnd_1
XFILLER_0_49_714 VGND VGND VPWR VPWR sky130_fd_sc_hd__fill_2
XFILLER_0_9_833 VGND VGND VPWR VPWR sky130_fd_sc_hd__decap_6
XFILLER_0_8_321 VPWR VGND VPWR VGND sky130_ef_sc_hd__decap_12
XFILLER_0_36_419 VGND VGND VPWR VPWR sky130_fd_sc_hd__fill_1
XFILLER_0_63_205 VPWR VGND VPWR VGND sky130_ef_sc_hd__decap_12
XFILLER_0_57_780 VGND VGND VPWR VPWR sky130_fd_sc_hd__decap_4
XFILLER_0_118_189 VGND VGND VPWR VPWR sky130_fd_sc_hd__decap_6
XFILLER_0_106_307 VGND VGND VPWR VPWR sky130_fd_sc_hd__fill_1
XFILLER_0_63_249 VPWR VGND VPWR VGND sky130_ef_sc_hd__decap_12
XFILLER_0_8_365 VPWR VGND VPWR VGND sky130_ef_sc_hd__decap_12
XFILLER_0_16_121 VPWR VGND VPWR VGND sky130_ef_sc_hd__decap_12
X_2979_ _0863_ _0941_ _0943_ _0657_ VGND VGND VPWR VPWR _0944_ sky130_fd_sc_hd__o22a_1
XFILLER_0_133_137 VPWR VGND VPWR VGND sky130_ef_sc_hd__decap_12
XFILLER_0_115_841 VGND VGND VPWR VPWR sky130_fd_sc_hd__fill_1
X_4718_ cpu_inst.decoder_inst.current_pc\[18\] _2331_ VGND VGND VPWR VPWR _2335_ sky130_fd_sc_hd__nor2_1
XFILLER_0_16_165 VPWR VGND VPWR VGND sky130_ef_sc_hd__decap_12
XFILLER_0_130_811 VGND VGND VPWR VPWR sky130_fd_sc_hd__fill_1
X_4649_ _1644_ _1692_ _1760_ _1833_ VGND VGND VPWR VPWR _2282_ sky130_fd_sc_hd__or4_4
XFILLER_0_71_293 VPWR VGND VPWR VGND sky130_ef_sc_hd__decap_12
XFILLER_0_31_113 VPWR VGND VPWR VGND sky130_ef_sc_hd__decap_12
XTAP_TAPCELL_ROW_75_1419 VGND VPWR sky130_fd_sc_hd__tapvpwrvgnd_1
XFILLER_0_97_81 VPWR VGND VPWR VGND sky130_ef_sc_hd__decap_12
XFILLER_0_99_669 VGND VGND VPWR VPWR sky130_fd_sc_hd__decap_3
XFILLER_0_95_831 VGND VGND VPWR VPWR sky130_fd_sc_hd__decap_6
XFILLER_0_94_363 VGND VGND VPWR VPWR sky130_fd_sc_hd__fill_1
XTAP_TAPCELL_ROW_15_528 VGND VPWR sky130_fd_sc_hd__tapvpwrvgnd_1
XFILLER_0_39_279 VGND VGND VPWR VPWR sky130_fd_sc_hd__fill_1
XFILLER_0_109_167 VGND VGND VPWR VPWR sky130_fd_sc_hd__fill_1
XFILLER_0_106_841 VGND VGND VPWR VPWR sky130_fd_sc_hd__fill_1
XFILLER_0_133_671 VGND VGND VPWR VPWR sky130_fd_sc_hd__fill_1
XTAP_TAPCELL_ROW_117_2058 VGND VPWR sky130_fd_sc_hd__tapvpwrvgnd_1
XFILLER_0_121_833 VGND VGND VPWR VPWR sky130_fd_sc_hd__decap_4
XFILLER_0_120_321 VPWR VGND VPWR VGND sky130_ef_sc_hd__decap_12
XFILLER_0_105_373 VPWR VGND VPWR VGND sky130_ef_sc_hd__decap_12
XFILLER_0_11_809 VPWR VGND VPWR VGND sky130_ef_sc_hd__decap_12
XTAP_TAPCELL_ROW_130_2247 VGND VPWR sky130_fd_sc_hd__tapvpwrvgnd_1
XFILLER_0_120_365 VPWR VGND VPWR VGND sky130_ef_sc_hd__decap_12
XTAP_TAPCELL_ROW_112_1980 VGND VPWR sky130_fd_sc_hd__tapvpwrvgnd_1
XFILLER_0_93_39 VPWR VGND VPWR VGND sky130_ef_sc_hd__decap_12
XFILLER_0_89_113 VPWR VGND VPWR VGND sky130_ef_sc_hd__decap_12
XFILLER_0_117_57 VPWR VGND VPWR VGND sky130_ef_sc_hd__decap_12
XFILLER_0_26_77 VGND VGND VPWR VPWR sky130_fd_sc_hd__decap_6
X_3951_ _1875_ _1841_ _1317_ VGND VGND VPWR VPWR _1876_ sky130_fd_sc_hd__mux2_1
XFILLER_0_58_533 VGND VGND VPWR VPWR sky130_fd_sc_hd__decap_6
XTAP_TAPCELL_ROW_34_804 VGND VPWR sky130_fd_sc_hd__tapvpwrvgnd_1
XTAP_TAPCELL_ROW_34_815 VGND VPWR sky130_fd_sc_hd__tapvpwrvgnd_1
XFILLER_0_128_421 VPWR VGND VPWR VGND sky130_ef_sc_hd__decap_12
X_2902_ _0866_ VGND VGND VPWR VPWR _0867_ sky130_fd_sc_hd__clkbuf_4
X_3882_ _1739_ _1807_ _1808_ VGND VGND VPWR VPWR _1809_ sky130_fd_sc_hd__or3_1
XFILLER_0_18_419 VGND VGND VPWR VPWR sky130_fd_sc_hd__fill_1
XFILLER_0_39_780 VGND VGND VPWR VPWR sky130_fd_sc_hd__decap_4
XFILLER_0_42_65 VPWR VGND VPWR VGND sky130_ef_sc_hd__decap_12
XFILLER_0_45_205 VPWR VGND VPWR VGND sky130_ef_sc_hd__decap_12
XFILLER_0_6_825 VPWR VGND VPWR VGND sky130_ef_sc_hd__decap_12
XFILLER_0_45_249 VPWR VGND VPWR VGND sky130_ef_sc_hd__decap_12
X_2833_ cpu_inst.regfile_inst.registers\[2\]\[5\] _0593_ _0702_ cpu_inst.regfile_inst.registers\[7\]\[5\]
+ _0613_ VGND VGND VPWR VPWR _0798_ sky130_fd_sc_hd__o221a_1
XFILLER_0_115_137 VPWR VGND VPWR VGND sky130_ef_sc_hd__decap_12
X_5552_ clknet_leaf_9_clk _0472_ VGND VGND VPWR VPWR cpu_inst.regfile_inst.registers\[15\]\[24\]
+ sky130_fd_sc_hd__dfxtp_1
XFILLER_0_5_335 VGND VGND VPWR VPWR sky130_fd_sc_hd__fill_1
X_2764_ _0728_ VGND VGND VPWR VPWR _0729_ sky130_fd_sc_hd__clkbuf_8
XFILLER_0_112_811 VGND VGND VPWR VPWR sky130_fd_sc_hd__fill_1
XFILLER_0_53_293 VPWR VGND VPWR VGND sky130_ef_sc_hd__decap_12
XFILLER_0_13_113 VPWR VGND VPWR VGND sky130_ef_sc_hd__decap_12
XFILLER_0_14_625 VPWR VGND VPWR VGND sky130_ef_sc_hd__decap_12
X_4503_ _2199_ VGND VGND VPWR VPWR _0258_ sky130_fd_sc_hd__clkbuf_1
XFILLER_0_124_693 VGND VGND VPWR VPWR sky130_fd_sc_hd__decap_6
X_5483_ clknet_leaf_18_clk _0403_ VGND VGND VPWR VPWR cpu_inst.regfile_inst.registers\[9\]\[19\]
+ sky130_fd_sc_hd__dfxtp_1
XFILLER_0_14_669 VPWR VGND VPWR VGND sky130_ef_sc_hd__decap_12
X_2695_ _0659_ cpu_inst.regfile_inst.registers\[10\]\[1\] _0653_ VGND VGND VPWR VPWR
+ _0660_ sky130_fd_sc_hd__mux2_1
XFILLER_0_123_181 VPWR VGND VPWR VGND sky130_ef_sc_hd__decap_12
XTAP_TAPCELL_ROW_57_1149 VGND VPWR sky130_fd_sc_hd__tapvpwrvgnd_1
XFILLER_0_1_541 VPWR VGND VPWR VGND sky130_ef_sc_hd__decap_12
X_4434_ _2163_ VGND VGND VPWR VPWR _0225_ sky130_fd_sc_hd__clkbuf_1
XFILLER_0_6_65 VPWR VGND VPWR VGND sky130_ef_sc_hd__decap_12
XFILLER_0_1_585 VPWR VGND VPWR VGND sky130_ef_sc_hd__decap_12
X_4365_ cpu_inst.regfile_inst.registers\[1\]\[0\] VGND VGND VPWR VPWR _2128_ sky130_fd_sc_hd__clkbuf_1
X_3316_ _1265_ _1274_ _1275_ _1277_ VGND VGND VPWR VPWR net10 sky130_fd_sc_hd__o31ai_1
XFILLER_0_67_51 VGND VGND VPWR VPWR sky130_fd_sc_hd__decap_4
XTAP_TAPCELL_ROW_70_1349 VGND VPWR sky130_fd_sc_hd__tapvpwrvgnd_1
X_4296_ _1290_ _2090_ _1298_ VGND VGND VPWR VPWR _2091_ sky130_fd_sc_hd__or3_4
X_3247_ _1061_ _1066_ _1062_ VGND VGND VPWR VPWR _1212_ sky130_fd_sc_hd__mux2_1
X_3178_ _0770_ _1106_ _1142_ VGND VGND VPWR VPWR _1143_ sky130_fd_sc_hd__a21oi_1
Xrebuffer10 net22 VGND VGND VPWR VPWR net23 sky130_fd_sc_hd__dlygate4sd1_1
Xrebuffer21 _0558_ VGND VGND VPWR VPWR net34 sky130_fd_sc_hd__dlymetal6s2s_1
XFILLER_0_95_105 VGND VGND VPWR VPWR sky130_fd_sc_hd__decap_6
XFILLER_0_89_691 VPWR VGND VPWR VGND sky130_ef_sc_hd__decap_12
XFILLER_0_95_149 VPWR VGND VPWR VGND sky130_ef_sc_hd__decap_12
XTAP_TAPCELL_ROW_85_1581 VGND VPWR sky130_fd_sc_hd__tapvpwrvgnd_1
XTAP_TAPCELL_ROW_85_1570 VGND VPWR sky130_fd_sc_hd__tapvpwrvgnd_1
XFILLER_0_76_363 VGND VGND VPWR VPWR sky130_fd_sc_hd__fill_1
XFILLER_0_9_641 VPWR VGND VPWR VGND sky130_ef_sc_hd__decap_12
XFILLER_0_134_413 VGND VGND VPWR VPWR sky130_fd_sc_hd__decap_6
XFILLER_0_107_605 VGND VGND VPWR VPWR sky130_fd_sc_hd__decap_4
XFILLER_0_9_685 VPWR VGND VPWR VGND sky130_ef_sc_hd__decap_12
XFILLER_0_17_441 VGND VGND VPWR VPWR sky130_fd_sc_hd__decap_6
XFILLER_0_107_649 VGND VGND VPWR VPWR sky130_fd_sc_hd__decap_8
XFILLER_0_8_195 VGND VGND VPWR VPWR sky130_fd_sc_hd__fill_1
XFILLER_0_45_761 VGND VGND VPWR VPWR sky130_fd_sc_hd__decap_4
XFILLER_0_134_457 VPWR VGND VPWR VGND sky130_ef_sc_hd__decap_12
XFILLER_0_17_485 VPWR VGND VPWR VGND sky130_ef_sc_hd__decap_12
XFILLER_0_32_433 VPWR VGND VPWR VGND sky130_ef_sc_hd__decap_12
XFILLER_0_115_671 VGND VGND VPWR VPWR sky130_fd_sc_hd__fill_1
XFILLER_0_103_833 VGND VGND VPWR VPWR sky130_fd_sc_hd__decap_6
XFILLER_0_60_764 VGND VGND VPWR VPWR sky130_fd_sc_hd__decap_8
XTAP_TAPCELL_ROW_20_597 VGND VPWR sky130_fd_sc_hd__tapvpwrvgnd_1
XFILLER_0_102_321 VPWR VGND VPWR VGND sky130_ef_sc_hd__decap_12
XFILLER_0_102_365 VPWR VGND VPWR VGND sky130_ef_sc_hd__decap_12
XFILLER_0_99_422 VGND VGND VPWR VPWR sky130_fd_sc_hd__fill_1
XFILLER_0_68_831 VGND VGND VPWR VPWR sky130_fd_sc_hd__fill_1
XFILLER_0_67_330 VGND VGND VPWR VPWR sky130_fd_sc_hd__decap_6
XFILLER_0_138_741 VPWR VGND VPWR VGND sky130_ef_sc_hd__decap_12
XFILLER_0_103_15 VPWR VGND VPWR VGND sky130_ef_sc_hd__decap_12
XFILLER_0_83_823 VPWR VGND VPWR VGND sky130_ef_sc_hd__decap_12
XFILLER_0_67_374 VGND VGND VPWR VPWR sky130_fd_sc_hd__fill_2
XFILLER_0_27_205 VPWR VGND VPWR VGND sky130_ef_sc_hd__decap_12
XFILLER_0_138_785 VPWR VGND VPWR VGND sky130_ef_sc_hd__decap_12
XFILLER_0_137_273 VGND VGND VPWR VPWR sky130_fd_sc_hd__decap_6
XFILLER_0_82_333 VPWR VGND VPWR VGND sky130_ef_sc_hd__decap_12
XFILLER_0_27_249 VPWR VGND VPWR VGND sky130_ef_sc_hd__decap_12
XFILLER_0_35_293 VPWR VGND VPWR VGND sky130_ef_sc_hd__decap_12
XFILLER_0_3_839 VGND VGND VPWR VPWR sky130_fd_sc_hd__fill_1
XFILLER_0_121_641 VPWR VGND VPWR VGND sky130_ef_sc_hd__decap_12
XFILLER_0_105_181 VPWR VGND VPWR VGND sky130_ef_sc_hd__decap_12
XFILLER_0_11_617 VPWR VGND VPWR VGND sky130_ef_sc_hd__decap_12
XFILLER_0_121_685 VPWR VGND VPWR VGND sky130_ef_sc_hd__decap_12
XFILLER_0_120_195 VGND VGND VPWR VPWR sky130_fd_sc_hd__fill_1
X_4150_ _1760_ cpu_inst.regfile_inst.registers\[25\]\[26\] _2010_ VGND VGND VPWR VPWR
+ _2015_ sky130_fd_sc_hd__mux2_1
X_3101_ _1064_ _1065_ _1057_ VGND VGND VPWR VPWR _1066_ sky130_fd_sc_hd__mux2_1
X_4081_ _1976_ VGND VGND VPWR VPWR _0059_ sky130_fd_sc_hd__clkbuf_1
XTAP_TAPCELL_ROW_52_1079 VGND VPWR sky130_fd_sc_hd__tapvpwrvgnd_1
X_3032_ _0995_ _0996_ _0883_ VGND VGND VPWR VPWR _0997_ sky130_fd_sc_hd__mux2_1
XFILLER_0_77_105 VGND VGND VPWR VPWR sky130_fd_sc_hd__decap_6
XFILLER_0_77_149 VPWR VGND VPWR VGND sky130_ef_sc_hd__decap_12
X_4983_ _2468_ VGND VGND VPWR VPWR _2480_ sky130_fd_sc_hd__buf_2
XFILLER_0_129_741 VPWR VGND VPWR VGND sky130_ef_sc_hd__decap_12
X_3934_ _1819_ _1826_ _1857_ VGND VGND VPWR VPWR _1860_ sky130_fd_sc_hd__and3_1
XFILLER_0_129_785 VPWR VGND VPWR VGND sky130_ef_sc_hd__decap_12
XFILLER_0_128_251 VGND VGND VPWR VPWR sky130_fd_sc_hd__fill_1
XFILLER_0_116_413 VGND VGND VPWR VPWR sky130_fd_sc_hd__decap_6
X_3865_ _1792_ cpu_inst.regfile_inst.registers\[6\]\[27\] _1609_ VGND VGND VPWR VPWR
+ _1793_ sky130_fd_sc_hd__mux2_1
XFILLER_0_85_193 VPWR VGND VPWR VGND sky130_ef_sc_hd__decap_12
XFILLER_0_61_528 VGND VGND VPWR VPWR sky130_fd_sc_hd__fill_1
X_2816_ cpu_inst.regfile_inst.registers\[24\]\[4\] _0640_ VGND VGND VPWR VPWR _0781_
+ sky130_fd_sc_hd__or2_1
XFILLER_0_131_405 VPWR VGND VPWR VGND sky130_ef_sc_hd__decap_12
XFILLER_0_116_457 VPWR VGND VPWR VGND sky130_ef_sc_hd__decap_12
X_3796_ _0684_ _1705_ _1722_ _1725_ VGND VGND VPWR VPWR _1726_ sky130_fd_sc_hd__a22o_1
XFILLER_0_73_399 VGND VGND VPWR VPWR sky130_fd_sc_hd__fill_1
XFILLER_0_27_783 VGND VGND VPWR VPWR sky130_fd_sc_hd__fill_1
XFILLER_0_14_433 VPWR VGND VPWR VGND sky130_ef_sc_hd__decap_12
XFILLER_0_6_699 VGND VGND VPWR VPWR sky130_fd_sc_hd__fill_1
X_2747_ cpu_inst.regfile_inst.registers\[8\]\[10\] _0598_ VGND VGND VPWR VPWR _0712_
+ sky130_fd_sc_hd__or2_1
X_5535_ clknet_leaf_36_clk _0455_ VGND VGND VPWR VPWR cpu_inst.regfile_inst.registers\[15\]\[7\]
+ sky130_fd_sc_hd__dfxtp_1
XFILLER_0_131_449 VPWR VGND VPWR VGND sky130_ef_sc_hd__decap_12
XFILLER_0_75_3 VPWR VGND VPWR VGND sky130_ef_sc_hd__decap_12
XFILLER_0_14_477 VPWR VGND VPWR VGND sky130_ef_sc_hd__decap_12
X_5466_ clknet_leaf_41_clk _0386_ VGND VGND VPWR VPWR cpu_inst.regfile_inst.registers\[9\]\[2\]
+ sky130_fd_sc_hd__dfxtp_1
X_2678_ _0642_ _0546_ VGND VGND VPWR VPWR _0643_ sky130_fd_sc_hd__and2_1
X_4417_ cpu_inst.regfile_inst.registers\[1\]\[26\] VGND VGND VPWR VPWR _2154_ sky130_fd_sc_hd__clkbuf_1
XFILLER_0_100_825 VPWR VGND VPWR VGND sky130_ef_sc_hd__decap_12
XFILLER_0_78_83 VGND VGND VPWR VPWR sky130_fd_sc_hd__fill_1
X_5397_ clknet_leaf_3_clk _0317_ VGND VGND VPWR VPWR cpu_inst.regfile_inst.registers\[10\]\[29\]
+ sky130_fd_sc_hd__dfxtp_1
XFILLER_0_1_393 VPWR VGND VPWR VGND sky130_ef_sc_hd__decap_12
X_4348_ _2119_ VGND VGND VPWR VPWR _0183_ sky130_fd_sc_hd__clkbuf_1
X_4279_ cpu_inst.regfile_inst.registers\[24\]\[24\] VGND VGND VPWR VPWR _2082_ sky130_fd_sc_hd__clkbuf_1
XTAP_TAPCELL_ROW_87_1610 VGND VPWR sky130_fd_sc_hd__tapvpwrvgnd_1
XFILLER_0_49_385 VGND VGND VPWR VPWR sky130_fd_sc_hd__decap_6
XTAP_TAPCELL_ROW_25_678 VGND VPWR sky130_fd_sc_hd__tapvpwrvgnd_1
XFILLER_0_134_221 VPWR VGND VPWR VGND sky130_ef_sc_hd__decap_12
XFILLER_0_119_273 VGND VGND VPWR VPWR sky130_fd_sc_hd__decap_6
XFILLER_0_25_709 VPWR VGND VPWR VGND sky130_ef_sc_hd__decap_12
XFILLER_0_37_569 VGND VGND VPWR VPWR sky130_fd_sc_hd__fill_1
XFILLER_0_135_777 VGND VGND VPWR VPWR sky130_fd_sc_hd__decap_6
XFILLER_0_134_265 VPWR VGND VPWR VGND sky130_ef_sc_hd__decap_12
XTAP_TAPCELL_ROW_114_2017 VGND VPWR sky130_fd_sc_hd__tapvpwrvgnd_1
XTAP_TAPCELL_ROW_114_2006 VGND VPWR sky130_fd_sc_hd__tapvpwrvgnd_1
XTAP_TAPCELL_ROW_98_1772 VGND VPWR sky130_fd_sc_hd__tapvpwrvgnd_1
XFILLER_0_17_293 VPWR VGND VPWR VGND sky130_ef_sc_hd__decap_12
XFILLER_0_33_753 VPWR VGND VPWR VGND sky130_ef_sc_hd__decap_12
XFILLER_0_60_561 VPWR VGND VPWR VGND sky130_ef_sc_hd__decap_12
XFILLER_0_0_809 VGND VGND VPWR VPWR sky130_fd_sc_hd__decap_3
XFILLER_0_33_797 VGND VGND VPWR VPWR sky130_fd_sc_hd__fill_1
XFILLER_0_102_195 VGND VGND VPWR VPWR sky130_fd_sc_hd__fill_1
XFILLER_0_20_469 VGND VGND VPWR VPWR sky130_fd_sc_hd__decap_6
XTAP_TAPCELL_ROW_5_381 VGND VPWR sky130_fd_sc_hd__tapvpwrvgnd_1
XTAP_TAPCELL_ROW_5_370 VGND VPWR sky130_fd_sc_hd__tapvpwrvgnd_1
XTAP_TAPCELL_ROW_125_2168 VGND VPWR sky130_fd_sc_hd__tapvpwrvgnd_1
XTAP_TAPCELL_ROW_125_2179 VGND VPWR sky130_fd_sc_hd__tapvpwrvgnd_1
XFILLER_0_59_105 VGND VGND VPWR VPWR sky130_fd_sc_hd__decap_6
XFILLER_0_90_29 VPWR VGND VPWR VGND sky130_ef_sc_hd__decap_12
XFILLER_0_59_149 VPWR VGND VPWR VGND sky130_ef_sc_hd__decap_12
XFILLER_0_28_514 VGND VGND VPWR VPWR sky130_fd_sc_hd__decap_3
XTAP_TAPCELL_ROW_44_954 VGND VPWR sky130_fd_sc_hd__tapvpwrvgnd_1
XTAP_TAPCELL_ROW_44_965 VGND VPWR sky130_fd_sc_hd__tapvpwrvgnd_1
XFILLER_0_67_193 VPWR VGND VPWR VGND sky130_ef_sc_hd__decap_12
XFILLER_0_55_333 VGND VGND VPWR VPWR sky130_fd_sc_hd__decap_3
XFILLER_0_99_27 VPWR VGND VPWR VGND sky130_ef_sc_hd__decap_12
XFILLER_0_83_664 VGND VGND VPWR VPWR sky130_fd_sc_hd__fill_2
XFILLER_0_82_141 VPWR VGND VPWR VGND sky130_ef_sc_hd__decap_12
XFILLER_0_55_377 VGND VGND VPWR VPWR sky130_fd_sc_hd__decap_4
XFILLER_0_126_755 VGND VGND VPWR VPWR sky130_fd_sc_hd__fill_1
XFILLER_0_113_405 VPWR VGND VPWR VGND sky130_ef_sc_hd__decap_12
X_3650_ _1536_ _1580_ _1582_ _1314_ VGND VGND VPWR VPWR _1583_ sky130_fd_sc_hd__o22a_1
X_3581_ _0735_ _1514_ _1515_ _0721_ VGND VGND VPWR VPWR _1516_ sky130_fd_sc_hd__o211a_1
Xrebuffer1 _0740_ VGND VGND VPWR VPWR net14 sky130_fd_sc_hd__dlygate4sd1_1
X_2601_ _0563_ _0564_ net40 _0548_ _0565_ VGND VGND VPWR VPWR _0566_ sky130_fd_sc_hd__o2111ai_4
XFILLER_0_113_449 VPWR VGND VPWR VGND sky130_ef_sc_hd__decap_12
X_5320_ clknet_leaf_22_clk _0240_ VGND VGND VPWR VPWR cpu_inst.regfile_inst.registers\[7\]\[16\]
+ sky130_fd_sc_hd__dfxtp_1
XTAP_TAPCELL_ROW_54_1108 VGND VPWR sky130_fd_sc_hd__tapvpwrvgnd_1
XFILLER_0_11_447 VGND VGND VPWR VPWR sky130_fd_sc_hd__fill_1
X_5251_ clknet_leaf_28_clk _0171_ VGND VGND VPWR VPWR cpu_inst.regfile_inst.registers\[5\]\[11\]
+ sky130_fd_sc_hd__dfxtp_1
X_4202_ cpu_inst.regfile_inst.registers\[4\]\[18\] _2035_ VGND VGND VPWR VPWR _2043_
+ sky130_fd_sc_hd__and2_1
X_5182_ clknet_leaf_33_clk _0102_ VGND VGND VPWR VPWR cpu_inst.regfile_inst.registers\[4\]\[6\]
+ sky130_fd_sc_hd__dfxtp_1
XFILLER_0_48_53 VPWR VGND VPWR VGND sky130_ef_sc_hd__decap_12
X_4133_ _1456_ cpu_inst.regfile_inst.registers\[25\]\[18\] _1998_ VGND VGND VPWR VPWR
+ _2006_ sky130_fd_sc_hd__mux2_1
XFILLER_0_48_97 VPWR VGND VPWR VGND sky130_ef_sc_hd__decap_12
X_4064_ cpu_inst.regfile_inst.registers\[2\]\[19\] VGND VGND VPWR VPWR _1968_ sky130_fd_sc_hd__clkbuf_1
XFILLER_0_3_55 VGND VGND VPWR VPWR sky130_fd_sc_hd__fill_1
XTAP_TAPCELL_ROW_69_1340 VGND VPWR sky130_fd_sc_hd__tapvpwrvgnd_1
XFILLER_0_64_41 VPWR VGND VPWR VGND sky130_ef_sc_hd__decap_12
X_3015_ cpu_inst.regfile_inst.registers\[7\]\[8\] cpu_inst.regfile_inst.registers\[6\]\[8\]
+ _0865_ VGND VGND VPWR VPWR _0980_ sky130_fd_sc_hd__mux2_1
XFILLER_0_64_85 VPWR VGND VPWR VGND sky130_ef_sc_hd__decap_12
XFILLER_0_93_439 VGND VGND VPWR VPWR sky130_fd_sc_hd__decap_3
XFILLER_0_93_406 VGND VGND VPWR VPWR sky130_fd_sc_hd__decap_4
XFILLER_0_19_503 VGND VGND VPWR VPWR sky130_fd_sc_hd__fill_1
XFILLER_0_47_823 VPWR VGND VPWR VGND sky130_ef_sc_hd__decap_12
XTAP_TAPCELL_ROW_22_626 VGND VPWR sky130_fd_sc_hd__tapvpwrvgnd_1
XFILLER_0_46_333 VPWR VGND VPWR VGND sky130_ef_sc_hd__decap_12
X_4966_ _2471_ VGND VGND VPWR VPWR _0449_ sky130_fd_sc_hd__clkbuf_1
XFILLER_0_116_221 VPWR VGND VPWR VGND sky130_ef_sc_hd__decap_12
X_3917_ cpu_inst.regfile_inst.registers\[11\]\[29\] cpu_inst.regfile_inst.registers\[10\]\[29\]
+ _1592_ VGND VGND VPWR VPWR _1843_ sky130_fd_sc_hd__mux2_1
XTAP_TAPCELL_ROW_22_637 VGND VPWR sky130_fd_sc_hd__tapvpwrvgnd_1
XFILLER_0_34_517 VGND VGND VPWR VPWR sky130_fd_sc_hd__fill_1
X_4897_ _2434_ VGND VGND VPWR VPWR _0417_ sky130_fd_sc_hd__clkbuf_1
XFILLER_0_46_377 VPWR VGND VPWR VGND sky130_ef_sc_hd__decap_12
XFILLER_0_117_777 VGND VGND VPWR VPWR sky130_fd_sc_hd__decap_6
X_3848_ cpu_inst.regfile_inst.registers\[15\]\[27\] _1775_ _1555_ VGND VGND VPWR VPWR
+ _1776_ sky130_fd_sc_hd__mux2_1
XFILLER_0_74_697 VGND VGND VPWR VPWR sky130_fd_sc_hd__decap_3
XFILLER_0_132_725 VPWR VGND VPWR VGND sky130_ef_sc_hd__decap_12
XFILLER_0_116_265 VPWR VGND VPWR VGND sky130_ef_sc_hd__decap_12
X_3779_ _1028_ VGND VGND VPWR VPWR _1709_ sky130_fd_sc_hd__clkbuf_4
XFILLER_0_61_369 VGND VGND VPWR VPWR sky130_fd_sc_hd__fill_1
XFILLER_0_15_753 VPWR VGND VPWR VGND sky130_ef_sc_hd__decap_12
XFILLER_0_132_769 VPWR VGND VPWR VGND sky130_ef_sc_hd__decap_12
X_5518_ clknet_leaf_13_clk _0438_ VGND VGND VPWR VPWR cpu_inst.regfile_inst.registers\[8\]\[22\]
+ sky130_fd_sc_hd__dfxtp_1
XFILLER_0_89_93 VPWR VGND VPWR VGND sky130_ef_sc_hd__decap_12
XFILLER_0_15_797 VPWR VGND VPWR VGND sky130_ef_sc_hd__decap_12
XFILLER_0_131_279 VGND VGND VPWR VPWR sky130_fd_sc_hd__fill_1
XFILLER_0_100_633 VGND VGND VPWR VPWR sky130_fd_sc_hd__fill_1
X_5449_ clknet_leaf_25_clk _0369_ VGND VGND VPWR VPWR cpu_inst.regfile_inst.registers\[0\]\[17\]
+ sky130_fd_sc_hd__dfxtp_1
XTAP_TAPCELL_ROW_93_1691 VGND VPWR sky130_fd_sc_hd__tapvpwrvgnd_1
XFILLER_0_97_712 VGND VGND VPWR VPWR sky130_fd_sc_hd__decap_4
XFILLER_0_96_233 VPWR VGND VPWR VGND sky130_ef_sc_hd__decap_12
XFILLER_0_69_458 VPWR VGND VPWR VGND sky130_ef_sc_hd__decap_12
XFILLER_0_96_277 VPWR VGND VPWR VGND sky130_ef_sc_hd__decap_12
XTAP_TAPCELL_ROW_120_2098 VGND VPWR sky130_fd_sc_hd__tapvpwrvgnd_1
XFILLER_0_77_480 VGND VGND VPWR VPWR sky130_fd_sc_hd__decap_3
XTAP_TAPCELL_ROW_41_913 VGND VPWR sky130_fd_sc_hd__tapvpwrvgnd_1
XFILLER_0_49_193 VPWR VGND VPWR VGND sky130_ef_sc_hd__decap_12
XFILLER_0_65_664 VGND VGND VPWR VPWR sky130_fd_sc_hd__decap_8
XFILLER_0_64_141 VPWR VGND VPWR VGND sky130_ef_sc_hd__decap_12
XFILLER_0_25_517 VGND VGND VPWR VPWR sky130_fd_sc_hd__decap_8
XFILLER_0_135_541 VPWR VGND VPWR VGND sky130_ef_sc_hd__decap_12
XFILLER_0_108_755 VGND VGND VPWR VPWR sky130_fd_sc_hd__fill_1
XFILLER_0_135_585 VPWR VGND VPWR VGND sky130_ef_sc_hd__decap_12
XFILLER_0_69_19 VPWR VGND VPWR VGND sky130_ef_sc_hd__decap_12
XFILLER_0_100_27 VGND VGND VPWR VPWR sky130_fd_sc_hd__fill_1
XFILLER_0_33_561 VPWR VGND VPWR VGND sky130_ef_sc_hd__decap_12
XFILLER_0_110_419 VGND VGND VPWR VPWR sky130_fd_sc_hd__fill_1
XFILLER_0_60_391 VGND VGND VPWR VPWR sky130_fd_sc_hd__decap_4
XFILLER_0_0_617 VPWR VGND VPWR VGND sky130_ef_sc_hd__decap_12
XFILLER_0_20_233 VPWR VGND VPWR VGND sky130_ef_sc_hd__decap_12
XFILLER_0_20_277 VPWR VGND VPWR VGND sky130_ef_sc_hd__decap_12
XTAP_TAPCELL_ROW_127_2208 VGND VPWR sky130_fd_sc_hd__tapvpwrvgnd_1
XFILLER_0_109_69 VPWR VGND VPWR VGND sky130_ef_sc_hd__decap_12
XTAP_TAPCELL_ROW_109_1941 VGND VPWR sky130_fd_sc_hd__tapvpwrvgnd_1
XTAP_TAPCELL_ROW_109_1930 VGND VPWR sky130_fd_sc_hd__tapvpwrvgnd_1
XFILLER_0_88_734 VGND VGND VPWR VPWR sky130_fd_sc_hd__fill_1
XFILLER_0_125_57 VPWR VGND VPWR VGND sky130_ef_sc_hd__decap_12
X_4820_ cpu_inst.regfile_inst.registers\[0\]\[28\] VGND VGND VPWR VPWR _2395_ sky130_fd_sc_hd__clkbuf_1
XFILLER_0_34_77 VGND VGND VPWR VPWR sky130_fd_sc_hd__decap_6
XFILLER_0_133_3 VPWR VGND VPWR VGND sky130_ef_sc_hd__decap_12
XFILLER_0_56_642 VGND VGND VPWR VPWR sky130_fd_sc_hd__fill_2
XFILLER_0_7_205 VPWR VGND VPWR VGND sky130_ef_sc_hd__decap_12
XFILLER_0_28_333 VPWR VGND VPWR VGND sky130_ef_sc_hd__decap_12
X_4751_ _2293_ _2358_ cpu_inst.decoder_inst.current_pc\[27\] _2289_ VGND VGND VPWR
+ VPWR _0347_ sky130_fd_sc_hd__o2bb2a_1
X_3702_ _1611_ _1601_ _1633_ VGND VGND VPWR VPWR _1634_ sky130_fd_sc_hd__and3_1
XFILLER_0_83_483 VPWR VGND VPWR VGND sky130_ef_sc_hd__decap_12
X_4682_ cpu_inst.decoder_inst.current_pc\[8\] _2303_ VGND VGND VPWR VPWR _2308_ sky130_fd_sc_hd__and2_1
XFILLER_0_7_249 VPWR VGND VPWR VGND sky130_ef_sc_hd__decap_12
XFILLER_0_28_377 VPWR VGND VPWR VGND sky130_ef_sc_hd__decap_12
XFILLER_0_50_65 VPWR VGND VPWR VGND sky130_ef_sc_hd__decap_12
XFILLER_0_114_725 VPWR VGND VPWR VGND sky130_ef_sc_hd__decap_12
X_3633_ _1551_ _1566_ VGND VGND VPWR VPWR _1567_ sky130_fd_sc_hd__xnor2_1
XFILLER_0_70_133 VGND VGND VPWR VPWR sky130_fd_sc_hd__decap_6
XFILLER_0_114_769 VPWR VGND VPWR VGND sky130_ef_sc_hd__decap_12
XFILLER_0_70_177 VPWR VGND VPWR VGND sky130_ef_sc_hd__decap_12
XFILLER_0_12_701 VPWR VGND VPWR VGND sky130_ef_sc_hd__decap_12
XFILLER_0_113_279 VGND VGND VPWR VPWR sky130_fd_sc_hd__fill_1
X_3564_ _1498_ cpu_inst.regfile_inst.registers\[10\]\[20\] _1351_ VGND VGND VPWR VPWR
+ _1499_ sky130_fd_sc_hd__mux2_1
X_3495_ cpu_inst.regfile_inst.registers\[8\]\[18\] _1431_ _0642_ VGND VGND VPWR VPWR
+ _1432_ sky130_fd_sc_hd__mux2_1
X_5303_ clknet_leaf_2_clk _0223_ VGND VGND VPWR VPWR cpu_inst.regfile_inst.registers\[1\]\[31\]
+ sky130_fd_sc_hd__dfxtp_1
X_5234_ clknet_leaf_10_clk _0154_ VGND VGND VPWR VPWR cpu_inst.regfile_inst.registers\[24\]\[26\]
+ sky130_fd_sc_hd__dfxtp_1
X_5165_ clknet_leaf_13_clk _0085_ VGND VGND VPWR VPWR cpu_inst.regfile_inst.registers\[25\]\[21\]
+ sky130_fd_sc_hd__dfxtp_1
XFILLER_0_75_51 VGND VGND VPWR VPWR sky130_fd_sc_hd__decap_4
X_4116_ _1164_ cpu_inst.regfile_inst.registers\[25\]\[10\] _1982_ VGND VGND VPWR VPWR
+ _1997_ sky130_fd_sc_hd__mux2_1
XFILLER_0_38_3 VPWR VGND VPWR VGND sky130_ef_sc_hd__decap_12
X_5096_ clknet_leaf_23_clk _0016_ VGND VGND VPWR VPWR cpu_inst.regfile_inst.registers\[6\]\[16\]
+ sky130_fd_sc_hd__dfxtp_1
XTAP_TAPCELL_ROW_27_707 VGND VPWR sky130_fd_sc_hd__tapvpwrvgnd_1
X_4047_ _1959_ VGND VGND VPWR VPWR _0042_ sky130_fd_sc_hd__clkbuf_1
XFILLER_0_79_778 VGND VGND VPWR VPWR sky130_fd_sc_hd__decap_3
XFILLER_0_79_756 VGND VGND VPWR VPWR sky130_fd_sc_hd__decap_8
XFILLER_0_78_233 VPWR VGND VPWR VGND sky130_ef_sc_hd__decap_12
XFILLER_0_78_277 VPWR VGND VPWR VGND sky130_ef_sc_hd__decap_12
XFILLER_0_137_839 VGND VGND VPWR VPWR sky130_fd_sc_hd__fill_1
XFILLER_0_93_225 VPWR VGND VPWR VGND sky130_ef_sc_hd__decap_12
X_4949_ _1945_ cpu_inst.regfile_inst.registers\[8\]\[26\] _2436_ VGND VGND VPWR VPWR
+ _2462_ sky130_fd_sc_hd__mux2_1
XFILLER_0_62_601 VGND VGND VPWR VPWR sky130_fd_sc_hd__decap_6
XFILLER_0_46_141 VPWR VGND VPWR VGND sky130_ef_sc_hd__decap_12
XFILLER_0_117_541 VPWR VGND VPWR VGND sky130_ef_sc_hd__decap_12
XFILLER_0_74_483 VGND VGND VPWR VPWR sky130_fd_sc_hd__fill_1
XFILLER_0_61_111 VGND VGND VPWR VPWR sky130_fd_sc_hd__fill_1
XFILLER_0_117_585 VPWR VGND VPWR VGND sky130_ef_sc_hd__decap_12
XFILLER_0_7_783 VGND VGND VPWR VPWR sky130_fd_sc_hd__fill_1
XFILLER_0_132_533 VPWR VGND VPWR VGND sky130_ef_sc_hd__decap_12
XTAP_TAPCELL_ROW_95_1731 VGND VPWR sky130_fd_sc_hd__tapvpwrvgnd_1
XTAP_TAPCELL_ROW_95_1720 VGND VPWR sky130_fd_sc_hd__tapvpwrvgnd_1
XFILLER_0_15_561 VPWR VGND VPWR VGND sky130_ef_sc_hd__decap_12
XFILLER_0_30_531 VGND VGND VPWR VPWR sky130_fd_sc_hd__fill_1
XFILLER_0_30_564 VGND VGND VPWR VPWR sky130_fd_sc_hd__fill_1
XTAP_TAPCELL_ROW_7_410 VGND VPWR sky130_fd_sc_hd__tapvpwrvgnd_1
XTAP_TAPCELL_ROW_122_2127 VGND VPWR sky130_fd_sc_hd__tapvpwrvgnd_1
XFILLER_0_57_428 VPWR VGND VPWR VGND sky130_ef_sc_hd__decap_12
XFILLER_0_127_305 VPWR VGND VPWR VGND sky130_ef_sc_hd__decap_12
XTAP_TAPCELL_ROW_104_1860 VGND VPWR sky130_fd_sc_hd__tapvpwrvgnd_1
XFILLER_0_38_620 VGND VGND VPWR VPWR sky130_fd_sc_hd__decap_4
XFILLER_0_53_601 VPWR VGND VPWR VGND sky130_ef_sc_hd__decap_12
XFILLER_0_38_664 VGND VGND VPWR VPWR sky130_fd_sc_hd__decap_8
XFILLER_0_127_349 VPWR VGND VPWR VGND sky130_ef_sc_hd__decap_12
XFILLER_0_5_709 VPWR VGND VPWR VGND sky130_ef_sc_hd__decap_12
XFILLER_0_111_15 VPWR VGND VPWR VGND sky130_ef_sc_hd__decap_12
XFILLER_0_53_656 VGND VGND VPWR VPWR sky130_fd_sc_hd__fill_1
XTAP_TAPCELL_ROW_13_489 VGND VPWR sky130_fd_sc_hd__tapvpwrvgnd_1
XFILLER_0_52_133 VGND VGND VPWR VPWR sky130_fd_sc_hd__decap_6
XFILLER_0_135_393 VPWR VGND VPWR VGND sky130_ef_sc_hd__decap_12
XFILLER_0_52_177 VPWR VGND VPWR VGND sky130_ef_sc_hd__decap_12
XFILLER_0_33_391 VGND VGND VPWR VPWR sky130_fd_sc_hd__fill_1
XTAP_TAPCELL_ROW_133_2289 VGND VPWR sky130_fd_sc_hd__tapvpwrvgnd_1
XFILLER_0_21_553 VGND VGND VPWR VPWR sky130_fd_sc_hd__decap_6
X_3280_ cpu_inst.regfile_inst.registers\[25\]\[15\] _0692_ _0694_ _1244_ VGND VGND
+ VPWR VPWR _1245_ sky130_fd_sc_hd__o211a_1
XFILLER_0_21_597 VPWR VGND VPWR VGND sky130_ef_sc_hd__decap_12
XFILLER_0_29_55 VGND VGND VPWR VPWR sky130_fd_sc_hd__fill_1
XFILLER_0_88_520 VPWR VGND VPWR VGND sky130_ef_sc_hd__decap_12
XTAP_TAPCELL_ROW_49_1029 VGND VPWR sky130_fd_sc_hd__tapvpwrvgnd_1
XFILLER_0_88_575 VGND VGND VPWR VPWR sky130_fd_sc_hd__decap_4
XFILLER_0_75_225 VPWR VGND VPWR VGND sky130_ef_sc_hd__decap_12
XFILLER_0_119_839 VGND VGND VPWR VPWR sky130_fd_sc_hd__fill_1
X_4803_ _2386_ VGND VGND VPWR VPWR _0371_ sky130_fd_sc_hd__clkbuf_1
XTAP_TAPCELL_ROW_62_1229 VGND VPWR sky130_fd_sc_hd__tapvpwrvgnd_1
XFILLER_0_8_525 VGND VGND VPWR VPWR sky130_fd_sc_hd__decap_6
XFILLER_0_28_141 VPWR VGND VPWR VGND sky130_ef_sc_hd__decap_12
X_4734_ cpu_inst.decoder_inst.current_pc\[23\] _2342_ VGND VGND VPWR VPWR _2346_ sky130_fd_sc_hd__nor2_1
X_2995_ _0952_ _0959_ _0948_ VGND VGND VPWR VPWR _0960_ sky130_fd_sc_hd__o21a_1
XFILLER_0_8_569 VPWR VGND VPWR VGND sky130_ef_sc_hd__decap_12
XFILLER_0_29_686 VPWR VGND VPWR VGND sky130_ef_sc_hd__decap_12
XTAP_TAPCELL_ROW_32_776 VGND VPWR sky130_fd_sc_hd__tapvpwrvgnd_1
XTAP_TAPCELL_ROW_32_787 VGND VPWR sky130_fd_sc_hd__tapvpwrvgnd_1
XFILLER_0_43_111 VGND VGND VPWR VPWR sky130_fd_sc_hd__fill_1
XFILLER_0_44_645 VGND VGND VPWR VPWR sky130_fd_sc_hd__decap_4
XFILLER_0_114_533 VPWR VGND VPWR VGND sky130_ef_sc_hd__decap_12
XFILLER_0_71_486 VGND VGND VPWR VPWR sky130_fd_sc_hd__decap_3
X_4665_ _0525_ _0539_ _2294_ _2295_ VGND VGND VPWR VPWR _2296_ sky130_fd_sc_hd__a211o_1
XFILLER_0_31_317 VPWR VGND VPWR VGND sky130_ef_sc_hd__decap_12
X_3616_ cpu_inst.regfile_inst.registers\[24\]\[20\] _1384_ _0961_ _1519_ VGND VGND
+ VPWR VPWR _1550_ sky130_fd_sc_hd__o211a_1
XTAP_TAPCELL_ROW_77_1450 VGND VPWR sky130_fd_sc_hd__tapvpwrvgnd_1
X_4596_ _2246_ VGND VGND VPWR VPWR _0304_ sky130_fd_sc_hd__clkbuf_1
XFILLER_0_12_531 VGND VGND VPWR VPWR sky130_fd_sc_hd__fill_1
XFILLER_0_101_205 VPWR VGND VPWR VGND sky130_ef_sc_hd__decap_12
XFILLER_0_101_81 VPWR VGND VPWR VGND sky130_ef_sc_hd__decap_12
X_3547_ _1465_ _1481_ VGND VGND VPWR VPWR _1483_ sky130_fd_sc_hd__nand2_1
XTAP_TAPCELL_ROW_77_1461 VGND VPWR sky130_fd_sc_hd__tapvpwrvgnd_1
XFILLER_0_101_249 VPWR VGND VPWR VGND sky130_ef_sc_hd__decap_12
XTAP_TAPCELL_ROW_90_1650 VGND VPWR sky130_fd_sc_hd__tapvpwrvgnd_1
XFILLER_0_86_83 VGND VGND VPWR VPWR sky130_fd_sc_hd__fill_1
X_3478_ _0912_ _1072_ VGND VGND VPWR VPWR _1416_ sky130_fd_sc_hd__nor2_1
X_5217_ clknet_leaf_35_clk _0137_ VGND VGND VPWR VPWR cpu_inst.regfile_inst.registers\[24\]\[9\]
+ sky130_fd_sc_hd__dfxtp_1
X_5148_ clknet_leaf_36_clk _0068_ VGND VGND VPWR VPWR cpu_inst.regfile_inst.registers\[25\]\[4\]
+ sky130_fd_sc_hd__dfxtp_1
X_5079_ clknet_leaf_5_clk net1 net2 VGND VGND VPWR VPWR edge_det.signal_reg sky130_fd_sc_hd__dfrtp_1
XFILLER_0_79_542 VGND VGND VPWR VPWR sky130_fd_sc_hd__decap_8
XFILLER_0_39_417 VGND VGND VPWR VPWR sky130_fd_sc_hd__decap_6
XFILLER_0_109_305 VPWR VGND VPWR VGND sky130_ef_sc_hd__decap_12
XFILLER_0_94_523 VGND VGND VPWR VPWR sky130_fd_sc_hd__decap_8
XFILLER_0_67_748 VGND VGND VPWR VPWR sky130_fd_sc_hd__decap_8
XFILLER_0_125_809 VPWR VGND VPWR VGND sky130_ef_sc_hd__decap_12
XFILLER_0_109_349 VPWR VGND VPWR VGND sky130_ef_sc_hd__decap_12
XFILLER_0_81_217 VGND VGND VPWR VPWR sky130_fd_sc_hd__decap_6
XFILLER_0_34_133 VGND VGND VPWR VPWR sky130_fd_sc_hd__decap_6
XFILLER_0_117_393 VPWR VGND VPWR VGND sky130_ef_sc_hd__decap_12
XFILLER_0_62_475 VGND VGND VPWR VPWR sky130_fd_sc_hd__fill_1
XTAP_TAPCELL_ROW_10_448 VGND VPWR sky130_fd_sc_hd__tapvpwrvgnd_1
XFILLER_0_34_177 VPWR VGND VPWR VGND sky130_ef_sc_hd__decap_12
XFILLER_0_35_689 VGND VGND VPWR VPWR sky130_fd_sc_hd__decap_8
XFILLER_0_132_363 VGND VGND VPWR VPWR sky130_fd_sc_hd__fill_1
XFILLER_0_120_525 VGND VGND VPWR VPWR sky130_fd_sc_hd__decap_6
XFILLER_0_15_391 VGND VGND VPWR VPWR sky130_fd_sc_hd__fill_1
XFILLER_0_120_569 VPWR VGND VPWR VGND sky130_ef_sc_hd__decap_12
XFILLER_0_101_783 VGND VGND VPWR VPWR sky130_fd_sc_hd__fill_1
XFILLER_0_89_317 VPWR VGND VPWR VGND sky130_ef_sc_hd__decap_12
XFILLER_0_106_15 VPWR VGND VPWR VGND sky130_ef_sc_hd__decap_12
XFILLER_0_97_361 VPWR VGND VPWR VGND sky130_ef_sc_hd__decap_12
XFILLER_0_15_57 VPWR VGND VPWR VGND sky130_ef_sc_hd__decap_12
XFILLER_0_57_225 VPWR VGND VPWR VGND sky130_ef_sc_hd__decap_12
XFILLER_0_128_625 VPWR VGND VPWR VGND sky130_ef_sc_hd__decap_12
XFILLER_0_127_113 VPWR VGND VPWR VGND sky130_ef_sc_hd__decap_12
XFILLER_0_45_409 VGND VGND VPWR VPWR sky130_fd_sc_hd__fill_1
XFILLER_0_128_669 VPWR VGND VPWR VGND sky130_ef_sc_hd__decap_12
XFILLER_0_73_729 VGND VGND VPWR VPWR sky130_fd_sc_hd__decap_8
XFILLER_0_26_623 VPWR VGND VPWR VGND sky130_ef_sc_hd__decap_12
XTAP_TAPCELL_ROW_135_2329 VGND VPWR sky130_fd_sc_hd__tapvpwrvgnd_1
XTAP_TAPCELL_ROW_135_2318 VGND VPWR sky130_fd_sc_hd__tapvpwrvgnd_1
XFILLER_0_5_517 VPWR VGND VPWR VGND sky130_ef_sc_hd__decap_12
XFILLER_0_25_111 VGND VGND VPWR VPWR sky130_fd_sc_hd__fill_1
XFILLER_0_26_645 VPWR VGND VPWR VGND sky130_ef_sc_hd__decap_12
X_2780_ _0584_ _0743_ _0744_ net22 VGND VGND VPWR VPWR _0745_ sky130_fd_sc_hd__o211a_1
XFILLER_0_81_762 VGND VGND VPWR VPWR sky130_fd_sc_hd__fill_1
XFILLER_0_13_317 VPWR VGND VPWR VGND sky130_ef_sc_hd__decap_12
XFILLER_0_111_503 VGND VGND VPWR VPWR sky130_fd_sc_hd__fill_1
X_4450_ _1100_ cpu_inst.regfile_inst.registers\[7\]\[9\] _2161_ VGND VGND VPWR VPWR
+ _2172_ sky130_fd_sc_hd__mux2_1
XFILLER_0_123_385 VGND VGND VPWR VPWR sky130_fd_sc_hd__decap_6
X_3401_ _1342_ VGND VGND VPWR VPWR _0013_ sky130_fd_sc_hd__clkbuf_1
X_4381_ cpu_inst.regfile_inst.registers\[1\]\[8\] VGND VGND VPWR VPWR _2136_ sky130_fd_sc_hd__clkbuf_1
X_3332_ edge_det.signal_reg net1 VGND VGND VPWR VPWR _1287_ sky130_fd_sc_hd__or2b_1
XTAP_TAPCELL_ROW_59_1191 VGND VPWR sky130_fd_sc_hd__tapvpwrvgnd_1
XTAP_TAPCELL_ROW_59_1180 VGND VPWR sky130_fd_sc_hd__tapvpwrvgnd_1
XFILLER_0_21_361 VPWR VGND VPWR VGND sky130_ef_sc_hd__decap_12
XFILLER_0_0_277 VGND VGND VPWR VPWR sky130_fd_sc_hd__decap_3
XTAP_TAPCELL_ROW_72_1380 VGND VPWR sky130_fd_sc_hd__tapvpwrvgnd_1
X_3263_ cpu_inst.regfile_inst.registers\[8\]\[15\] _1227_ _0725_ VGND VGND VPWR VPWR
+ _1228_ sky130_fd_sc_hd__mux2_1
X_5002_ cpu_inst.regfile_inst.registers\[15\]\[19\] _2480_ VGND VGND VPWR VPWR _2490_
+ sky130_fd_sc_hd__and2_1
X_3194_ _1020_ _1158_ _1016_ VGND VGND VPWR VPWR _1159_ sky130_fd_sc_hd__a21o_1
XFILLER_0_56_53 VPWR VGND VPWR VGND sky130_ef_sc_hd__decap_12
XFILLER_0_56_97 VPWR VGND VPWR VGND sky130_ef_sc_hd__decap_12
XFILLER_0_72_41 VPWR VGND VPWR VGND sky130_ef_sc_hd__decap_12
XTAP_TAPCELL_ROW_37_857 VGND VPWR sky130_fd_sc_hd__tapvpwrvgnd_1
XFILLER_0_49_726 VGND VGND VPWR VPWR sky130_fd_sc_hd__fill_2
XFILLER_0_72_85 VPWR VGND VPWR VGND sky130_ef_sc_hd__decap_12
XFILLER_0_107_809 VPWR VGND VPWR VGND sky130_ef_sc_hd__decap_12
XFILLER_0_63_217 VGND VGND VPWR VPWR sky130_fd_sc_hd__decap_6
XFILLER_0_8_333 VPWR VGND VPWR VGND sky130_ef_sc_hd__decap_12
XFILLER_0_29_461 VPWR VGND VPWR VGND sky130_ef_sc_hd__decap_12
XFILLER_0_133_105 VGND VGND VPWR VPWR sky130_fd_sc_hd__decap_6
XFILLER_0_72_740 VGND VGND VPWR VPWR sky130_fd_sc_hd__fill_2
XFILLER_0_8_377 VPWR VGND VPWR VGND sky130_ef_sc_hd__decap_12
XFILLER_0_16_133 VGND VGND VPWR VPWR sky130_fd_sc_hd__decap_6
X_2978_ _0942_ cpu_inst.regfile_inst.registers\[10\]\[6\] _0883_ VGND VGND VPWR VPWR
+ _0943_ sky130_fd_sc_hd__mux2_1
XFILLER_0_133_149 VPWR VGND VPWR VGND sky130_ef_sc_hd__decap_12
XFILLER_0_71_261 VPWR VGND VPWR VGND sky130_ef_sc_hd__decap_12
X_4717_ cpu_inst.decoder_inst.current_pc\[17\] cpu_inst.decoder_inst.current_pc\[18\]
+ _2328_ VGND VGND VPWR VPWR _2334_ sky130_fd_sc_hd__and3_1
XFILLER_0_114_363 VGND VGND VPWR VPWR sky130_fd_sc_hd__fill_1
X_4648_ _1493_ _1608_ _1726_ _2280_ VGND VGND VPWR VPWR _2281_ sky130_fd_sc_hd__or4_4
XFILLER_0_16_177 VPWR VGND VPWR VGND sky130_ef_sc_hd__decap_12
XFILLER_0_31_125 VPWR VGND VPWR VGND sky130_ef_sc_hd__decap_12
XFILLER_0_31_169 VPWR VGND VPWR VGND sky130_ef_sc_hd__decap_12
XFILLER_0_102_547 VGND VGND VPWR VPWR sky130_fd_sc_hd__fill_1
X_4579_ _2237_ VGND VGND VPWR VPWR _0296_ sky130_fd_sc_hd__clkbuf_1
XFILLER_0_97_93 VPWR VGND VPWR VGND sky130_ef_sc_hd__decap_12
XFILLER_0_86_309 VPWR VGND VPWR VGND sky130_ef_sc_hd__decap_12
XFILLER_0_79_361 VGND VGND VPWR VPWR sky130_fd_sc_hd__decap_8
XFILLER_0_39_225 VPWR VGND VPWR VGND sky130_ef_sc_hd__decap_12
XFILLER_0_109_113 VPWR VGND VPWR VGND sky130_ef_sc_hd__decap_12
XTAP_TAPCELL_ROW_15_518 VGND VPWR sky130_fd_sc_hd__tapvpwrvgnd_1
XTAP_TAPCELL_ROW_15_529 VGND VPWR sky130_fd_sc_hd__tapvpwrvgnd_1
XFILLER_0_125_617 VPWR VGND VPWR VGND sky130_ef_sc_hd__decap_12
XTAP_TAPCELL_ROW_117_2048 VGND VPWR sky130_fd_sc_hd__tapvpwrvgnd_1
XFILLER_0_63_773 VGND VGND VPWR VPWR sky130_fd_sc_hd__decap_8
XFILLER_0_23_615 VGND VGND VPWR VPWR sky130_fd_sc_hd__fill_1
XFILLER_0_50_401 VPWR VGND VPWR VGND sky130_ef_sc_hd__decap_12
XTAP_TAPCELL_ROW_117_2059 VGND VPWR sky130_fd_sc_hd__tapvpwrvgnd_1
XFILLER_0_35_486 VGND VGND VPWR VPWR sky130_fd_sc_hd__fill_2
XFILLER_0_105_385 VGND VGND VPWR VPWR sky130_fd_sc_hd__decap_6
XTAP_TAPCELL_ROW_130_2248 VGND VPWR sky130_fd_sc_hd__tapvpwrvgnd_1
XFILLER_0_120_333 VPWR VGND VPWR VGND sky130_ef_sc_hd__decap_12
XFILLER_0_10_309 VPWR VGND VPWR VGND sky130_ef_sc_hd__decap_12
XFILLER_0_120_377 VPWR VGND VPWR VGND sky130_ef_sc_hd__decap_12
XTAP_TAPCELL_ROW_112_1981 VGND VPWR sky130_fd_sc_hd__tapvpwrvgnd_1
XFILLER_0_117_69 VPWR VGND VPWR VGND sky130_ef_sc_hd__decap_12
XFILLER_0_89_125 VPWR VGND VPWR VGND sky130_ef_sc_hd__decap_12
XFILLER_0_98_670 VGND VGND VPWR VPWR sky130_fd_sc_hd__decap_4
XFILLER_0_89_169 VPWR VGND VPWR VGND sky130_ef_sc_hd__decap_12
XFILLER_0_86_832 VGND VGND VPWR VPWR sky130_fd_sc_hd__decap_8
X_3950_ cpu_inst.regfile_inst.registers\[25\]\[30\] _1310_ _1311_ _1874_ VGND VGND
+ VPWR VPWR _1875_ sky130_fd_sc_hd__o211a_1
XTAP_TAPCELL_ROW_34_805 VGND VPWR sky130_fd_sc_hd__tapvpwrvgnd_1
XTAP_TAPCELL_ROW_34_816 VGND VPWR sky130_fd_sc_hd__tapvpwrvgnd_1
XFILLER_0_133_57 VPWR VGND VPWR VGND sky130_ef_sc_hd__decap_12
X_2901_ _0865_ VGND VGND VPWR VPWR _0866_ sky130_fd_sc_hd__buf_4
XFILLER_0_128_433 VPWR VGND VPWR VGND sky130_ef_sc_hd__decap_12
X_3881_ cpu_inst.regfile_inst.registers\[1\]\[28\] _1804_ _1805_ cpu_inst.regfile_inst.registers\[5\]\[28\]
+ _0562_ VGND VGND VPWR VPWR _1808_ sky130_fd_sc_hd__o221a_1
XFILLER_0_42_77 VGND VGND VPWR VPWR sky130_fd_sc_hd__decap_6
XFILLER_0_45_217 VGND VGND VPWR VPWR sky130_fd_sc_hd__decap_6
XFILLER_0_128_477 VPWR VGND VPWR VGND sky130_ef_sc_hd__decap_12
XFILLER_0_115_105 VGND VGND VPWR VPWR sky130_fd_sc_hd__decap_6
XFILLER_0_6_837 VGND VGND VPWR VPWR sky130_fd_sc_hd__decap_4
X_2832_ cpu_inst.regfile_inst.registers\[15\]\[5\] _0796_ _0720_ VGND VGND VPWR VPWR
+ _0797_ sky130_fd_sc_hd__mux2_1
X_5551_ clknet_leaf_15_clk _0471_ VGND VGND VPWR VPWR cpu_inst.regfile_inst.registers\[15\]\[23\]
+ sky130_fd_sc_hd__dfxtp_1
XFILLER_0_60_209 VPWR VGND VPWR VGND sky130_ef_sc_hd__decap_12
XFILLER_0_26_475 VGND VGND VPWR VPWR sky130_fd_sc_hd__fill_1
X_2763_ _0709_ _0634_ _0622_ VGND VGND VPWR VPWR _0728_ sky130_fd_sc_hd__nand3_1
XFILLER_0_131_609 VGND VGND VPWR VPWR sky130_fd_sc_hd__decap_6
XFILLER_0_115_149 VPWR VGND VPWR VGND sky130_ef_sc_hd__decap_12
XFILLER_0_53_261 VPWR VGND VPWR VGND sky130_ef_sc_hd__decap_12
XFILLER_0_13_125 VPWR VGND VPWR VGND sky130_ef_sc_hd__decap_12
XFILLER_0_14_637 VGND VGND VPWR VPWR sky130_fd_sc_hd__decap_6
X_4502_ cpu_inst.regfile_inst.registers\[11\]\[2\] VGND VGND VPWR VPWR _2199_ sky130_fd_sc_hd__clkbuf_1
X_5482_ clknet_leaf_19_clk _0402_ VGND VGND VPWR VPWR cpu_inst.regfile_inst.registers\[9\]\[18\]
+ sky130_fd_sc_hd__dfxtp_1
X_2694_ cpu_inst.regfile_inst.registers\[9\]\[1\] cpu_inst.regfile_inst.registers\[8\]\[1\]
+ _0648_ VGND VGND VPWR VPWR _0659_ sky130_fd_sc_hd__mux2_1
XFILLER_0_123_193 VPWR VGND VPWR VGND sky130_ef_sc_hd__decap_12
XFILLER_0_13_169 VPWR VGND VPWR VGND sky130_ef_sc_hd__decap_12
XFILLER_0_1_553 VGND VGND VPWR VPWR sky130_fd_sc_hd__decap_6
XFILLER_0_22_681 VPWR VGND VPWR VGND sky130_ef_sc_hd__decap_12
X_4433_ _0688_ cpu_inst.regfile_inst.registers\[7\]\[1\] _2161_ VGND VGND VPWR VPWR
+ _2163_ sky130_fd_sc_hd__mux2_1
X_4364_ _2127_ VGND VGND VPWR VPWR _0191_ sky130_fd_sc_hd__clkbuf_1
X_3315_ _1273_ _1276_ _1262_ VGND VGND VPWR VPWR _1277_ sky130_fd_sc_hd__o21ai_1
X_4295_ _0709_ _0550_ _1283_ VGND VGND VPWR VPWR _2090_ sky130_fd_sc_hd__and3_1
XFILLER_0_6_77 VGND VGND VPWR VPWR sky130_fd_sc_hd__decap_6
XFILLER_0_1_597 VPWR VGND VPWR VGND sky130_ef_sc_hd__decap_12
X_3246_ _1210_ VGND VGND VPWR VPWR _1211_ sky130_fd_sc_hd__inv_2
XFILLER_0_83_51 VGND VGND VPWR VPWR sky130_fd_sc_hd__decap_4
X_3177_ _0912_ _1141_ VGND VGND VPWR VPWR _1142_ sky130_fd_sc_hd__and2_1
XFILLER_0_20_3 VPWR VGND VPWR VGND sky130_ef_sc_hd__decap_12
Xrebuffer11 net23 VGND VGND VPWR VPWR net24 sky130_fd_sc_hd__dlygate4sd1_1
XFILLER_0_68_309 VGND VGND VPWR VPWR sky130_fd_sc_hd__decap_8
Xrebuffer22 _0579_ VGND VGND VPWR VPWR net35 sky130_fd_sc_hd__dlygate4sd1_1
XTAP_TAPCELL_ROW_85_1582 VGND VPWR sky130_fd_sc_hd__tapvpwrvgnd_1
XTAP_TAPCELL_ROW_85_1571 VGND VPWR sky130_fd_sc_hd__tapvpwrvgnd_1
XFILLER_0_92_813 VPWR VGND VPWR VGND sky130_ef_sc_hd__decap_12
XFILLER_0_9_653 VPWR VGND VPWR VGND sky130_ef_sc_hd__decap_12
XFILLER_0_49_589 VGND VGND VPWR VPWR sky130_fd_sc_hd__fill_1
XFILLER_0_64_559 VGND VGND VPWR VPWR sky130_fd_sc_hd__fill_2
XFILLER_0_8_141 VPWR VGND VPWR VGND sky130_ef_sc_hd__decap_12
XFILLER_0_9_697 VPWR VGND VPWR VGND sky130_ef_sc_hd__decap_12
XFILLER_0_134_469 VGND VGND VPWR VPWR sky130_fd_sc_hd__decap_6
XFILLER_0_17_497 VGND VGND VPWR VPWR sky130_fd_sc_hd__decap_6
XFILLER_0_32_401 VPWR VGND VPWR VGND sky130_ef_sc_hd__decap_12
XFILLER_0_60_754 VGND VGND VPWR VPWR sky130_fd_sc_hd__fill_2
XTAP_TAPCELL_ROW_20_598 VGND VPWR sky130_fd_sc_hd__tapvpwrvgnd_1
XFILLER_0_32_445 VPWR VGND VPWR VGND sky130_ef_sc_hd__decap_12
XFILLER_0_102_333 VPWR VGND VPWR VGND sky130_ef_sc_hd__decap_12
XFILLER_0_102_377 VPWR VGND VPWR VGND sky130_ef_sc_hd__decap_12
XFILLER_0_87_607 VGND VGND VPWR VPWR sky130_fd_sc_hd__decap_3
XFILLER_0_86_139 VGND VGND VPWR VPWR sky130_fd_sc_hd__fill_1
XFILLER_0_68_821 VGND VGND VPWR VPWR sky130_fd_sc_hd__fill_1
XFILLER_0_68_810 VGND VGND VPWR VPWR sky130_fd_sc_hd__fill_2
XTAP_TAPCELL_ROW_0_290 VGND VPWR sky130_fd_sc_hd__tapvpwrvgnd_1
XFILLER_0_138_753 VGND VGND VPWR VPWR sky130_fd_sc_hd__decap_3
XFILLER_0_95_673 VGND VGND VPWR VPWR sky130_fd_sc_hd__decap_4
XFILLER_0_83_835 VGND VGND VPWR VPWR sky130_fd_sc_hd__decap_4
XFILLER_0_82_301 VGND VGND VPWR VPWR sky130_fd_sc_hd__decap_6
XFILLER_0_55_515 VGND VGND VPWR VPWR sky130_fd_sc_hd__decap_6
XFILLER_0_27_217 VGND VGND VPWR VPWR sky130_fd_sc_hd__decap_6
XFILLER_0_138_797 VPWR VGND VPWR VGND sky130_ef_sc_hd__decap_12
XFILLER_0_103_27 VPWR VGND VPWR VGND sky130_ef_sc_hd__decap_12
XFILLER_0_82_345 VPWR VGND VPWR VGND sky130_ef_sc_hd__decap_12
XFILLER_0_125_447 VGND VGND VPWR VPWR sky130_fd_sc_hd__fill_1
XFILLER_0_42_209 VPWR VGND VPWR VGND sky130_ef_sc_hd__decap_12
XFILLER_0_113_609 VGND VGND VPWR VPWR sky130_fd_sc_hd__decap_6
XFILLER_0_35_261 VPWR VGND VPWR VGND sky130_ef_sc_hd__decap_12
XFILLER_0_88_29 VPWR VGND VPWR VGND sky130_ef_sc_hd__decap_12
XFILLER_0_121_653 VPWR VGND VPWR VGND sky130_ef_sc_hd__decap_12
XFILLER_0_105_193 VPWR VGND VPWR VGND sky130_ef_sc_hd__decap_12
XFILLER_0_11_629 VPWR VGND VPWR VGND sky130_ef_sc_hd__decap_12
XFILLER_0_50_253 VPWR VGND VPWR VGND sky130_ef_sc_hd__decap_12
XFILLER_0_120_141 VPWR VGND VPWR VGND sky130_ef_sc_hd__decap_12
XFILLER_0_10_139 VGND VGND VPWR VPWR sky130_fd_sc_hd__fill_1
XFILLER_0_121_697 VPWR VGND VPWR VGND sky130_ef_sc_hd__decap_12
X_3100_ cpu_inst.regfile_inst.registers\[25\]\[11\] _1022_ _0921_ _1000_ VGND VGND
+ VPWR VPWR _1065_ sky130_fd_sc_hd__o211a_1
X_4080_ cpu_inst.regfile_inst.registers\[2\]\[27\] VGND VGND VPWR VPWR _1976_ sky130_fd_sc_hd__clkbuf_1
XFILLER_0_37_55 VGND VGND VPWR VPWR sky130_fd_sc_hd__fill_1
X_3031_ cpu_inst.regfile_inst.registers\[7\]\[11\] cpu_inst.regfile_inst.registers\[6\]\[11\]
+ _0922_ VGND VGND VPWR VPWR _0996_ sky130_fd_sc_hd__mux2_1
XFILLER_0_59_810 VGND VGND VPWR VPWR sky130_fd_sc_hd__fill_1
XFILLER_0_86_640 VGND VGND VPWR VPWR sky130_fd_sc_hd__decap_4
XFILLER_0_58_342 VGND VGND VPWR VPWR sky130_fd_sc_hd__fill_2
X_4982_ _2479_ VGND VGND VPWR VPWR _0457_ sky130_fd_sc_hd__clkbuf_1
XFILLER_0_129_753 VPWR VGND VPWR VGND sky130_ef_sc_hd__decap_12
XFILLER_0_92_109 VPWR VGND VPWR VGND sky130_ef_sc_hd__decap_12
XFILLER_0_85_161 VGND VGND VPWR VPWR sky130_fd_sc_hd__decap_6
X_3933_ _1857_ _1858_ VGND VGND VPWR VPWR _1859_ sky130_fd_sc_hd__and2b_1
XFILLER_0_58_386 VGND VGND VPWR VPWR sky130_fd_sc_hd__fill_2
XFILLER_0_19_729 VPWR VGND VPWR VGND sky130_ef_sc_hd__decap_12
X_3864_ _1088_ _1785_ _1791_ VGND VGND VPWR VPWR _1792_ sky130_fd_sc_hd__o21ai_2
XFILLER_0_73_345 VGND VGND VPWR VPWR sky130_fd_sc_hd__fill_1
XFILLER_0_6_601 VPWR VGND VPWR VGND sky130_ef_sc_hd__decap_12
XFILLER_0_129_797 VPWR VGND VPWR VGND sky130_ef_sc_hd__decap_12
XFILLER_0_6_645 VPWR VGND VPWR VGND sky130_ef_sc_hd__decap_12
XFILLER_0_5_111 VGND VGND VPWR VPWR sky130_fd_sc_hd__fill_1
X_2815_ _0774_ _0779_ _0606_ VGND VGND VPWR VPWR _0780_ sky130_fd_sc_hd__a21o_1
XFILLER_0_116_469 VGND VGND VPWR VPWR sky130_fd_sc_hd__decap_6
X_3795_ _1682_ _1723_ _1724_ _1224_ VGND VGND VPWR VPWR _1725_ sky130_fd_sc_hd__o211a_1
XFILLER_0_73_389 VGND VGND VPWR VPWR sky130_fd_sc_hd__decap_3
XFILLER_0_14_401 VPWR VGND VPWR VGND sky130_ef_sc_hd__decap_12
XFILLER_0_131_417 VPWR VGND VPWR VGND sky130_ef_sc_hd__decap_12
XFILLER_0_14_445 VPWR VGND VPWR VGND sky130_ef_sc_hd__decap_12
X_2746_ cpu_inst.regfile_inst.registers\[11\]\[10\] cpu_inst.regfile_inst.registers\[10\]\[10\]
+ _0620_ VGND VGND VPWR VPWR _0711_ sky130_fd_sc_hd__mux2_1
X_5534_ clknet_leaf_34_clk _0454_ VGND VGND VPWR VPWR cpu_inst.regfile_inst.registers\[15\]\[6\]
+ sky130_fd_sc_hd__dfxtp_1
XFILLER_0_14_489 VPWR VGND VPWR VGND sky130_ef_sc_hd__decap_12
X_2677_ _0613_ VGND VGND VPWR VPWR _0642_ sky130_fd_sc_hd__buf_4
X_5465_ clknet_leaf_40_clk _0385_ VGND VGND VPWR VPWR cpu_inst.regfile_inst.registers\[9\]\[1\]
+ sky130_fd_sc_hd__dfxtp_1
X_4416_ _2153_ VGND VGND VPWR VPWR _0217_ sky130_fd_sc_hd__clkbuf_1
XFILLER_0_68_3 VPWR VGND VPWR VGND sky130_ef_sc_hd__decap_12
XFILLER_0_1_361 VPWR VGND VPWR VGND sky130_ef_sc_hd__decap_12
XFILLER_0_100_837 VGND VGND VPWR VPWR sky130_fd_sc_hd__decap_4
X_5396_ clknet_leaf_6_clk _0316_ VGND VGND VPWR VPWR cpu_inst.regfile_inst.registers\[10\]\[28\]
+ sky130_fd_sc_hd__dfxtp_1
X_4347_ _1644_ cpu_inst.regfile_inst.registers\[5\]\[23\] _2117_ VGND VGND VPWR VPWR
+ _2119_ sky130_fd_sc_hd__mux2_1
X_4278_ _2081_ VGND VGND VPWR VPWR _0151_ sky130_fd_sc_hd__clkbuf_1
XFILLER_0_94_83 VGND VGND VPWR VPWR sky130_fd_sc_hd__fill_1
XTAP_TAPCELL_ROW_87_1611 VGND VPWR sky130_fd_sc_hd__tapvpwrvgnd_1
XTAP_TAPCELL_ROW_87_1600 VGND VPWR sky130_fd_sc_hd__tapvpwrvgnd_1
X_3229_ _1193_ _0918_ VGND VGND VPWR VPWR _1194_ sky130_fd_sc_hd__xor2_1
XFILLER_0_96_415 VGND VGND VPWR VPWR sky130_fd_sc_hd__decap_4
XFILLER_0_68_139 VGND VGND VPWR VPWR sky130_fd_sc_hd__fill_1
XFILLER_0_77_673 VGND VGND VPWR VPWR sky130_fd_sc_hd__decap_4
XFILLER_0_64_301 VGND VGND VPWR VPWR sky130_fd_sc_hd__decap_6
XFILLER_0_64_334 VGND VGND VPWR VPWR sky130_fd_sc_hd__decap_3
XFILLER_0_9_461 VPWR VGND VPWR VGND sky130_ef_sc_hd__decap_12
XTAP_TAPCELL_ROW_25_668 VGND VPWR sky130_fd_sc_hd__tapvpwrvgnd_1
XTAP_TAPCELL_ROW_25_679 VGND VPWR sky130_fd_sc_hd__tapvpwrvgnd_1
XFILLER_0_80_816 VPWR VGND VPWR VGND sky130_ef_sc_hd__decap_12
XFILLER_0_24_209 VPWR VGND VPWR VGND sky130_ef_sc_hd__decap_12
XFILLER_0_134_233 VPWR VGND VPWR VGND sky130_ef_sc_hd__decap_12
XFILLER_0_107_447 VGND VGND VPWR VPWR sky130_fd_sc_hd__fill_1
XFILLER_0_17_261 VPWR VGND VPWR VGND sky130_ef_sc_hd__decap_12
XFILLER_0_134_277 VPWR VGND VPWR VGND sky130_ef_sc_hd__decap_12
XTAP_TAPCELL_ROW_114_2007 VGND VPWR sky130_fd_sc_hd__tapvpwrvgnd_1
XTAP_TAPCELL_ROW_98_1773 VGND VPWR sky130_fd_sc_hd__tapvpwrvgnd_1
XFILLER_0_60_551 VGND VGND VPWR VPWR sky130_fd_sc_hd__decap_3
XFILLER_0_33_765 VPWR VGND VPWR VGND sky130_ef_sc_hd__decap_12
XFILLER_0_60_573 VGND VGND VPWR VPWR sky130_fd_sc_hd__fill_2
XFILLER_0_32_253 VPWR VGND VPWR VGND sky130_ef_sc_hd__decap_12
XFILLER_0_102_141 VPWR VGND VPWR VGND sky130_ef_sc_hd__decap_12
XTAP_TAPCELL_ROW_5_382 VGND VPWR sky130_fd_sc_hd__tapvpwrvgnd_1
XTAP_TAPCELL_ROW_5_371 VGND VPWR sky130_fd_sc_hd__tapvpwrvgnd_1
XTAP_TAPCELL_ROW_125_2169 VGND VPWR sky130_fd_sc_hd__tapvpwrvgnd_1
XFILLER_0_114_15 VPWR VGND VPWR VGND sky130_ef_sc_hd__decap_12
XFILLER_0_74_109 VPWR VGND VPWR VGND sky130_ef_sc_hd__decap_12
XFILLER_0_67_161 VGND VGND VPWR VPWR sky130_fd_sc_hd__decap_6
XFILLER_0_56_813 VGND VGND VPWR VPWR sky130_fd_sc_hd__decap_4
XTAP_TAPCELL_ROW_44_955 VGND VPWR sky130_fd_sc_hd__tapvpwrvgnd_1
XTAP_TAPCELL_ROW_44_966 VGND VPWR sky130_fd_sc_hd__tapvpwrvgnd_1
XFILLER_0_138_561 VPWR VGND VPWR VGND sky130_ef_sc_hd__decap_12
XFILLER_0_126_701 VPWR VGND VPWR VGND sky130_ef_sc_hd__decap_12
XFILLER_0_23_57 VPWR VGND VPWR VGND sky130_ef_sc_hd__decap_12
XFILLER_0_82_153 VPWR VGND VPWR VGND sky130_ef_sc_hd__decap_12
XFILLER_0_55_367 VGND VGND VPWR VPWR sky130_fd_sc_hd__fill_2
XFILLER_0_43_518 VGND VGND VPWR VPWR sky130_fd_sc_hd__fill_1
XFILLER_0_99_39 VPWR VGND VPWR VGND sky130_ef_sc_hd__decap_12
XFILLER_0_113_417 VPWR VGND VPWR VGND sky130_ef_sc_hd__decap_12
X_3580_ cpu_inst.regfile_inst.registers\[8\]\[20\] _0642_ VGND VGND VPWR VPWR _1515_
+ sky130_fd_sc_hd__or2_1
XFILLER_0_82_197 VPWR VGND VPWR VGND sky130_ef_sc_hd__decap_12
Xrebuffer2 net14 VGND VGND VPWR VPWR net15 sky130_fd_sc_hd__dlymetal6s4s_1
XFILLER_0_3_615 VGND VGND VPWR VPWR sky130_fd_sc_hd__fill_1
X_2600_ _0511_ _0518_ _0549_ _0516_ VGND VGND VPWR VPWR _0565_ sky130_fd_sc_hd__or4_4
XFILLER_0_121_461 VPWR VGND VPWR VGND sky130_ef_sc_hd__decap_12
XTAP_TAPCELL_ROW_54_1109 VGND VPWR sky130_fd_sc_hd__tapvpwrvgnd_1
X_5250_ clknet_leaf_32_clk _0170_ VGND VGND VPWR VPWR cpu_inst.regfile_inst.registers\[5\]\[10\]
+ sky130_fd_sc_hd__dfxtp_1
X_4201_ _2042_ VGND VGND VPWR VPWR _0113_ sky130_fd_sc_hd__clkbuf_1
X_5181_ clknet_leaf_35_clk _0101_ VGND VGND VPWR VPWR cpu_inst.regfile_inst.registers\[4\]\[5\]
+ sky130_fd_sc_hd__dfxtp_1
XFILLER_0_48_65 VPWR VGND VPWR VGND sky130_ef_sc_hd__decap_12
X_4132_ _2005_ VGND VGND VPWR VPWR _0081_ sky130_fd_sc_hd__clkbuf_1
X_4063_ _1967_ VGND VGND VPWR VPWR _0050_ sky130_fd_sc_hd__clkbuf_1
XTAP_TAPCELL_ROW_69_1330 VGND VPWR sky130_fd_sc_hd__tapvpwrvgnd_1
XFILLER_0_64_53 VPWR VGND VPWR VGND sky130_ef_sc_hd__decap_12
X_3014_ cpu_inst.regfile_inst.registers\[5\]\[8\] cpu_inst.regfile_inst.registers\[4\]\[8\]
+ _0865_ VGND VGND VPWR VPWR _0979_ sky130_fd_sc_hd__mux2_1
XFILLER_0_78_437 VGND VGND VPWR VPWR sky130_fd_sc_hd__decap_6
XFILLER_0_78_415 VGND VGND VPWR VPWR sky130_fd_sc_hd__decap_4
XTAP_TAPCELL_ROW_69_1341 VGND VPWR sky130_fd_sc_hd__tapvpwrvgnd_1
XFILLER_0_64_97 VPWR VGND VPWR VGND sky130_ef_sc_hd__decap_12
XTAP_TAPCELL_ROW_82_1530 VGND VPWR sky130_fd_sc_hd__tapvpwrvgnd_1
XFILLER_0_80_41 VPWR VGND VPWR VGND sky130_ef_sc_hd__decap_12
XFILLER_0_59_673 VPWR VGND VPWR VGND sky130_ef_sc_hd__decap_12
XFILLER_0_59_662 VGND VGND VPWR VPWR sky130_fd_sc_hd__decap_8
XFILLER_0_46_301 VGND VGND VPWR VPWR sky130_fd_sc_hd__decap_6
X_4965_ cpu_inst.regfile_inst.registers\[15\]\[1\] _2469_ VGND VGND VPWR VPWR _2471_
+ sky130_fd_sc_hd__or2b_1
XFILLER_0_129_561 VPWR VGND VPWR VGND sky130_ef_sc_hd__decap_12
X_3916_ _1803_ _1815_ _0686_ VGND VGND VPWR VPWR _1842_ sky130_fd_sc_hd__o21a_1
XFILLER_0_74_621 VGND VGND VPWR VPWR sky130_fd_sc_hd__decap_3
XFILLER_0_47_835 VGND VGND VPWR VPWR sky130_fd_sc_hd__decap_4
XFILLER_0_80_85 VPWR VGND VPWR VGND sky130_ef_sc_hd__decap_12
XFILLER_0_74_665 VGND VGND VPWR VPWR sky130_fd_sc_hd__decap_3
XFILLER_0_62_816 VGND VGND VPWR VPWR sky130_fd_sc_hd__decap_3
XFILLER_0_19_559 VGND VGND VPWR VPWR sky130_fd_sc_hd__fill_1
XTAP_TAPCELL_ROW_22_627 VGND VPWR sky130_fd_sc_hd__tapvpwrvgnd_1
X_4896_ _0688_ cpu_inst.regfile_inst.registers\[8\]\[1\] _2432_ VGND VGND VPWR VPWR
+ _2434_ sky130_fd_sc_hd__mux2_1
XFILLER_0_46_345 VPWR VGND VPWR VGND sky130_ef_sc_hd__decap_12
XFILLER_0_116_233 VPWR VGND VPWR VGND sky130_ef_sc_hd__decap_12
X_3847_ cpu_inst.regfile_inst.registers\[8\]\[27\] _1774_ _1557_ VGND VGND VPWR VPWR
+ _1775_ sky130_fd_sc_hd__mux2_1
XFILLER_0_15_721 VGND VGND VPWR VPWR sky130_fd_sc_hd__decap_6
XFILLER_0_46_389 VPWR VGND VPWR VGND sky130_ef_sc_hd__decap_12
XFILLER_0_132_737 VPWR VGND VPWR VGND sky130_ef_sc_hd__decap_12
XFILLER_0_116_277 VPWR VGND VPWR VGND sky130_ef_sc_hd__decap_12
X_3778_ _0686_ _1676_ _1663_ VGND VGND VPWR VPWR _1708_ sky130_fd_sc_hd__a21bo_1
XFILLER_0_6_475 VGND VGND VPWR VPWR sky130_fd_sc_hd__fill_1
XFILLER_0_131_225 VPWR VGND VPWR VGND sky130_ef_sc_hd__decap_12
X_5517_ clknet_leaf_16_clk _0437_ VGND VGND VPWR VPWR cpu_inst.regfile_inst.registers\[8\]\[21\]
+ sky130_fd_sc_hd__dfxtp_1
X_2729_ _0663_ VGND VGND VPWR VPWR _0694_ sky130_fd_sc_hd__clkbuf_4
XFILLER_0_14_253 VPWR VGND VPWR VGND sky130_ef_sc_hd__decap_12
XFILLER_0_15_765 VPWR VGND VPWR VGND sky130_ef_sc_hd__decap_12
XFILLER_0_42_562 VGND VGND VPWR VPWR sky130_fd_sc_hd__fill_2
XFILLER_0_30_757 VPWR VGND VPWR VGND sky130_ef_sc_hd__decap_12
X_5448_ clknet_leaf_20_clk _0368_ VGND VGND VPWR VPWR cpu_inst.regfile_inst.registers\[0\]\[16\]
+ sky130_fd_sc_hd__dfxtp_1
XFILLER_0_2_681 VPWR VGND VPWR VGND sky130_ef_sc_hd__decap_12
XTAP_TAPCELL_ROW_93_1692 VGND VPWR sky130_fd_sc_hd__tapvpwrvgnd_1
X_5379_ clknet_leaf_29_clk _0299_ VGND VGND VPWR VPWR cpu_inst.regfile_inst.registers\[10\]\[11\]
+ sky130_fd_sc_hd__dfxtp_1
XTAP_TAPCELL_ROW_2_330 VGND VPWR sky130_fd_sc_hd__tapvpwrvgnd_1
XPHY_EDGE_ROW_29_Right_29 VGND VGND VPWR VPWR sky130_fd_sc_hd__decap_3
XFILLER_0_97_735 VGND VGND VPWR VPWR sky130_fd_sc_hd__decap_6
XFILLER_0_96_245 VGND VGND VPWR VPWR sky130_fd_sc_hd__decap_6
XFILLER_0_96_289 VPWR VGND VPWR VGND sky130_ef_sc_hd__decap_12
XFILLER_0_56_109 VPWR VGND VPWR VGND sky130_ef_sc_hd__decap_12
XFILLER_0_38_813 VGND VGND VPWR VPWR sky130_fd_sc_hd__fill_2
XFILLER_0_108_701 VPWR VGND VPWR VGND sky130_ef_sc_hd__decap_12
XTAP_TAPCELL_ROW_41_914 VGND VPWR sky130_fd_sc_hd__tapvpwrvgnd_1
XFILLER_0_49_161 VGND VGND VPWR VPWR sky130_fd_sc_hd__decap_6
XTAP_TAPCELL_ROW_120_2099 VGND VPWR sky130_fd_sc_hd__tapvpwrvgnd_1
XFILLER_0_64_153 VPWR VGND VPWR VGND sky130_ef_sc_hd__decap_12
XFILLER_0_53_805 VGND VGND VPWR VPWR sky130_fd_sc_hd__decap_4
XFILLER_0_135_553 VGND VGND VPWR VPWR sky130_fd_sc_hd__decap_6
XFILLER_0_80_635 VGND VGND VPWR VPWR sky130_fd_sc_hd__fill_1
XFILLER_0_18_581 VGND VGND VPWR VPWR sky130_fd_sc_hd__decap_6
XPHY_EDGE_ROW_38_Right_38 VGND VGND VPWR VPWR sky130_fd_sc_hd__decap_3
XFILLER_0_135_597 VPWR VGND VPWR VGND sky130_ef_sc_hd__decap_12
XFILLER_0_64_197 VPWR VGND VPWR VGND sky130_ef_sc_hd__decap_12
XFILLER_0_33_540 VGND VGND VPWR VPWR sky130_fd_sc_hd__fill_1
XFILLER_0_33_573 VGND VGND VPWR VPWR sky130_fd_sc_hd__decap_4
XFILLER_0_0_629 VPWR VGND VPWR VGND sky130_ef_sc_hd__decap_12
XFILLER_0_33_595 VGND VGND VPWR VPWR sky130_fd_sc_hd__decap_3
XFILLER_0_20_245 VGND VGND VPWR VPWR sky130_fd_sc_hd__decap_6
XFILLER_0_20_289 VPWR VGND VPWR VGND sky130_ef_sc_hd__decap_12
XTAP_TAPCELL_ROW_127_2209 VGND VPWR sky130_fd_sc_hd__tapvpwrvgnd_1
XFILLER_0_109_15 VPWR VGND VPWR VGND sky130_ef_sc_hd__decap_12
XPHY_EDGE_ROW_47_Right_47 VGND VGND VPWR VPWR sky130_fd_sc_hd__decap_3
XTAP_TAPCELL_ROW_109_1931 VGND VPWR sky130_fd_sc_hd__tapvpwrvgnd_1
XTAP_TAPCELL_ROW_109_1942 VGND VPWR sky130_fd_sc_hd__tapvpwrvgnd_1
XFILLER_0_87_223 VGND VGND VPWR VPWR sky130_fd_sc_hd__fill_1
XFILLER_0_125_69 VPWR VGND VPWR VGND sky130_ef_sc_hd__decap_12
XTAP_TAPCELL_ROW_64_1260 VGND VPWR sky130_fd_sc_hd__tapvpwrvgnd_1
XFILLER_0_28_301 VGND VGND VPWR VPWR sky130_fd_sc_hd__decap_6
XFILLER_0_126_3 VPWR VGND VPWR VGND sky130_ef_sc_hd__decap_12
X_4750_ cpu_inst.decoder_inst.current_pc\[27\] _2355_ VGND VGND VPWR VPWR _2358_ sky130_fd_sc_hd__xnor2_1
XPHY_EDGE_ROW_56_Right_56 VGND VGND VPWR VPWR sky130_fd_sc_hd__decap_3
XFILLER_0_7_217 VGND VGND VPWR VPWR sky130_fd_sc_hd__decap_6
XFILLER_0_28_345 VPWR VGND VPWR VGND sky130_ef_sc_hd__decap_12
XFILLER_0_126_531 VGND VGND VPWR VPWR sky130_fd_sc_hd__fill_1
X_3701_ _1618_ _1632_ VGND VGND VPWR VPWR _1633_ sky130_fd_sc_hd__xnor2_1
XFILLER_0_83_495 VGND VGND VPWR VPWR sky130_fd_sc_hd__decap_3
X_4681_ cpu_inst.decoder_inst.current_pc\[8\] _2307_ VGND VGND VPWR VPWR _0328_ sky130_fd_sc_hd__xnor2_1
XFILLER_0_28_389 VPWR VGND VPWR VGND sky130_ef_sc_hd__decap_12
XFILLER_0_114_737 VPWR VGND VPWR VGND sky130_ef_sc_hd__decap_12
X_3632_ _0639_ _1565_ VGND VGND VPWR VPWR _1566_ sky130_fd_sc_hd__nor2_1
XFILLER_0_43_337 VPWR VGND VPWR VGND sky130_ef_sc_hd__decap_12
XFILLER_0_50_77 VGND VGND VPWR VPWR sky130_fd_sc_hd__decap_6
XFILLER_0_113_225 VPWR VGND VPWR VGND sky130_ef_sc_hd__decap_12
XFILLER_0_12_713 VPWR VGND VPWR VGND sky130_ef_sc_hd__decap_12
X_3563_ cpu_inst.regfile_inst.registers\[9\]\[20\] cpu_inst.regfile_inst.registers\[8\]\[20\]
+ _1348_ VGND VGND VPWR VPWR _1498_ sky130_fd_sc_hd__mux2_1
X_5302_ clknet_leaf_6_clk _0222_ VGND VGND VPWR VPWR cpu_inst.regfile_inst.registers\[1\]\[30\]
+ sky130_fd_sc_hd__dfxtp_1
XFILLER_0_70_189 VGND VGND VPWR VPWR sky130_fd_sc_hd__decap_6
XFILLER_0_11_223 VGND VGND VPWR VPWR sky130_fd_sc_hd__fill_1
XFILLER_0_122_781 VPWR VGND VPWR VGND sky130_ef_sc_hd__decap_12
X_3494_ cpu_inst.regfile_inst.registers\[11\]\[18\] cpu_inst.regfile_inst.registers\[10\]\[18\]
+ _0731_ VGND VGND VPWR VPWR _1431_ sky130_fd_sc_hd__mux2_1
XFILLER_0_12_757 VPWR VGND VPWR VGND sky130_ef_sc_hd__decap_12
X_5233_ clknet_leaf_9_clk _0153_ VGND VGND VPWR VPWR cpu_inst.regfile_inst.registers\[24\]\[25\]
+ sky130_fd_sc_hd__dfxtp_1
XPHY_EDGE_ROW_65_Right_65 VGND VGND VPWR VPWR sky130_fd_sc_hd__decap_3
X_5164_ clknet_leaf_12_clk _0084_ VGND VGND VPWR VPWR cpu_inst.regfile_inst.registers\[25\]\[20\]
+ sky130_fd_sc_hd__dfxtp_1
X_4115_ _1996_ VGND VGND VPWR VPWR _0073_ sky130_fd_sc_hd__clkbuf_1
X_5095_ clknet_leaf_22_clk _0015_ VGND VGND VPWR VPWR cpu_inst.regfile_inst.registers\[6\]\[15\]
+ sky130_fd_sc_hd__dfxtp_1
XTAP_TAPCELL_ROW_27_708 VGND VPWR sky130_fd_sc_hd__tapvpwrvgnd_1
X_4046_ cpu_inst.regfile_inst.registers\[2\]\[10\] VGND VGND VPWR VPWR _1959_ sky130_fd_sc_hd__clkbuf_1
XFILLER_0_91_51 VGND VGND VPWR VPWR sky130_fd_sc_hd__decap_4
XFILLER_0_78_245 VGND VGND VPWR VPWR sky130_fd_sc_hd__decap_6
XFILLER_0_94_727 VGND VGND VPWR VPWR sky130_fd_sc_hd__decap_4
XFILLER_0_38_109 VPWR VGND VPWR VGND sky130_ef_sc_hd__decap_12
XFILLER_0_93_237 VPWR VGND VPWR VGND sky130_ef_sc_hd__decap_12
XFILLER_0_78_289 VPWR VGND VPWR VGND sky130_ef_sc_hd__decap_12
XPHY_EDGE_ROW_74_Right_74 VGND VGND VPWR VPWR sky130_fd_sc_hd__decap_3
X_4948_ _2461_ VGND VGND VPWR VPWR _0441_ sky130_fd_sc_hd__clkbuf_1
XFILLER_0_129_391 VGND VGND VPWR VPWR sky130_fd_sc_hd__fill_1
XFILLER_0_117_553 VGND VGND VPWR VPWR sky130_fd_sc_hd__decap_6
X_4879_ _2424_ VGND VGND VPWR VPWR _0409_ sky130_fd_sc_hd__clkbuf_1
XFILLER_0_46_153 VPWR VGND VPWR VGND sky130_ef_sc_hd__decap_12
XFILLER_0_132_501 VPWR VGND VPWR VGND sky130_ef_sc_hd__decap_12
XFILLER_0_105_726 VGND VGND VPWR VPWR sky130_fd_sc_hd__fill_2
XFILLER_0_46_197 VPWR VGND VPWR VGND sky130_ef_sc_hd__decap_12
XFILLER_0_132_545 VPWR VGND VPWR VGND sky130_ef_sc_hd__decap_12
XFILLER_0_117_597 VPWR VGND VPWR VGND sky130_ef_sc_hd__decap_12
XTAP_TAPCELL_ROW_95_1721 VGND VPWR sky130_fd_sc_hd__tapvpwrvgnd_1
XFILLER_0_61_167 VGND VGND VPWR VPWR sky130_fd_sc_hd__fill_1
XFILLER_0_15_573 VPWR VGND VPWR VGND sky130_ef_sc_hd__decap_12
XFILLER_0_132_589 VPWR VGND VPWR VGND sky130_ef_sc_hd__decap_12
XTAP_TAPCELL_ROW_95_1732 VGND VPWR sky130_fd_sc_hd__tapvpwrvgnd_1
XFILLER_0_70_690 VGND VGND VPWR VPWR sky130_fd_sc_hd__fill_1
XFILLER_0_30_521 VGND VGND VPWR VPWR sky130_fd_sc_hd__fill_1
XPHY_EDGE_ROW_83_Right_83 VGND VGND VPWR VPWR sky130_fd_sc_hd__decap_3
XPHY_EDGE_ROW_18_Left_157 VGND VGND VPWR VPWR sky130_fd_sc_hd__decap_3
XTAP_TAPCELL_ROW_7_411 VGND VPWR sky130_fd_sc_hd__tapvpwrvgnd_1
XTAP_TAPCELL_ROW_7_400 VGND VPWR sky130_fd_sc_hd__tapvpwrvgnd_1
XFILLER_0_30_587 VGND VGND VPWR VPWR sky130_fd_sc_hd__fill_1
XFILLER_0_100_475 VGND VGND VPWR VPWR sky130_fd_sc_hd__fill_1
XTAP_TAPCELL_ROW_122_2128 VGND VPWR sky130_fd_sc_hd__tapvpwrvgnd_1
XFILLER_0_69_223 VGND VGND VPWR VPWR sky130_fd_sc_hd__fill_1
XPHY_EDGE_ROW_92_Right_92 VGND VGND VPWR VPWR sky130_fd_sc_hd__decap_3
XPHY_EDGE_ROW_27_Left_166 VGND VGND VPWR VPWR sky130_fd_sc_hd__decap_3
XPHY_EDGE_ROW_133_Right_133 VGND VGND VPWR VPWR sky130_fd_sc_hd__decap_3
XTAP_TAPCELL_ROW_104_1861 VGND VPWR sky130_fd_sc_hd__tapvpwrvgnd_1
XFILLER_0_127_317 VPWR VGND VPWR VGND sky130_ef_sc_hd__decap_12
XFILLER_0_26_805 VGND VGND VPWR VPWR sky130_fd_sc_hd__decap_6
XFILLER_0_38_643 VGND VGND VPWR VPWR sky130_fd_sc_hd__fill_1
XFILLER_0_108_531 VGND VGND VPWR VPWR sky130_fd_sc_hd__fill_1
XFILLER_0_53_613 VGND VGND VPWR VPWR sky130_fd_sc_hd__decap_3
XTAP_TAPCELL_ROW_137_2360 VGND VPWR sky130_fd_sc_hd__tapvpwrvgnd_1
XFILLER_0_135_361 VPWR VGND VPWR VGND sky130_ef_sc_hd__decap_12
XFILLER_0_111_27 VPWR VGND VPWR VGND sky130_ef_sc_hd__decap_12
XFILLER_0_108_586 VGND VGND VPWR VPWR sky130_fd_sc_hd__fill_2
XFILLER_0_80_421 VGND VGND VPWR VPWR sky130_fd_sc_hd__decap_4
XFILLER_0_4_209 VPWR VGND VPWR VGND sky130_ef_sc_hd__decap_12
XFILLER_0_25_337 VPWR VGND VPWR VGND sky130_ef_sc_hd__decap_12
XFILLER_0_40_307 VGND VGND VPWR VPWR sky130_fd_sc_hd__fill_1
XFILLER_0_111_729 VPWR VGND VPWR VGND sky130_ef_sc_hd__decap_12
XPHY_EDGE_ROW_36_Left_175 VGND VGND VPWR VPWR sky130_fd_sc_hd__decap_3
XFILLER_0_52_189 VGND VGND VPWR VPWR sky130_fd_sc_hd__decap_6
XFILLER_0_104_781 VPWR VGND VPWR VGND sky130_ef_sc_hd__decap_12
XFILLER_0_96_29 VPWR VGND VPWR VGND sky130_ef_sc_hd__decap_12
XFILLER_0_45_55 VGND VGND VPWR VPWR sky130_fd_sc_hd__fill_1
XPHY_EDGE_ROW_45_Left_184 VGND VGND VPWR VPWR sky130_fd_sc_hd__decap_3
XFILLER_0_75_237 VPWR VGND VPWR VGND sky130_ef_sc_hd__decap_12
XFILLER_0_0_57 VPWR VGND VPWR VGND sky130_ef_sc_hd__decap_12
XPHY_EDGE_ROW_100_Right_100 VGND VGND VPWR VPWR sky130_fd_sc_hd__decap_3
X_4802_ cpu_inst.regfile_inst.registers\[0\]\[19\] VGND VGND VPWR VPWR _2386_ sky130_fd_sc_hd__clkbuf_1
X_2994_ cpu_inst.regfile_inst.registers\[25\]\[7\] _0903_ _0921_ _0958_ VGND VGND
+ VPWR VPWR _0959_ sky130_fd_sc_hd__o211ai_4
X_4733_ cpu_inst.decoder_inst.current_pc\[23\] _2342_ VGND VGND VPWR VPWR _2345_ sky130_fd_sc_hd__and2_1
XFILLER_0_28_153 VPWR VGND VPWR VGND sky130_ef_sc_hd__decap_12
XFILLER_0_29_698 VPWR VGND VPWR VGND sky130_ef_sc_hd__decap_12
XFILLER_0_114_501 VPWR VGND VPWR VGND sky130_ef_sc_hd__decap_12
XFILLER_0_83_281 VPWR VGND VPWR VGND sky130_ef_sc_hd__decap_12
XFILLER_0_28_197 VPWR VGND VPWR VGND sky130_ef_sc_hd__decap_12
XTAP_TAPCELL_ROW_32_777 VGND VPWR sky130_fd_sc_hd__tapvpwrvgnd_1
XFILLER_0_114_545 VPWR VGND VPWR VGND sky130_ef_sc_hd__decap_12
X_4664_ _0521_ cpu_inst.decoder_inst.current_pc\[2\] cpu_inst.decoder_inst.current_pc\[4\]
+ VGND VGND VPWR VPWR _2295_ sky130_fd_sc_hd__and3_1
XPHY_EDGE_ROW_54_Left_193 VGND VGND VPWR VPWR sky130_fd_sc_hd__decap_3
XFILLER_0_9_55 VGND VGND VPWR VPWR sky130_fd_sc_hd__fill_1
XFILLER_0_43_167 VGND VGND VPWR VPWR sky130_fd_sc_hd__fill_1
X_3615_ cpu_inst.regfile_inst.registers\[25\]\[21\] _0693_ _0695_ _1543_ VGND VGND
+ VPWR VPWR _1549_ sky130_fd_sc_hd__o211ai_1
X_4595_ cpu_inst.regfile_inst.registers\[10\]\[16\] _2241_ VGND VGND VPWR VPWR _2246_
+ sky130_fd_sc_hd__and2_1
XFILLER_0_31_329 VGND VGND VPWR VPWR sky130_fd_sc_hd__decap_6
XFILLER_0_114_589 VPWR VGND VPWR VGND sky130_ef_sc_hd__decap_12
XFILLER_0_101_217 VGND VGND VPWR VPWR sky130_fd_sc_hd__decap_6
XFILLER_0_101_93 VPWR VGND VPWR VGND sky130_ef_sc_hd__decap_12
X_3546_ _1465_ _1481_ VGND VGND VPWR VPWR _1482_ sky130_fd_sc_hd__nor2_1
XTAP_TAPCELL_ROW_77_1462 VGND VPWR sky130_fd_sc_hd__tapvpwrvgnd_1
XTAP_TAPCELL_ROW_77_1451 VGND VPWR sky130_fd_sc_hd__tapvpwrvgnd_1
XFILLER_0_12_587 VGND VGND VPWR VPWR sky130_fd_sc_hd__fill_1
XTAP_TAPCELL_ROW_90_1651 VGND VPWR sky130_fd_sc_hd__tapvpwrvgnd_1
X_3477_ _1144_ _1414_ VGND VGND VPWR VPWR _1415_ sky130_fd_sc_hd__nor2_1
X_5216_ clknet_leaf_25_clk _0136_ VGND VGND VPWR VPWR cpu_inst.regfile_inst.registers\[24\]\[8\]
+ sky130_fd_sc_hd__dfxtp_1
XFILLER_0_50_3 VPWR VGND VPWR VGND sky130_ef_sc_hd__decap_12
X_5147_ clknet_leaf_1_clk _0067_ VGND VGND VPWR VPWR cpu_inst.regfile_inst.registers\[25\]\[3\]
+ sky130_fd_sc_hd__dfxtp_1
XFILLER_0_98_307 VGND VGND VPWR VPWR sky130_fd_sc_hd__fill_1
X_5078_ cpu_inst.display_inst.counter\[19\] _2533_ VGND VGND VPWR VPWR _0499_ sky130_fd_sc_hd__xor2_1
XFILLER_0_79_521 VGND VGND VPWR VPWR sky130_fd_sc_hd__decap_8
X_4029_ _1950_ VGND VGND VPWR VPWR _0033_ sky130_fd_sc_hd__clkbuf_1
XFILLER_0_67_727 VGND VGND VPWR VPWR sky130_fd_sc_hd__fill_1
XFILLER_0_137_615 VGND VGND VPWR VPWR sky130_fd_sc_hd__fill_1
XFILLER_0_109_317 VPWR VGND VPWR VGND sky130_ef_sc_hd__decap_12
XFILLER_0_124_309 VPWR VGND VPWR VGND sky130_ef_sc_hd__decap_12
XFILLER_0_117_361 VPWR VGND VPWR VGND sky130_ef_sc_hd__decap_12
XFILLER_0_90_730 VGND VGND VPWR VPWR sky130_fd_sc_hd__fill_1
XFILLER_0_133_821 VPWR VGND VPWR VGND sky130_ef_sc_hd__decap_12
XTAP_TAPCELL_ROW_119_2090 VGND VPWR sky130_fd_sc_hd__tapvpwrvgnd_1
XFILLER_0_105_523 VGND VGND VPWR VPWR sky130_fd_sc_hd__fill_1
XTAP_TAPCELL_ROW_10_449 VGND VPWR sky130_fd_sc_hd__tapvpwrvgnd_1
XFILLER_0_22_307 VGND VGND VPWR VPWR sky130_fd_sc_hd__fill_1
XFILLER_0_35_668 VGND VGND VPWR VPWR sky130_fd_sc_hd__fill_1
XFILLER_0_50_605 VGND VGND VPWR VPWR sky130_fd_sc_hd__fill_2
XFILLER_0_34_189 VGND VGND VPWR VPWR sky130_fd_sc_hd__decap_6
XFILLER_0_31_841 VGND VGND VPWR VPWR sky130_fd_sc_hd__fill_1
XFILLER_0_89_329 VGND VGND VPWR VPWR sky130_fd_sc_hd__decap_6
XFILLER_0_106_27 VGND VGND VPWR VPWR sky130_fd_sc_hd__fill_1
XFILLER_0_98_841 VGND VGND VPWR VPWR sky130_fd_sc_hd__fill_1
XFILLER_0_85_502 VGND VGND VPWR VPWR sky130_fd_sc_hd__fill_2
XFILLER_0_97_373 VPWR VGND VPWR VGND sky130_ef_sc_hd__decap_12
XFILLER_0_15_69 VPWR VGND VPWR VGND sky130_ef_sc_hd__decap_12
XFILLER_0_128_637 VGND VGND VPWR VPWR sky130_fd_sc_hd__decap_6
XFILLER_0_85_557 VGND VGND VPWR VPWR sky130_fd_sc_hd__decap_3
XFILLER_0_57_237 VPWR VGND VPWR VGND sky130_ef_sc_hd__decap_12
XFILLER_0_127_125 VPWR VGND VPWR VGND sky130_ef_sc_hd__decap_12
XFILLER_0_122_15 VPWR VGND VPWR VGND sky130_ef_sc_hd__decap_12
XTAP_TAPCELL_ROW_135_2319 VGND VPWR sky130_fd_sc_hd__tapvpwrvgnd_1
XFILLER_0_127_169 VPWR VGND VPWR VGND sky130_ef_sc_hd__decap_12
XFILLER_0_65_281 VPWR VGND VPWR VGND sky130_ef_sc_hd__decap_12
XFILLER_0_53_432 VPWR VGND VPWR VGND sky130_ef_sc_hd__decap_12
XFILLER_0_5_529 VPWR VGND VPWR VGND sky130_ef_sc_hd__decap_12
XFILLER_0_26_635 VGND VGND VPWR VPWR sky130_fd_sc_hd__decap_8
XFILLER_0_26_657 VPWR VGND VPWR VGND sky130_ef_sc_hd__decap_12
XFILLER_0_31_57 VPWR VGND VPWR VGND sky130_ef_sc_hd__decap_12
XFILLER_0_136_681 VPWR VGND VPWR VGND sky130_ef_sc_hd__decap_12
XFILLER_0_81_785 VGND VGND VPWR VPWR sky130_fd_sc_hd__decap_8
XFILLER_0_80_251 VGND VGND VPWR VPWR sky130_fd_sc_hd__fill_1
XFILLER_0_53_465 VGND VGND VPWR VPWR sky130_fd_sc_hd__fill_1
XFILLER_0_25_167 VGND VGND VPWR VPWR sky130_fd_sc_hd__fill_1
XFILLER_0_13_329 VGND VGND VPWR VPWR sky130_fd_sc_hd__decap_6
X_3400_ net16 cpu_inst.regfile_inst.registers\[6\]\[13\] _1339_ VGND VGND VPWR VPWR
+ _1342_ sky130_fd_sc_hd__mux2_1
XFILLER_0_22_841 VGND VGND VPWR VPWR sky130_fd_sc_hd__fill_1
X_4380_ _2135_ VGND VGND VPWR VPWR _0199_ sky130_fd_sc_hd__clkbuf_1
XFILLER_0_111_559 VGND VGND VPWR VPWR sky130_fd_sc_hd__fill_1
XTAP_TAPCELL_ROW_59_1192 VGND VPWR sky130_fd_sc_hd__tapvpwrvgnd_1
XTAP_TAPCELL_ROW_59_1181 VGND VPWR sky130_fd_sc_hd__tapvpwrvgnd_1
X_3331_ _0520_ _0580_ _0536_ _1285_ _1092_ VGND VGND VPWR VPWR _1286_ sky130_fd_sc_hd__o2111ai_1
XFILLER_0_21_373 VPWR VGND VPWR VGND sky130_ef_sc_hd__decap_12
X_3262_ cpu_inst.regfile_inst.registers\[11\]\[15\] cpu_inst.regfile_inst.registers\[10\]\[15\]
+ _0731_ VGND VGND VPWR VPWR _1227_ sky130_fd_sc_hd__mux2_1
X_5001_ _2489_ VGND VGND VPWR VPWR _0466_ sky130_fd_sc_hd__clkbuf_1
XTAP_TAPCELL_ROW_72_1381 VGND VPWR sky130_fd_sc_hd__tapvpwrvgnd_1
X_3193_ _0950_ _0960_ _0989_ _1018_ VGND VGND VPWR VPWR _1158_ sky130_fd_sc_hd__a211o_1
XFILLER_0_56_65 VPWR VGND VPWR VGND sky130_ef_sc_hd__decap_12
XFILLER_0_89_841 VGND VGND VPWR VPWR sky130_fd_sc_hd__fill_1
XTAP_TAPCELL_ROW_37_858 VGND VPWR sky130_fd_sc_hd__tapvpwrvgnd_1
XFILLER_0_72_53 VPWR VGND VPWR VGND sky130_ef_sc_hd__decap_12
XFILLER_0_119_615 VGND VGND VPWR VPWR sky130_fd_sc_hd__fill_1
XFILLER_0_72_97 VPWR VGND VPWR VGND sky130_ef_sc_hd__decap_12
XFILLER_0_8_301 VGND VGND VPWR VPWR sky130_fd_sc_hd__decap_6
XTAP_TAPCELL_ROW_17_560 VGND VPWR sky130_fd_sc_hd__tapvpwrvgnd_1
XFILLER_0_8_345 VPWR VGND VPWR VGND sky130_ef_sc_hd__decap_12
XFILLER_0_29_473 VGND VGND VPWR VPWR sky130_fd_sc_hd__fill_2
XFILLER_0_106_309 VPWR VGND VPWR VGND sky130_ef_sc_hd__decap_12
XPHY_EDGE_ROW_62_Left_201 VGND VGND VPWR VPWR sky130_fd_sc_hd__decap_3
XFILLER_0_29_495 VGND VGND VPWR VPWR sky130_fd_sc_hd__fill_1
X_2977_ cpu_inst.regfile_inst.registers\[9\]\[6\] cpu_inst.regfile_inst.registers\[8\]\[6\]
+ _0865_ VGND VGND VPWR VPWR _0942_ sky130_fd_sc_hd__mux2_1
XFILLER_0_115_821 VPWR VGND VPWR VGND sky130_ef_sc_hd__decap_12
XFILLER_0_98_3 VPWR VGND VPWR VGND sky130_ef_sc_hd__decap_12
X_4716_ cpu_inst.decoder_inst.current_pc\[17\] _2288_ _2318_ _2333_ VGND VGND VPWR
+ VPWR _0337_ sky130_fd_sc_hd__o22a_1
XFILLER_0_8_389 VPWR VGND VPWR VGND sky130_ef_sc_hd__decap_12
XFILLER_0_32_605 VGND VGND VPWR VPWR sky130_fd_sc_hd__fill_2
X_4647_ _1260_ _1534_ _1574_ _2279_ VGND VGND VPWR VPWR _2280_ sky130_fd_sc_hd__or4_4
XFILLER_0_72_796 VGND VGND VPWR VPWR sky130_fd_sc_hd__fill_1
XFILLER_0_71_273 VGND VGND VPWR VPWR sky130_fd_sc_hd__decap_6
XFILLER_0_16_189 VGND VGND VPWR VPWR sky130_fd_sc_hd__decap_6
XFILLER_0_130_813 VPWR VGND VPWR VGND sky130_ef_sc_hd__decap_12
XFILLER_0_13_841 VGND VGND VPWR VPWR sky130_fd_sc_hd__fill_1
XFILLER_0_31_137 VPWR VGND VPWR VGND sky130_ef_sc_hd__decap_12
X_4578_ cpu_inst.regfile_inst.registers\[10\]\[8\] _2230_ VGND VGND VPWR VPWR _2237_
+ sky130_fd_sc_hd__and2_1
X_3529_ cpu_inst.regfile_inst.registers\[25\]\[19\] _0693_ _0695_ _1464_ VGND VGND
+ VPWR VPWR _1465_ sky130_fd_sc_hd__o211a_1
XFILLER_0_110_581 VGND VGND VPWR VPWR sky130_fd_sc_hd__decap_6
XPHY_EDGE_ROW_71_Left_210 VGND VGND VPWR VPWR sky130_fd_sc_hd__decap_3
XFILLER_0_99_649 VPWR VGND VPWR VGND sky130_ef_sc_hd__decap_12
XFILLER_0_94_321 VPWR VGND VPWR VGND sky130_ef_sc_hd__decap_12
XTAP_TAPCELL_ROW_15_519 VGND VPWR sky130_fd_sc_hd__tapvpwrvgnd_1
XFILLER_0_39_237 VPWR VGND VPWR VGND sky130_ef_sc_hd__decap_12
XFILLER_0_109_125 VPWR VGND VPWR VGND sky130_ef_sc_hd__decap_12
XTAP_TAPCELL_ROW_101_1820 VGND VPWR sky130_fd_sc_hd__tapvpwrvgnd_1
XFILLER_0_94_365 VPWR VGND VPWR VGND sky130_ef_sc_hd__decap_12
XFILLER_0_125_629 VPWR VGND VPWR VGND sky130_ef_sc_hd__decap_12
XFILLER_0_109_169 VPWR VGND VPWR VGND sky130_ef_sc_hd__decap_12
XFILLER_0_47_281 VPWR VGND VPWR VGND sky130_ef_sc_hd__decap_12
XFILLER_0_124_139 VGND VGND VPWR VPWR sky130_fd_sc_hd__fill_1
XFILLER_0_118_681 VPWR VGND VPWR VGND sky130_ef_sc_hd__decap_12
XFILLER_0_62_251 VGND VGND VPWR VPWR sky130_fd_sc_hd__fill_1
XTAP_TAPCELL_ROW_117_2049 VGND VPWR sky130_fd_sc_hd__tapvpwrvgnd_1
XFILLER_0_63_785 VGND VGND VPWR VPWR sky130_fd_sc_hd__fill_2
XFILLER_0_50_413 VGND VGND VPWR VPWR sky130_fd_sc_hd__decap_6
XFILLER_0_133_673 VPWR VGND VPWR VGND sky130_ef_sc_hd__decap_12
XFILLER_0_120_301 VGND VGND VPWR VPWR sky130_fd_sc_hd__decap_6
XTAP_TAPCELL_ROW_130_2249 VGND VPWR sky130_fd_sc_hd__tapvpwrvgnd_1
XFILLER_0_120_345 VPWR VGND VPWR VGND sky130_ef_sc_hd__decap_12
XFILLER_0_120_389 VPWR VGND VPWR VGND sky130_ef_sc_hd__decap_12
XTAP_TAPCELL_ROW_112_1982 VGND VPWR sky130_fd_sc_hd__tapvpwrvgnd_1
XFILLER_0_117_15 VPWR VGND VPWR VGND sky130_ef_sc_hd__decap_12
XFILLER_0_89_137 VPWR VGND VPWR VGND sky130_ef_sc_hd__decap_12
XFILLER_0_58_502 VGND VGND VPWR VPWR sky130_fd_sc_hd__decap_4
XTAP_TAPCELL_ROW_34_806 VGND VPWR sky130_fd_sc_hd__tapvpwrvgnd_1
XTAP_TAPCELL_ROW_34_817 VGND VPWR sky130_fd_sc_hd__tapvpwrvgnd_1
XFILLER_0_128_401 VPWR VGND VPWR VGND sky130_ef_sc_hd__decap_12
XFILLER_0_97_181 VPWR VGND VPWR VGND sky130_ef_sc_hd__decap_12
X_2900_ _0675_ VGND VGND VPWR VPWR _0865_ sky130_fd_sc_hd__clkbuf_4
XFILLER_0_133_69 VPWR VGND VPWR VGND sky130_ef_sc_hd__decap_12
XFILLER_0_128_445 VPWR VGND VPWR VGND sky130_ef_sc_hd__decap_12
X_3880_ cpu_inst.regfile_inst.registers\[0\]\[28\] _1804_ _1805_ cpu_inst.regfile_inst.registers\[4\]\[28\]
+ _1560_ VGND VGND VPWR VPWR _1807_ sky130_fd_sc_hd__o221a_1
XFILLER_0_128_489 VPWR VGND VPWR VGND sky130_ef_sc_hd__decap_12
XFILLER_0_54_741 VGND VGND VPWR VPWR sky130_fd_sc_hd__fill_1
XFILLER_0_6_805 VGND VGND VPWR VPWR sky130_fd_sc_hd__decap_6
XFILLER_0_26_421 VPWR VGND VPWR VGND sky130_ef_sc_hd__decap_12
X_2831_ cpu_inst.regfile_inst.registers\[11\]\[5\] cpu_inst.regfile_inst.registers\[10\]\[5\]
+ _0620_ VGND VGND VPWR VPWR _0796_ sky130_fd_sc_hd__mux2_1
X_5550_ clknet_leaf_16_clk _0470_ VGND VGND VPWR VPWR cpu_inst.regfile_inst.registers\[15\]\[22\]
+ sky130_fd_sc_hd__dfxtp_1
XFILLER_0_5_337 VPWR VGND VPWR VGND sky130_ef_sc_hd__decap_12
X_2762_ cpu_inst.regfile_inst.registers\[0\]\[11\] _0726_ _0703_ cpu_inst.regfile_inst.registers\[4\]\[11\]
+ _0705_ VGND VGND VPWR VPWR _0727_ sky130_fd_sc_hd__o221a_1
X_5481_ clknet_leaf_26_clk _0401_ VGND VGND VPWR VPWR cpu_inst.regfile_inst.registers\[9\]\[17\]
+ sky130_fd_sc_hd__dfxtp_1
XFILLER_0_53_273 VGND VGND VPWR VPWR sky130_fd_sc_hd__decap_6
XFILLER_0_41_413 VGND VGND VPWR VPWR sky130_fd_sc_hd__decap_3
X_4501_ _2198_ VGND VGND VPWR VPWR _0257_ sky130_fd_sc_hd__clkbuf_1
XFILLER_0_130_109 VPWR VGND VPWR VGND sky130_ef_sc_hd__decap_12
XFILLER_0_123_161 VGND VGND VPWR VPWR sky130_fd_sc_hd__decap_6
XFILLER_0_112_813 VPWR VGND VPWR VGND sky130_ef_sc_hd__decap_12
X_2693_ _0569_ _0657_ VGND VGND VPWR VPWR _0658_ sky130_fd_sc_hd__nand2_2
XFILLER_0_13_137 VPWR VGND VPWR VGND sky130_ef_sc_hd__decap_12
X_4432_ _2162_ VGND VGND VPWR VPWR _0224_ sky130_fd_sc_hd__clkbuf_1
XTAP_TAPCELL_ROW_74_1410 VGND VPWR sky130_fd_sc_hd__tapvpwrvgnd_1
XFILLER_0_10_811 VGND VGND VPWR VPWR sky130_fd_sc_hd__fill_1
X_4363_ _1928_ cpu_inst.regfile_inst.registers\[5\]\[31\] _2117_ VGND VGND VPWR VPWR
+ _2127_ sky130_fd_sc_hd__mux2_1
XFILLER_0_21_181 VPWR VGND VPWR VGND sky130_ef_sc_hd__decap_12
XFILLER_0_22_693 VGND VGND VPWR VPWR sky130_fd_sc_hd__decap_6
X_4294_ _2089_ VGND VGND VPWR VPWR _0159_ sky130_fd_sc_hd__clkbuf_1
X_3314_ _1199_ _1267_ VGND VGND VPWR VPWR _1276_ sky130_fd_sc_hd__nor2_1
X_3245_ _1176_ _1058_ _1209_ VGND VGND VPWR VPWR _1210_ sky130_fd_sc_hd__o21ai_1
X_3176_ _1138_ _1140_ _0644_ VGND VGND VPWR VPWR _1141_ sky130_fd_sc_hd__mux2_1
Xrebuffer12 _0504_ VGND VGND VPWR VPWR net25 sky130_fd_sc_hd__dlygate4sd1_1
XFILLER_0_13_3 VPWR VGND VPWR VGND sky130_ef_sc_hd__decap_12
Xrebuffer23 net35 VGND VGND VPWR VPWR net36 sky130_fd_sc_hd__dlymetal6s2s_1
XFILLER_0_107_81 VPWR VGND VPWR VGND sky130_ef_sc_hd__decap_12
XFILLER_0_138_209 VPWR VGND VPWR VGND sky130_ef_sc_hd__decap_12
XTAP_TAPCELL_ROW_85_1572 VGND VPWR sky130_fd_sc_hd__tapvpwrvgnd_1
XFILLER_0_76_321 VPWR VGND VPWR VGND sky130_ef_sc_hd__decap_12
XFILLER_0_92_825 VPWR VGND VPWR VGND sky130_ef_sc_hd__decap_12
XFILLER_0_76_365 VGND VGND VPWR VPWR sky130_fd_sc_hd__decap_8
XFILLER_0_64_505 VGND VGND VPWR VPWR sky130_fd_sc_hd__decap_6
XFILLER_0_91_335 VGND VGND VPWR VPWR sky130_fd_sc_hd__fill_1
XFILLER_0_64_549 VGND VGND VPWR VPWR sky130_fd_sc_hd__fill_1
XFILLER_0_57_590 VPWR VGND VPWR VGND sky130_ef_sc_hd__decap_12
XFILLER_0_9_665 VGND VGND VPWR VPWR sky130_fd_sc_hd__decap_6
XFILLER_0_8_153 VPWR VGND VPWR VGND sky130_ef_sc_hd__decap_12
XFILLER_0_29_281 VPWR VGND VPWR VGND sky130_ef_sc_hd__decap_12
XFILLER_0_8_197 VPWR VGND VPWR VGND sky130_ef_sc_hd__decap_12
XFILLER_0_44_251 VGND VGND VPWR VPWR sky130_fd_sc_hd__fill_1
XFILLER_0_106_139 VGND VGND VPWR VPWR sky130_fd_sc_hd__fill_1
XFILLER_0_32_413 VGND VGND VPWR VPWR sky130_fd_sc_hd__decap_6
XFILLER_0_115_673 VPWR VGND VPWR VGND sky130_ef_sc_hd__decap_12
XFILLER_0_102_301 VGND VGND VPWR VPWR sky130_fd_sc_hd__decap_6
XTAP_TAPCELL_ROW_20_599 VGND VPWR sky130_fd_sc_hd__tapvpwrvgnd_1
XFILLER_0_32_457 VPWR VGND VPWR VGND sky130_ef_sc_hd__decap_12
XFILLER_0_130_643 VGND VGND VPWR VPWR sky130_fd_sc_hd__fill_1
XFILLER_0_102_345 VPWR VGND VPWR VGND sky130_ef_sc_hd__decap_12
XFILLER_0_60_799 VGND VGND VPWR VPWR sky130_fd_sc_hd__fill_1
XFILLER_0_13_671 VGND VGND VPWR VPWR sky130_fd_sc_hd__fill_1
XFILLER_0_102_389 VPWR VGND VPWR VGND sky130_ef_sc_hd__decap_12
XFILLER_0_99_413 VGND VGND VPWR VPWR sky130_fd_sc_hd__fill_2
XFILLER_0_79_181 VPWR VGND VPWR VGND sky130_ef_sc_hd__decap_12
XTAP_TAPCELL_ROW_0_280 VGND VPWR sky130_fd_sc_hd__tapvpwrvgnd_1
XTAP_TAPCELL_ROW_0_291 VGND VPWR sky130_fd_sc_hd__tapvpwrvgnd_1
XFILLER_0_103_39 VPWR VGND VPWR VGND sky130_ef_sc_hd__decap_12
XFILLER_0_95_696 VGND VGND VPWR VPWR sky130_fd_sc_hd__decap_8
XFILLER_0_94_195 VGND VGND VPWR VPWR sky130_fd_sc_hd__fill_1
XFILLER_0_12_15 VPWR VGND VPWR VGND sky130_ef_sc_hd__decap_12
XFILLER_0_82_357 VGND VGND VPWR VPWR sky130_fd_sc_hd__decap_6
XFILLER_0_35_273 VGND VGND VPWR VPWR sky130_fd_sc_hd__decap_6
XFILLER_0_112_109 VPWR VGND VPWR VGND sky130_ef_sc_hd__decap_12
XFILLER_0_106_684 VPWR VGND VPWR VGND sky130_ef_sc_hd__decap_12
XFILLER_0_105_161 VGND VGND VPWR VPWR sky130_fd_sc_hd__decap_6
XFILLER_0_2_307 VGND VGND VPWR VPWR sky130_fd_sc_hd__fill_1
XFILLER_0_50_221 VPWR VGND VPWR VGND sky130_ef_sc_hd__decap_12
XFILLER_0_50_265 VPWR VGND VPWR VGND sky130_ef_sc_hd__decap_12
XFILLER_0_121_665 VGND VGND VPWR VPWR sky130_fd_sc_hd__decap_6
XFILLER_0_120_153 VPWR VGND VPWR VGND sky130_ef_sc_hd__decap_12
XTAP_TAPCELL_ROW_56_1140 VGND VPWR sky130_fd_sc_hd__tapvpwrvgnd_1
XFILLER_0_120_197 VPWR VGND VPWR VGND sky130_ef_sc_hd__decap_12
X_3030_ cpu_inst.regfile_inst.registers\[5\]\[11\] cpu_inst.regfile_inst.registers\[4\]\[11\]
+ _0922_ VGND VGND VPWR VPWR _0995_ sky130_fd_sc_hd__mux2_1
XFILLER_0_58_321 VGND VGND VPWR VPWR sky130_fd_sc_hd__fill_1
X_4981_ cpu_inst.regfile_inst.registers\[15\]\[9\] _2469_ VGND VGND VPWR VPWR _2479_
+ sky130_fd_sc_hd__and2_1
XFILLER_0_53_55 VGND VGND VPWR VPWR sky130_fd_sc_hd__fill_1
XFILLER_0_129_721 VGND VGND VPWR VPWR sky130_fd_sc_hd__decap_6
X_3932_ _1819_ _1826_ _1818_ VGND VGND VPWR VPWR _1858_ sky130_fd_sc_hd__a21oi_1
XFILLER_0_58_365 VGND VGND VPWR VPWR sky130_fd_sc_hd__decap_6
XFILLER_0_129_765 VPWR VGND VPWR VGND sky130_ef_sc_hd__decap_12
XFILLER_0_128_253 VPWR VGND VPWR VGND sky130_ef_sc_hd__decap_12
X_3863_ _1153_ _1789_ _1790_ _1092_ VGND VGND VPWR VPWR _1791_ sky130_fd_sc_hd__a31o_1
XFILLER_0_73_313 VGND VGND VPWR VPWR sky130_fd_sc_hd__decap_3
XFILLER_0_46_527 VGND VGND VPWR VPWR sky130_fd_sc_hd__decap_4
XFILLER_0_6_613 VPWR VGND VPWR VGND sky130_ef_sc_hd__decap_12
XFILLER_0_27_741 VPWR VGND VPWR VGND sky130_ef_sc_hd__decap_12
X_2814_ _0613_ _0775_ _0776_ _0778_ VGND VGND VPWR VPWR _0779_ sky130_fd_sc_hd__o31a_1
X_3794_ _1653_ _1648_ _1681_ _1721_ VGND VGND VPWR VPWR _1724_ sky130_fd_sc_hd__a211o_1
XFILLER_0_14_413 VGND VGND VPWR VPWR sky130_fd_sc_hd__decap_6
XFILLER_0_6_657 VPWR VGND VPWR VGND sky130_ef_sc_hd__decap_12
XFILLER_0_26_251 VGND VGND VPWR VPWR sky130_fd_sc_hd__fill_1
XFILLER_0_27_785 VPWR VGND VPWR VGND sky130_ef_sc_hd__decap_12
X_5533_ clknet_leaf_35_clk _0453_ VGND VGND VPWR VPWR cpu_inst.regfile_inst.registers\[15\]\[5\]
+ sky130_fd_sc_hd__dfxtp_1
XFILLER_0_131_429 VPWR VGND VPWR VGND sky130_ef_sc_hd__decap_12
XFILLER_0_14_457 VPWR VGND VPWR VGND sky130_ef_sc_hd__decap_12
XFILLER_0_5_167 VGND VGND VPWR VPWR sky130_fd_sc_hd__fill_1
X_2745_ _0709_ _0545_ _0622_ VGND VGND VPWR VPWR _0710_ sky130_fd_sc_hd__nand3_4
XFILLER_0_112_643 VGND VGND VPWR VPWR sky130_fd_sc_hd__fill_1
XFILLER_0_78_41 VPWR VGND VPWR VGND sky130_ef_sc_hd__decap_12
X_2676_ cpu_inst.regfile_inst.registers\[24\]\[1\] _0640_ VGND VGND VPWR VPWR _0641_
+ sky130_fd_sc_hd__or2_1
XFILLER_0_2_841 VGND VGND VPWR VPWR sky130_fd_sc_hd__fill_1
X_5464_ clknet_leaf_41_clk _0384_ VGND VGND VPWR VPWR cpu_inst.regfile_inst.registers\[9\]\[0\]
+ sky130_fd_sc_hd__dfxtp_1
XFILLER_0_42_788 VPWR VGND VPWR VGND sky130_ef_sc_hd__decap_12
X_4415_ cpu_inst.regfile_inst.registers\[1\]\[25\] VGND VGND VPWR VPWR _2153_ sky130_fd_sc_hd__clkbuf_1
X_5395_ clknet_leaf_7_clk _0315_ VGND VGND VPWR VPWR cpu_inst.regfile_inst.registers\[10\]\[27\]
+ sky130_fd_sc_hd__dfxtp_1
XFILLER_0_78_85 VPWR VGND VPWR VGND sky130_ef_sc_hd__decap_12
X_4346_ _2118_ VGND VGND VPWR VPWR _0182_ sky130_fd_sc_hd__clkbuf_1
XFILLER_0_1_373 VPWR VGND VPWR VGND sky130_ef_sc_hd__decap_12
X_4277_ cpu_inst.regfile_inst.registers\[24\]\[23\] VGND VGND VPWR VPWR _2081_ sky130_fd_sc_hd__clkbuf_1
XTAP_TAPCELL_ROW_87_1612 VGND VPWR sky130_fd_sc_hd__tapvpwrvgnd_1
XTAP_TAPCELL_ROW_87_1601 VGND VPWR sky130_fd_sc_hd__tapvpwrvgnd_1
X_3228_ _0889_ _0919_ VGND VGND VPWR VPWR _1193_ sky130_fd_sc_hd__nand2_1
X_3159_ cpu_inst.regfile_inst.registers\[24\]\[14\] _0698_ _0961_ _1123_ VGND VGND
+ VPWR VPWR _1124_ sky130_fd_sc_hd__o211a_1
XFILLER_0_96_438 VGND VGND VPWR VPWR sky130_fd_sc_hd__fill_1
XFILLER_0_77_685 VGND VGND VPWR VPWR sky130_fd_sc_hd__decap_8
XFILLER_0_37_505 VGND VGND VPWR VPWR sky130_fd_sc_hd__decap_4
Xclkbuf_leaf_34_clk clknet_2_2__leaf_clk VGND VGND VPWR VPWR clknet_leaf_34_clk sky130_fd_sc_hd__clkbuf_8
XFILLER_0_76_195 VGND VGND VPWR VPWR sky130_fd_sc_hd__fill_1
XTAP_TAPCELL_ROW_25_669 VGND VPWR sky130_fd_sc_hd__tapvpwrvgnd_1
XFILLER_0_37_538 VGND VGND VPWR VPWR sky130_fd_sc_hd__decap_3
XFILLER_0_9_473 VPWR VGND VPWR VGND sky130_ef_sc_hd__decap_12
XFILLER_0_134_245 VGND VGND VPWR VPWR sky130_fd_sc_hd__decap_6
XFILLER_0_92_699 VGND VGND VPWR VPWR sky130_fd_sc_hd__fill_1
XFILLER_0_80_828 VPWR VGND VPWR VGND sky130_ef_sc_hd__decap_12
XFILLER_0_17_273 VGND VGND VPWR VPWR sky130_fd_sc_hd__decap_6
XFILLER_0_45_582 VGND VGND VPWR VPWR sky130_fd_sc_hd__decap_3
XFILLER_0_134_289 VPWR VGND VPWR VGND sky130_ef_sc_hd__decap_12
XTAP_TAPCELL_ROW_114_2008 VGND VPWR sky130_fd_sc_hd__tapvpwrvgnd_1
XTAP_TAPCELL_ROW_98_1774 VGND VPWR sky130_fd_sc_hd__tapvpwrvgnd_1
XTAP_TAPCELL_ROW_98_1763 VGND VPWR sky130_fd_sc_hd__tapvpwrvgnd_1
XFILLER_0_32_221 VPWR VGND VPWR VGND sky130_ef_sc_hd__decap_12
XFILLER_0_32_265 VPWR VGND VPWR VGND sky130_ef_sc_hd__decap_12
XFILLER_0_33_777 VGND VGND VPWR VPWR sky130_fd_sc_hd__decap_6
XFILLER_0_103_676 VGND VGND VPWR VPWR sky130_fd_sc_hd__fill_1
XFILLER_0_102_153 VPWR VGND VPWR VGND sky130_ef_sc_hd__decap_12
XFILLER_0_2_3 VPWR VGND VPWR VGND sky130_ef_sc_hd__decap_12
XFILLER_0_102_197 VPWR VGND VPWR VGND sky130_ef_sc_hd__decap_12
XTAP_TAPCELL_ROW_129_2240 VGND VPWR sky130_fd_sc_hd__tapvpwrvgnd_1
XTAP_TAPCELL_ROW_5_372 VGND VPWR sky130_fd_sc_hd__tapvpwrvgnd_1
XTAP_TAPCELL_ROW_51_1070 VGND VPWR sky130_fd_sc_hd__tapvpwrvgnd_1
XFILLER_0_87_449 VGND VGND VPWR VPWR sky130_fd_sc_hd__decap_3
XFILLER_0_114_27 VGND VGND VPWR VPWR sky130_fd_sc_hd__fill_1
Xclkbuf_leaf_25_clk clknet_2_2__leaf_clk VGND VGND VPWR VPWR clknet_leaf_25_clk sky130_fd_sc_hd__clkbuf_8
XTAP_TAPCELL_ROW_44_956 VGND VPWR sky130_fd_sc_hd__tapvpwrvgnd_1
XTAP_TAPCELL_ROW_44_967 VGND VPWR sky130_fd_sc_hd__tapvpwrvgnd_1
XFILLER_0_95_482 VGND VGND VPWR VPWR sky130_fd_sc_hd__decap_4
XFILLER_0_83_633 VGND VGND VPWR VPWR sky130_fd_sc_hd__decap_3
XFILLER_0_23_69 VPWR VGND VPWR VGND sky130_ef_sc_hd__decap_12
XFILLER_0_138_573 VPWR VGND VPWR VGND sky130_ef_sc_hd__decap_12
XFILLER_0_126_713 VPWR VGND VPWR VGND sky130_ef_sc_hd__decap_12
XFILLER_0_83_677 VPWR VGND VPWR VGND sky130_ef_sc_hd__decap_12
XFILLER_0_82_121 VPWR VGND VPWR VGND sky130_ef_sc_hd__decap_12
XFILLER_0_130_15 VPWR VGND VPWR VGND sky130_ef_sc_hd__decap_12
XFILLER_0_126_757 VPWR VGND VPWR VGND sky130_ef_sc_hd__decap_12
XFILLER_0_125_223 VGND VGND VPWR VPWR sky130_fd_sc_hd__fill_1
XFILLER_0_82_165 VPWR VGND VPWR VGND sky130_ef_sc_hd__decap_12
XFILLER_0_36_571 VGND VGND VPWR VPWR sky130_fd_sc_hd__decap_4
XFILLER_0_113_429 VPWR VGND VPWR VGND sky130_ef_sc_hd__decap_12
Xrebuffer3 _1075_ VGND VGND VPWR VPWR net16 sky130_fd_sc_hd__dlygate4sd1_1
XFILLER_0_24_755 VGND VGND VPWR VPWR sky130_fd_sc_hd__fill_1
XFILLER_0_11_405 VPWR VGND VPWR VGND sky130_ef_sc_hd__decap_12
XFILLER_0_11_449 VPWR VGND VPWR VGND sky130_ef_sc_hd__decap_12
XFILLER_0_121_473 VPWR VGND VPWR VGND sky130_ef_sc_hd__decap_12
X_4200_ cpu_inst.regfile_inst.registers\[4\]\[17\] _2035_ VGND VGND VPWR VPWR _2042_
+ sky130_fd_sc_hd__and2_1
X_5180_ clknet_leaf_33_clk _0100_ VGND VGND VPWR VPWR cpu_inst.regfile_inst.registers\[4\]\[4\]
+ sky130_fd_sc_hd__dfxtp_1
X_4131_ _1418_ cpu_inst.regfile_inst.registers\[25\]\[17\] _1991_ VGND VGND VPWR VPWR
+ _2005_ sky130_fd_sc_hd__mux2_1
XFILLER_0_48_77 VGND VGND VPWR VPWR sky130_fd_sc_hd__decap_6
X_4062_ cpu_inst.regfile_inst.registers\[2\]\[18\] VGND VGND VPWR VPWR _1967_ sky130_fd_sc_hd__clkbuf_1
XTAP_TAPCELL_ROW_69_1331 VGND VPWR sky130_fd_sc_hd__tapvpwrvgnd_1
X_3013_ _0962_ _0977_ VGND VGND VPWR VPWR _0978_ sky130_fd_sc_hd__xnor2_1
XFILLER_0_3_57 VPWR VGND VPWR VGND sky130_ef_sc_hd__decap_12
XTAP_TAPCELL_ROW_69_1342 VGND VPWR sky130_fd_sc_hd__tapvpwrvgnd_1
XFILLER_0_64_65 VPWR VGND VPWR VGND sky130_ef_sc_hd__decap_12
Xclkbuf_leaf_16_clk clknet_2_3__leaf_clk VGND VGND VPWR VPWR clknet_leaf_16_clk sky130_fd_sc_hd__clkbuf_8
XTAP_TAPCELL_ROW_82_1531 VGND VPWR sky130_fd_sc_hd__tapvpwrvgnd_1
XFILLER_0_19_505 VPWR VGND VPWR VGND sky130_ef_sc_hd__decap_12
X_4964_ _2470_ VGND VGND VPWR VPWR _0448_ sky130_fd_sc_hd__clkbuf_1
X_3915_ cpu_inst.regfile_inst.registers\[25\]\[29\] _1310_ _1311_ _1840_ VGND VGND
+ VPWR VPWR _1841_ sky130_fd_sc_hd__o211a_1
XFILLER_0_80_53 VPWR VGND VPWR VGND sky130_ef_sc_hd__decap_12
XFILLER_0_59_685 VPWR VGND VPWR VGND sky130_ef_sc_hd__decap_12
XFILLER_0_129_573 VPWR VGND VPWR VGND sky130_ef_sc_hd__decap_12
XFILLER_0_80_97 VPWR VGND VPWR VGND sky130_ef_sc_hd__decap_12
XFILLER_0_58_195 VGND VGND VPWR VPWR sky130_fd_sc_hd__fill_1
XTAP_TAPCELL_ROW_22_628 VGND VPWR sky130_fd_sc_hd__tapvpwrvgnd_1
X_4895_ _2433_ VGND VGND VPWR VPWR _0416_ sky130_fd_sc_hd__clkbuf_1
XFILLER_0_46_357 VGND VGND VPWR VPWR sky130_fd_sc_hd__decap_6
XFILLER_0_116_245 VGND VGND VPWR VPWR sky130_fd_sc_hd__decap_6
X_3846_ cpu_inst.regfile_inst.registers\[11\]\[27\] cpu_inst.regfile_inst.registers\[10\]\[27\]
+ _1592_ VGND VGND VPWR VPWR _1774_ sky130_fd_sc_hd__mux2_1
XFILLER_0_61_305 VGND VGND VPWR VPWR sky130_fd_sc_hd__decap_4
XFILLER_0_6_421 VPWR VGND VPWR VGND sky130_ef_sc_hd__decap_12
XFILLER_0_89_51 VGND VGND VPWR VPWR sky130_fd_sc_hd__decap_4
X_3777_ _1706_ VGND VGND VPWR VPWR _1707_ sky130_fd_sc_hd__inv_2
XFILLER_0_80_3 VPWR VGND VPWR VGND sky130_ef_sc_hd__decap_12
XFILLER_0_61_349 VPWR VGND VPWR VGND sky130_ef_sc_hd__decap_12
XFILLER_0_14_221 VPWR VGND VPWR VGND sky130_ef_sc_hd__decap_12
XFILLER_0_132_749 VGND VGND VPWR VPWR sky130_fd_sc_hd__decap_6
XFILLER_0_131_237 VPWR VGND VPWR VGND sky130_ef_sc_hd__decap_12
XFILLER_0_116_289 VPWR VGND VPWR VGND sky130_ef_sc_hd__decap_12
X_5516_ clknet_leaf_17_clk _0436_ VGND VGND VPWR VPWR cpu_inst.regfile_inst.registers\[8\]\[20\]
+ sky130_fd_sc_hd__dfxtp_1
X_2728_ _0692_ VGND VGND VPWR VPWR _0693_ sky130_fd_sc_hd__clkbuf_4
XFILLER_0_14_265 VPWR VGND VPWR VGND sky130_ef_sc_hd__decap_12
XFILLER_0_15_777 VGND VGND VPWR VPWR sky130_fd_sc_hd__decap_6
X_5447_ clknet_leaf_21_clk _0367_ VGND VGND VPWR VPWR cpu_inst.regfile_inst.registers\[0\]\[15\]
+ sky130_fd_sc_hd__dfxtp_1
XFILLER_0_2_693 VGND VGND VPWR VPWR sky130_fd_sc_hd__decap_6
XFILLER_0_30_769 VPWR VGND VPWR VGND sky130_ef_sc_hd__decap_12
X_2659_ cpu_inst.regfile_inst.registers\[8\]\[1\] _0598_ VGND VGND VPWR VPWR _0624_
+ sky130_fd_sc_hd__or2_1
XTAP_TAPCELL_ROW_93_1693 VGND VPWR sky130_fd_sc_hd__tapvpwrvgnd_1
XFILLER_0_1_181 VPWR VGND VPWR VGND sky130_ef_sc_hd__decap_12
X_5378_ clknet_leaf_32_clk _0298_ VGND VGND VPWR VPWR cpu_inst.regfile_inst.registers\[10\]\[10\]
+ sky130_fd_sc_hd__dfxtp_1
X_4329_ _2109_ VGND VGND VPWR VPWR _0174_ sky130_fd_sc_hd__clkbuf_1
XPHY_EDGE_ROW_114_Right_114 VGND VGND VPWR VPWR sky130_fd_sc_hd__decap_3
XTAP_TAPCELL_ROW_2_331 VGND VPWR sky130_fd_sc_hd__tapvpwrvgnd_1
XTAP_TAPCELL_ROW_41_915 VGND VPWR sky130_fd_sc_hd__tapvpwrvgnd_1
XFILLER_0_108_713 VPWR VGND VPWR VGND sky130_ef_sc_hd__decap_12
XFILLER_0_64_121 VPWR VGND VPWR VGND sky130_ef_sc_hd__decap_12
XFILLER_0_37_335 VGND VGND VPWR VPWR sky130_fd_sc_hd__fill_1
XFILLER_0_108_757 VPWR VGND VPWR VGND sky130_ef_sc_hd__decap_12
XFILLER_0_107_223 VGND VGND VPWR VPWR sky130_fd_sc_hd__fill_1
XFILLER_0_64_165 VPWR VGND VPWR VGND sky130_ef_sc_hd__decap_12
XFILLER_0_9_281 VPWR VGND VPWR VGND sky130_ef_sc_hd__decap_12
XFILLER_0_123_727 VGND VGND VPWR VPWR sky130_fd_sc_hd__fill_1
XFILLER_0_100_29 VPWR VGND VPWR VGND sky130_ef_sc_hd__decap_12
XFILLER_0_109_27 VPWR VGND VPWR VGND sky130_ef_sc_hd__decap_12
XFILLER_0_125_15 VPWR VGND VPWR VGND sky130_ef_sc_hd__decap_12
XTAP_TAPCELL_ROW_109_1932 VGND VPWR sky130_fd_sc_hd__tapvpwrvgnd_1
XFILLER_0_87_279 VGND VGND VPWR VPWR sky130_fd_sc_hd__fill_1
XFILLER_0_68_493 VPWR VGND VPWR VGND sky130_ef_sc_hd__decap_12
XFILLER_0_68_460 VGND VGND VPWR VPWR sky130_fd_sc_hd__decap_6
XTAP_TAPCELL_ROW_64_1261 VGND VPWR sky130_fd_sc_hd__tapvpwrvgnd_1
X_3700_ _1620_ _1631_ VGND VGND VPWR VPWR _1632_ sky130_fd_sc_hd__xnor2_2
XFILLER_0_56_666 VPWR VGND VPWR VGND sky130_ef_sc_hd__decap_12
XFILLER_0_28_357 VGND VGND VPWR VPWR sky130_fd_sc_hd__decap_6
XFILLER_0_71_614 VGND VGND VPWR VPWR sky130_fd_sc_hd__fill_2
X_4680_ _1988_ _2303_ VGND VGND VPWR VPWR _2307_ sky130_fd_sc_hd__nand2_1
XFILLER_0_43_305 VPWR VGND VPWR VGND sky130_ef_sc_hd__decap_12
XFILLER_0_126_587 VGND VGND VPWR VPWR sky130_fd_sc_hd__fill_1
XFILLER_0_119_3 VPWR VGND VPWR VGND sky130_ef_sc_hd__decap_12
X_3631_ _0843_ _1563_ _1564_ net42 VGND VGND VPWR VPWR _1565_ sky130_fd_sc_hd__o211a_1
XFILLER_0_43_349 VPWR VGND VPWR VGND sky130_ef_sc_hd__decap_12
XFILLER_0_114_749 VGND VGND VPWR VPWR sky130_fd_sc_hd__decap_6
XFILLER_0_113_237 VPWR VGND VPWR VGND sky130_ef_sc_hd__decap_12
X_3562_ _1495_ _1496_ _1351_ VGND VGND VPWR VPWR _1497_ sky130_fd_sc_hd__mux2_1
X_5301_ clknet_leaf_6_clk _0221_ VGND VGND VPWR VPWR cpu_inst.regfile_inst.registers\[1\]\[29\]
+ sky130_fd_sc_hd__dfxtp_1
XFILLER_0_12_725 VPWR VGND VPWR VGND sky130_ef_sc_hd__decap_12
XFILLER_0_24_585 VGND VGND VPWR VPWR sky130_fd_sc_hd__decap_3
XFILLER_0_51_382 VGND VGND VPWR VPWR sky130_fd_sc_hd__fill_2
XFILLER_0_122_793 VPWR VGND VPWR VGND sky130_ef_sc_hd__decap_12
X_3493_ _1359_ _1369_ _1429_ _0696_ VGND VGND VPWR VPWR _1430_ sky130_fd_sc_hd__a31o_1
XFILLER_0_12_769 VPWR VGND VPWR VGND sky130_ef_sc_hd__decap_12
XFILLER_0_121_281 VPWR VGND VPWR VGND sky130_ef_sc_hd__decap_12
X_5232_ clknet_leaf_10_clk _0152_ VGND VGND VPWR VPWR cpu_inst.regfile_inst.registers\[24\]\[24\]
+ sky130_fd_sc_hd__dfxtp_1
Xclkbuf_leaf_5_clk clknet_2_1__leaf_clk VGND VGND VPWR VPWR clknet_leaf_5_clk sky130_fd_sc_hd__clkbuf_8
XFILLER_0_11_279 VGND VGND VPWR VPWR sky130_fd_sc_hd__fill_1
X_5163_ clknet_leaf_12_clk _0083_ VGND VGND VPWR VPWR cpu_inst.regfile_inst.registers\[25\]\[19\]
+ sky130_fd_sc_hd__dfxtp_1
X_4114_ _1100_ cpu_inst.regfile_inst.registers\[25\]\[9\] _1982_ VGND VGND VPWR VPWR
+ _1996_ sky130_fd_sc_hd__mux2_1
X_5094_ clknet_leaf_27_clk _0014_ VGND VGND VPWR VPWR cpu_inst.regfile_inst.registers\[6\]\[14\]
+ sky130_fd_sc_hd__dfxtp_1
XTAP_TAPCELL_ROW_27_709 VGND VPWR sky130_fd_sc_hd__tapvpwrvgnd_1
X_4045_ _1958_ VGND VGND VPWR VPWR _0041_ sky130_fd_sc_hd__clkbuf_1
XFILLER_0_93_205 VPWR VGND VPWR VGND sky130_ef_sc_hd__decap_12
XFILLER_0_115_81 VPWR VGND VPWR VGND sky130_ef_sc_hd__decap_12
XFILLER_0_47_633 VGND VGND VPWR VPWR sky130_fd_sc_hd__fill_2
XFILLER_0_136_307 VGND VGND VPWR VPWR sky130_fd_sc_hd__fill_1
X_4947_ _1726_ cpu_inst.regfile_inst.registers\[8\]\[25\] _2449_ VGND VGND VPWR VPWR
+ _2461_ sky130_fd_sc_hd__mux2_1
XFILLER_0_93_249 VPWR VGND VPWR VGND sky130_ef_sc_hd__decap_12
XFILLER_0_19_335 VGND VGND VPWR VPWR sky130_fd_sc_hd__fill_1
XFILLER_0_46_121 VPWR VGND VPWR VGND sky130_ef_sc_hd__decap_12
X_4878_ cpu_inst.regfile_inst.registers\[9\]\[25\] VGND VGND VPWR VPWR _2424_ sky130_fd_sc_hd__clkbuf_1
XFILLER_0_74_474 VGND VGND VPWR VPWR sky130_fd_sc_hd__fill_2
XFILLER_0_7_741 VPWR VGND VPWR VGND sky130_ef_sc_hd__decap_12
XFILLER_0_35_839 VGND VGND VPWR VPWR sky130_fd_sc_hd__fill_1
XFILLER_0_46_165 VPWR VGND VPWR VGND sky130_ef_sc_hd__decap_12
XFILLER_0_132_513 VPWR VGND VPWR VGND sky130_ef_sc_hd__decap_12
X_3829_ _1251_ _1605_ VGND VGND VPWR VPWR _1758_ sky130_fd_sc_hd__or2_1
XFILLER_0_61_113 VPWR VGND VPWR VGND sky130_ef_sc_hd__decap_12
XFILLER_0_7_785 VPWR VGND VPWR VGND sky130_ef_sc_hd__decap_12
XFILLER_0_6_251 VGND VGND VPWR VPWR sky130_fd_sc_hd__fill_1
XTAP_TAPCELL_ROW_95_1722 VGND VPWR sky130_fd_sc_hd__tapvpwrvgnd_1
XFILLER_0_15_541 VPWR VGND VPWR VGND sky130_ef_sc_hd__decap_12
XFILLER_0_132_557 VPWR VGND VPWR VGND sky130_ef_sc_hd__decap_12
XFILLER_0_15_585 VPWR VGND VPWR VGND sky130_ef_sc_hd__decap_12
XFILLER_0_30_533 VGND VGND VPWR VPWR sky130_fd_sc_hd__decap_3
XTAP_TAPCELL_ROW_7_412 VGND VPWR sky130_fd_sc_hd__tapvpwrvgnd_1
XTAP_TAPCELL_ROW_7_401 VGND VPWR sky130_fd_sc_hd__tapvpwrvgnd_1
XFILLER_0_100_487 VGND VGND VPWR VPWR sky130_fd_sc_hd__decap_8
XTAP_TAPCELL_ROW_122_2129 VGND VPWR sky130_fd_sc_hd__tapvpwrvgnd_1
XTAP_TAPCELL_ROW_104_1862 VGND VPWR sky130_fd_sc_hd__tapvpwrvgnd_1
XFILLER_0_97_599 VGND VGND VPWR VPWR sky130_fd_sc_hd__fill_2
XFILLER_0_69_279 VGND VGND VPWR VPWR sky130_fd_sc_hd__fill_1
XFILLER_0_127_329 VGND VGND VPWR VPWR sky130_fd_sc_hd__decap_6
XFILLER_0_136_841 VGND VGND VPWR VPWR sky130_fd_sc_hd__fill_1
XFILLER_0_93_794 VGND VGND VPWR VPWR sky130_fd_sc_hd__fill_1
XFILLER_0_25_305 VPWR VGND VPWR VGND sky130_ef_sc_hd__decap_12
XTAP_TAPCELL_ROW_137_2361 VGND VPWR sky130_fd_sc_hd__tapvpwrvgnd_1
XTAP_TAPCELL_ROW_137_2350 VGND VPWR sky130_fd_sc_hd__tapvpwrvgnd_1
XFILLER_0_20_15 VPWR VGND VPWR VGND sky130_ef_sc_hd__decap_12
XFILLER_0_25_349 VPWR VGND VPWR VGND sky130_ef_sc_hd__decap_12
XFILLER_0_135_373 VPWR VGND VPWR VGND sky130_ef_sc_hd__decap_12
XFILLER_0_111_39 VPWR VGND VPWR VGND sky130_ef_sc_hd__decap_12
XFILLER_0_104_793 VPWR VGND VPWR VGND sky130_ef_sc_hd__decap_12
XFILLER_0_0_405 VPWR VGND VPWR VGND sky130_ef_sc_hd__decap_12
XFILLER_0_33_393 VPWR VGND VPWR VGND sky130_ef_sc_hd__decap_12
XFILLER_0_103_281 VPWR VGND VPWR VGND sky130_ef_sc_hd__decap_12
XFILLER_0_0_449 VPWR VGND VPWR VGND sky130_ef_sc_hd__decap_12
XFILLER_0_29_57 VPWR VGND VPWR VGND sky130_ef_sc_hd__decap_12
XFILLER_0_75_205 VPWR VGND VPWR VGND sky130_ef_sc_hd__decap_12
XFILLER_0_118_307 VGND VGND VPWR VPWR sky130_fd_sc_hd__fill_1
X_4801_ _2385_ VGND VGND VPWR VPWR _0370_ sky130_fd_sc_hd__clkbuf_1
XFILLER_0_84_750 VGND VGND VPWR VPWR sky130_fd_sc_hd__decap_6
XFILLER_0_75_249 VPWR VGND VPWR VGND sky130_ef_sc_hd__decap_12
XFILLER_0_61_55 VGND VGND VPWR VPWR sky130_fd_sc_hd__fill_1
XFILLER_0_0_69 VPWR VGND VPWR VGND sky130_ef_sc_hd__decap_12
XFILLER_0_28_121 VPWR VGND VPWR VGND sky130_ef_sc_hd__decap_12
X_2993_ _0863_ _0955_ _0957_ _0875_ VGND VGND VPWR VPWR _0958_ sky130_fd_sc_hd__o22a_1
XFILLER_0_127_841 VGND VGND VPWR VPWR sky130_fd_sc_hd__fill_1
XFILLER_0_84_761 VGND VGND VPWR VPWR sky130_fd_sc_hd__fill_1
X_4732_ _2293_ _2344_ cpu_inst.decoder_inst.current_pc\[22\] _2289_ VGND VGND VPWR
+ VPWR _0342_ sky130_fd_sc_hd__o2bb2a_1
XFILLER_0_28_165 VPWR VGND VPWR VGND sky130_ef_sc_hd__decap_12
XFILLER_0_83_293 VPWR VGND VPWR VGND sky130_ef_sc_hd__decap_12
XFILLER_0_71_444 VGND VGND VPWR VPWR sky130_fd_sc_hd__fill_1
X_4663_ _0521_ cpu_inst.decoder_inst.current_pc\[2\] cpu_inst.decoder_inst.current_pc\[4\]
+ VGND VGND VPWR VPWR _2294_ sky130_fd_sc_hd__a21oi_1
XTAP_TAPCELL_ROW_32_778 VGND VPWR sky130_fd_sc_hd__tapvpwrvgnd_1
XFILLER_0_43_113 VPWR VGND VPWR VGND sky130_ef_sc_hd__decap_12
XFILLER_0_114_513 VPWR VGND VPWR VGND sky130_ef_sc_hd__decap_12
X_3614_ _1251_ _1414_ _1547_ _1153_ VGND VGND VPWR VPWR _1548_ sky130_fd_sc_hd__o211a_1
XTAP_TAPCELL_ROW_12_480 VGND VPWR sky130_fd_sc_hd__tapvpwrvgnd_1
XFILLER_0_32_809 VGND VGND VPWR VPWR sky130_fd_sc_hd__decap_3
XFILLER_0_114_557 VPWR VGND VPWR VGND sky130_ef_sc_hd__decap_12
X_4594_ _2245_ VGND VGND VPWR VPWR _0303_ sky130_fd_sc_hd__clkbuf_1
XFILLER_0_4_755 VGND VGND VPWR VPWR sky130_fd_sc_hd__fill_1
X_3545_ _1468_ _1480_ VGND VGND VPWR VPWR _1481_ sky130_fd_sc_hd__xnor2_1
XTAP_TAPCELL_ROW_77_1452 VGND VPWR sky130_fd_sc_hd__tapvpwrvgnd_1
XFILLER_0_12_533 VPWR VGND VPWR VGND sky130_ef_sc_hd__decap_12
X_3476_ _1254_ _1413_ _1062_ VGND VGND VPWR VPWR _1414_ sky130_fd_sc_hd__mux2_1
XTAP_TAPCELL_ROW_90_1652 VGND VPWR sky130_fd_sc_hd__tapvpwrvgnd_1
XFILLER_0_86_41 VPWR VGND VPWR VGND sky130_ef_sc_hd__decap_12
X_5215_ clknet_leaf_36_clk _0135_ VGND VGND VPWR VPWR cpu_inst.regfile_inst.registers\[24\]\[7\]
+ sky130_fd_sc_hd__dfxtp_1
XFILLER_0_86_85 VPWR VGND VPWR VGND sky130_ef_sc_hd__decap_12
XFILLER_0_43_3 VPWR VGND VPWR VGND sky130_ef_sc_hd__decap_12
XFILLER_0_99_809 VPWR VGND VPWR VGND sky130_ef_sc_hd__decap_12
X_5146_ clknet_leaf_1_clk _0066_ VGND VGND VPWR VPWR cpu_inst.regfile_inst.registers\[25\]\[2\]
+ sky130_fd_sc_hd__dfxtp_1
X_5077_ cpu_inst.display_inst.counter\[18\] _2532_ VGND VGND VPWR VPWR _2533_ sky130_fd_sc_hd__and2_1
X_4028_ cpu_inst.regfile_inst.registers\[2\]\[1\] VGND VGND VPWR VPWR _1950_ sky130_fd_sc_hd__clkbuf_1
XFILLER_0_79_566 VGND VGND VPWR VPWR sky130_fd_sc_hd__decap_4
XFILLER_0_94_536 VGND VGND VPWR VPWR sky130_fd_sc_hd__decap_8
XFILLER_0_109_329 VGND VGND VPWR VPWR sky130_fd_sc_hd__decap_6
XFILLER_0_47_441 VGND VGND VPWR VPWR sky130_fd_sc_hd__decap_6
XFILLER_0_118_841 VGND VGND VPWR VPWR sky130_fd_sc_hd__fill_1
XFILLER_0_75_783 VGND VGND VPWR VPWR sky130_fd_sc_hd__fill_1
XFILLER_0_47_474 VPWR VGND VPWR VGND sky130_ef_sc_hd__decap_12
XFILLER_0_105_502 VGND VGND VPWR VPWR sky130_fd_sc_hd__fill_2
XFILLER_0_133_833 VGND VGND VPWR VPWR sky130_fd_sc_hd__decap_6
XFILLER_0_132_321 VPWR VGND VPWR VGND sky130_ef_sc_hd__decap_12
XTAP_TAPCELL_ROW_119_2080 VGND VPWR sky130_fd_sc_hd__tapvpwrvgnd_1
XFILLER_0_117_373 VPWR VGND VPWR VGND sky130_ef_sc_hd__decap_12
XFILLER_0_23_809 VPWR VGND VPWR VGND sky130_ef_sc_hd__decap_12
XTAP_TAPCELL_ROW_119_2091 VGND VPWR sky130_fd_sc_hd__tapvpwrvgnd_1
XFILLER_0_62_499 VGND VGND VPWR VPWR sky130_fd_sc_hd__decap_8
XFILLER_0_50_639 VGND VGND VPWR VPWR sky130_fd_sc_hd__fill_1
XFILLER_0_132_365 VPWR VGND VPWR VGND sky130_ef_sc_hd__decap_12
XFILLER_0_15_393 VPWR VGND VPWR VGND sky130_ef_sc_hd__decap_12
XTAP_TAPCELL_ROW_132_2280 VGND VPWR sky130_fd_sc_hd__tapvpwrvgnd_1
XFILLER_0_30_363 VGND VGND VPWR VPWR sky130_fd_sc_hd__fill_1
XFILLER_0_101_785 VPWR VGND VPWR VGND sky130_ef_sc_hd__decap_12
XFILLER_0_100_251 VGND VGND VPWR VPWR sky130_fd_sc_hd__fill_1
XFILLER_0_15_15 VPWR VGND VPWR VGND sky130_ef_sc_hd__decap_12
XTAP_TAPCELL_ROW_48_1020 VGND VPWR sky130_fd_sc_hd__tapvpwrvgnd_1
XFILLER_0_97_385 VGND VGND VPWR VPWR sky130_fd_sc_hd__decap_6
XFILLER_0_57_205 VPWR VGND VPWR VGND sky130_ef_sc_hd__decap_12
XFILLER_0_57_249 VPWR VGND VPWR VGND sky130_ef_sc_hd__decap_12
XFILLER_0_127_137 VPWR VGND VPWR VGND sky130_ef_sc_hd__decap_12
XFILLER_0_122_27 VGND VGND VPWR VPWR sky130_fd_sc_hd__fill_1
XFILLER_0_109_841 VGND VGND VPWR VPWR sky130_fd_sc_hd__fill_1
XFILLER_0_66_772 VGND VGND VPWR VPWR sky130_fd_sc_hd__decap_3
XTAP_TAPCELL_ROW_61_1220 VGND VPWR sky130_fd_sc_hd__tapvpwrvgnd_1
XFILLER_0_65_293 VPWR VGND VPWR VGND sky130_ef_sc_hd__decap_12
XFILLER_0_25_113 VPWR VGND VPWR VGND sky130_ef_sc_hd__decap_12
XFILLER_0_136_693 VGND VGND VPWR VPWR sky130_fd_sc_hd__decap_6
XFILLER_0_124_811 VGND VGND VPWR VPWR sky130_fd_sc_hd__fill_1
XFILLER_0_53_444 VGND VGND VPWR VPWR sky130_fd_sc_hd__decap_4
XFILLER_0_26_669 VPWR VGND VPWR VGND sky130_ef_sc_hd__decap_12
XFILLER_0_31_69 VPWR VGND VPWR VGND sky130_ef_sc_hd__decap_12
XFILLER_0_135_181 VPWR VGND VPWR VGND sky130_ef_sc_hd__decap_12
XFILLER_0_53_499 VGND VGND VPWR VPWR sky130_fd_sc_hd__decap_4
XFILLER_0_53_488 VGND VGND VPWR VPWR sky130_fd_sc_hd__decap_4
XFILLER_0_111_505 VPWR VGND VPWR VGND sky130_ef_sc_hd__decap_12
X_3330_ _1252_ VGND VGND VPWR VPWR _1285_ sky130_fd_sc_hd__clkbuf_4
XTAP_TAPCELL_ROW_59_1182 VGND VPWR sky130_fd_sc_hd__tapvpwrvgnd_1
XFILLER_0_21_385 VGND VGND VPWR VPWR sky130_fd_sc_hd__decap_6
X_5000_ cpu_inst.regfile_inst.registers\[15\]\[18\] _2480_ VGND VGND VPWR VPWR _2489_
+ sky130_fd_sc_hd__and2_1
X_3261_ _0841_ _1112_ _1225_ _0696_ VGND VGND VPWR VPWR _1226_ sky130_fd_sc_hd__a31o_1
XTAP_TAPCELL_ROW_72_1382 VGND VPWR sky130_fd_sc_hd__tapvpwrvgnd_1
X_3192_ cpu_inst.display_inst.digit_select\[0\] _0690_ VGND VGND VPWR VPWR _1157_
+ sky130_fd_sc_hd__nor2_1
XPHY_EDGE_ROW_0_Left_139 VGND VGND VPWR VPWR sky130_fd_sc_hd__decap_3
XFILLER_0_56_77 VGND VGND VPWR VPWR sky130_fd_sc_hd__decap_6
XTAP_TAPCELL_ROW_37_848 VGND VPWR sky130_fd_sc_hd__tapvpwrvgnd_1
XFILLER_0_49_706 VGND VGND VPWR VPWR sky130_fd_sc_hd__decap_8
XFILLER_0_88_363 VGND VGND VPWR VPWR sky130_fd_sc_hd__fill_1
XFILLER_0_72_65 VPWR VGND VPWR VGND sky130_ef_sc_hd__decap_12
XTAP_TAPCELL_ROW_37_859 VGND VPWR sky130_fd_sc_hd__tapvpwrvgnd_1
XTAP_TAPCELL_ROW_17_550 VGND VPWR sky130_fd_sc_hd__tapvpwrvgnd_1
XTAP_TAPCELL_ROW_17_561 VGND VPWR sky130_fd_sc_hd__tapvpwrvgnd_1
XFILLER_0_29_441 VGND VGND VPWR VPWR sky130_fd_sc_hd__decap_6
XFILLER_0_57_794 VGND VGND VPWR VPWR sky130_fd_sc_hd__fill_2
XFILLER_0_8_357 VGND VGND VPWR VPWR sky130_fd_sc_hd__decap_6
X_2976_ _0939_ _0940_ _0653_ VGND VGND VPWR VPWR _0941_ sky130_fd_sc_hd__mux2_1
XFILLER_0_127_671 VGND VGND VPWR VPWR sky130_fd_sc_hd__fill_1
XFILLER_0_115_833 VGND VGND VPWR VPWR sky130_fd_sc_hd__decap_6
X_4715_ _2331_ _2332_ VGND VGND VPWR VPWR _2333_ sky130_fd_sc_hd__nor2_1
XFILLER_0_114_321 VPWR VGND VPWR VGND sky130_ef_sc_hd__decap_12
X_4646_ _1456_ _2272_ _2278_ VGND VGND VPWR VPWR _2279_ sky130_fd_sc_hd__or3_4
XFILLER_0_31_105 VGND VGND VPWR VPWR sky130_fd_sc_hd__decap_6
XFILLER_0_44_477 VGND VGND VPWR VPWR sky130_fd_sc_hd__fill_2
XFILLER_0_130_825 VPWR VGND VPWR VGND sky130_ef_sc_hd__decap_12
XFILLER_0_114_365 VPWR VGND VPWR VGND sky130_ef_sc_hd__decap_12
XFILLER_0_31_149 VPWR VGND VPWR VGND sky130_ef_sc_hd__decap_12
X_4577_ _2236_ VGND VGND VPWR VPWR _0295_ sky130_fd_sc_hd__clkbuf_1
XFILLER_0_97_51 VGND VGND VPWR VPWR sky130_fd_sc_hd__decap_4
XFILLER_0_12_363 VGND VGND VPWR VPWR sky130_fd_sc_hd__fill_1
X_3528_ _0864_ _1461_ _1463_ _0876_ VGND VGND VPWR VPWR _1464_ sky130_fd_sc_hd__o22a_1
X_3459_ cpu_inst.regfile_inst.registers\[15\]\[17\] _0710_ _0721_ _1396_ _0844_ VGND
+ VGND VPWR VPWR _1397_ sky130_fd_sc_hd__a221o_1
X_5129_ clknet_leaf_25_clk _0049_ VGND VGND VPWR VPWR cpu_inst.regfile_inst.registers\[2\]\[17\]
+ sky130_fd_sc_hd__dfxtp_1
XFILLER_0_67_503 VGND VGND VPWR VPWR sky130_fd_sc_hd__fill_1
XFILLER_0_39_205 VPWR VGND VPWR VGND sky130_ef_sc_hd__decap_12
XFILLER_0_94_333 VPWR VGND VPWR VGND sky130_ef_sc_hd__decap_12
XFILLER_0_67_558 VGND VGND VPWR VPWR sky130_fd_sc_hd__fill_2
XFILLER_0_39_249 VPWR VGND VPWR VGND sky130_ef_sc_hd__decap_12
XFILLER_0_109_137 VPWR VGND VPWR VGND sky130_ef_sc_hd__decap_12
XTAP_TAPCELL_ROW_101_1821 VGND VPWR sky130_fd_sc_hd__tapvpwrvgnd_1
XTAP_TAPCELL_ROW_101_1810 VGND VPWR sky130_fd_sc_hd__tapvpwrvgnd_1
XFILLER_0_94_377 VPWR VGND VPWR VGND sky130_ef_sc_hd__decap_12
XFILLER_0_82_517 VPWR VGND VPWR VGND sky130_ef_sc_hd__decap_12
XFILLER_0_82_506 VGND VGND VPWR VPWR sky130_fd_sc_hd__fill_2
XFILLER_0_118_693 VGND VGND VPWR VPWR sky130_fd_sc_hd__decap_6
XFILLER_0_106_811 VGND VGND VPWR VPWR sky130_fd_sc_hd__fill_1
XFILLER_0_47_293 VPWR VGND VPWR VGND sky130_ef_sc_hd__decap_12
XFILLER_0_133_641 VPWR VGND VPWR VGND sky130_ef_sc_hd__decap_12
XFILLER_0_117_181 VPWR VGND VPWR VGND sky130_ef_sc_hd__decap_12
XFILLER_0_23_617 VPWR VGND VPWR VGND sky130_ef_sc_hd__decap_12
XFILLER_0_133_685 VPWR VGND VPWR VGND sky130_ef_sc_hd__decap_12
XFILLER_0_50_458 VGND VGND VPWR VPWR sky130_fd_sc_hd__decap_4
XFILLER_0_132_195 VGND VGND VPWR VPWR sky130_fd_sc_hd__fill_1
XFILLER_0_120_357 VGND VGND VPWR VPWR sky130_fd_sc_hd__decap_6
XTAP_TAPCELL_ROW_112_1983 VGND VPWR sky130_fd_sc_hd__tapvpwrvgnd_1
XFILLER_0_117_27 VPWR VGND VPWR VGND sky130_ef_sc_hd__decap_12
XFILLER_0_89_105 VGND VGND VPWR VPWR sky130_fd_sc_hd__decap_6
XFILLER_0_89_149 VPWR VGND VPWR VGND sky130_ef_sc_hd__decap_12
XFILLER_0_133_15 VPWR VGND VPWR VGND sky130_ef_sc_hd__decap_12
XTAP_TAPCELL_ROW_34_807 VGND VPWR sky130_fd_sc_hd__tapvpwrvgnd_1
XFILLER_0_97_193 VPWR VGND VPWR VGND sky130_ef_sc_hd__decap_12
XFILLER_0_128_413 VGND VGND VPWR VPWR sky130_fd_sc_hd__decap_6
X_2830_ _0794_ _0783_ _0636_ _0639_ VGND VGND VPWR VPWR _0795_ sky130_fd_sc_hd__a31o_1
XFILLER_0_128_457 VPWR VGND VPWR VGND sky130_ef_sc_hd__decap_12
XFILLER_0_85_388 VGND VGND VPWR VPWR sky130_fd_sc_hd__decap_4
XFILLER_0_109_671 VGND VGND VPWR VPWR sky130_fd_sc_hd__fill_1
XFILLER_0_54_775 VPWR VGND VPWR VGND sky130_ef_sc_hd__decap_12
XFILLER_0_5_305 VPWR VGND VPWR VGND sky130_ef_sc_hd__decap_12
XFILLER_0_26_433 VPWR VGND VPWR VGND sky130_ef_sc_hd__decap_12
X_2761_ _0593_ VGND VGND VPWR VPWR _0726_ sky130_fd_sc_hd__buf_2
XFILLER_0_81_561 VGND VGND VPWR VPWR sky130_fd_sc_hd__fill_1
X_5480_ clknet_leaf_22_clk _0400_ VGND VGND VPWR VPWR cpu_inst.regfile_inst.registers\[9\]\[16\]
+ sky130_fd_sc_hd__dfxtp_1
XFILLER_0_13_105 VGND VGND VPWR VPWR sky130_fd_sc_hd__decap_6
XFILLER_0_5_349 VPWR VGND VPWR VGND sky130_ef_sc_hd__decap_12
XFILLER_0_26_477 VPWR VGND VPWR VGND sky130_ef_sc_hd__decap_12
X_4500_ cpu_inst.regfile_inst.registers\[11\]\[1\] VGND VGND VPWR VPWR _2198_ sky130_fd_sc_hd__clkbuf_1
X_2692_ _0656_ VGND VGND VPWR VPWR _0657_ sky130_fd_sc_hd__buf_2
XFILLER_0_112_825 VPWR VGND VPWR VGND sky130_ef_sc_hd__decap_12
XFILLER_0_101_3 VPWR VGND VPWR VGND sky130_ef_sc_hd__decap_12
XFILLER_0_13_149 VPWR VGND VPWR VGND sky130_ef_sc_hd__decap_12
X_4431_ _1174_ cpu_inst.regfile_inst.registers\[7\]\[0\] _2161_ VGND VGND VPWR VPWR
+ _2162_ sky130_fd_sc_hd__mux2_1
XFILLER_0_41_436 VGND VGND VPWR VPWR sky130_fd_sc_hd__decap_4
XFILLER_0_41_447 VGND VGND VPWR VPWR sky130_fd_sc_hd__fill_1
XFILLER_0_111_335 VGND VGND VPWR VPWR sky130_fd_sc_hd__fill_1
XTAP_TAPCELL_ROW_74_1411 VGND VPWR sky130_fd_sc_hd__tapvpwrvgnd_1
X_4362_ _2126_ VGND VGND VPWR VPWR _0190_ sky130_fd_sc_hd__clkbuf_1
X_3313_ _1200_ _1267_ VGND VGND VPWR VPWR _1275_ sky130_fd_sc_hd__and2b_1
X_4293_ cpu_inst.regfile_inst.registers\[24\]\[31\] VGND VGND VPWR VPWR _2089_ sky130_fd_sc_hd__clkbuf_1
XFILLER_0_21_193 VPWR VGND VPWR VGND sky130_ef_sc_hd__decap_12
X_3244_ net15 _1082_ VGND VGND VPWR VPWR _1209_ sky130_fd_sc_hd__nand2_1
X_3175_ _0929_ _1139_ _1057_ VGND VGND VPWR VPWR _1140_ sky130_fd_sc_hd__mux2_1
XFILLER_0_89_650 VPWR VGND VPWR VGND sky130_ef_sc_hd__decap_12
Xrebuffer24 cpu_inst.decoder_inst.current_pc\[9\] VGND VGND VPWR VPWR net37 sky130_fd_sc_hd__clkbuf_1
Xrebuffer13 _0582_ VGND VGND VPWR VPWR net26 sky130_fd_sc_hd__dlymetal6s2s_1
XFILLER_0_107_93 VPWR VGND VPWR VGND sky130_ef_sc_hd__decap_12
XFILLER_0_77_823 VPWR VGND VPWR VGND sky130_ef_sc_hd__decap_12
XTAP_TAPCELL_ROW_85_1573 VGND VPWR sky130_fd_sc_hd__tapvpwrvgnd_1
XFILLER_0_76_333 VPWR VGND VPWR VGND sky130_ef_sc_hd__decap_12
XFILLER_0_8_121 VPWR VGND VPWR VGND sky130_ef_sc_hd__decap_12
XFILLER_0_92_837 VGND VGND VPWR VPWR sky130_fd_sc_hd__decap_4
XFILLER_0_123_81 VPWR VGND VPWR VGND sky130_ef_sc_hd__decap_12
XFILLER_0_8_165 VPWR VGND VPWR VGND sky130_ef_sc_hd__decap_12
XFILLER_0_29_293 VPWR VGND VPWR VGND sky130_ef_sc_hd__decap_12
X_2959_ cpu_inst.regfile_inst.registers\[7\]\[5\] cpu_inst.regfile_inst.registers\[6\]\[5\]
+ _0922_ VGND VGND VPWR VPWR _0924_ sky130_fd_sc_hd__mux2_1
XFILLER_0_115_641 VPWR VGND VPWR VGND sky130_ef_sc_hd__decap_12
XFILLER_0_60_701 VGND VGND VPWR VPWR sky130_fd_sc_hd__decap_8
XFILLER_0_115_685 VPWR VGND VPWR VGND sky130_ef_sc_hd__decap_12
XFILLER_0_114_195 VGND VGND VPWR VPWR sky130_fd_sc_hd__fill_1
X_4629_ cpu_inst.display_inst.counter\[1\] cpu_inst.display_inst.counter\[0\] cpu_inst.display_inst.counter\[3\]
+ cpu_inst.display_inst.counter\[2\] VGND VGND VPWR VPWR _2264_ sky130_fd_sc_hd__or4_1
XFILLER_0_32_469 VGND VGND VPWR VPWR sky130_fd_sc_hd__fill_1
XFILLER_0_102_357 VGND VGND VPWR VPWR sky130_fd_sc_hd__decap_6
XFILLER_0_130_699 VGND VGND VPWR VPWR sky130_fd_sc_hd__fill_1
XFILLER_0_79_193 VPWR VGND VPWR VGND sky130_ef_sc_hd__decap_12
XTAP_TAPCELL_ROW_0_281 VGND VPWR sky130_fd_sc_hd__tapvpwrvgnd_1
XFILLER_0_94_141 VPWR VGND VPWR VGND sky130_ef_sc_hd__decap_12
XTAP_TAPCELL_ROW_0_292 VGND VPWR sky130_fd_sc_hd__tapvpwrvgnd_1
XFILLER_0_12_27 VGND VGND VPWR VPWR sky130_fd_sc_hd__fill_1
XFILLER_0_125_405 VPWR VGND VPWR VGND sky130_ef_sc_hd__decap_12
XFILLER_0_36_753 VGND VGND VPWR VPWR sky130_fd_sc_hd__decap_3
XFILLER_0_125_449 VPWR VGND VPWR VGND sky130_ef_sc_hd__decap_12
XFILLER_0_63_561 VGND VGND VPWR VPWR sky130_fd_sc_hd__decap_6
XFILLER_0_3_809 VPWR VGND VPWR VGND sky130_ef_sc_hd__decap_12
XFILLER_0_23_447 VGND VGND VPWR VPWR sky130_fd_sc_hd__fill_1
XFILLER_0_50_233 VPWR VGND VPWR VGND sky130_ef_sc_hd__decap_12
XFILLER_0_51_745 VGND VGND VPWR VPWR sky130_fd_sc_hd__fill_1
XFILLER_0_120_121 VPWR VGND VPWR VGND sky130_ef_sc_hd__decap_12
XFILLER_0_106_696 VGND VGND VPWR VPWR sky130_fd_sc_hd__decap_4
XFILLER_0_11_609 VGND VGND VPWR VPWR sky130_fd_sc_hd__decap_6
XPHY_EDGE_ROW_128_Right_128 VGND VGND VPWR VPWR sky130_fd_sc_hd__decap_3
XTAP_TAPCELL_ROW_56_1141 VGND VPWR sky130_fd_sc_hd__tapvpwrvgnd_1
Xoutput3 net3 VGND VGND VPWR VPWR an[0] sky130_fd_sc_hd__buf_1
XFILLER_0_50_277 VPWR VGND VPWR VGND sky130_ef_sc_hd__decap_12
XFILLER_0_120_165 VPWR VGND VPWR VGND sky130_ef_sc_hd__decap_12
XFILLER_0_128_15 VPWR VGND VPWR VGND sky130_ef_sc_hd__decap_12
XFILLER_0_37_57 VPWR VGND VPWR VGND sky130_ef_sc_hd__decap_12
XPHY_EDGE_ROW_90_Left_229 VGND VGND VPWR VPWR sky130_fd_sc_hd__decap_3
XFILLER_0_59_801 VGND VGND VPWR VPWR sky130_fd_sc_hd__decap_3
XFILLER_0_86_620 VGND VGND VPWR VPWR sky130_fd_sc_hd__fill_1
X_4980_ _2478_ VGND VGND VPWR VPWR _0456_ sky130_fd_sc_hd__clkbuf_1
XTAP_TAPCELL_ROW_47_998 VGND VPWR sky130_fd_sc_hd__tapvpwrvgnd_1
XFILLER_0_128_221 VPWR VGND VPWR VGND sky130_ef_sc_hd__decap_12
XFILLER_0_86_686 VGND VGND VPWR VPWR sky130_fd_sc_hd__fill_2
X_3931_ _1855_ _1856_ VGND VGND VPWR VPWR _1857_ sky130_fd_sc_hd__nor2_1
XFILLER_0_19_709 VPWR VGND VPWR VGND sky130_ef_sc_hd__decap_12
XFILLER_0_129_777 VGND VGND VPWR VPWR sky130_fd_sc_hd__decap_6
X_3862_ _1487_ _1641_ VGND VGND VPWR VPWR _1790_ sky130_fd_sc_hd__or2_1
XFILLER_0_128_265 VPWR VGND VPWR VGND sky130_ef_sc_hd__decap_12
XFILLER_0_6_625 VPWR VGND VPWR VGND sky130_ef_sc_hd__decap_12
XFILLER_0_27_753 VPWR VGND VPWR VGND sky130_ef_sc_hd__decap_12
X_2813_ _0584_ _0777_ VGND VGND VPWR VPWR _0778_ sky130_fd_sc_hd__or2_1
XFILLER_0_39_591 VGND VGND VPWR VPWR sky130_fd_sc_hd__decap_4
X_3793_ _1680_ _1721_ VGND VGND VPWR VPWR _1723_ sky130_fd_sc_hd__nand2_1
XFILLER_0_54_583 VGND VGND VPWR VPWR sky130_fd_sc_hd__fill_2
XFILLER_0_6_669 VPWR VGND VPWR VGND sky130_ef_sc_hd__decap_12
XFILLER_0_5_113 VPWR VGND VPWR VGND sky130_ef_sc_hd__decap_12
XFILLER_0_27_797 VGND VGND VPWR VPWR sky130_fd_sc_hd__decap_8
X_5532_ clknet_leaf_37_clk _0452_ VGND VGND VPWR VPWR cpu_inst.regfile_inst.registers\[15\]\[4\]
+ sky130_fd_sc_hd__dfxtp_1
XFILLER_0_81_391 VGND VGND VPWR VPWR sky130_fd_sc_hd__fill_1
X_2744_ _0555_ _0536_ VGND VGND VPWR VPWR _0709_ sky130_fd_sc_hd__and2_2
X_5463_ clknet_leaf_11_clk _0383_ VGND VGND VPWR VPWR cpu_inst.regfile_inst.registers\[0\]\[31\]
+ sky130_fd_sc_hd__dfxtp_1
X_2675_ _0639_ _0611_ VGND VGND VPWR VPWR _0640_ sky130_fd_sc_hd__nor2_2
XFILLER_0_14_469 VGND VGND VPWR VPWR sky130_fd_sc_hd__decap_6
X_4414_ _2152_ VGND VGND VPWR VPWR _0216_ sky130_fd_sc_hd__clkbuf_1
X_5394_ clknet_leaf_7_clk _0314_ VGND VGND VPWR VPWR cpu_inst.regfile_inst.registers\[10\]\[26\]
+ sky130_fd_sc_hd__dfxtp_1
XFILLER_0_78_53 VPWR VGND VPWR VGND sky130_ef_sc_hd__decap_12
XFILLER_0_112_699 VGND VGND VPWR VPWR sky130_fd_sc_hd__fill_1
X_4345_ _1608_ cpu_inst.regfile_inst.registers\[5\]\[22\] _2117_ VGND VGND VPWR VPWR
+ _2118_ sky130_fd_sc_hd__mux2_1
XFILLER_0_78_97 VPWR VGND VPWR VGND sky130_ef_sc_hd__decap_12
XFILLER_0_1_385 VGND VGND VPWR VPWR sky130_fd_sc_hd__decap_6
XFILLER_0_94_41 VPWR VGND VPWR VGND sky130_ef_sc_hd__decap_12
X_4276_ _2080_ VGND VGND VPWR VPWR _0150_ sky130_fd_sc_hd__clkbuf_1
XPHY_EDGE_ROW_129_Left_268 VGND VGND VPWR VPWR sky130_fd_sc_hd__decap_3
XFILLER_0_94_85 VPWR VGND VPWR VGND sky130_ef_sc_hd__decap_12
XTAP_TAPCELL_ROW_87_1602 VGND VPWR sky130_fd_sc_hd__tapvpwrvgnd_1
X_3227_ _1053_ _1026_ _1185_ _1191_ _0682_ VGND VGND VPWR VPWR _1192_ sky130_fd_sc_hd__a32o_2
X_3158_ _0700_ _1122_ VGND VGND VPWR VPWR _1123_ sky130_fd_sc_hd__or2_1
X_3089_ _1051_ _1047_ _1053_ VGND VGND VPWR VPWR _1054_ sky130_fd_sc_hd__o21a_1
XFILLER_0_76_141 VPWR VGND VPWR VGND sky130_ef_sc_hd__decap_12
XFILLER_0_92_623 VGND VGND VPWR VPWR sky130_fd_sc_hd__fill_2
XFILLER_0_91_111 VGND VGND VPWR VPWR sky130_fd_sc_hd__fill_1
XFILLER_0_9_441 VGND VGND VPWR VPWR sky130_fd_sc_hd__decap_6
XFILLER_0_107_405 VPWR VGND VPWR VGND sky130_ef_sc_hd__decap_12
XFILLER_0_64_358 VGND VGND VPWR VPWR sky130_fd_sc_hd__fill_1
XFILLER_0_9_485 VPWR VGND VPWR VGND sky130_ef_sc_hd__decap_12
XPHY_EDGE_ROW_138_Left_277 VGND VGND VPWR VPWR sky130_fd_sc_hd__decap_3
XFILLER_0_107_449 VGND VGND VPWR VPWR sky130_fd_sc_hd__fill_2
XFILLER_0_45_561 VGND VGND VPWR VPWR sky130_fd_sc_hd__decap_4
XFILLER_0_122_419 VGND VGND VPWR VPWR sky130_fd_sc_hd__fill_1
XTAP_TAPCELL_ROW_114_2009 VGND VPWR sky130_fd_sc_hd__tapvpwrvgnd_1
XTAP_TAPCELL_ROW_98_1764 VGND VPWR sky130_fd_sc_hd__tapvpwrvgnd_1
XFILLER_0_60_531 VGND VGND VPWR VPWR sky130_fd_sc_hd__fill_1
XFILLER_0_32_233 VPWR VGND VPWR VGND sky130_ef_sc_hd__decap_12
XTAP_TAPCELL_ROW_98_1775 VGND VPWR sky130_fd_sc_hd__tapvpwrvgnd_1
XFILLER_0_102_121 VPWR VGND VPWR VGND sky130_ef_sc_hd__decap_12
XFILLER_0_32_277 VPWR VGND VPWR VGND sky130_ef_sc_hd__decap_12
XFILLER_0_102_165 VPWR VGND VPWR VGND sky130_ef_sc_hd__decap_12
XTAP_TAPCELL_ROW_129_2241 VGND VPWR sky130_fd_sc_hd__tapvpwrvgnd_1
XTAP_TAPCELL_ROW_129_2230 VGND VPWR sky130_fd_sc_hd__tapvpwrvgnd_1
XTAP_TAPCELL_ROW_5_373 VGND VPWR sky130_fd_sc_hd__tapvpwrvgnd_1
XTAP_TAPCELL_ROW_51_1060 VGND VPWR sky130_fd_sc_hd__tapvpwrvgnd_1
XTAP_TAPCELL_ROW_51_1071 VGND VPWR sky130_fd_sc_hd__tapvpwrvgnd_1
XFILLER_0_23_15 VPWR VGND VPWR VGND sky130_ef_sc_hd__decap_12
XTAP_TAPCELL_ROW_44_957 VGND VPWR sky130_fd_sc_hd__tapvpwrvgnd_1
XFILLER_0_56_837 VGND VGND VPWR VPWR sky130_fd_sc_hd__fill_2
XFILLER_0_138_585 VGND VGND VPWR VPWR sky130_fd_sc_hd__decap_3
XFILLER_0_126_725 VPWR VGND VPWR VGND sky130_ef_sc_hd__decap_12
XFILLER_0_82_133 VGND VGND VPWR VPWR sky130_fd_sc_hd__decap_6
XFILLER_0_130_27 VGND VGND VPWR VPWR sky130_fd_sc_hd__fill_1
XFILLER_0_126_769 VPWR VGND VPWR VGND sky130_ef_sc_hd__decap_12
XFILLER_0_82_177 VPWR VGND VPWR VGND sky130_ef_sc_hd__decap_12
XFILLER_0_24_701 VPWR VGND VPWR VGND sky130_ef_sc_hd__decap_12
XFILLER_0_125_279 VGND VGND VPWR VPWR sky130_fd_sc_hd__fill_1
XFILLER_0_63_380 VGND VGND VPWR VPWR sky130_fd_sc_hd__decap_3
XFILLER_0_3_617 VPWR VGND VPWR VGND sky130_ef_sc_hd__decap_12
XFILLER_0_106_493 VGND VGND VPWR VPWR sky130_fd_sc_hd__decap_3
XFILLER_0_121_441 VGND VGND VPWR VPWR sky130_fd_sc_hd__decap_6
XFILLER_0_11_417 VPWR VGND VPWR VGND sky130_ef_sc_hd__decap_12
XFILLER_0_121_485 VPWR VGND VPWR VGND sky130_ef_sc_hd__decap_12
X_4130_ _2004_ VGND VGND VPWR VPWR _0080_ sky130_fd_sc_hd__clkbuf_1
X_4061_ _1966_ VGND VGND VPWR VPWR _0049_ sky130_fd_sc_hd__clkbuf_1
X_3012_ _0696_ _0816_ VGND VGND VPWR VPWR _0977_ sky130_fd_sc_hd__nor2_1
XFILLER_0_3_69 VPWR VGND VPWR VGND sky130_ef_sc_hd__decap_12
XTAP_TAPCELL_ROW_69_1332 VGND VPWR sky130_fd_sc_hd__tapvpwrvgnd_1
XFILLER_0_64_77 VGND VGND VPWR VPWR sky130_fd_sc_hd__decap_6
XTAP_TAPCELL_ROW_82_1532 VGND VPWR sky130_fd_sc_hd__tapvpwrvgnd_1
XFILLER_0_74_601 VPWR VGND VPWR VGND sky130_ef_sc_hd__decap_12
XFILLER_0_58_141 VPWR VGND VPWR VGND sky130_ef_sc_hd__decap_12
X_4963_ cpu_inst.regfile_inst.registers\[15\]\[0\] _2469_ VGND VGND VPWR VPWR _2470_
+ sky130_fd_sc_hd__or2b_1
XFILLER_0_129_541 VPWR VGND VPWR VGND sky130_ef_sc_hd__decap_12
X_3914_ _1536_ _1837_ _1839_ _1314_ VGND VGND VPWR VPWR _1840_ sky130_fd_sc_hd__o22a_1
XFILLER_0_80_65 VPWR VGND VPWR VGND sky130_ef_sc_hd__decap_12
XFILLER_0_73_111 VGND VGND VPWR VPWR sky130_fd_sc_hd__fill_1
XFILLER_0_59_697 VGND VGND VPWR VPWR sky130_fd_sc_hd__decap_6
XFILLER_0_19_517 VPWR VGND VPWR VGND sky130_ef_sc_hd__decap_12
XFILLER_0_129_585 VPWR VGND VPWR VGND sky130_ef_sc_hd__decap_12
XFILLER_0_74_645 VPWR VGND VPWR VGND sky130_ef_sc_hd__decap_12
XTAP_TAPCELL_ROW_22_629 VGND VPWR sky130_fd_sc_hd__tapvpwrvgnd_1
X_4894_ _1174_ cpu_inst.regfile_inst.registers\[8\]\[0\] _2432_ VGND VGND VPWR VPWR
+ _2433_ sky130_fd_sc_hd__mux2_1
XFILLER_0_104_83 VGND VGND VPWR VPWR sky130_fd_sc_hd__fill_1
X_3845_ cpu_inst.regfile_inst.registers\[2\]\[27\] _1667_ _1668_ cpu_inst.regfile_inst.registers\[7\]\[27\]
+ VGND VGND VPWR VPWR _1773_ sky130_fd_sc_hd__o22a_1
XFILLER_0_74_689 VGND VGND VPWR VPWR sky130_fd_sc_hd__decap_8
XFILLER_0_61_317 VGND VGND VPWR VPWR sky130_fd_sc_hd__fill_2
XFILLER_0_13_81 VPWR VGND VPWR VGND sky130_ef_sc_hd__decap_12
XFILLER_0_6_433 VPWR VGND VPWR VGND sky130_ef_sc_hd__decap_12
XFILLER_0_34_509 VGND VGND VPWR VPWR sky130_fd_sc_hd__decap_8
XFILLER_0_131_205 VPWR VGND VPWR VGND sky130_ef_sc_hd__decap_12
XFILLER_0_104_419 VGND VGND VPWR VPWR sky130_fd_sc_hd__fill_1
X_3776_ cpu_inst.regfile_inst.registers\[25\]\[25\] _0693_ _0695_ _1699_ VGND VGND
+ VPWR VPWR _1706_ sky130_fd_sc_hd__o211a_1
XFILLER_0_6_477 VPWR VGND VPWR VGND sky130_ef_sc_hd__decap_12
XFILLER_0_27_583 VPWR VGND VPWR VGND sky130_ef_sc_hd__decap_12
X_5515_ clknet_leaf_19_clk _0435_ VGND VGND VPWR VPWR cpu_inst.regfile_inst.registers\[8\]\[19\]
+ sky130_fd_sc_hd__dfxtp_1
X_2727_ _0569_ VGND VGND VPWR VPWR _0692_ sky130_fd_sc_hd__clkbuf_4
XFILLER_0_14_233 VPWR VGND VPWR VGND sky130_ef_sc_hd__decap_12
XFILLER_0_30_704 VPWR VGND VPWR VGND sky130_ef_sc_hd__decap_12
XFILLER_0_131_249 VPWR VGND VPWR VGND sky130_ef_sc_hd__decap_12
XFILLER_0_73_3 VPWR VGND VPWR VGND sky130_ef_sc_hd__decap_12
XFILLER_0_14_277 VPWR VGND VPWR VGND sky130_ef_sc_hd__decap_12
X_5446_ clknet_leaf_28_clk _0366_ VGND VGND VPWR VPWR cpu_inst.regfile_inst.registers\[0\]\[14\]
+ sky130_fd_sc_hd__dfxtp_1
X_2658_ _0563_ _0564_ _0536_ _0548_ _0622_ VGND VGND VPWR VPWR _0623_ sky130_fd_sc_hd__o2111a_1
XTAP_TAPCELL_ROW_93_1694 VGND VPWR sky130_fd_sc_hd__tapvpwrvgnd_1
X_2589_ _0533_ VGND VGND VPWR VPWR _0554_ sky130_fd_sc_hd__clkbuf_2
XFILLER_0_1_193 VPWR VGND VPWR VGND sky130_ef_sc_hd__decap_12
X_5377_ clknet_leaf_32_clk _0297_ VGND VGND VPWR VPWR cpu_inst.regfile_inst.registers\[10\]\[9\]
+ sky130_fd_sc_hd__dfxtp_1
X_4328_ _1156_ cpu_inst.regfile_inst.registers\[5\]\[14\] _2105_ VGND VGND VPWR VPWR
+ _2109_ sky130_fd_sc_hd__mux2_1
X_4259_ cpu_inst.regfile_inst.registers\[24\]\[14\] VGND VGND VPWR VPWR _2072_ sky130_fd_sc_hd__clkbuf_1
XTAP_TAPCELL_ROW_2_332 VGND VPWR sky130_fd_sc_hd__tapvpwrvgnd_1
XTAP_TAPCELL_ROW_124_2160 VGND VPWR sky130_fd_sc_hd__tapvpwrvgnd_1
XTAP_TAPCELL_ROW_41_916 VGND VPWR sky130_fd_sc_hd__tapvpwrvgnd_1
XFILLER_0_108_725 VPWR VGND VPWR VGND sky130_ef_sc_hd__decap_12
XFILLER_0_65_656 VGND VGND VPWR VPWR sky130_fd_sc_hd__decap_3
XFILLER_0_64_133 VGND VGND VPWR VPWR sky130_fd_sc_hd__decap_6
XFILLER_0_108_769 VPWR VGND VPWR VGND sky130_ef_sc_hd__decap_12
XFILLER_0_64_177 VPWR VGND VPWR VGND sky130_ef_sc_hd__decap_12
XFILLER_0_9_293 VPWR VGND VPWR VGND sky130_ef_sc_hd__decap_12
XFILLER_0_107_279 VGND VGND VPWR VPWR sky130_fd_sc_hd__fill_1
XFILLER_0_33_520 VGND VGND VPWR VPWR sky130_fd_sc_hd__fill_1
XFILLER_0_45_391 VGND VGND VPWR VPWR sky130_fd_sc_hd__fill_1
XFILLER_0_131_783 VGND VGND VPWR VPWR sky130_fd_sc_hd__fill_1
XFILLER_0_103_463 VPWR VGND VPWR VGND sky130_ef_sc_hd__decap_12
XTAP_TAPCELL_ROW_53_1100 VGND VPWR sky130_fd_sc_hd__tapvpwrvgnd_1
XFILLER_0_109_39 VPWR VGND VPWR VGND sky130_ef_sc_hd__decap_12
XFILLER_0_18_15 VPWR VGND VPWR VGND sky130_ef_sc_hd__decap_12
XTAP_TAPCELL_ROW_109_1933 VGND VPWR sky130_fd_sc_hd__tapvpwrvgnd_1
XFILLER_0_88_726 VGND VGND VPWR VPWR sky130_fd_sc_hd__decap_8
XTAP_TAPCELL_ROW_29_740 VGND VPWR sky130_fd_sc_hd__tapvpwrvgnd_1
XFILLER_0_125_27 VPWR VGND VPWR VGND sky130_ef_sc_hd__decap_12
XFILLER_0_87_225 VPWR VGND VPWR VGND sky130_ef_sc_hd__decap_12
XTAP_TAPCELL_ROW_64_1262 VGND VPWR sky130_fd_sc_hd__tapvpwrvgnd_1
XFILLER_0_55_111 VGND VGND VPWR VPWR sky130_fd_sc_hd__fill_1
XFILLER_0_138_393 VPWR VGND VPWR VGND sky130_ef_sc_hd__decap_12
XFILLER_0_126_533 VPWR VGND VPWR VGND sky130_ef_sc_hd__decap_12
XFILLER_0_43_317 VPWR VGND VPWR VGND sky130_ef_sc_hd__decap_12
X_3630_ cpu_inst.regfile_inst.registers\[24\]\[21\] _0698_ VGND VGND VPWR VPWR _1564_
+ sky130_fd_sc_hd__or2_1
XFILLER_0_24_531 VGND VGND VPWR VPWR sky130_fd_sc_hd__fill_1
XFILLER_0_113_205 VPWR VGND VPWR VGND sky130_ef_sc_hd__decap_12
X_3561_ cpu_inst.regfile_inst.registers\[7\]\[20\] cpu_inst.regfile_inst.registers\[6\]\[20\]
+ _1386_ VGND VGND VPWR VPWR _1496_ sky130_fd_sc_hd__mux2_1
XFILLER_0_113_249 VPWR VGND VPWR VGND sky130_ef_sc_hd__decap_12
X_5300_ clknet_leaf_7_clk _0220_ VGND VGND VPWR VPWR cpu_inst.regfile_inst.registers\[1\]\[28\]
+ sky130_fd_sc_hd__dfxtp_1
XFILLER_0_12_737 VPWR VGND VPWR VGND sky130_ef_sc_hd__decap_12
XFILLER_0_3_447 VGND VGND VPWR VPWR sky130_fd_sc_hd__fill_1
XFILLER_0_51_361 VPWR VGND VPWR VGND sky130_ef_sc_hd__decap_12
X_3492_ _1405_ VGND VGND VPWR VPWR _1429_ sky130_fd_sc_hd__inv_2
XFILLER_0_59_55 VGND VGND VPWR VPWR sky130_fd_sc_hd__fill_1
XFILLER_0_11_225 VPWR VGND VPWR VGND sky130_ef_sc_hd__decap_12
XFILLER_0_121_293 VPWR VGND VPWR VGND sky130_ef_sc_hd__decap_12
X_5231_ clknet_leaf_13_clk _0151_ VGND VGND VPWR VPWR cpu_inst.regfile_inst.registers\[24\]\[23\]
+ sky130_fd_sc_hd__dfxtp_1
X_5162_ clknet_leaf_12_clk _0082_ VGND VGND VPWR VPWR cpu_inst.regfile_inst.registers\[25\]\[18\]
+ sky130_fd_sc_hd__dfxtp_1
XFILLER_0_20_781 VPWR VGND VPWR VGND sky130_ef_sc_hd__decap_12
X_5093_ clknet_leaf_26_clk _0013_ VGND VGND VPWR VPWR cpu_inst.regfile_inst.registers\[6\]\[13\]
+ sky130_fd_sc_hd__dfxtp_1
X_4113_ _1995_ VGND VGND VPWR VPWR _0072_ sky130_fd_sc_hd__clkbuf_1
XFILLER_0_79_726 VGND VGND VPWR VPWR sky130_fd_sc_hd__fill_2
XFILLER_0_79_704 VGND VGND VPWR VPWR sky130_fd_sc_hd__fill_1
X_4044_ cpu_inst.regfile_inst.registers\[2\]\[9\] VGND VGND VPWR VPWR _1958_ sky130_fd_sc_hd__clkbuf_1
XFILLER_0_94_707 VGND VGND VPWR VPWR sky130_fd_sc_hd__fill_1
XFILLER_0_137_809 VPWR VGND VPWR VGND sky130_ef_sc_hd__decap_12
XFILLER_0_93_217 VGND VGND VPWR VPWR sky130_fd_sc_hd__decap_6
XFILLER_0_115_93 VPWR VGND VPWR VGND sky130_ef_sc_hd__decap_12
X_4946_ _2460_ VGND VGND VPWR VPWR _0440_ sky130_fd_sc_hd__clkbuf_1
XFILLER_0_46_133 VGND VGND VPWR VPWR sky130_fd_sc_hd__decap_6
XFILLER_0_129_393 VPWR VGND VPWR VGND sky130_ef_sc_hd__decap_12
X_4877_ _2423_ VGND VGND VPWR VPWR _0408_ sky130_fd_sc_hd__clkbuf_1
XFILLER_0_105_706 VPWR VGND VPWR VGND sky130_ef_sc_hd__decap_12
X_3828_ _1487_ _1756_ VGND VGND VPWR VPWR _1757_ sky130_fd_sc_hd__nand2_1
XFILLER_0_61_125 VPWR VGND VPWR VGND sky130_ef_sc_hd__decap_12
XFILLER_0_7_753 VPWR VGND VPWR VGND sky130_ef_sc_hd__decap_12
XFILLER_0_46_177 VPWR VGND VPWR VGND sky130_ef_sc_hd__decap_12
XFILLER_0_132_525 VGND VGND VPWR VPWR sky130_fd_sc_hd__decap_6
XFILLER_0_131_81 VPWR VGND VPWR VGND sky130_ef_sc_hd__decap_12
XFILLER_0_61_169 VPWR VGND VPWR VGND sky130_ef_sc_hd__decap_12
XFILLER_0_7_797 VPWR VGND VPWR VGND sky130_ef_sc_hd__decap_12
XFILLER_0_15_553 VGND VGND VPWR VPWR sky130_fd_sc_hd__decap_6
XFILLER_0_27_391 VGND VGND VPWR VPWR sky130_fd_sc_hd__fill_1
XFILLER_0_132_569 VPWR VGND VPWR VGND sky130_ef_sc_hd__decap_12
XTAP_TAPCELL_ROW_95_1723 VGND VPWR sky130_fd_sc_hd__tapvpwrvgnd_1
X_3759_ _1251_ _1688_ _1689_ _1208_ VGND VGND VPWR VPWR _1690_ sky130_fd_sc_hd__a211o_1
XFILLER_0_15_597 VPWR VGND VPWR VGND sky130_ef_sc_hd__decap_12
XFILLER_0_113_783 VGND VGND VPWR VPWR sky130_fd_sc_hd__fill_1
X_5429_ clknet_leaf_42_clk _0349_ net2 VGND VGND VPWR VPWR cpu_inst.decoder_inst.current_pc\[29\]
+ sky130_fd_sc_hd__dfrtp_1
XTAP_TAPCELL_ROW_7_402 VGND VPWR sky130_fd_sc_hd__tapvpwrvgnd_1
XFILLER_0_30_589 VGND VGND VPWR VPWR sky130_fd_sc_hd__decap_3
XFILLER_0_69_225 VPWR VGND VPWR VGND sky130_ef_sc_hd__decap_12
XFILLER_0_85_729 VGND VGND VPWR VPWR sky130_fd_sc_hd__fill_2
XTAP_TAPCELL_ROW_104_1863 VGND VPWR sky130_fd_sc_hd__tapvpwrvgnd_1
XFILLER_0_65_442 VGND VGND VPWR VPWR sky130_fd_sc_hd__decap_6
XFILLER_0_37_111 VGND VGND VPWR VPWR sky130_fd_sc_hd__fill_1
XFILLER_0_38_645 VGND VGND VPWR VPWR sky130_fd_sc_hd__fill_1
XFILLER_0_108_533 VPWR VGND VPWR VGND sky130_ef_sc_hd__decap_12
XTAP_TAPCELL_ROW_137_2362 VGND VPWR sky130_fd_sc_hd__tapvpwrvgnd_1
XTAP_TAPCELL_ROW_137_2351 VGND VPWR sky130_fd_sc_hd__tapvpwrvgnd_1
XFILLER_0_123_503 VGND VGND VPWR VPWR sky130_fd_sc_hd__fill_1
XFILLER_0_108_566 VPWR VGND VPWR VGND sky130_ef_sc_hd__decap_12
XFILLER_0_25_317 VPWR VGND VPWR VGND sky130_ef_sc_hd__decap_12
XFILLER_0_135_385 VGND VGND VPWR VPWR sky130_fd_sc_hd__decap_6
XFILLER_0_20_27 VGND VGND VPWR VPWR sky130_fd_sc_hd__fill_1
XFILLER_0_40_309 VPWR VGND VPWR VGND sky130_ef_sc_hd__decap_12
XFILLER_0_111_709 VPWR VGND VPWR VGND sky130_ef_sc_hd__decap_12
XFILLER_0_33_361 VPWR VGND VPWR VGND sky130_ef_sc_hd__decap_12
XFILLER_0_0_417 VGND VGND VPWR VPWR sky130_fd_sc_hd__decap_3
XFILLER_0_103_293 VPWR VGND VPWR VGND sky130_ef_sc_hd__decap_12
XFILLER_0_29_69 VPWR VGND VPWR VGND sky130_ef_sc_hd__decap_12
XFILLER_0_136_15 VPWR VGND VPWR VGND sky130_ef_sc_hd__decap_12
XFILLER_0_45_57 VPWR VGND VPWR VGND sky130_ef_sc_hd__decap_12
XFILLER_0_0_15 VPWR VGND VPWR VGND sky130_ef_sc_hd__decap_12
XFILLER_0_119_809 VPWR VGND VPWR VGND sky130_ef_sc_hd__decap_12
X_4800_ cpu_inst.regfile_inst.registers\[0\]\[18\] VGND VGND VPWR VPWR _2385_ sky130_fd_sc_hd__clkbuf_1
XFILLER_0_75_217 VGND VGND VPWR VPWR sky130_fd_sc_hd__decap_6
XFILLER_0_131_3 VPWR VGND VPWR VGND sky130_ef_sc_hd__decap_12
XFILLER_0_28_133 VGND VGND VPWR VPWR sky130_fd_sc_hd__decap_6
X_2992_ _0956_ cpu_inst.regfile_inst.registers\[10\]\[7\] _0870_ VGND VGND VPWR VPWR
+ _0957_ sky130_fd_sc_hd__mux2_1
XFILLER_0_90_209 VPWR VGND VPWR VGND sky130_ef_sc_hd__decap_12
XFILLER_0_83_261 VPWR VGND VPWR VGND sky130_ef_sc_hd__decap_12
X_4731_ _2342_ _2343_ VGND VGND VPWR VPWR _2344_ sky130_fd_sc_hd__or2_1
X_4662_ _2292_ VGND VGND VPWR VPWR _2293_ sky130_fd_sc_hd__buf_6
XFILLER_0_56_497 VGND VGND VPWR VPWR sky130_fd_sc_hd__decap_8
XFILLER_0_4_701 VPWR VGND VPWR VGND sky130_ef_sc_hd__decap_12
XFILLER_0_28_177 VPWR VGND VPWR VGND sky130_ef_sc_hd__decap_12
XTAP_TAPCELL_ROW_32_779 VGND VPWR sky130_fd_sc_hd__tapvpwrvgnd_1
XFILLER_0_43_125 VPWR VGND VPWR VGND sky130_ef_sc_hd__decap_12
XFILLER_0_126_363 VGND VGND VPWR VPWR sky130_fd_sc_hd__fill_1
XFILLER_0_114_525 VGND VGND VPWR VPWR sky130_fd_sc_hd__decap_6
X_3613_ _1448_ _1546_ VGND VGND VPWR VPWR _1547_ sky130_fd_sc_hd__or2_1
XTAP_TAPCELL_ROW_12_481 VGND VPWR sky130_fd_sc_hd__tapvpwrvgnd_1
XFILLER_0_9_57 VPWR VGND VPWR VGND sky130_ef_sc_hd__decap_12
XFILLER_0_44_659 VGND VGND VPWR VPWR sky130_fd_sc_hd__fill_1
XFILLER_0_114_569 VPWR VGND VPWR VGND sky130_ef_sc_hd__decap_12
XFILLER_0_101_51 VGND VGND VPWR VPWR sky130_fd_sc_hd__decap_4
X_4593_ cpu_inst.regfile_inst.registers\[10\]\[15\] _2241_ VGND VGND VPWR VPWR _2245_
+ sky130_fd_sc_hd__and2_1
XFILLER_0_12_501 VPWR VGND VPWR VGND sky130_ef_sc_hd__decap_12
XFILLER_0_43_169 VPWR VGND VPWR VGND sky130_ef_sc_hd__decap_12
X_3544_ cpu_inst.regfile_inst.registers\[24\]\[19\] _0698_ _0700_ _1479_ _0961_ VGND
+ VGND VPWR VPWR _1480_ sky130_fd_sc_hd__o221a_1
XTAP_TAPCELL_ROW_77_1453 VGND VPWR sky130_fd_sc_hd__tapvpwrvgnd_1
XFILLER_0_12_545 VPWR VGND VPWR VGND sky130_ef_sc_hd__decap_12
X_3475_ _1356_ _1412_ _1060_ VGND VGND VPWR VPWR _1413_ sky130_fd_sc_hd__mux2_1
XFILLER_0_12_589 VPWR VGND VPWR VGND sky130_ef_sc_hd__decap_12
XFILLER_0_86_53 VPWR VGND VPWR VGND sky130_ef_sc_hd__decap_12
X_5214_ clknet_leaf_35_clk _0134_ VGND VGND VPWR VPWR cpu_inst.regfile_inst.registers\[24\]\[6\]
+ sky130_fd_sc_hd__dfxtp_1
XTAP_TAPCELL_ROW_90_1653 VGND VPWR sky130_fd_sc_hd__tapvpwrvgnd_1
XFILLER_0_86_97 VPWR VGND VPWR VGND sky130_ef_sc_hd__decap_12
X_5145_ clknet_leaf_1_clk _0065_ VGND VGND VPWR VPWR cpu_inst.regfile_inst.registers\[25\]\[1\]
+ sky130_fd_sc_hd__dfxtp_1
XFILLER_0_36_3 VPWR VGND VPWR VGND sky130_ef_sc_hd__decap_12
XFILLER_0_98_309 VPWR VGND VPWR VGND sky130_ef_sc_hd__decap_12
XFILLER_0_79_501 VGND VGND VPWR VPWR sky130_fd_sc_hd__decap_3
X_5076_ cpu_inst.display_inst.counter\[18\] _2532_ VGND VGND VPWR VPWR _0498_ sky130_fd_sc_hd__xor2_1
X_4027_ _1949_ VGND VGND VPWR VPWR _0032_ sky130_fd_sc_hd__clkbuf_1
XFILLER_0_137_617 VPWR VGND VPWR VGND sky130_ef_sc_hd__decap_12
XFILLER_0_19_111 VGND VGND VPWR VPWR sky130_fd_sc_hd__fill_1
X_4929_ _1382_ cpu_inst.regfile_inst.registers\[8\]\[16\] _2449_ VGND VGND VPWR VPWR
+ _2452_ sky130_fd_sc_hd__mux2_1
XFILLER_0_62_401 VPWR VGND VPWR VGND sky130_ef_sc_hd__decap_12
XFILLER_0_35_615 VGND VGND VPWR VPWR sky130_fd_sc_hd__fill_1
XFILLER_0_90_710 VGND VGND VPWR VPWR sky130_fd_sc_hd__fill_1
XFILLER_0_47_486 VGND VGND VPWR VPWR sky130_fd_sc_hd__decap_4
XTAP_TAPCELL_ROW_119_2081 VGND VPWR sky130_fd_sc_hd__tapvpwrvgnd_1
XFILLER_0_117_385 VGND VGND VPWR VPWR sky130_fd_sc_hd__decap_6
XFILLER_0_7_561 VPWR VGND VPWR VGND sky130_ef_sc_hd__decap_12
XFILLER_0_132_333 VPWR VGND VPWR VGND sky130_ef_sc_hd__decap_12
XTAP_TAPCELL_ROW_119_2092 VGND VPWR sky130_fd_sc_hd__tapvpwrvgnd_1
XFILLER_0_105_569 VGND VGND VPWR VPWR sky130_fd_sc_hd__decap_3
XFILLER_0_15_361 VPWR VGND VPWR VGND sky130_ef_sc_hd__decap_12
XFILLER_0_22_309 VPWR VGND VPWR VGND sky130_ef_sc_hd__decap_12
XFILLER_0_31_810 VGND VGND VPWR VPWR sky130_fd_sc_hd__decap_8
XFILLER_0_132_377 VPWR VGND VPWR VGND sky130_ef_sc_hd__decap_12
XFILLER_0_31_832 VGND VGND VPWR VPWR sky130_fd_sc_hd__decap_4
XTAP_TAPCELL_ROW_132_2281 VGND VPWR sky130_fd_sc_hd__tapvpwrvgnd_1
XFILLER_0_101_797 VPWR VGND VPWR VGND sky130_ef_sc_hd__decap_12
XFILLER_0_106_29 VPWR VGND VPWR VGND sky130_ef_sc_hd__decap_12
XFILLER_0_15_27 VPWR VGND VPWR VGND sky130_ef_sc_hd__decap_12
XTAP_TAPCELL_ROW_39_890 VGND VPWR sky130_fd_sc_hd__tapvpwrvgnd_1
XTAP_TAPCELL_ROW_48_1021 VGND VPWR sky130_fd_sc_hd__tapvpwrvgnd_1
XFILLER_0_85_515 VGND VGND VPWR VPWR sky130_fd_sc_hd__decap_6
XFILLER_0_57_217 VGND VGND VPWR VPWR sky130_fd_sc_hd__decap_6
XFILLER_0_127_105 VGND VGND VPWR VPWR sky130_fd_sc_hd__decap_6
XFILLER_0_72_209 VPWR VGND VPWR VGND sky130_ef_sc_hd__decap_12
XTAP_TAPCELL_ROW_61_1221 VGND VPWR sky130_fd_sc_hd__tapvpwrvgnd_1
XTAP_TAPCELL_ROW_61_1210 VGND VPWR sky130_fd_sc_hd__tapvpwrvgnd_1
XFILLER_0_31_15 VPWR VGND VPWR VGND sky130_ef_sc_hd__decap_12
XFILLER_0_38_453 VGND VGND VPWR VPWR sky130_fd_sc_hd__fill_1
XFILLER_0_127_149 VPWR VGND VPWR VGND sky130_ef_sc_hd__decap_12
XFILLER_0_65_261 VPWR VGND VPWR VGND sky130_ef_sc_hd__decap_12
XFILLER_0_25_125 VPWR VGND VPWR VGND sky130_ef_sc_hd__decap_12
XFILLER_0_38_486 VPWR VGND VPWR VGND sky130_ef_sc_hd__decap_12
XFILLER_0_108_363 VGND VGND VPWR VPWR sky130_fd_sc_hd__fill_1
XFILLER_0_80_253 VPWR VGND VPWR VGND sky130_ef_sc_hd__decap_12
XFILLER_0_135_193 VPWR VGND VPWR VGND sky130_ef_sc_hd__decap_12
XFILLER_0_25_169 VPWR VGND VPWR VGND sky130_ef_sc_hd__decap_12
XFILLER_0_111_517 VPWR VGND VPWR VGND sky130_ef_sc_hd__decap_12
XFILLER_0_40_139 VGND VGND VPWR VPWR sky130_fd_sc_hd__fill_1
XTAP_TAPCELL_ROW_59_1183 VGND VPWR sky130_fd_sc_hd__tapvpwrvgnd_1
XFILLER_0_0_225 VPWR VGND VPWR VGND sky130_ef_sc_hd__decap_12
X_3260_ _1124_ VGND VGND VPWR VPWR _1225_ sky130_fd_sc_hd__inv_2
XTAP_TAPCELL_ROW_72_1383 VGND VPWR sky130_fd_sc_hd__tapvpwrvgnd_1
X_3191_ _1053_ _1136_ _1137_ _1155_ _0683_ VGND VGND VPWR VPWR _1156_ sky130_fd_sc_hd__a32o_2
XTAP_TAPCELL_ROW_37_849 VGND VPWR sky130_fd_sc_hd__tapvpwrvgnd_1
XFILLER_0_72_77 VGND VGND VPWR VPWR sky130_fd_sc_hd__decap_6
XFILLER_0_49_729 VGND VGND VPWR VPWR sky130_fd_sc_hd__decap_4
XFILLER_0_119_617 VPWR VGND VPWR VGND sky130_ef_sc_hd__decap_12
XTAP_TAPCELL_ROW_17_551 VGND VPWR sky130_fd_sc_hd__tapvpwrvgnd_1
XTAP_TAPCELL_ROW_17_562 VGND VPWR sky130_fd_sc_hd__tapvpwrvgnd_1
XFILLER_0_72_710 VGND VGND VPWR VPWR sky130_fd_sc_hd__decap_4
X_4714_ cpu_inst.decoder_inst.current_pc\[17\] _2328_ VGND VGND VPWR VPWR _2332_ sky130_fd_sc_hd__nor2_1
XFILLER_0_17_615 VGND VGND VPWR VPWR sky130_fd_sc_hd__fill_1
X_2975_ cpu_inst.regfile_inst.registers\[7\]\[6\] cpu_inst.regfile_inst.registers\[6\]\[6\]
+ _0675_ VGND VGND VPWR VPWR _0940_ sky130_fd_sc_hd__mux2_1
XFILLER_0_44_401 VPWR VGND VPWR VGND sky130_ef_sc_hd__decap_12
XFILLER_0_114_333 VPWR VGND VPWR VGND sky130_ef_sc_hd__decap_12
XFILLER_0_112_83 VGND VGND VPWR VPWR sky130_fd_sc_hd__fill_1
X_4645_ _1164_ _1192_ _2273_ _2277_ VGND VGND VPWR VPWR _2278_ sky130_fd_sc_hd__or4_4
XFILLER_0_4_531 VGND VGND VPWR VPWR sky130_fd_sc_hd__fill_1
XFILLER_0_13_821 VPWR VGND VPWR VGND sky130_ef_sc_hd__decap_12
XFILLER_0_21_81 VPWR VGND VPWR VGND sky130_ef_sc_hd__decap_12
XFILLER_0_114_377 VPWR VGND VPWR VGND sky130_ef_sc_hd__decap_12
X_4576_ cpu_inst.regfile_inst.registers\[10\]\[7\] _2230_ VGND VGND VPWR VPWR _2236_
+ sky130_fd_sc_hd__and2_1
XFILLER_0_130_837 VGND VGND VPWR VPWR sky130_fd_sc_hd__decap_4
X_3527_ _1462_ cpu_inst.regfile_inst.registers\[10\]\[19\] _0871_ VGND VGND VPWR VPWR
+ _1463_ sky130_fd_sc_hd__mux2_1
X_3458_ cpu_inst.regfile_inst.registers\[8\]\[17\] _1395_ _0642_ VGND VGND VPWR VPWR
+ _1396_ sky130_fd_sc_hd__mux2_1
XFILLER_0_0_781 VGND VGND VPWR VPWR sky130_fd_sc_hd__decap_3
XPHY_EDGE_ROW_110_Left_249 VGND VGND VPWR VPWR sky130_fd_sc_hd__decap_3
X_3389_ _1183_ cpu_inst.regfile_inst.registers\[6\]\[8\] _1300_ VGND VGND VPWR VPWR
+ _1336_ sky130_fd_sc_hd__mux2_1
XFILLER_0_99_629 VGND VGND VPWR VPWR sky130_fd_sc_hd__fill_1
X_5128_ clknet_leaf_22_clk _0048_ VGND VGND VPWR VPWR cpu_inst.regfile_inst.registers\[2\]\[16\]
+ sky130_fd_sc_hd__dfxtp_1
XFILLER_0_98_139 VGND VGND VPWR VPWR sky130_fd_sc_hd__fill_1
X_5059_ _2521_ _2522_ VGND VGND VPWR VPWR _0491_ sky130_fd_sc_hd__nor2_1
XFILLER_0_94_301 VGND VGND VPWR VPWR sky130_fd_sc_hd__decap_6
XFILLER_0_39_217 VGND VGND VPWR VPWR sky130_fd_sc_hd__decap_6
XFILLER_0_94_345 VPWR VGND VPWR VGND sky130_ef_sc_hd__decap_12
XFILLER_0_137_447 VGND VGND VPWR VPWR sky130_fd_sc_hd__fill_1
XFILLER_0_109_105 VGND VGND VPWR VPWR sky130_fd_sc_hd__decap_6
XTAP_TAPCELL_ROW_101_1822 VGND VPWR sky130_fd_sc_hd__tapvpwrvgnd_1
XTAP_TAPCELL_ROW_101_1811 VGND VPWR sky130_fd_sc_hd__tapvpwrvgnd_1
XFILLER_0_54_209 VPWR VGND VPWR VGND sky130_ef_sc_hd__decap_12
XFILLER_0_125_609 VGND VGND VPWR VPWR sky130_fd_sc_hd__decap_6
XFILLER_0_109_149 VPWR VGND VPWR VGND sky130_ef_sc_hd__decap_12
XFILLER_0_94_389 VGND VGND VPWR VPWR sky130_fd_sc_hd__decap_4
XFILLER_0_82_529 VGND VGND VPWR VPWR sky130_fd_sc_hd__decap_3
XFILLER_0_47_261 VPWR VGND VPWR VGND sky130_ef_sc_hd__decap_12
XTAP_TAPCELL_ROW_134_2310 VGND VPWR sky130_fd_sc_hd__tapvpwrvgnd_1
XPHY_EDGE_ROW_109_Right_109 VGND VGND VPWR VPWR sky130_fd_sc_hd__decap_3
XFILLER_0_133_653 VPWR VGND VPWR VGND sky130_ef_sc_hd__decap_12
XFILLER_0_117_193 VPWR VGND VPWR VGND sky130_ef_sc_hd__decap_12
XFILLER_0_62_253 VPWR VGND VPWR VGND sky130_ef_sc_hd__decap_12
XFILLER_0_7_391 VGND VGND VPWR VPWR sky130_fd_sc_hd__fill_1
XFILLER_0_23_629 VPWR VGND VPWR VGND sky130_ef_sc_hd__decap_12
XFILLER_0_132_141 VPWR VGND VPWR VGND sky130_ef_sc_hd__decap_12
XFILLER_0_16_681 VPWR VGND VPWR VGND sky130_ef_sc_hd__decap_12
XFILLER_0_22_139 VGND VGND VPWR VPWR sky130_fd_sc_hd__fill_1
XFILLER_0_133_697 VPWR VGND VPWR VGND sky130_ef_sc_hd__decap_12
XFILLER_0_101_561 VGND VGND VPWR VPWR sky130_fd_sc_hd__fill_2
XTAP_TAPCELL_ROW_112_1984 VGND VPWR sky130_fd_sc_hd__tapvpwrvgnd_1
XTAP_TAPCELL_ROW_112_1973 VGND VPWR sky130_fd_sc_hd__tapvpwrvgnd_1
XFILLER_0_26_15 VPWR VGND VPWR VGND sky130_ef_sc_hd__decap_12
XFILLER_0_117_39 VPWR VGND VPWR VGND sky130_ef_sc_hd__decap_12
XFILLER_0_97_161 VGND VGND VPWR VPWR sky130_fd_sc_hd__decap_6
XTAP_TAPCELL_ROW_34_808 VGND VPWR sky130_fd_sc_hd__tapvpwrvgnd_1
XFILLER_0_133_27 VPWR VGND VPWR VGND sky130_ef_sc_hd__decap_12
XTAP_TAPCELL_ROW_14_510 VGND VPWR sky130_fd_sc_hd__tapvpwrvgnd_1
XFILLER_0_128_469 VGND VGND VPWR VPWR sky130_fd_sc_hd__decap_6
XFILLER_0_26_401 VPWR VGND VPWR VGND sky130_ef_sc_hd__decap_12
X_2760_ _0642_ VGND VGND VPWR VPWR _0725_ sky130_fd_sc_hd__clkbuf_4
XFILLER_0_54_754 VGND VGND VPWR VPWR sky130_fd_sc_hd__fill_2
XFILLER_0_5_317 VPWR VGND VPWR VGND sky130_ef_sc_hd__decap_12
XFILLER_0_26_445 VPWR VGND VPWR VGND sky130_ef_sc_hd__decap_12
XFILLER_0_26_489 VPWR VGND VPWR VGND sky130_ef_sc_hd__decap_12
X_2691_ _0536_ _0655_ VGND VGND VPWR VPWR _0656_ sky130_fd_sc_hd__and2_1
XFILLER_0_81_595 VGND VGND VPWR VPWR sky130_fd_sc_hd__decap_8
X_4430_ _2160_ VGND VGND VPWR VPWR _2161_ sky130_fd_sc_hd__buf_4
XFILLER_0_112_837 VGND VGND VPWR VPWR sky130_fd_sc_hd__decap_4
XTAP_TAPCELL_ROW_74_1412 VGND VPWR sky130_fd_sc_hd__tapvpwrvgnd_1
X_4361_ _1899_ cpu_inst.regfile_inst.registers\[5\]\[30\] _2117_ VGND VGND VPWR VPWR
+ _2126_ sky130_fd_sc_hd__mux2_1
XFILLER_0_10_813 VPWR VGND VPWR VGND sky130_ef_sc_hd__decap_12
XFILLER_0_21_161 VGND VGND VPWR VPWR sky130_fd_sc_hd__decap_6
X_3312_ _1102_ _1199_ VGND VGND VPWR VPWR _1274_ sky130_fd_sc_hd__and2b_1
X_4292_ _2088_ VGND VGND VPWR VPWR _0158_ sky130_fd_sc_hd__clkbuf_1
XFILLER_0_67_55 VGND VGND VPWR VPWR sky130_fd_sc_hd__fill_1
X_3243_ _0756_ VGND VGND VPWR VPWR _1208_ sky130_fd_sc_hd__buf_2
X_3174_ _0947_ VGND VGND VPWR VPWR _1139_ sky130_fd_sc_hd__inv_2
Xrebuffer14 net28 VGND VGND VPWR VPWR net27 sky130_fd_sc_hd__dlygate4sd1_1
Xrebuffer25 _0602_ VGND VGND VPWR VPWR net38 sky130_fd_sc_hd__buf_2
XFILLER_0_89_662 VGND VGND VPWR VPWR sky130_fd_sc_hd__fill_1
XFILLER_0_77_813 VGND VGND VPWR VPWR sky130_fd_sc_hd__fill_1
XFILLER_0_76_301 VGND VGND VPWR VPWR sky130_fd_sc_hd__decap_6
XTAP_TAPCELL_ROW_85_1574 VGND VPWR sky130_fd_sc_hd__tapvpwrvgnd_1
XFILLER_0_77_835 VGND VGND VPWR VPWR sky130_fd_sc_hd__decap_4
XFILLER_0_76_345 VPWR VGND VPWR VGND sky130_ef_sc_hd__decap_12
XFILLER_0_36_209 VPWR VGND VPWR VGND sky130_ef_sc_hd__decap_12
XFILLER_0_119_447 VGND VGND VPWR VPWR sky130_fd_sc_hd__fill_1
XFILLER_0_107_609 VGND VGND VPWR VPWR sky130_fd_sc_hd__fill_1
XFILLER_0_91_337 VPWR VGND VPWR VGND sky130_ef_sc_hd__decap_12
XFILLER_0_8_133 VGND VGND VPWR VPWR sky130_fd_sc_hd__decap_6
XFILLER_0_29_261 VPWR VGND VPWR VGND sky130_ef_sc_hd__decap_12
XFILLER_0_123_93 VPWR VGND VPWR VGND sky130_ef_sc_hd__decap_12
XFILLER_0_8_177 VPWR VGND VPWR VGND sky130_ef_sc_hd__decap_12
X_2958_ cpu_inst.regfile_inst.registers\[5\]\[5\] cpu_inst.regfile_inst.registers\[4\]\[5\]
+ _0922_ VGND VGND VPWR VPWR _0923_ sky130_fd_sc_hd__mux2_1
XFILLER_0_72_573 VGND VGND VPWR VPWR sky130_fd_sc_hd__fill_1
XFILLER_0_44_253 VPWR VGND VPWR VGND sky130_ef_sc_hd__decap_12
XFILLER_0_130_601 VPWR VGND VPWR VGND sky130_ef_sc_hd__decap_12
XTAP_TAPCELL_ROW_116_2040 VGND VPWR sky130_fd_sc_hd__tapvpwrvgnd_1
XFILLER_0_115_653 VPWR VGND VPWR VGND sky130_ef_sc_hd__decap_12
XFILLER_0_114_141 VPWR VGND VPWR VGND sky130_ef_sc_hd__decap_12
XFILLER_0_60_757 VGND VGND VPWR VPWR sky130_fd_sc_hd__decap_4
X_2889_ _0622_ VGND VGND VPWR VPWR _0854_ sky130_fd_sc_hd__clkbuf_8
X_4628_ cpu_inst.display_inst.counter\[5\] cpu_inst.display_inst.counter\[7\] VGND
+ VGND VPWR VPWR _2263_ sky130_fd_sc_hd__nand2_1
XFILLER_0_130_645 VPWR VGND VPWR VGND sky130_ef_sc_hd__decap_12
XFILLER_0_115_697 VPWR VGND VPWR VGND sky130_ef_sc_hd__decap_12
X_4559_ _2227_ VGND VGND VPWR VPWR _0286_ sky130_fd_sc_hd__clkbuf_1
XFILLER_0_13_673 VPWR VGND VPWR VGND sky130_ef_sc_hd__decap_12
XFILLER_0_86_109 VPWR VGND VPWR VGND sky130_ef_sc_hd__decap_12
XFILLER_0_79_161 VGND VGND VPWR VPWR sky130_fd_sc_hd__decap_6
XFILLER_0_68_813 VGND VGND VPWR VPWR sky130_fd_sc_hd__decap_8
XFILLER_0_67_301 VGND VGND VPWR VPWR sky130_fd_sc_hd__fill_2
XFILLER_0_138_701 VPWR VGND VPWR VGND sky130_ef_sc_hd__decap_12
XFILLER_0_94_153 VPWR VGND VPWR VGND sky130_ef_sc_hd__decap_12
XTAP_TAPCELL_ROW_0_282 VGND VPWR sky130_fd_sc_hd__tapvpwrvgnd_1
XTAP_TAPCELL_ROW_0_293 VGND VPWR sky130_fd_sc_hd__tapvpwrvgnd_1
XFILLER_0_125_417 VPWR VGND VPWR VGND sky130_ef_sc_hd__decap_12
XFILLER_0_94_197 VPWR VGND VPWR VGND sky130_ef_sc_hd__decap_12
XFILLER_0_133_461 VPWR VGND VPWR VGND sky130_ef_sc_hd__decap_12
XFILLER_0_2_309 VPWR VGND VPWR VGND sky130_ef_sc_hd__decap_12
XFILLER_0_50_245 VGND VGND VPWR VPWR sky130_fd_sc_hd__decap_6
XFILLER_0_120_133 VGND VGND VPWR VPWR sky130_fd_sc_hd__decap_6
XFILLER_0_10_109 VPWR VGND VPWR VGND sky130_ef_sc_hd__decap_12
Xoutput4 net4 VGND VGND VPWR VPWR an[1] sky130_fd_sc_hd__buf_1
XFILLER_0_50_289 VPWR VGND VPWR VGND sky130_ef_sc_hd__decap_12
XFILLER_0_120_177 VPWR VGND VPWR VGND sky130_ef_sc_hd__decap_12
XTAP_TAPCELL_ROW_56_1142 VGND VPWR sky130_fd_sc_hd__tapvpwrvgnd_1
XFILLER_0_128_27 VGND VGND VPWR VPWR sky130_fd_sc_hd__fill_1
XFILLER_0_101_391 VGND VGND VPWR VPWR sky130_fd_sc_hd__fill_1
XFILLER_0_37_69 VPWR VGND VPWR VGND sky130_ef_sc_hd__decap_12
XFILLER_0_59_824 VGND VGND VPWR VPWR sky130_fd_sc_hd__fill_1
X_3930_ cpu_inst.regfile_inst.registers\[25\]\[29\] _1285_ _1449_ _1840_ _1854_ VGND
+ VGND VPWR VPWR _1856_ sky130_fd_sc_hd__o2111a_1
XTAP_TAPCELL_ROW_47_999 VGND VPWR sky130_fd_sc_hd__tapvpwrvgnd_1
XFILLER_0_53_57 VPWR VGND VPWR VGND sky130_ef_sc_hd__decap_12
XFILLER_0_128_233 VPWR VGND VPWR VGND sky130_ef_sc_hd__decap_12
X_3861_ _1487_ _1788_ VGND VGND VPWR VPWR _1789_ sky130_fd_sc_hd__nand2_1
XFILLER_0_58_378 VGND VGND VPWR VPWR sky130_fd_sc_hd__decap_8
XFILLER_0_18_209 VPWR VGND VPWR VGND sky130_ef_sc_hd__decap_12
XFILLER_0_27_721 VGND VGND VPWR VPWR sky130_fd_sc_hd__decap_6
XFILLER_0_128_277 VPWR VGND VPWR VGND sky130_ef_sc_hd__decap_12
X_3792_ _1680_ _1721_ VGND VGND VPWR VPWR _1722_ sky130_fd_sc_hd__or2_1
XFILLER_0_73_337 VGND VGND VPWR VPWR sky130_fd_sc_hd__decap_8
X_2812_ cpu_inst.regfile_inst.registers\[2\]\[4\] _0592_ net38 cpu_inst.regfile_inst.registers\[7\]\[4\]
+ VGND VGND VPWR VPWR _0777_ sky130_fd_sc_hd__o22a_1
XTAP_TAPCELL_ROW_80_1493 VGND VPWR sky130_fd_sc_hd__tapvpwrvgnd_1
XFILLER_0_6_637 VGND VGND VPWR VPWR sky130_fd_sc_hd__decap_6
XFILLER_0_5_125 VPWR VGND VPWR VGND sky130_ef_sc_hd__decap_12
XFILLER_0_26_253 VPWR VGND VPWR VGND sky130_ef_sc_hd__decap_12
XFILLER_0_27_765 VPWR VGND VPWR VGND sky130_ef_sc_hd__decap_12
X_2743_ _0642_ _0706_ _0707_ VGND VGND VPWR VPWR _0708_ sky130_fd_sc_hd__or3_1
X_5531_ clknet_leaf_38_clk _0451_ VGND VGND VPWR VPWR cpu_inst.regfile_inst.registers\[15\]\[3\]
+ sky130_fd_sc_hd__dfxtp_1
XFILLER_0_112_601 VPWR VGND VPWR VGND sky130_ef_sc_hd__decap_12
XFILLER_0_5_169 VPWR VGND VPWR VGND sky130_ef_sc_hd__decap_12
XFILLER_0_41_223 VGND VGND VPWR VPWR sky130_fd_sc_hd__fill_1
XFILLER_0_42_746 VGND VGND VPWR VPWR sky130_fd_sc_hd__fill_1
XFILLER_0_42_757 VGND VGND VPWR VPWR sky130_fd_sc_hd__decap_8
XFILLER_0_111_111 VGND VGND VPWR VPWR sky130_fd_sc_hd__fill_1
X_5462_ clknet_leaf_6_clk _0382_ VGND VGND VPWR VPWR cpu_inst.regfile_inst.registers\[0\]\[30\]
+ sky130_fd_sc_hd__dfxtp_1
X_2674_ _0638_ VGND VGND VPWR VPWR _0639_ sky130_fd_sc_hd__buf_4
XFILLER_0_112_645 VPWR VGND VPWR VGND sky130_ef_sc_hd__decap_12
X_4413_ cpu_inst.regfile_inst.registers\[1\]\[24\] VGND VGND VPWR VPWR _2152_ sky130_fd_sc_hd__clkbuf_1
X_5393_ clknet_leaf_14_clk _0313_ VGND VGND VPWR VPWR cpu_inst.regfile_inst.registers\[10\]\[25\]
+ sky130_fd_sc_hd__dfxtp_1
XFILLER_0_78_65 VPWR VGND VPWR VGND sky130_ef_sc_hd__decap_12
X_4344_ _2091_ VGND VGND VPWR VPWR _2117_ sky130_fd_sc_hd__buf_4
XFILLER_0_10_643 VGND VGND VPWR VPWR sky130_fd_sc_hd__fill_1
XFILLER_0_94_53 VPWR VGND VPWR VGND sky130_ef_sc_hd__decap_12
X_4275_ cpu_inst.regfile_inst.registers\[24\]\[22\] VGND VGND VPWR VPWR _2080_ sky130_fd_sc_hd__clkbuf_1
XTAP_TAPCELL_ROW_87_1603 VGND VPWR sky130_fd_sc_hd__tapvpwrvgnd_1
X_3226_ _1153_ _1187_ _1190_ VGND VGND VPWR VPWR _1191_ sky130_fd_sc_hd__o21ai_1
XFILLER_0_94_97 VPWR VGND VPWR VGND sky130_ef_sc_hd__decap_12
X_3157_ _0735_ _1114_ _1117_ _1121_ VGND VGND VPWR VPWR _1122_ sky130_fd_sc_hd__o211a_1
XFILLER_0_68_109 VPWR VGND VPWR VGND sky130_ef_sc_hd__decap_12
XFILLER_0_77_632 VPWR VGND VPWR VGND sky130_ef_sc_hd__decap_12
X_3088_ _1052_ VGND VGND VPWR VPWR _1053_ sky130_fd_sc_hd__buf_2
XFILLER_0_76_153 VPWR VGND VPWR VGND sky130_ef_sc_hd__decap_12
XFILLER_0_107_417 VPWR VGND VPWR VGND sky130_ef_sc_hd__decap_12
XFILLER_0_76_197 VPWR VGND VPWR VGND sky130_ef_sc_hd__decap_12
XFILLER_0_91_167 VGND VGND VPWR VPWR sky130_fd_sc_hd__fill_1
XFILLER_0_9_497 VGND VGND VPWR VPWR sky130_fd_sc_hd__decap_6
XTAP_TAPCELL_ROW_98_1765 VGND VPWR sky130_fd_sc_hd__tapvpwrvgnd_1
XFILLER_0_72_370 VPWR VGND VPWR VGND sky130_ef_sc_hd__decap_12
XFILLER_0_115_461 VPWR VGND VPWR VGND sky130_ef_sc_hd__decap_12
XTAP_TAPCELL_ROW_98_1776 VGND VPWR sky130_fd_sc_hd__tapvpwrvgnd_1
XFILLER_0_32_245 VGND VGND VPWR VPWR sky130_fd_sc_hd__decap_6
XFILLER_0_102_133 VGND VGND VPWR VPWR sky130_fd_sc_hd__decap_6
XFILLER_0_32_289 VPWR VGND VPWR VGND sky130_ef_sc_hd__decap_12
XFILLER_0_130_475 VGND VGND VPWR VPWR sky130_fd_sc_hd__fill_1
XFILLER_0_102_177 VPWR VGND VPWR VGND sky130_ef_sc_hd__decap_12
XTAP_TAPCELL_ROW_129_2242 VGND VPWR sky130_fd_sc_hd__tapvpwrvgnd_1
XTAP_TAPCELL_ROW_129_2231 VGND VPWR sky130_fd_sc_hd__tapvpwrvgnd_1
XTAP_TAPCELL_ROW_51_1061 VGND VPWR sky130_fd_sc_hd__tapvpwrvgnd_1
XFILLER_0_99_223 VGND VGND VPWR VPWR sky130_fd_sc_hd__fill_1
XTAP_TAPCELL_ROW_5_374 VGND VPWR sky130_fd_sc_hd__tapvpwrvgnd_1
XTAP_TAPCELL_ROW_51_1072 VGND VPWR sky130_fd_sc_hd__tapvpwrvgnd_1
XFILLER_0_114_29 VPWR VGND VPWR VGND sky130_ef_sc_hd__decap_12
XFILLER_0_23_27 VPWR VGND VPWR VGND sky130_ef_sc_hd__decap_12
XFILLER_0_28_507 VGND VGND VPWR VPWR sky130_fd_sc_hd__decap_4
XTAP_TAPCELL_ROW_44_958 VGND VPWR sky130_fd_sc_hd__tapvpwrvgnd_1
XFILLER_0_55_359 VGND VGND VPWR VPWR sky130_fd_sc_hd__decap_8
XFILLER_0_55_337 VGND VGND VPWR VPWR sky130_fd_sc_hd__fill_2
XTAP_TAPCELL_ROW_24_660 VGND VPWR sky130_fd_sc_hd__tapvpwrvgnd_1
XFILLER_0_126_737 VPWR VGND VPWR VGND sky130_ef_sc_hd__decap_12
XFILLER_0_125_225 VPWR VGND VPWR VGND sky130_ef_sc_hd__decap_12
XFILLER_0_24_713 VPWR VGND VPWR VGND sky130_ef_sc_hd__decap_12
XFILLER_0_82_189 VGND VGND VPWR VPWR sky130_fd_sc_hd__decap_6
Xrebuffer5 _0742_ VGND VGND VPWR VPWR net18 sky130_fd_sc_hd__dlygate4sd1_1
XFILLER_0_23_223 VGND VGND VPWR VPWR sky130_fd_sc_hd__fill_1
XFILLER_0_36_584 VGND VGND VPWR VPWR sky130_fd_sc_hd__decap_4
XFILLER_0_134_781 VPWR VGND VPWR VGND sky130_ef_sc_hd__decap_12
XFILLER_0_3_629 VPWR VGND VPWR VGND sky130_ef_sc_hd__decap_12
XFILLER_0_24_757 VPWR VGND VPWR VGND sky130_ef_sc_hd__decap_12
XFILLER_0_11_429 VPWR VGND VPWR VGND sky130_ef_sc_hd__decap_12
XFILLER_0_2_139 VGND VGND VPWR VPWR sky130_fd_sc_hd__fill_1
XFILLER_0_121_497 VGND VGND VPWR VPWR sky130_fd_sc_hd__decap_6
X_4060_ cpu_inst.regfile_inst.registers\[2\]\[17\] VGND VGND VPWR VPWR _1966_ sky130_fd_sc_hd__clkbuf_1
XFILLER_0_3_15 VPWR VGND VPWR VGND sky130_ef_sc_hd__decap_12
X_3011_ _0974_ _0975_ VGND VGND VPWR VPWR _0976_ sky130_fd_sc_hd__or2b_1
XTAP_TAPCELL_ROW_69_1333 VGND VPWR sky130_fd_sc_hd__tapvpwrvgnd_1
XTAP_TAPCELL_ROW_82_1533 VGND VPWR sky130_fd_sc_hd__tapvpwrvgnd_1
X_4962_ _2468_ VGND VGND VPWR VPWR _2469_ sky130_fd_sc_hd__clkbuf_2
XFILLER_0_129_553 VGND VGND VPWR VPWR sky130_fd_sc_hd__decap_6
X_3913_ _1838_ cpu_inst.regfile_inst.registers\[10\]\[29\] _1313_ VGND VGND VPWR VPWR
+ _1839_ sky130_fd_sc_hd__mux2_1
XFILLER_0_74_613 VGND VGND VPWR VPWR sky130_fd_sc_hd__decap_8
X_4893_ _2431_ VGND VGND VPWR VPWR _2432_ sky130_fd_sc_hd__buf_4
XFILLER_0_58_153 VPWR VGND VPWR VGND sky130_ef_sc_hd__decap_12
XFILLER_0_19_529 VPWR VGND VPWR VGND sky130_ef_sc_hd__decap_12
X_3844_ _1739_ _1770_ _1771_ VGND VGND VPWR VPWR _1772_ sky130_fd_sc_hd__or3_1
XFILLER_0_80_77 VGND VGND VPWR VPWR sky130_fd_sc_hd__decap_6
XFILLER_0_74_657 VGND VGND VPWR VPWR sky130_fd_sc_hd__decap_8
XFILLER_0_58_197 VPWR VGND VPWR VGND sky130_ef_sc_hd__decap_12
XFILLER_0_6_401 VPWR VGND VPWR VGND sky130_ef_sc_hd__decap_12
XFILLER_0_129_597 VPWR VGND VPWR VGND sky130_ef_sc_hd__decap_12
XFILLER_0_73_167 VGND VGND VPWR VPWR sky130_fd_sc_hd__fill_1
XFILLER_0_13_93 VPWR VGND VPWR VGND sky130_ef_sc_hd__decap_12
XFILLER_0_6_445 VPWR VGND VPWR VGND sky130_ef_sc_hd__decap_12
X_3775_ _1487_ _1703_ _1704_ _1208_ VGND VGND VPWR VPWR _1705_ sky130_fd_sc_hd__a211o_1
XFILLER_0_131_217 VGND VGND VPWR VPWR sky130_fd_sc_hd__decap_6
X_5514_ clknet_leaf_19_clk _0434_ VGND VGND VPWR VPWR cpu_inst.regfile_inst.registers\[8\]\[18\]
+ sky130_fd_sc_hd__dfxtp_1
X_2726_ _0689_ _0690_ VGND VGND VPWR VPWR _0691_ sky130_fd_sc_hd__nor2_2
XFILLER_0_14_245 VGND VGND VPWR VPWR sky130_fd_sc_hd__decap_6
XFILLER_0_6_489 VPWR VGND VPWR VGND sky130_ef_sc_hd__decap_12
XFILLER_0_120_83 VGND VGND VPWR VPWR sky130_fd_sc_hd__fill_1
X_5445_ clknet_leaf_27_clk _0365_ VGND VGND VPWR VPWR cpu_inst.regfile_inst.registers\[0\]\[13\]
+ sky130_fd_sc_hd__dfxtp_1
XFILLER_0_14_289 VPWR VGND VPWR VGND sky130_ef_sc_hd__decap_12
XFILLER_0_30_716 VPWR VGND VPWR VGND sky130_ef_sc_hd__decap_12
X_2657_ _0565_ VGND VGND VPWR VPWR _0622_ sky130_fd_sc_hd__buf_4
XFILLER_0_112_475 VGND VGND VPWR VPWR sky130_fd_sc_hd__fill_1
XFILLER_0_66_3 VPWR VGND VPWR VGND sky130_ef_sc_hd__decap_12
XFILLER_0_1_161 VGND VGND VPWR VPWR sky130_fd_sc_hd__decap_6
XTAP_TAPCELL_ROW_93_1695 VGND VPWR sky130_fd_sc_hd__tapvpwrvgnd_1
X_5376_ clknet_leaf_34_clk _0296_ VGND VGND VPWR VPWR cpu_inst.regfile_inst.registers\[10\]\[8\]
+ sky130_fd_sc_hd__dfxtp_1
X_2588_ _0550_ _0548_ _0552_ VGND VGND VPWR VPWR _0553_ sky130_fd_sc_hd__and3_4
X_4327_ _2108_ VGND VGND VPWR VPWR _0173_ sky130_fd_sc_hd__clkbuf_1
XFILLER_0_129_81 VPWR VGND VPWR VGND sky130_ef_sc_hd__decap_12
X_4258_ _2071_ VGND VGND VPWR VPWR _0141_ sky130_fd_sc_hd__clkbuf_1
X_3209_ _1088_ _1173_ VGND VGND VPWR VPWR _1174_ sky130_fd_sc_hd__nor2_2
XTAP_TAPCELL_ROW_2_333 VGND VPWR sky130_fd_sc_hd__tapvpwrvgnd_1
X_4189_ _2036_ VGND VGND VPWR VPWR _0107_ sky130_fd_sc_hd__clkbuf_1
XTAP_TAPCELL_ROW_124_2161 VGND VPWR sky130_fd_sc_hd__tapvpwrvgnd_1
XFILLER_0_92_410 VGND VGND VPWR VPWR sky130_fd_sc_hd__fill_1
XFILLER_0_65_602 VGND VGND VPWR VPWR sky130_fd_sc_hd__fill_1
XFILLER_0_9_261 VPWR VGND VPWR VGND sky130_ef_sc_hd__decap_12
XFILLER_0_37_337 VPWR VGND VPWR VGND sky130_ef_sc_hd__decap_12
XTAP_TAPCELL_ROW_41_917 VGND VPWR sky130_fd_sc_hd__tapvpwrvgnd_1
XFILLER_0_108_737 VPWR VGND VPWR VGND sky130_ef_sc_hd__decap_12
XFILLER_0_107_225 VPWR VGND VPWR VGND sky130_ef_sc_hd__decap_12
XFILLER_0_80_627 VGND VGND VPWR VPWR sky130_fd_sc_hd__decap_8
XFILLER_0_52_307 VGND VGND VPWR VPWR sky130_fd_sc_hd__fill_1
XFILLER_0_80_649 VGND VGND VPWR VPWR sky130_fd_sc_hd__decap_3
XFILLER_0_73_690 VGND VGND VPWR VPWR sky130_fd_sc_hd__decap_6
XFILLER_0_64_189 VGND VGND VPWR VPWR sky130_fd_sc_hd__decap_6
XFILLER_0_123_729 VPWR VGND VPWR VGND sky130_ef_sc_hd__decap_12
XFILLER_0_116_781 VPWR VGND VPWR VGND sky130_ef_sc_hd__decap_12
XFILLER_0_61_841 VGND VGND VPWR VPWR sky130_fd_sc_hd__fill_1
XFILLER_0_21_727 VGND VGND VPWR VPWR sky130_fd_sc_hd__fill_1
XFILLER_0_33_587 VGND VGND VPWR VPWR sky130_fd_sc_hd__decap_8
XFILLER_0_60_395 VGND VGND VPWR VPWR sky130_fd_sc_hd__fill_1
XTAP_TAPCELL_ROW_53_1101 VGND VPWR sky130_fd_sc_hd__tapvpwrvgnd_1
XFILLER_0_18_27 VGND VGND VPWR VPWR sky130_fd_sc_hd__fill_1
XTAP_TAPCELL_ROW_109_1934 VGND VPWR sky130_fd_sc_hd__tapvpwrvgnd_1
XTAP_TAPCELL_ROW_29_730 VGND VPWR sky130_fd_sc_hd__tapvpwrvgnd_1
XFILLER_0_125_39 VPWR VGND VPWR VGND sky130_ef_sc_hd__decap_12
XFILLER_0_88_738 VPWR VGND VPWR VGND sky130_ef_sc_hd__decap_12
XFILLER_0_87_237 VPWR VGND VPWR VGND sky130_ef_sc_hd__decap_12
XPHY_EDGE_ROW_16_Right_16 VGND VGND VPWR VPWR sky130_fd_sc_hd__decap_3
XTAP_TAPCELL_ROW_29_741 VGND VPWR sky130_fd_sc_hd__tapvpwrvgnd_1
XFILLER_0_34_15 VPWR VGND VPWR VGND sky130_ef_sc_hd__decap_12
XFILLER_0_96_782 VGND VGND VPWR VPWR sky130_fd_sc_hd__fill_1
XFILLER_0_29_838 VGND VGND VPWR VPWR sky130_fd_sc_hd__fill_2
XFILLER_0_138_361 VGND VGND VPWR VPWR sky130_fd_sc_hd__decap_3
XFILLER_0_126_501 VPWR VGND VPWR VGND sky130_ef_sc_hd__decap_12
XFILLER_0_95_281 VPWR VGND VPWR VGND sky130_ef_sc_hd__decap_12
XTAP_TAPCELL_ROW_64_1263 VGND VPWR sky130_fd_sc_hd__tapvpwrvgnd_1
XFILLER_0_126_545 VPWR VGND VPWR VGND sky130_ef_sc_hd__decap_12
XFILLER_0_55_167 VGND VGND VPWR VPWR sky130_fd_sc_hd__fill_1
XFILLER_0_44_808 VGND VGND VPWR VPWR sky130_fd_sc_hd__decap_4
XFILLER_0_43_329 VGND VGND VPWR VPWR sky130_fd_sc_hd__decap_6
XFILLER_0_126_589 VPWR VGND VPWR VGND sky130_ef_sc_hd__decap_12
XFILLER_0_113_217 VGND VGND VPWR VPWR sky130_fd_sc_hd__decap_6
X_3560_ cpu_inst.regfile_inst.registers\[5\]\[20\] cpu_inst.regfile_inst.registers\[4\]\[20\]
+ _1348_ VGND VGND VPWR VPWR _1495_ sky130_fd_sc_hd__mux2_1
XFILLER_0_52_841 VGND VGND VPWR VPWR sky130_fd_sc_hd__fill_1
XFILLER_0_24_554 VPWR VGND VPWR VGND sky130_ef_sc_hd__decap_12
XPHY_EDGE_ROW_25_Right_25 VGND VGND VPWR VPWR sky130_fd_sc_hd__decap_3
XFILLER_0_51_373 VGND VGND VPWR VPWR sky130_fd_sc_hd__fill_2
XFILLER_0_121_261 VPWR VGND VPWR VGND sky130_ef_sc_hd__decap_12
X_5230_ clknet_leaf_13_clk _0150_ VGND VGND VPWR VPWR cpu_inst.regfile_inst.registers\[24\]\[22\]
+ sky130_fd_sc_hd__dfxtp_1
X_3491_ cpu_inst.regfile_inst.registers\[25\]\[18\] _0693_ _0695_ _1427_ VGND VGND
+ VPWR VPWR _1428_ sky130_fd_sc_hd__o211ai_1
XFILLER_0_12_749 VGND VGND VPWR VPWR sky130_fd_sc_hd__decap_6
XFILLER_0_11_237 VPWR VGND VPWR VGND sky130_ef_sc_hd__decap_12
X_5161_ clknet_leaf_24_clk _0081_ VGND VGND VPWR VPWR cpu_inst.regfile_inst.registers\[25\]\[17\]
+ sky130_fd_sc_hd__dfxtp_1
XFILLER_0_20_793 VPWR VGND VPWR VGND sky130_ef_sc_hd__decap_12
X_5092_ clknet_leaf_21_clk _0012_ VGND VGND VPWR VPWR cpu_inst.regfile_inst.registers\[6\]\[12\]
+ sky130_fd_sc_hd__dfxtp_1
XFILLER_0_75_55 VGND VGND VPWR VPWR sky130_fd_sc_hd__fill_1
X_4112_ _1183_ cpu_inst.regfile_inst.registers\[25\]\[8\] _1982_ VGND VGND VPWR VPWR
+ _1995_ sky130_fd_sc_hd__mux2_1
X_4043_ _1957_ VGND VGND VPWR VPWR _0040_ sky130_fd_sc_hd__clkbuf_1
XFILLER_0_79_716 VGND VGND VPWR VPWR sky130_fd_sc_hd__decap_3
XPHY_EDGE_ROW_34_Right_34 VGND VGND VPWR VPWR sky130_fd_sc_hd__decap_3
XFILLER_0_79_738 VGND VGND VPWR VPWR sky130_fd_sc_hd__fill_2
XFILLER_0_59_440 VGND VGND VPWR VPWR sky130_fd_sc_hd__fill_1
X_4945_ _1944_ cpu_inst.regfile_inst.registers\[8\]\[24\] _2436_ VGND VGND VPWR VPWR
+ _2460_ sky130_fd_sc_hd__mux2_1
XFILLER_0_136_309 VPWR VGND VPWR VGND sky130_ef_sc_hd__decap_12
XFILLER_0_129_361 VPWR VGND VPWR VGND sky130_ef_sc_hd__decap_12
XFILLER_0_74_421 VGND VGND VPWR VPWR sky130_fd_sc_hd__decap_6
XFILLER_0_19_337 VPWR VGND VPWR VGND sky130_ef_sc_hd__decap_12
X_4876_ cpu_inst.regfile_inst.registers\[9\]\[24\] VGND VGND VPWR VPWR _2423_ sky130_fd_sc_hd__clkbuf_1
XFILLER_0_74_465 VGND VGND VPWR VPWR sky130_fd_sc_hd__decap_6
XFILLER_0_7_721 VGND VGND VPWR VPWR sky130_fd_sc_hd__decap_6
XFILLER_0_34_307 VGND VGND VPWR VPWR sky130_fd_sc_hd__fill_1
XFILLER_0_105_718 VGND VGND VPWR VPWR sky130_fd_sc_hd__decap_8
X_3827_ _1687_ _1755_ _1306_ VGND VGND VPWR VPWR _1756_ sky130_fd_sc_hd__mux2_1
XFILLER_0_7_765 VPWR VGND VPWR VGND sky130_ef_sc_hd__decap_12
XFILLER_0_6_253 VPWR VGND VPWR VGND sky130_ef_sc_hd__decap_12
XPHY_EDGE_ROW_43_Right_43 VGND VGND VPWR VPWR sky130_fd_sc_hd__decap_3
XFILLER_0_46_189 VGND VGND VPWR VPWR sky130_fd_sc_hd__decap_6
XFILLER_0_131_93 VPWR VGND VPWR VGND sky130_ef_sc_hd__decap_12
XFILLER_0_105_729 VPWR VGND VPWR VGND sky130_ef_sc_hd__decap_12
X_3758_ _1251_ _1504_ VGND VGND VPWR VPWR _1689_ sky130_fd_sc_hd__nor2_1
XFILLER_0_61_137 VPWR VGND VPWR VGND sky130_ef_sc_hd__decap_12
XFILLER_0_43_841 VGND VGND VPWR VPWR sky130_fd_sc_hd__fill_1
XTAP_TAPCELL_ROW_95_1724 VGND VPWR sky130_fd_sc_hd__tapvpwrvgnd_1
X_2709_ _0556_ _0647_ VGND VGND VPWR VPWR _0674_ sky130_fd_sc_hd__nand2_1
XFILLER_0_100_401 VGND VGND VPWR VPWR sky130_fd_sc_hd__decap_3
X_3689_ cpu_inst.regfile_inst.registers\[11\]\[23\] cpu_inst.regfile_inst.registers\[10\]\[23\]
+ _1592_ VGND VGND VPWR VPWR _1621_ sky130_fd_sc_hd__mux2_1
X_5428_ clknet_leaf_42_clk _0348_ net2 VGND VGND VPWR VPWR cpu_inst.decoder_inst.current_pc\[28\]
+ sky130_fd_sc_hd__dfrtp_1
XTAP_TAPCELL_ROW_7_403 VGND VPWR sky130_fd_sc_hd__tapvpwrvgnd_1
X_5359_ clknet_leaf_15_clk _0279_ VGND VGND VPWR VPWR cpu_inst.regfile_inst.registers\[11\]\[23\]
+ sky130_fd_sc_hd__dfxtp_1
XPHY_EDGE_ROW_52_Right_52 VGND VGND VPWR VPWR sky130_fd_sc_hd__decap_3
XFILLER_0_97_524 VGND VGND VPWR VPWR sky130_fd_sc_hd__fill_1
XFILLER_0_69_237 VPWR VGND VPWR VGND sky130_ef_sc_hd__decap_12
XFILLER_0_97_579 VGND VGND VPWR VPWR sky130_fd_sc_hd__fill_1
XFILLER_0_108_501 VPWR VGND VPWR VGND sky130_ef_sc_hd__decap_12
XTAP_TAPCELL_ROW_104_1864 VGND VPWR sky130_fd_sc_hd__tapvpwrvgnd_1
XTAP_TAPCELL_ROW_104_1853 VGND VPWR sky130_fd_sc_hd__tapvpwrvgnd_1
XFILLER_0_77_281 VPWR VGND VPWR VGND sky130_ef_sc_hd__decap_12
XFILLER_0_93_763 VGND VGND VPWR VPWR sky130_fd_sc_hd__fill_2
XFILLER_0_92_251 VGND VGND VPWR VPWR sky130_fd_sc_hd__fill_1
XPHY_EDGE_ROW_61_Right_61 VGND VGND VPWR VPWR sky130_fd_sc_hd__decap_3
XFILLER_0_26_819 VGND VGND VPWR VPWR sky130_fd_sc_hd__fill_1
XFILLER_0_37_167 VGND VGND VPWR VPWR sky130_fd_sc_hd__fill_1
XFILLER_0_38_679 VGND VGND VPWR VPWR sky130_fd_sc_hd__decap_3
XTAP_TAPCELL_ROW_137_2352 VGND VPWR sky130_fd_sc_hd__tapvpwrvgnd_1
XFILLER_0_108_545 VGND VGND VPWR VPWR sky130_fd_sc_hd__fill_1
XFILLER_0_53_638 VPWR VGND VPWR VGND sky130_ef_sc_hd__decap_12
XFILLER_0_25_329 VGND VGND VPWR VPWR sky130_fd_sc_hd__decap_6
XFILLER_0_108_589 VPWR VGND VPWR VGND sky130_ef_sc_hd__decap_12
XFILLER_0_108_578 VGND VGND VPWR VPWR sky130_fd_sc_hd__decap_8
XFILLER_0_80_446 VGND VGND VPWR VPWR sky130_fd_sc_hd__fill_2
XFILLER_0_34_841 VGND VGND VPWR VPWR sky130_fd_sc_hd__fill_1
XFILLER_0_123_559 VGND VGND VPWR VPWR sky130_fd_sc_hd__fill_1
XFILLER_0_33_373 VPWR VGND VPWR VGND sky130_ef_sc_hd__decap_12
XFILLER_0_110_209 VPWR VGND VPWR VGND sky130_ef_sc_hd__decap_12
XFILLER_0_103_261 VPWR VGND VPWR VGND sky130_ef_sc_hd__decap_12
XFILLER_0_29_15 VPWR VGND VPWR VGND sky130_ef_sc_hd__decap_12
XPHY_EDGE_ROW_70_Right_70 VGND VGND VPWR VPWR sky130_fd_sc_hd__decap_3
XFILLER_0_136_27 VGND VGND VPWR VPWR sky130_fd_sc_hd__fill_1
XFILLER_0_45_69 VPWR VGND VPWR VGND sky130_ef_sc_hd__decap_12
XFILLER_0_88_579 VGND VGND VPWR VPWR sky130_fd_sc_hd__fill_1
XFILLER_0_69_782 VGND VGND VPWR VPWR sky130_fd_sc_hd__fill_2
XFILLER_0_0_27 VGND VGND VPWR VPWR sky130_fd_sc_hd__fill_1
XFILLER_0_118_309 VPWR VGND VPWR VGND sky130_ef_sc_hd__decap_12
XFILLER_0_61_57 VPWR VGND VPWR VGND sky130_ef_sc_hd__decap_12
XPHY_EDGE_ROW_14_Left_153 VGND VGND VPWR VPWR sky130_fd_sc_hd__decap_3
X_2991_ cpu_inst.regfile_inst.registers\[9\]\[7\] cpu_inst.regfile_inst.registers\[8\]\[7\]
+ _0866_ VGND VGND VPWR VPWR _0956_ sky130_fd_sc_hd__mux2_1
XFILLER_0_127_821 VPWR VGND VPWR VGND sky130_ef_sc_hd__decap_12
X_4730_ cpu_inst.decoder_inst.current_pc\[21\] _2338_ cpu_inst.decoder_inst.current_pc\[22\]
+ VGND VGND VPWR VPWR _2343_ sky130_fd_sc_hd__a21oi_1
XFILLER_0_16_307 VGND VGND VPWR VPWR sky130_fd_sc_hd__fill_1
XFILLER_0_124_3 VPWR VGND VPWR VGND sky130_ef_sc_hd__decap_12
XFILLER_0_83_273 VGND VGND VPWR VPWR sky130_fd_sc_hd__decap_6
X_4661_ _2284_ _1988_ _0527_ VGND VGND VPWR VPWR _2292_ sky130_fd_sc_hd__and3_1
XFILLER_0_28_189 VGND VGND VPWR VPWR sky130_fd_sc_hd__decap_6
X_3612_ _1489_ _1545_ _1255_ VGND VGND VPWR VPWR _1546_ sky130_fd_sc_hd__mux2_1
XFILLER_0_9_69 VPWR VGND VPWR VGND sky130_ef_sc_hd__decap_12
XFILLER_0_4_713 VPWR VGND VPWR VGND sky130_ef_sc_hd__decap_12
XFILLER_0_25_841 VGND VGND VPWR VPWR sky130_fd_sc_hd__fill_1
XFILLER_0_43_137 VPWR VGND VPWR VGND sky130_ef_sc_hd__decap_12
X_4592_ _2244_ VGND VGND VPWR VPWR _0302_ sky130_fd_sc_hd__clkbuf_1
XFILLER_0_52_660 VGND VGND VPWR VPWR sky130_fd_sc_hd__fill_1
XTAP_TAPCELL_ROW_12_482 VGND VPWR sky130_fd_sc_hd__tapvpwrvgnd_1
XFILLER_0_12_513 VPWR VGND VPWR VGND sky130_ef_sc_hd__decap_12
XFILLER_0_4_757 VPWR VGND VPWR VGND sky130_ef_sc_hd__decap_12
XFILLER_0_3_223 VGND VGND VPWR VPWR sky130_fd_sc_hd__fill_1
XFILLER_0_40_811 VGND VGND VPWR VPWR sky130_fd_sc_hd__fill_1
X_3543_ _1028_ _1471_ _1474_ _1478_ VGND VGND VPWR VPWR _1479_ sky130_fd_sc_hd__o211a_1
XTAP_TAPCELL_ROW_77_1454 VGND VPWR sky130_fd_sc_hd__tapvpwrvgnd_1
XFILLER_0_52_693 VGND VGND VPWR VPWR sky130_fd_sc_hd__decap_4
XFILLER_0_51_181 VPWR VGND VPWR VGND sky130_ef_sc_hd__decap_12
XFILLER_0_122_581 VGND VGND VPWR VPWR sky130_fd_sc_hd__decap_6
X_3474_ cpu_inst.regfile_inst.registers\[25\]\[17\] _1252_ _1069_ _1392_ VGND VGND
+ VPWR VPWR _1412_ sky130_fd_sc_hd__o211ai_2
XFILLER_0_12_557 VPWR VGND VPWR VGND sky130_ef_sc_hd__decap_12
XFILLER_0_10_83 VGND VGND VPWR VPWR sky130_fd_sc_hd__fill_1
XPHY_EDGE_ROW_23_Left_162 VGND VGND VPWR VPWR sky130_fd_sc_hd__decap_3
XTAP_TAPCELL_ROW_90_1643 VGND VPWR sky130_fd_sc_hd__tapvpwrvgnd_1
XFILLER_0_86_65 VPWR VGND VPWR VGND sky130_ef_sc_hd__decap_12
X_5213_ clknet_leaf_35_clk _0133_ VGND VGND VPWR VPWR cpu_inst.regfile_inst.registers\[24\]\[5\]
+ sky130_fd_sc_hd__dfxtp_1
XTAP_TAPCELL_ROW_90_1654 VGND VPWR sky130_fd_sc_hd__tapvpwrvgnd_1
X_5144_ clknet_leaf_1_clk _0064_ VGND VGND VPWR VPWR cpu_inst.regfile_inst.registers\[25\]\[0\]
+ sky130_fd_sc_hd__dfxtp_1
XFILLER_0_19_81 VPWR VGND VPWR VGND sky130_ef_sc_hd__decap_12
X_5075_ cpu_inst.display_inst.counter\[17\] cpu_inst.display_inst.counter\[16\] _2528_
+ VGND VGND VPWR VPWR _2532_ sky130_fd_sc_hd__and3_1
XFILLER_0_29_3 VPWR VGND VPWR VGND sky130_ef_sc_hd__decap_12
X_4026_ cpu_inst.regfile_inst.registers\[2\]\[0\] VGND VGND VPWR VPWR _1949_ sky130_fd_sc_hd__clkbuf_1
XTAP_TAPCELL_ROW_121_2120 VGND VPWR sky130_fd_sc_hd__tapvpwrvgnd_1
XPHY_EDGE_ROW_32_Left_171 VGND VGND VPWR VPWR sky130_fd_sc_hd__decap_3
XFILLER_0_137_629 VPWR VGND VPWR VGND sky130_ef_sc_hd__decap_12
XFILLER_0_75_741 VGND VGND VPWR VPWR sky130_fd_sc_hd__fill_1
XFILLER_0_59_281 VPWR VGND VPWR VGND sky130_ef_sc_hd__decap_12
XFILLER_0_136_139 VGND VGND VPWR VPWR sky130_fd_sc_hd__fill_1
XFILLER_0_74_251 VGND VGND VPWR VPWR sky130_fd_sc_hd__fill_1
X_4928_ _2451_ VGND VGND VPWR VPWR _0431_ sky130_fd_sc_hd__clkbuf_1
XFILLER_0_62_413 VGND VGND VPWR VPWR sky130_fd_sc_hd__fill_2
XFILLER_0_19_167 VGND VGND VPWR VPWR sky130_fd_sc_hd__fill_1
XFILLER_0_132_301 VGND VGND VPWR VPWR sky130_fd_sc_hd__decap_6
XFILLER_0_90_755 VGND VGND VPWR VPWR sky130_fd_sc_hd__fill_1
X_4859_ _2414_ VGND VGND VPWR VPWR _0399_ sky130_fd_sc_hd__clkbuf_1
XFILLER_0_7_573 VPWR VGND VPWR VGND sky130_ef_sc_hd__decap_12
XFILLER_0_16_841 VGND VGND VPWR VPWR sky130_fd_sc_hd__fill_1
XFILLER_0_132_345 VPWR VGND VPWR VGND sky130_ef_sc_hd__decap_12
XTAP_TAPCELL_ROW_119_2082 VGND VPWR sky130_fd_sc_hd__tapvpwrvgnd_1
XFILLER_0_15_373 VPWR VGND VPWR VGND sky130_ef_sc_hd__decap_12
XFILLER_0_30_321 VPWR VGND VPWR VGND sky130_ef_sc_hd__decap_12
XPHY_EDGE_ROW_41_Left_180 VGND VGND VPWR VPWR sky130_fd_sc_hd__decap_3
XTAP_TAPCELL_ROW_132_2282 VGND VPWR sky130_fd_sc_hd__tapvpwrvgnd_1
XFILLER_0_132_389 VPWR VGND VPWR VGND sky130_ef_sc_hd__decap_12
XFILLER_0_30_365 VPWR VGND VPWR VGND sky130_ef_sc_hd__decap_12
XFILLER_0_100_253 VPWR VGND VPWR VGND sky130_ef_sc_hd__decap_12
XFILLER_0_98_811 VGND VGND VPWR VPWR sky130_fd_sc_hd__fill_1
XFILLER_0_15_39 VPWR VGND VPWR VGND sky130_ef_sc_hd__decap_12
XTAP_TAPCELL_ROW_39_880 VGND VPWR sky130_fd_sc_hd__tapvpwrvgnd_1
XTAP_TAPCELL_ROW_48_1022 VGND VPWR sky130_fd_sc_hd__tapvpwrvgnd_1
XFILLER_0_85_505 VGND VGND VPWR VPWR sky130_fd_sc_hd__fill_1
XTAP_TAPCELL_ROW_39_891 VGND VPWR sky130_fd_sc_hd__tapvpwrvgnd_1
XFILLER_0_122_29 VPWR VGND VPWR VGND sky130_ef_sc_hd__decap_12
XFILLER_0_109_821 VPWR VGND VPWR VGND sky130_ef_sc_hd__decap_12
XTAP_TAPCELL_ROW_61_1222 VGND VPWR sky130_fd_sc_hd__tapvpwrvgnd_1
XTAP_TAPCELL_ROW_61_1211 VGND VPWR sky130_fd_sc_hd__tapvpwrvgnd_1
XFILLER_0_26_605 VGND VGND VPWR VPWR sky130_fd_sc_hd__fill_2
XFILLER_0_81_722 VGND VGND VPWR VPWR sky130_fd_sc_hd__fill_2
XFILLER_0_65_273 VGND VGND VPWR VPWR sky130_fd_sc_hd__decap_6
XFILLER_0_31_27 VPWR VGND VPWR VGND sky130_ef_sc_hd__decap_12
XFILLER_0_38_498 VGND VGND VPWR VPWR sky130_fd_sc_hd__decap_4
XFILLER_0_135_161 VGND VGND VPWR VPWR sky130_fd_sc_hd__decap_6
XFILLER_0_124_813 VPWR VGND VPWR VGND sky130_ef_sc_hd__decap_12
XFILLER_0_80_221 VPWR VGND VPWR VGND sky130_ef_sc_hd__decap_12
XFILLER_0_25_137 VPWR VGND VPWR VGND sky130_ef_sc_hd__decap_12
XFILLER_0_80_265 VPWR VGND VPWR VGND sky130_ef_sc_hd__decap_12
XFILLER_0_22_811 VGND VGND VPWR VPWR sky130_fd_sc_hd__fill_1
XFILLER_0_34_660 VGND VGND VPWR VPWR sky130_fd_sc_hd__fill_2
XFILLER_0_1_727 VGND VGND VPWR VPWR sky130_fd_sc_hd__fill_1
XFILLER_0_33_181 VPWR VGND VPWR VGND sky130_ef_sc_hd__decap_12
XFILLER_0_111_529 VPWR VGND VPWR VGND sky130_ef_sc_hd__decap_12
XFILLER_0_104_581 VGND VGND VPWR VPWR sky130_fd_sc_hd__decap_6
XTAP_TAPCELL_ROW_59_1184 VGND VPWR sky130_fd_sc_hd__tapvpwrvgnd_1
XFILLER_0_0_237 VPWR VGND VPWR VGND sky130_ef_sc_hd__decap_12
XTAP_TAPCELL_ROW_72_1384 VGND VPWR sky130_fd_sc_hd__tapvpwrvgnd_1
XTAP_TAPCELL_ROW_72_1373 VGND VPWR sky130_fd_sc_hd__tapvpwrvgnd_1
X_3190_ _0756_ _1143_ _1154_ VGND VGND VPWR VPWR _1155_ sky130_fd_sc_hd__a21o_1
XFILLER_0_88_321 VPWR VGND VPWR VGND sky130_ef_sc_hd__decap_12
XFILLER_0_88_365 VPWR VGND VPWR VGND sky130_ef_sc_hd__decap_12
XTAP_TAPCELL_ROW_17_552 VGND VPWR sky130_fd_sc_hd__tapvpwrvgnd_1
XFILLER_0_119_629 VPWR VGND VPWR VGND sky130_ef_sc_hd__decap_12
XFILLER_0_57_752 VGND VGND VPWR VPWR sky130_fd_sc_hd__fill_1
X_2974_ cpu_inst.regfile_inst.registers\[5\]\[6\] cpu_inst.regfile_inst.registers\[4\]\[6\]
+ _0865_ VGND VGND VPWR VPWR _0939_ sky130_fd_sc_hd__mux2_1
XFILLER_0_118_139 VGND VGND VPWR VPWR sky130_fd_sc_hd__fill_1
XFILLER_0_84_560 VPWR VGND VPWR VGND sky130_ef_sc_hd__decap_12
X_4713_ cpu_inst.decoder_inst.current_pc\[17\] _2328_ VGND VGND VPWR VPWR _2331_ sky130_fd_sc_hd__and2_1
XFILLER_0_56_251 VGND VGND VPWR VPWR sky130_fd_sc_hd__fill_1
XFILLER_0_44_413 VGND VGND VPWR VPWR sky130_fd_sc_hd__decap_6
XFILLER_0_127_673 VPWR VGND VPWR VGND sky130_ef_sc_hd__decap_12
XFILLER_0_114_301 VGND VGND VPWR VPWR sky130_fd_sc_hd__decap_6
X_4644_ _1075_ _1100_ _2276_ VGND VGND VPWR VPWR _2277_ sky130_fd_sc_hd__or3_4
XFILLER_0_130_805 VGND VGND VPWR VPWR sky130_fd_sc_hd__decap_6
XFILLER_0_114_345 VPWR VGND VPWR VGND sky130_ef_sc_hd__decap_12
XFILLER_0_12_321 VPWR VGND VPWR VGND sky130_ef_sc_hd__decap_12
XFILLER_0_13_833 VGND VGND VPWR VPWR sky130_fd_sc_hd__decap_6
XFILLER_0_21_93 VPWR VGND VPWR VGND sky130_ef_sc_hd__decap_12
X_4575_ _2235_ VGND VGND VPWR VPWR _0294_ sky130_fd_sc_hd__clkbuf_1
XFILLER_0_114_389 VPWR VGND VPWR VGND sky130_ef_sc_hd__decap_12
X_3526_ cpu_inst.regfile_inst.registers\[9\]\[19\] cpu_inst.regfile_inst.registers\[8\]\[19\]
+ _1386_ VGND VGND VPWR VPWR _1462_ sky130_fd_sc_hd__mux2_1
XFILLER_0_4_587 VGND VGND VPWR VPWR sky130_fd_sc_hd__fill_1
XFILLER_0_12_365 VPWR VGND VPWR VGND sky130_ef_sc_hd__decap_12
XFILLER_0_40_696 VGND VGND VPWR VPWR sky130_fd_sc_hd__decap_4
X_3457_ cpu_inst.regfile_inst.registers\[11\]\[17\] cpu_inst.regfile_inst.registers\[10\]\[17\]
+ _0620_ VGND VGND VPWR VPWR _1395_ sky130_fd_sc_hd__mux2_1
X_3388_ _1335_ VGND VGND VPWR VPWR _0007_ sky130_fd_sc_hd__clkbuf_1
X_5127_ clknet_leaf_21_clk _0047_ VGND VGND VPWR VPWR cpu_inst.regfile_inst.registers\[2\]\[15\]
+ sky130_fd_sc_hd__dfxtp_1
XFILLER_0_137_81 VPWR VGND VPWR VGND sky130_ef_sc_hd__decap_12
XPHY_EDGE_ROW_2_Right_2 VGND VGND VPWR VPWR sky130_fd_sc_hd__decap_3
X_5058_ cpu_inst.display_inst.counter\[11\] cpu_inst.display_inst.counter\[10\] _2517_
+ VGND VGND VPWR VPWR _2522_ sky130_fd_sc_hd__and3_1
X_4009_ _1306_ _1930_ _1931_ VGND VGND VPWR VPWR _1932_ sky130_fd_sc_hd__a21oi_1
XFILLER_0_67_505 VGND VGND VPWR VPWR sky130_fd_sc_hd__decap_4
XFILLER_0_1_81 VPWR VGND VPWR VGND sky130_ef_sc_hd__decap_12
XTAP_TAPCELL_ROW_101_1812 VGND VPWR sky130_fd_sc_hd__tapvpwrvgnd_1
XFILLER_0_94_357 VGND VGND VPWR VPWR sky130_fd_sc_hd__decap_6
XFILLER_0_63_711 VGND VGND VPWR VPWR sky130_fd_sc_hd__fill_1
XFILLER_0_47_273 VGND VGND VPWR VPWR sky130_fd_sc_hd__decap_6
XFILLER_0_124_109 VPWR VGND VPWR VGND sky130_ef_sc_hd__decap_12
XFILLER_0_117_161 VGND VGND VPWR VPWR sky130_fd_sc_hd__decap_6
XFILLER_0_106_813 VPWR VGND VPWR VGND sky130_ef_sc_hd__decap_12
XFILLER_0_62_221 VPWR VGND VPWR VGND sky130_ef_sc_hd__decap_12
XTAP_TAPCELL_ROW_134_2311 VGND VPWR sky130_fd_sc_hd__tapvpwrvgnd_1
XFILLER_0_62_265 VPWR VGND VPWR VGND sky130_ef_sc_hd__decap_12
XFILLER_0_133_665 VGND VGND VPWR VPWR sky130_fd_sc_hd__decap_6
XFILLER_0_132_153 VPWR VGND VPWR VGND sky130_ef_sc_hd__decap_12
XFILLER_0_15_181 VPWR VGND VPWR VGND sky130_ef_sc_hd__decap_12
XFILLER_0_16_693 VGND VGND VPWR VPWR sky130_fd_sc_hd__decap_6
XFILLER_0_132_197 VPWR VGND VPWR VGND sky130_ef_sc_hd__decap_12
XFILLER_0_31_641 VGND VGND VPWR VPWR sky130_fd_sc_hd__decap_6
XFILLER_0_30_195 VGND VGND VPWR VPWR sky130_fd_sc_hd__fill_1
XTAP_TAPCELL_ROW_112_1985 VGND VPWR sky130_fd_sc_hd__tapvpwrvgnd_1
XTAP_TAPCELL_ROW_112_1974 VGND VPWR sky130_fd_sc_hd__tapvpwrvgnd_1
XFILLER_0_26_27 VGND VGND VPWR VPWR sky130_fd_sc_hd__fill_1
XFILLER_0_98_674 VGND VGND VPWR VPWR sky130_fd_sc_hd__fill_1
XFILLER_0_133_39 VPWR VGND VPWR VGND sky130_ef_sc_hd__decap_12
XFILLER_0_98_696 VGND VGND VPWR VPWR sky130_fd_sc_hd__decap_4
XFILLER_0_85_335 VGND VGND VPWR VPWR sky130_fd_sc_hd__fill_1
XFILLER_0_58_549 VPWR VGND VPWR VGND sky130_ef_sc_hd__decap_12
XFILLER_0_58_527 VGND VGND VPWR VPWR sky130_fd_sc_hd__decap_4
XTAP_TAPCELL_ROW_34_809 VGND VPWR sky130_fd_sc_hd__tapvpwrvgnd_1
XFILLER_0_42_15 VPWR VGND VPWR VGND sky130_ef_sc_hd__decap_12
XTAP_TAPCELL_ROW_14_511 VGND VPWR sky130_fd_sc_hd__tapvpwrvgnd_1
XFILLER_0_66_582 VGND VGND VPWR VPWR sky130_fd_sc_hd__decap_3
XFILLER_0_26_413 VGND VGND VPWR VPWR sky130_fd_sc_hd__decap_6
XFILLER_0_38_251 VGND VGND VPWR VPWR sky130_fd_sc_hd__fill_1
XFILLER_0_39_785 VPWR VGND VPWR VGND sky130_ef_sc_hd__decap_12
XFILLER_0_109_673 VPWR VGND VPWR VGND sky130_ef_sc_hd__decap_12
XFILLER_0_5_329 VGND VGND VPWR VPWR sky130_fd_sc_hd__decap_6
XFILLER_0_26_457 VPWR VGND VPWR VGND sky130_ef_sc_hd__decap_12
XFILLER_0_124_643 VGND VGND VPWR VPWR sky130_fd_sc_hd__fill_1
XFILLER_0_41_405 VGND VGND VPWR VPWR sky130_fd_sc_hd__decap_8
X_2690_ _0529_ _0531_ _0551_ VGND VGND VPWR VPWR _0655_ sky130_fd_sc_hd__or3_1
XFILLER_0_112_805 VGND VGND VPWR VPWR sky130_fd_sc_hd__decap_6
XFILLER_0_41_449 VGND VGND VPWR VPWR sky130_fd_sc_hd__decap_4
X_4360_ _2125_ VGND VGND VPWR VPWR _0189_ sky130_fd_sc_hd__clkbuf_1
XTAP_TAPCELL_ROW_74_1413 VGND VPWR sky130_fd_sc_hd__tapvpwrvgnd_1
XFILLER_0_6_15 VPWR VGND VPWR VGND sky130_ef_sc_hd__decap_12
XFILLER_0_111_337 VPWR VGND VPWR VGND sky130_ef_sc_hd__decap_12
X_3311_ _1268_ _1272_ _1273_ _1263_ VGND VGND VPWR VPWR net9 sky130_fd_sc_hd__a22o_1
XFILLER_0_10_825 VPWR VGND VPWR VGND sky130_ef_sc_hd__decap_12
X_4291_ cpu_inst.regfile_inst.registers\[24\]\[30\] VGND VGND VPWR VPWR _2088_ sky130_fd_sc_hd__clkbuf_1
X_3242_ _1015_ _1159_ _1004_ VGND VGND VPWR VPWR _1207_ sky130_fd_sc_hd__a21oi_1
X_3173_ _0910_ _1081_ _1057_ VGND VGND VPWR VPWR _1138_ sky130_fd_sc_hd__mux2_1
XFILLER_0_107_51 VGND VGND VPWR VPWR sky130_fd_sc_hd__decap_4
XFILLER_0_83_55 VGND VGND VPWR VPWR sky130_fd_sc_hd__fill_1
Xrebuffer15 net29 VGND VGND VPWR VPWR net28 sky130_fd_sc_hd__dlygate4sd1_1
Xrebuffer26 _0594_ VGND VGND VPWR VPWR net39 sky130_fd_sc_hd__dlygate4sd1_1
XFILLER_0_88_195 VGND VGND VPWR VPWR sky130_fd_sc_hd__fill_1
XTAP_TAPCELL_ROW_85_1575 VGND VPWR sky130_fd_sc_hd__tapvpwrvgnd_1
XFILLER_0_76_357 VGND VGND VPWR VPWR sky130_fd_sc_hd__decap_6
XFILLER_0_91_305 VPWR VGND VPWR VGND sky130_ef_sc_hd__decap_12
XFILLER_0_29_273 VGND VGND VPWR VPWR sky130_fd_sc_hd__decap_6
XFILLER_0_106_109 VPWR VGND VPWR VGND sky130_ef_sc_hd__decap_12
XFILLER_0_91_349 VPWR VGND VPWR VGND sky130_ef_sc_hd__decap_12
X_2957_ _0675_ VGND VGND VPWR VPWR _0922_ sky130_fd_sc_hd__clkbuf_4
XFILLER_0_44_221 VPWR VGND VPWR VGND sky130_ef_sc_hd__decap_12
XFILLER_0_96_3 VPWR VGND VPWR VGND sky130_ef_sc_hd__decap_12
XFILLER_0_72_552 VGND VGND VPWR VPWR sky130_fd_sc_hd__fill_2
XFILLER_0_8_189 VGND VGND VPWR VPWR sky130_fd_sc_hd__decap_6
XFILLER_0_5_841 VGND VGND VPWR VPWR sky130_fd_sc_hd__fill_1
XFILLER_0_44_265 VPWR VGND VPWR VGND sky130_ef_sc_hd__decap_12
X_2888_ _0705_ VGND VGND VPWR VPWR _0853_ sky130_fd_sc_hd__clkbuf_4
XTAP_TAPCELL_ROW_116_2041 VGND VPWR sky130_fd_sc_hd__tapvpwrvgnd_1
XFILLER_0_115_665 VGND VGND VPWR VPWR sky130_fd_sc_hd__decap_6
XFILLER_0_114_153 VPWR VGND VPWR VGND sky130_ef_sc_hd__decap_12
X_4627_ _2262_ VGND VGND VPWR VPWR _0319_ sky130_fd_sc_hd__clkbuf_1
XFILLER_0_130_613 VPWR VGND VPWR VGND sky130_ef_sc_hd__decap_12
XFILLER_0_13_641 VPWR VGND VPWR VGND sky130_ef_sc_hd__decap_12
XFILLER_0_130_657 VPWR VGND VPWR VGND sky130_ef_sc_hd__decap_12
XFILLER_0_114_197 VPWR VGND VPWR VGND sky130_ef_sc_hd__decap_12
X_4558_ cpu_inst.regfile_inst.registers\[11\]\[30\] VGND VGND VPWR VPWR _2227_ sky130_fd_sc_hd__clkbuf_1
XFILLER_0_13_685 VPWR VGND VPWR VGND sky130_ef_sc_hd__decap_12
XFILLER_0_40_460 VGND VGND VPWR VPWR sky130_fd_sc_hd__fill_1
X_4489_ _2192_ VGND VGND VPWR VPWR _0251_ sky130_fd_sc_hd__clkbuf_1
X_3509_ _1408_ _1421_ _1445_ VGND VGND VPWR VPWR _1446_ sky130_fd_sc_hd__a21o_1
XFILLER_0_12_195 VGND VGND VPWR VPWR sky130_fd_sc_hd__fill_1
XFILLER_0_99_405 VGND VGND VPWR VPWR sky130_fd_sc_hd__decap_8
Xclkbuf_leaf_37_clk clknet_2_0__leaf_clk VGND VGND VPWR VPWR clknet_leaf_37_clk sky130_fd_sc_hd__clkbuf_8
XFILLER_0_138_713 VPWR VGND VPWR VGND sky130_ef_sc_hd__decap_12
XFILLER_0_95_677 VGND VGND VPWR VPWR sky130_fd_sc_hd__fill_1
XFILLER_0_94_121 VPWR VGND VPWR VGND sky130_ef_sc_hd__decap_12
XTAP_TAPCELL_ROW_0_283 VGND VPWR sky130_fd_sc_hd__tapvpwrvgnd_1
XTAP_TAPCELL_ROW_0_294 VGND VPWR sky130_fd_sc_hd__tapvpwrvgnd_1
XFILLER_0_138_757 VPWR VGND VPWR VGND sky130_ef_sc_hd__decap_12
XFILLER_0_137_223 VGND VGND VPWR VPWR sky130_fd_sc_hd__fill_1
XFILLER_0_94_165 VPWR VGND VPWR VGND sky130_ef_sc_hd__decap_12
XFILLER_0_83_839 VGND VGND VPWR VPWR sky130_fd_sc_hd__fill_1
XFILLER_0_125_429 VPWR VGND VPWR VGND sky130_ef_sc_hd__decap_12
XFILLER_0_12_29 VPWR VGND VPWR VGND sky130_ef_sc_hd__decap_12
XFILLER_0_23_405 VPWR VGND VPWR VGND sky130_ef_sc_hd__decap_12
XFILLER_0_133_473 VPWR VGND VPWR VGND sky130_ef_sc_hd__decap_12
XFILLER_0_23_449 VPWR VGND VPWR VGND sky130_ef_sc_hd__decap_12
Xoutput5 net5 VGND VGND VPWR VPWR an[2] sky130_fd_sc_hd__buf_1
XTAP_TAPCELL_ROW_56_1143 VGND VPWR sky130_fd_sc_hd__tapvpwrvgnd_1
XFILLER_0_120_189 VGND VGND VPWR VPWR sky130_fd_sc_hd__decap_6
XFILLER_0_37_15 VPWR VGND VPWR VGND sky130_ef_sc_hd__decap_12
Xclkbuf_leaf_28_clk clknet_2_2__leaf_clk VGND VGND VPWR VPWR clknet_leaf_28_clk sky130_fd_sc_hd__clkbuf_8
XFILLER_0_53_69 VPWR VGND VPWR VGND sky130_ef_sc_hd__decap_12
XFILLER_0_86_666 VGND VGND VPWR VPWR sky130_fd_sc_hd__decap_4
XFILLER_0_128_245 VGND VGND VPWR VPWR sky130_fd_sc_hd__decap_6
X_3860_ _1701_ _1787_ _1306_ VGND VGND VPWR VPWR _1788_ sky130_fd_sc_hd__mux2_1
XFILLER_0_73_305 VGND VGND VPWR VPWR sky130_fd_sc_hd__decap_8
X_3791_ _1707_ _1720_ VGND VGND VPWR VPWR _1721_ sky130_fd_sc_hd__xnor2_1
XFILLER_0_54_530 VGND VGND VPWR VPWR sky130_fd_sc_hd__fill_2
XFILLER_0_26_221 VPWR VGND VPWR VGND sky130_ef_sc_hd__decap_12
X_2811_ cpu_inst.regfile_inst.registers\[1\]\[4\] _0627_ _0603_ cpu_inst.regfile_inst.registers\[5\]\[4\]
+ _0561_ VGND VGND VPWR VPWR _0776_ sky130_fd_sc_hd__o221a_1
XFILLER_0_128_289 VPWR VGND VPWR VGND sky130_ef_sc_hd__decap_12
XTAP_TAPCELL_ROW_80_1494 VGND VPWR sky130_fd_sc_hd__tapvpwrvgnd_1
XFILLER_0_54_563 VGND VGND VPWR VPWR sky130_fd_sc_hd__fill_2
XFILLER_0_5_137 VPWR VGND VPWR VGND sky130_ef_sc_hd__decap_12
XFILLER_0_26_265 VPWR VGND VPWR VGND sky130_ef_sc_hd__decap_12
XFILLER_0_27_777 VGND VGND VPWR VPWR sky130_fd_sc_hd__decap_6
X_2742_ cpu_inst.regfile_inst.registers\[1\]\[10\] _0593_ _0702_ cpu_inst.regfile_inst.registers\[5\]\[10\]
+ _0561_ VGND VGND VPWR VPWR _0707_ sky130_fd_sc_hd__o221a_1
XFILLER_0_42_714 VPWR VGND VPWR VGND sky130_ef_sc_hd__decap_12
X_5530_ clknet_leaf_37_clk _0450_ VGND VGND VPWR VPWR cpu_inst.regfile_inst.registers\[15\]\[2\]
+ sky130_fd_sc_hd__dfxtp_1
X_5461_ clknet_leaf_6_clk _0381_ VGND VGND VPWR VPWR cpu_inst.regfile_inst.registers\[0\]\[29\]
+ sky130_fd_sc_hd__dfxtp_1
XFILLER_0_81_393 VGND VGND VPWR VPWR sky130_fd_sc_hd__decap_6
XFILLER_0_112_613 VPWR VGND VPWR VGND sky130_ef_sc_hd__decap_12
X_4412_ _2151_ VGND VGND VPWR VPWR _0215_ sky130_fd_sc_hd__clkbuf_1
X_2673_ _0608_ _0575_ _0609_ VGND VGND VPWR VPWR _0638_ sky130_fd_sc_hd__and3_1
XFILLER_0_2_811 VGND VGND VPWR VPWR sky130_fd_sc_hd__fill_1
XFILLER_0_112_657 VPWR VGND VPWR VGND sky130_ef_sc_hd__decap_12
XFILLER_0_100_808 VGND VGND VPWR VPWR sky130_fd_sc_hd__decap_4
X_5392_ clknet_leaf_9_clk _0312_ VGND VGND VPWR VPWR cpu_inst.regfile_inst.registers\[10\]\[24\]
+ sky130_fd_sc_hd__dfxtp_1
XFILLER_0_41_279 VGND VGND VPWR VPWR sky130_fd_sc_hd__fill_1
XFILLER_0_111_167 VGND VGND VPWR VPWR sky130_fd_sc_hd__fill_1
XPHY_EDGE_ROW_99_Right_99 VGND VGND VPWR VPWR sky130_fd_sc_hd__decap_3
X_4343_ _2116_ VGND VGND VPWR VPWR _0181_ sky130_fd_sc_hd__clkbuf_1
XFILLER_0_78_77 VGND VGND VPWR VPWR sky130_fd_sc_hd__decap_6
X_4274_ _2079_ VGND VGND VPWR VPWR _0149_ sky130_fd_sc_hd__clkbuf_1
X_3225_ _1144_ _1178_ _1189_ _0756_ VGND VGND VPWR VPWR _1190_ sky130_fd_sc_hd__a211o_1
XFILLER_0_10_699 VGND VGND VPWR VPWR sky130_fd_sc_hd__fill_1
XFILLER_0_94_65 VPWR VGND VPWR VGND sky130_ef_sc_hd__decap_12
XFILLER_0_118_83 VGND VGND VPWR VPWR sky130_fd_sc_hd__fill_1
XTAP_TAPCELL_ROW_87_1604 VGND VPWR sky130_fd_sc_hd__tapvpwrvgnd_1
XFILLER_0_27_81 VPWR VGND VPWR VGND sky130_ef_sc_hd__decap_12
X_3156_ cpu_inst.regfile_inst.registers\[15\]\[14\] _0710_ _1120_ _0714_ VGND VGND
+ VPWR VPWR _1121_ sky130_fd_sc_hd__a211o_1
XFILLER_0_96_419 VGND VGND VPWR VPWR sky130_fd_sc_hd__fill_1
Xclkbuf_leaf_19_clk clknet_2_3__leaf_clk VGND VGND VPWR VPWR clknet_leaf_19_clk sky130_fd_sc_hd__clkbuf_8
X_3087_ _0682_ _0528_ VGND VGND VPWR VPWR _1052_ sky130_fd_sc_hd__nor2_1
XPHY_EDGE_ROW_6_Left_145 VGND VGND VPWR VPWR sky130_fd_sc_hd__decap_3
XFILLER_0_11_3 VPWR VGND VPWR VGND sky130_ef_sc_hd__decap_12
XFILLER_0_77_644 VPWR VGND VPWR VGND sky130_ef_sc_hd__decap_12
XFILLER_0_76_121 VPWR VGND VPWR VGND sky130_ef_sc_hd__decap_12
XFILLER_0_49_335 VGND VGND VPWR VPWR sky130_fd_sc_hd__fill_1
XFILLER_0_119_223 VGND VGND VPWR VPWR sky130_fd_sc_hd__fill_1
XFILLER_0_77_677 VGND VGND VPWR VPWR sky130_fd_sc_hd__fill_1
XFILLER_0_76_165 VPWR VGND VPWR VGND sky130_ef_sc_hd__decap_12
XFILLER_0_65_839 VGND VGND VPWR VPWR sky130_fd_sc_hd__fill_1
XFILLER_0_135_727 VGND VGND VPWR VPWR sky130_fd_sc_hd__fill_1
XFILLER_0_91_113 VPWR VGND VPWR VGND sky130_ef_sc_hd__decap_12
XFILLER_0_18_755 VGND VGND VPWR VPWR sky130_fd_sc_hd__fill_1
XFILLER_0_107_429 VPWR VGND VPWR VGND sky130_ef_sc_hd__decap_12
X_3989_ cpu_inst.regfile_inst.registers\[11\]\[31\] cpu_inst.regfile_inst.registers\[10\]\[31\]
+ _1592_ VGND VGND VPWR VPWR _1913_ sky130_fd_sc_hd__mux2_1
XFILLER_0_72_382 VGND VGND VPWR VPWR sky130_fd_sc_hd__decap_3
XFILLER_0_72_360 VGND VGND VPWR VPWR sky130_fd_sc_hd__decap_4
XFILLER_0_115_473 VPWR VGND VPWR VGND sky130_ef_sc_hd__decap_12
XTAP_TAPCELL_ROW_98_1777 VGND VPWR sky130_fd_sc_hd__tapvpwrvgnd_1
XTAP_TAPCELL_ROW_98_1766 VGND VPWR sky130_fd_sc_hd__tapvpwrvgnd_1
XFILLER_0_5_671 VGND VGND VPWR VPWR sky130_fd_sc_hd__fill_1
XFILLER_0_130_421 VPWR VGND VPWR VGND sky130_ef_sc_hd__decap_12
XFILLER_0_103_668 VGND VGND VPWR VPWR sky130_fd_sc_hd__decap_4
XFILLER_0_20_419 VGND VGND VPWR VPWR sky130_fd_sc_hd__fill_1
XFILLER_0_102_189 VGND VGND VPWR VPWR sky130_fd_sc_hd__decap_6
XTAP_TAPCELL_ROW_129_2232 VGND VPWR sky130_fd_sc_hd__tapvpwrvgnd_1
XTAP_TAPCELL_ROW_51_1062 VGND VPWR sky130_fd_sc_hd__tapvpwrvgnd_1
XTAP_TAPCELL_ROW_5_375 VGND VPWR sky130_fd_sc_hd__tapvpwrvgnd_1
XFILLER_0_99_279 VGND VGND VPWR VPWR sky130_fd_sc_hd__fill_1
XFILLER_0_68_666 VGND VGND VPWR VPWR sky130_fd_sc_hd__fill_1
XFILLER_0_23_39 VPWR VGND VPWR VGND sky130_ef_sc_hd__decap_12
XTAP_TAPCELL_ROW_44_959 VGND VPWR sky130_fd_sc_hd__tapvpwrvgnd_1
XTAP_TAPCELL_ROW_24_661 VGND VPWR sky130_fd_sc_hd__tapvpwrvgnd_1
XFILLER_0_126_749 VGND VGND VPWR VPWR sky130_fd_sc_hd__decap_6
XFILLER_0_125_237 VPWR VGND VPWR VGND sky130_ef_sc_hd__decap_12
XFILLER_0_83_669 VGND VGND VPWR VPWR sky130_fd_sc_hd__decap_3
XFILLER_0_130_29 VPWR VGND VPWR VGND sky130_ef_sc_hd__decap_12
XFILLER_0_24_725 VPWR VGND VPWR VGND sky130_ef_sc_hd__decap_12
XFILLER_0_134_793 VPWR VGND VPWR VGND sky130_ef_sc_hd__decap_12
Xrebuffer6 net27 VGND VGND VPWR VPWR net19 sky130_fd_sc_hd__dlygate4sd1_1
XFILLER_0_24_769 VPWR VGND VPWR VGND sky130_ef_sc_hd__decap_12
XFILLER_0_133_281 VPWR VGND VPWR VGND sky130_ef_sc_hd__decap_12
XFILLER_0_23_279 VGND VGND VPWR VPWR sky130_fd_sc_hd__fill_1
XFILLER_0_3_27 VPWR VGND VPWR VGND sky130_ef_sc_hd__decap_12
X_3010_ _0966_ _0973_ VGND VGND VPWR VPWR _0975_ sky130_fd_sc_hd__nand2_1
XFILLER_0_78_419 VGND VGND VPWR VPWR sky130_fd_sc_hd__fill_1
XTAP_TAPCELL_ROW_69_1334 VGND VPWR sky130_fd_sc_hd__tapvpwrvgnd_1
XTAP_TAPCELL_ROW_82_1523 VGND VPWR sky130_fd_sc_hd__tapvpwrvgnd_1
X_4961_ _0554_ _0523_ _1328_ VGND VGND VPWR VPWR _2468_ sky130_fd_sc_hd__or3_4
XFILLER_0_58_121 VPWR VGND VPWR VGND sky130_ef_sc_hd__decap_12
XFILLER_0_86_485 VPWR VGND VPWR VGND sky130_ef_sc_hd__decap_12
XFILLER_0_86_474 VGND VGND VPWR VPWR sky130_fd_sc_hd__fill_2
XTAP_TAPCELL_ROW_82_1534 VGND VPWR sky130_fd_sc_hd__tapvpwrvgnd_1
X_3912_ cpu_inst.regfile_inst.registers\[9\]\[29\] cpu_inst.regfile_inst.registers\[8\]\[29\]
+ _1797_ VGND VGND VPWR VPWR _1838_ sky130_fd_sc_hd__mux2_1
X_4892_ _0543_ _1292_ VGND VGND VPWR VPWR _2431_ sky130_fd_sc_hd__or2_2
XFILLER_0_58_165 VPWR VGND VPWR VGND sky130_ef_sc_hd__decap_12
XFILLER_0_47_839 VGND VGND VPWR VPWR sky130_fd_sc_hd__fill_1
XFILLER_0_117_727 VGND VGND VPWR VPWR sky130_fd_sc_hd__fill_1
XFILLER_0_104_41 VPWR VGND VPWR VGND sky130_ef_sc_hd__decap_12
X_3843_ cpu_inst.regfile_inst.registers\[1\]\[27\] _1667_ _1668_ cpu_inst.regfile_inst.registers\[5\]\[27\]
+ _0562_ VGND VGND VPWR VPWR _1771_ sky130_fd_sc_hd__o221a_1
XFILLER_0_73_113 VPWR VGND VPWR VGND sky130_ef_sc_hd__decap_12
XFILLER_0_104_85 VPWR VGND VPWR VGND sky130_ef_sc_hd__decap_12
XFILLER_0_6_413 VGND VGND VPWR VPWR sky130_fd_sc_hd__decap_6
X_3774_ _1487_ _1546_ VGND VGND VPWR VPWR _1704_ sky130_fd_sc_hd__nor2_1
XFILLER_0_6_457 VPWR VGND VPWR VGND sky130_ef_sc_hd__decap_12
XTAP_TAPCELL_ROW_113_2000 VGND VPWR sky130_fd_sc_hd__tapvpwrvgnd_1
X_5513_ clknet_leaf_25_clk _0433_ VGND VGND VPWR VPWR cpu_inst.regfile_inst.registers\[8\]\[17\]
+ sky130_fd_sc_hd__dfxtp_1
X_2725_ cpu_inst.display_inst.digit_select\[1\] VGND VGND VPWR VPWR _0690_ sky130_fd_sc_hd__inv_2
XFILLER_0_112_421 VPWR VGND VPWR VGND sky130_ef_sc_hd__decap_12
Xclkbuf_leaf_8_clk clknet_2_1__leaf_clk VGND VGND VPWR VPWR clknet_leaf_8_clk sky130_fd_sc_hd__clkbuf_8
X_5444_ clknet_leaf_21_clk _0364_ VGND VGND VPWR VPWR cpu_inst.regfile_inst.registers\[0\]\[12\]
+ sky130_fd_sc_hd__dfxtp_1
XFILLER_0_30_728 VPWR VGND VPWR VGND sky130_ef_sc_hd__decap_12
X_2656_ cpu_inst.regfile_inst.registers\[11\]\[1\] cpu_inst.regfile_inst.registers\[10\]\[1\]
+ _0620_ VGND VGND VPWR VPWR _0621_ sky130_fd_sc_hd__mux2_1
XFILLER_0_59_3 VPWR VGND VPWR VGND sky130_ef_sc_hd__decap_12
X_5375_ clknet_leaf_34_clk _0295_ VGND VGND VPWR VPWR cpu_inst.regfile_inst.registers\[10\]\[7\]
+ sky130_fd_sc_hd__dfxtp_1
X_2587_ _0511_ _0518_ _0551_ _0516_ VGND VGND VPWR VPWR _0552_ sky130_fd_sc_hd__or4_4
XTAP_TAPCELL_ROW_93_1696 VGND VPWR sky130_fd_sc_hd__tapvpwrvgnd_1
X_4326_ net16 cpu_inst.regfile_inst.registers\[5\]\[13\] _2105_ VGND VGND VPWR VPWR
+ _2108_ sky130_fd_sc_hd__mux2_1
XFILLER_0_129_93 VPWR VGND VPWR VGND sky130_ef_sc_hd__decap_12
X_4257_ cpu_inst.regfile_inst.registers\[24\]\[13\] VGND VGND VPWR VPWR _2071_ sky130_fd_sc_hd__clkbuf_1
X_3208_ _0680_ _1103_ VGND VGND VPWR VPWR _1173_ sky130_fd_sc_hd__nor2_1
XTAP_TAPCELL_ROW_2_323 VGND VPWR sky130_fd_sc_hd__tapvpwrvgnd_1
X_4188_ cpu_inst.regfile_inst.registers\[4\]\[11\] _2035_ VGND VGND VPWR VPWR _2036_
+ sky130_fd_sc_hd__and2_1
X_3139_ _1103_ VGND VGND VPWR VPWR _1104_ sky130_fd_sc_hd__inv_2
XTAP_TAPCELL_ROW_2_334 VGND VPWR sky130_fd_sc_hd__tapvpwrvgnd_1
XTAP_TAPCELL_ROW_124_2162 VGND VPWR sky130_fd_sc_hd__tapvpwrvgnd_1
XFILLER_0_37_305 VPWR VGND VPWR VGND sky130_ef_sc_hd__decap_12
XFILLER_0_38_839 VGND VGND VPWR VPWR sky130_fd_sc_hd__decap_3
XFILLER_0_37_349 VPWR VGND VPWR VGND sky130_ef_sc_hd__decap_12
XTAP_TAPCELL_ROW_41_918 VGND VPWR sky130_fd_sc_hd__tapvpwrvgnd_1
XFILLER_0_108_749 VGND VGND VPWR VPWR sky130_fd_sc_hd__decap_6
XFILLER_0_9_273 VGND VGND VPWR VPWR sky130_fd_sc_hd__decap_6
XTAP_TAPCELL_ROW_21_620 VGND VPWR sky130_fd_sc_hd__tapvpwrvgnd_1
XFILLER_0_107_237 VPWR VGND VPWR VGND sky130_ef_sc_hd__decap_12
XFILLER_0_45_393 VPWR VGND VPWR VGND sky130_ef_sc_hd__decap_12
XFILLER_0_131_741 VPWR VGND VPWR VGND sky130_ef_sc_hd__decap_12
XFILLER_0_116_793 VPWR VGND VPWR VGND sky130_ef_sc_hd__decap_12
XFILLER_0_115_281 VPWR VGND VPWR VGND sky130_ef_sc_hd__decap_12
XFILLER_0_103_421 VGND VGND VPWR VPWR sky130_fd_sc_hd__fill_1
XFILLER_0_131_785 VPWR VGND VPWR VGND sky130_ef_sc_hd__decap_12
XFILLER_0_130_251 VGND VGND VPWR VPWR sky130_fd_sc_hd__fill_1
XTAP_TAPCELL_ROW_53_1102 VGND VPWR sky130_fd_sc_hd__tapvpwrvgnd_1
XFILLER_0_0_3 VPWR VGND VPWR VGND sky130_ef_sc_hd__decap_12
XPHY_EDGE_ROW_69_Left_208 VGND VGND VPWR VPWR sky130_fd_sc_hd__decap_3
XTAP_TAPCELL_ROW_109_1935 VGND VPWR sky130_fd_sc_hd__tapvpwrvgnd_1
XTAP_TAPCELL_ROW_29_731 VGND VPWR sky130_fd_sc_hd__tapvpwrvgnd_1
XFILLER_0_87_205 VPWR VGND VPWR VGND sky130_ef_sc_hd__decap_12
XTAP_TAPCELL_ROW_29_742 VGND VPWR sky130_fd_sc_hd__tapvpwrvgnd_1
XFILLER_0_34_27 VGND VGND VPWR VPWR sky130_fd_sc_hd__fill_1
XFILLER_0_87_249 VPWR VGND VPWR VGND sky130_ef_sc_hd__decap_12
XFILLER_0_96_794 VPWR VGND VPWR VGND sky130_ef_sc_hd__decap_12
XFILLER_0_95_293 VPWR VGND VPWR VGND sky130_ef_sc_hd__decap_12
XTAP_TAPCELL_ROW_64_1264 VGND VPWR sky130_fd_sc_hd__tapvpwrvgnd_1
XTAP_TAPCELL_ROW_64_1253 VGND VPWR sky130_fd_sc_hd__tapvpwrvgnd_1
XFILLER_0_55_113 VPWR VGND VPWR VGND sky130_ef_sc_hd__decap_12
XFILLER_0_50_15 VPWR VGND VPWR VGND sky130_ef_sc_hd__decap_12
XFILLER_0_126_513 VPWR VGND VPWR VGND sky130_ef_sc_hd__decap_12
XPHY_EDGE_ROW_78_Left_217 VGND VGND VPWR VPWR sky130_fd_sc_hd__decap_3
XFILLER_0_71_617 VPWR VGND VPWR VGND sky130_ef_sc_hd__decap_12
XFILLER_0_126_557 VPWR VGND VPWR VGND sky130_ef_sc_hd__decap_12
XFILLER_0_3_405 VPWR VGND VPWR VGND sky130_ef_sc_hd__decap_12
XFILLER_0_24_533 VPWR VGND VPWR VGND sky130_ef_sc_hd__decap_12
X_3490_ _0864_ _1424_ _1426_ _0876_ VGND VGND VPWR VPWR _1427_ sky130_fd_sc_hd__o22a_1
XFILLER_0_11_205 VPWR VGND VPWR VGND sky130_ef_sc_hd__decap_12
XFILLER_0_3_449 VPWR VGND VPWR VGND sky130_ef_sc_hd__decap_12
XFILLER_0_24_566 VGND VGND VPWR VPWR sky130_fd_sc_hd__decap_8
XFILLER_0_24_577 VGND VGND VPWR VPWR sky130_fd_sc_hd__decap_8
XFILLER_0_59_57 VPWR VGND VPWR VGND sky130_ef_sc_hd__decap_12
XFILLER_0_121_273 VGND VGND VPWR VPWR sky130_fd_sc_hd__decap_6
XFILLER_0_11_249 VPWR VGND VPWR VGND sky130_ef_sc_hd__decap_12
XPHY_EDGE_ROW_87_Left_226 VGND VGND VPWR VPWR sky130_fd_sc_hd__decap_3
X_5160_ clknet_leaf_12_clk _0080_ VGND VGND VPWR VPWR cpu_inst.regfile_inst.registers\[25\]\[16\]
+ sky130_fd_sc_hd__dfxtp_1
X_4111_ _1994_ VGND VGND VPWR VPWR _0071_ sky130_fd_sc_hd__clkbuf_1
X_5091_ clknet_leaf_29_clk _0011_ VGND VGND VPWR VPWR cpu_inst.regfile_inst.registers\[6\]\[11\]
+ sky130_fd_sc_hd__dfxtp_1
X_4042_ cpu_inst.regfile_inst.registers\[2\]\[8\] VGND VGND VPWR VPWR _1957_ sky130_fd_sc_hd__clkbuf_1
XFILLER_0_91_55 VGND VGND VPWR VPWR sky130_fd_sc_hd__fill_1
XFILLER_0_115_51 VGND VGND VPWR VPWR sky130_fd_sc_hd__decap_4
X_4944_ _2459_ VGND VGND VPWR VPWR _0439_ sky130_fd_sc_hd__clkbuf_1
XFILLER_0_87_783 VGND VGND VPWR VPWR sky130_fd_sc_hd__fill_1
XFILLER_0_59_463 VPWR VGND VPWR VGND sky130_ef_sc_hd__decap_12
XFILLER_0_19_305 VPWR VGND VPWR VGND sky130_ef_sc_hd__decap_12
XPHY_EDGE_ROW_96_Left_235 VGND VGND VPWR VPWR sky130_fd_sc_hd__decap_3
XFILLER_0_87_794 VGND VGND VPWR VPWR sky130_fd_sc_hd__decap_8
XFILLER_0_47_647 VGND VGND VPWR VPWR sky130_fd_sc_hd__fill_1
XFILLER_0_129_373 VPWR VGND VPWR VGND sky130_ef_sc_hd__decap_12
X_4875_ _2422_ VGND VGND VPWR VPWR _0407_ sky130_fd_sc_hd__clkbuf_1
XFILLER_0_62_617 VPWR VGND VPWR VGND sky130_ef_sc_hd__decap_12
XFILLER_0_19_349 VPWR VGND VPWR VGND sky130_ef_sc_hd__decap_12
X_3826_ _1700_ _1754_ _1451_ VGND VGND VPWR VPWR _1755_ sky130_fd_sc_hd__mux2_1
XFILLER_0_74_477 VGND VGND VPWR VPWR sky130_fd_sc_hd__decap_6
XFILLER_0_61_105 VGND VGND VPWR VPWR sky130_fd_sc_hd__decap_6
XFILLER_0_7_777 VGND VGND VPWR VPWR sky130_fd_sc_hd__decap_6
XFILLER_0_6_221 VPWR VGND VPWR VGND sky130_ef_sc_hd__decap_12
X_3757_ _1685_ _1687_ _1255_ VGND VGND VPWR VPWR _1688_ sky130_fd_sc_hd__mux2_1
XFILLER_0_61_149 VPWR VGND VPWR VGND sky130_ef_sc_hd__decap_12
XFILLER_0_6_265 VPWR VGND VPWR VGND sky130_ef_sc_hd__decap_12
XFILLER_0_27_393 VPWR VGND VPWR VGND sky130_ef_sc_hd__decap_12
XFILLER_0_113_741 VPWR VGND VPWR VGND sky130_ef_sc_hd__decap_12
XTAP_TAPCELL_ROW_95_1725 VGND VPWR sky130_fd_sc_hd__tapvpwrvgnd_1
XFILLER_0_42_363 VGND VGND VPWR VPWR sky130_fd_sc_hd__fill_1
X_2708_ _0658_ _0672_ VGND VGND VPWR VPWR _0673_ sky130_fd_sc_hd__or2_1
XFILLER_0_112_251 VGND VGND VPWR VPWR sky130_fd_sc_hd__fill_1
X_3688_ _1586_ _1619_ _1295_ VGND VGND VPWR VPWR _1620_ sky130_fd_sc_hd__a21o_1
XFILLER_0_113_785 VPWR VGND VPWR VGND sky130_ef_sc_hd__decap_12
X_5427_ clknet_leaf_42_clk _0347_ net2 VGND VGND VPWR VPWR cpu_inst.decoder_inst.current_pc\[27\]
+ sky130_fd_sc_hd__dfrtp_1
XTAP_TAPCELL_ROW_7_404 VGND VPWR sky130_fd_sc_hd__tapvpwrvgnd_1
X_2639_ cpu_inst.regfile_inst.registers\[7\]\[0\] _0598_ _0599_ _0601_ _0603_ VGND
+ VGND VPWR VPWR _0604_ sky130_fd_sc_hd__a221o_1
XFILLER_0_100_446 VGND VGND VPWR VPWR sky130_fd_sc_hd__fill_2
X_5358_ clknet_leaf_13_clk _0278_ VGND VGND VPWR VPWR cpu_inst.regfile_inst.registers\[11\]\[22\]
+ sky130_fd_sc_hd__dfxtp_1
XFILLER_0_11_783 VGND VGND VPWR VPWR sky130_fd_sc_hd__fill_1
X_4309_ _1325_ cpu_inst.regfile_inst.registers\[5\]\[5\] _2098_ VGND VGND VPWR VPWR
+ _2099_ sky130_fd_sc_hd__mux2_1
X_5289_ clknet_leaf_25_clk _0209_ VGND VGND VPWR VPWR cpu_inst.regfile_inst.registers\[1\]\[17\]
+ sky130_fd_sc_hd__dfxtp_1
XFILLER_0_69_205 VPWR VGND VPWR VGND sky130_ef_sc_hd__decap_12
XFILLER_0_69_249 VPWR VGND VPWR VGND sky130_ef_sc_hd__decap_12
XTAP_TAPCELL_ROW_104_1865 VGND VPWR sky130_fd_sc_hd__tapvpwrvgnd_1
XTAP_TAPCELL_ROW_104_1854 VGND VPWR sky130_fd_sc_hd__tapvpwrvgnd_1
XFILLER_0_77_293 VPWR VGND VPWR VGND sky130_ef_sc_hd__decap_12
XFILLER_0_65_422 VGND VGND VPWR VPWR sky130_fd_sc_hd__fill_2
XFILLER_0_37_113 VPWR VGND VPWR VGND sky130_ef_sc_hd__decap_12
XFILLER_0_136_811 VGND VGND VPWR VPWR sky130_fd_sc_hd__fill_1
XFILLER_0_108_513 VPWR VGND VPWR VGND sky130_ef_sc_hd__decap_12
XFILLER_0_65_455 VGND VGND VPWR VPWR sky130_fd_sc_hd__fill_2
XTAP_TAPCELL_ROW_137_2353 VGND VPWR sky130_fd_sc_hd__tapvpwrvgnd_1
XFILLER_0_123_505 VPWR VGND VPWR VGND sky130_ef_sc_hd__decap_12
XFILLER_0_80_469 VGND VGND VPWR VPWR sky130_fd_sc_hd__fill_2
XFILLER_0_20_29 VPWR VGND VPWR VGND sky130_ef_sc_hd__decap_12
XFILLER_0_61_661 VGND VGND VPWR VPWR sky130_fd_sc_hd__decap_8
XFILLER_0_21_503 VGND VGND VPWR VPWR sky130_fd_sc_hd__fill_1
XFILLER_0_33_385 VGND VGND VPWR VPWR sky130_fd_sc_hd__decap_6
XFILLER_0_103_273 VGND VGND VPWR VPWR sky130_fd_sc_hd__decap_6
XFILLER_0_29_27 VPWR VGND VPWR VGND sky130_ef_sc_hd__decap_12
XFILLER_0_45_15 VPWR VGND VPWR VGND sky130_ef_sc_hd__decap_12
XFILLER_0_88_514 VGND VGND VPWR VPWR sky130_fd_sc_hd__fill_2
XFILLER_0_88_547 VGND VGND VPWR VPWR sky130_fd_sc_hd__decap_4
XFILLER_0_96_580 VGND VGND VPWR VPWR sky130_fd_sc_hd__decap_3
XFILLER_0_84_742 VGND VGND VPWR VPWR sky130_fd_sc_hd__decap_4
X_2990_ _0953_ _0954_ _0870_ VGND VGND VPWR VPWR _0955_ sky130_fd_sc_hd__mux2_1
XFILLER_0_127_833 VGND VGND VPWR VPWR sky130_fd_sc_hd__decap_6
XFILLER_0_61_69 VPWR VGND VPWR VGND sky130_ef_sc_hd__decap_12
XFILLER_0_17_809 VPWR VGND VPWR VGND sky130_ef_sc_hd__decap_12
XFILLER_0_138_181 VPWR VGND VPWR VGND sky130_ef_sc_hd__decap_12
XFILLER_0_126_321 VPWR VGND VPWR VGND sky130_ef_sc_hd__decap_12
X_4660_ _0521_ _2289_ _2291_ VGND VGND VPWR VPWR _0323_ sky130_fd_sc_hd__o21a_1
XFILLER_0_9_15 VPWR VGND VPWR VGND sky130_ef_sc_hd__decap_12
XFILLER_0_43_105 VGND VGND VPWR VPWR sky130_fd_sc_hd__decap_6
XFILLER_0_126_365 VPWR VGND VPWR VGND sky130_ef_sc_hd__decap_12
XFILLER_0_117_3 VPWR VGND VPWR VGND sky130_ef_sc_hd__decap_12
X_3611_ _1502_ _1544_ _1451_ VGND VGND VPWR VPWR _1545_ sky130_fd_sc_hd__mux2_1
XFILLER_0_4_725 VPWR VGND VPWR VGND sky130_ef_sc_hd__decap_12
XFILLER_0_37_691 VGND VGND VPWR VPWR sky130_fd_sc_hd__decap_3
XFILLER_0_43_149 VPWR VGND VPWR VGND sky130_ef_sc_hd__decap_12
X_4591_ cpu_inst.regfile_inst.registers\[10\]\[14\] _2241_ VGND VGND VPWR VPWR _2244_
+ sky130_fd_sc_hd__and2_1
XTAP_TAPCELL_ROW_12_483 VGND VPWR sky130_fd_sc_hd__tapvpwrvgnd_1
XFILLER_0_24_363 VGND VGND VPWR VPWR sky130_fd_sc_hd__fill_1
X_3542_ cpu_inst.regfile_inst.registers\[15\]\[19\] _0729_ _1477_ _0844_ VGND VGND
+ VPWR VPWR _1478_ sky130_fd_sc_hd__a211o_1
XTAP_TAPCELL_ROW_77_1455 VGND VPWR sky130_fd_sc_hd__tapvpwrvgnd_1
XFILLER_0_12_525 VGND VGND VPWR VPWR sky130_fd_sc_hd__decap_6
XFILLER_0_4_769 VPWR VGND VPWR VGND sky130_ef_sc_hd__decap_12
X_3473_ _1372_ _1407_ _1410_ VGND VGND VPWR VPWR _1411_ sky130_fd_sc_hd__nand3b_1
XFILLER_0_12_569 VPWR VGND VPWR VGND sky130_ef_sc_hd__decap_12
XFILLER_0_3_279 VGND VGND VPWR VPWR sky130_fd_sc_hd__fill_1
XFILLER_0_51_193 VPWR VGND VPWR VGND sky130_ef_sc_hd__decap_12
XFILLER_0_110_755 VGND VGND VPWR VPWR sky130_fd_sc_hd__fill_1
X_5212_ clknet_leaf_36_clk _0132_ VGND VGND VPWR VPWR cpu_inst.regfile_inst.registers\[24\]\[4\]
+ sky130_fd_sc_hd__dfxtp_1
XTAP_TAPCELL_ROW_90_1655 VGND VPWR sky130_fd_sc_hd__tapvpwrvgnd_1
XTAP_TAPCELL_ROW_90_1644 VGND VPWR sky130_fd_sc_hd__tapvpwrvgnd_1
XFILLER_0_86_77 VGND VGND VPWR VPWR sky130_fd_sc_hd__decap_6
X_5143_ clknet_leaf_2_clk _0063_ VGND VGND VPWR VPWR cpu_inst.regfile_inst.registers\[2\]\[31\]
+ sky130_fd_sc_hd__dfxtp_1
XFILLER_0_19_93 VPWR VGND VPWR VGND sky130_ef_sc_hd__decap_12
X_5074_ cpu_inst.display_inst.counter\[17\] _2531_ VGND VGND VPWR VPWR _0497_ sky130_fd_sc_hd__xnor2_1
X_4025_ _1385_ _1921_ _1922_ _1927_ VGND VGND VPWR VPWR _1948_ sky130_fd_sc_hd__a31o_1
XFILLER_0_126_83 VGND VGND VPWR VPWR sky130_fd_sc_hd__fill_1
XTAP_TAPCELL_ROW_121_2110 VGND VPWR sky130_fd_sc_hd__tapvpwrvgnd_1
XTAP_TAPCELL_ROW_121_2121 VGND VPWR sky130_fd_sc_hd__tapvpwrvgnd_1
XFILLER_0_35_81 VPWR VGND VPWR VGND sky130_ef_sc_hd__decap_12
XFILLER_0_19_113 VPWR VGND VPWR VGND sky130_ef_sc_hd__decap_12
XFILLER_0_118_811 VGND VGND VPWR VPWR sky130_fd_sc_hd__fill_1
X_4927_ _1260_ cpu_inst.regfile_inst.registers\[8\]\[15\] _2449_ VGND VGND VPWR VPWR
+ _2451_ sky130_fd_sc_hd__mux2_1
XFILLER_0_59_293 VGND VGND VPWR VPWR sky130_fd_sc_hd__decap_8
XFILLER_0_129_181 VPWR VGND VPWR VGND sky130_ef_sc_hd__decap_12
X_4858_ cpu_inst.regfile_inst.registers\[9\]\[15\] VGND VGND VPWR VPWR _2414_ sky130_fd_sc_hd__clkbuf_1
XFILLER_0_7_541 VPWR VGND VPWR VGND sky130_ef_sc_hd__decap_12
XFILLER_0_35_639 VGND VGND VPWR VPWR sky130_fd_sc_hd__fill_1
XFILLER_0_47_499 VGND VGND VPWR VPWR sky130_fd_sc_hd__decap_4
XFILLER_0_105_527 VPWR VGND VPWR VGND sky130_ef_sc_hd__decap_12
XFILLER_0_105_505 VPWR VGND VPWR VGND sky130_ef_sc_hd__decap_12
X_3809_ cpu_inst.regfile_inst.registers\[2\]\[26\] _1667_ _1668_ cpu_inst.regfile_inst.registers\[7\]\[26\]
+ VGND VGND VPWR VPWR _1738_ sky130_fd_sc_hd__o22a_1
XFILLER_0_7_585 VPWR VGND VPWR VGND sky130_ef_sc_hd__decap_12
XTAP_TAPCELL_ROW_31_770 VGND VPWR sky130_fd_sc_hd__tapvpwrvgnd_1
XTAP_TAPCELL_ROW_119_2083 VGND VPWR sky130_fd_sc_hd__tapvpwrvgnd_1
X_4789_ _2379_ VGND VGND VPWR VPWR _0364_ sky130_fd_sc_hd__clkbuf_1
XFILLER_0_62_469 VGND VGND VPWR VPWR sky130_fd_sc_hd__decap_6
XFILLER_0_132_357 VGND VGND VPWR VPWR sky130_fd_sc_hd__decap_6
XFILLER_0_15_385 VGND VGND VPWR VPWR sky130_fd_sc_hd__decap_6
XTAP_TAPCELL_ROW_132_2283 VGND VPWR sky130_fd_sc_hd__tapvpwrvgnd_1
XFILLER_0_30_333 VPWR VGND VPWR VGND sky130_ef_sc_hd__decap_12
XFILLER_0_100_221 VPWR VGND VPWR VGND sky130_ef_sc_hd__decap_12
XFILLER_0_30_377 VPWR VGND VPWR VGND sky130_ef_sc_hd__decap_12
XFILLER_0_101_777 VGND VGND VPWR VPWR sky130_fd_sc_hd__decap_6
XFILLER_0_100_265 VPWR VGND VPWR VGND sky130_ef_sc_hd__decap_12
XTAP_TAPCELL_ROW_39_881 VGND VPWR sky130_fd_sc_hd__tapvpwrvgnd_1
XFILLER_0_58_709 VGND VGND VPWR VPWR sky130_fd_sc_hd__fill_1
XTAP_TAPCELL_ROW_39_892 VGND VPWR sky130_fd_sc_hd__tapvpwrvgnd_1
XTAP_TAPCELL_ROW_48_1023 VGND VPWR sky130_fd_sc_hd__tapvpwrvgnd_1
XFILLER_0_66_731 VGND VGND VPWR VPWR sky130_fd_sc_hd__fill_1
XFILLER_0_109_833 VGND VGND VPWR VPWR sky130_fd_sc_hd__decap_6
XTAP_TAPCELL_ROW_61_1212 VGND VPWR sky130_fd_sc_hd__tapvpwrvgnd_1
XFILLER_0_108_321 VPWR VGND VPWR VGND sky130_ef_sc_hd__decap_12
XFILLER_0_93_561 VGND VGND VPWR VPWR sky130_fd_sc_hd__fill_2
XFILLER_0_25_105 VGND VGND VPWR VPWR sky130_fd_sc_hd__decap_6
XFILLER_0_31_39 VPWR VGND VPWR VGND sky130_ef_sc_hd__decap_12
XFILLER_0_124_825 VPWR VGND VPWR VGND sky130_ef_sc_hd__decap_12
XFILLER_0_108_365 VPWR VGND VPWR VGND sky130_ef_sc_hd__decap_12
XFILLER_0_80_233 VPWR VGND VPWR VGND sky130_ef_sc_hd__decap_12
XFILLER_0_25_149 VPWR VGND VPWR VGND sky130_ef_sc_hd__decap_12
XFILLER_0_123_335 VGND VGND VPWR VPWR sky130_fd_sc_hd__fill_1
XFILLER_0_80_277 VPWR VGND VPWR VGND sky130_ef_sc_hd__decap_12
XFILLER_0_33_193 VPWR VGND VPWR VGND sky130_ef_sc_hd__decap_12
XTAP_TAPCELL_ROW_59_1185 VGND VPWR sky130_fd_sc_hd__tapvpwrvgnd_1
XFILLER_0_0_249 VGND VGND VPWR VPWR sky130_fd_sc_hd__decap_3
XTAP_TAPCELL_ROW_72_1385 VGND VPWR sky130_fd_sc_hd__tapvpwrvgnd_1
XTAP_TAPCELL_ROW_72_1374 VGND VPWR sky130_fd_sc_hd__tapvpwrvgnd_1
XFILLER_0_88_333 VPWR VGND VPWR VGND sky130_ef_sc_hd__decap_12
XFILLER_0_88_377 VPWR VGND VPWR VGND sky130_ef_sc_hd__decap_12
XTAP_TAPCELL_ROW_17_553 VGND VPWR sky130_fd_sc_hd__tapvpwrvgnd_1
X_2973_ _0814_ _0937_ VGND VGND VPWR VPWR _0938_ sky130_fd_sc_hd__xnor2_1
XFILLER_0_9_839 VGND VGND VPWR VPWR sky130_fd_sc_hd__fill_1
XFILLER_0_127_641 VPWR VGND VPWR VGND sky130_ef_sc_hd__decap_12
XFILLER_0_84_572 VPWR VGND VPWR VGND sky130_ef_sc_hd__decap_12
X_4712_ cpu_inst.decoder_inst.current_pc\[16\] _2288_ _2318_ _2330_ VGND VGND VPWR
+ VPWR _0336_ sky130_fd_sc_hd__o22a_1
XFILLER_0_17_617 VPWR VGND VPWR VGND sky130_ef_sc_hd__decap_12
XFILLER_0_127_685 VPWR VGND VPWR VGND sky130_ef_sc_hd__decap_12
XFILLER_0_112_41 VPWR VGND VPWR VGND sky130_ef_sc_hd__decap_12
XFILLER_0_29_499 VGND VGND VPWR VPWR sky130_fd_sc_hd__decap_4
XFILLER_0_126_195 VGND VGND VPWR VPWR sky130_fd_sc_hd__fill_1
XFILLER_0_112_85 VPWR VGND VPWR VGND sky130_ef_sc_hd__decap_12
X_4643_ _1183_ _1204_ _1223_ _2275_ VGND VGND VPWR VPWR _2276_ sky130_fd_sc_hd__or4b_1
XFILLER_0_4_533 VPWR VGND VPWR VGND sky130_ef_sc_hd__decap_12
XFILLER_0_114_357 VGND VGND VPWR VPWR sky130_fd_sc_hd__decap_6
X_4574_ cpu_inst.regfile_inst.registers\[10\]\[6\] _2230_ VGND VGND VPWR VPWR _2235_
+ sky130_fd_sc_hd__and2_1
X_3525_ _1459_ _1460_ _0871_ VGND VGND VPWR VPWR _1461_ sky130_fd_sc_hd__mux2_1
XFILLER_0_12_333 VPWR VGND VPWR VGND sky130_ef_sc_hd__decap_12
XFILLER_0_40_653 VGND VGND VPWR VPWR sky130_fd_sc_hd__fill_1
XPHY_EDGE_ROW_123_Right_123 VGND VGND VPWR VPWR sky130_fd_sc_hd__decap_3
XFILLER_0_12_377 VPWR VGND VPWR VGND sky130_ef_sc_hd__decap_12
X_3456_ _0903_ _1359_ _1369_ _0696_ VGND VGND VPWR VPWR _1394_ sky130_fd_sc_hd__a31o_1
X_3387_ _1223_ cpu_inst.regfile_inst.registers\[6\]\[7\] _1300_ VGND VGND VPWR VPWR
+ _1335_ sky130_fd_sc_hd__mux2_1
XFILLER_0_41_3 VPWR VGND VPWR VGND sky130_ef_sc_hd__decap_12
X_5126_ clknet_leaf_27_clk _0046_ VGND VGND VPWR VPWR cpu_inst.regfile_inst.registers\[2\]\[14\]
+ sky130_fd_sc_hd__dfxtp_1
X_5057_ cpu_inst.display_inst.counter\[11\] _2520_ VGND VGND VPWR VPWR _2521_ sky130_fd_sc_hd__nor2_1
XFILLER_0_137_93 VPWR VGND VPWR VGND sky130_ef_sc_hd__decap_12
X_4008_ _1317_ _1316_ _1176_ VGND VGND VPWR VPWR _1931_ sky130_fd_sc_hd__and3b_1
XFILLER_0_79_388 VGND VGND VPWR VPWR sky130_fd_sc_hd__fill_1
XFILLER_0_67_539 VGND VGND VPWR VPWR sky130_fd_sc_hd__fill_2
XTAP_TAPCELL_ROW_36_840 VGND VPWR sky130_fd_sc_hd__tapvpwrvgnd_1
XFILLER_0_137_405 VPWR VGND VPWR VGND sky130_ef_sc_hd__decap_12
XTAP_TAPCELL_ROW_101_1813 VGND VPWR sky130_fd_sc_hd__tapvpwrvgnd_1
XFILLER_0_1_93 VPWR VGND VPWR VGND sky130_ef_sc_hd__decap_12
XFILLER_0_137_449 VPWR VGND VPWR VGND sky130_ef_sc_hd__decap_12
XFILLER_0_106_825 VPWR VGND VPWR VGND sky130_ef_sc_hd__decap_12
XFILLER_0_90_542 VGND VGND VPWR VPWR sky130_fd_sc_hd__decap_8
XFILLER_0_90_531 VGND VGND VPWR VPWR sky130_fd_sc_hd__fill_1
XFILLER_0_62_233 VPWR VGND VPWR VGND sky130_ef_sc_hd__decap_12
XTAP_TAPCELL_ROW_134_2312 VGND VPWR sky130_fd_sc_hd__tapvpwrvgnd_1
XFILLER_0_105_335 VGND VGND VPWR VPWR sky130_fd_sc_hd__fill_1
XFILLER_0_90_564 VGND VGND VPWR VPWR sky130_fd_sc_hd__decap_8
XFILLER_0_7_393 VPWR VGND VPWR VGND sky130_ef_sc_hd__decap_12
XFILLER_0_23_609 VGND VGND VPWR VPWR sky130_fd_sc_hd__decap_6
XFILLER_0_132_121 VPWR VGND VPWR VGND sky130_ef_sc_hd__decap_12
XFILLER_0_62_277 VPWR VGND VPWR VGND sky130_ef_sc_hd__decap_12
XFILLER_0_132_165 VPWR VGND VPWR VGND sky130_ef_sc_hd__decap_12
XFILLER_0_15_193 VPWR VGND VPWR VGND sky130_ef_sc_hd__decap_12
XFILLER_0_30_141 VPWR VGND VPWR VGND sky130_ef_sc_hd__decap_12
XTAP_TAPCELL_ROW_112_1986 VGND VPWR sky130_fd_sc_hd__tapvpwrvgnd_1
XTAP_TAPCELL_ROW_112_1975 VGND VPWR sky130_fd_sc_hd__tapvpwrvgnd_1
XFILLER_0_58_506 VGND VGND VPWR VPWR sky130_fd_sc_hd__fill_1
XFILLER_0_58_539 VGND VGND VPWR VPWR sky130_fd_sc_hd__fill_1
XTAP_TAPCELL_ROW_14_512 VGND VPWR sky130_fd_sc_hd__tapvpwrvgnd_1
XFILLER_0_42_27 VGND VGND VPWR VPWR sky130_fd_sc_hd__fill_1
XFILLER_0_109_641 VPWR VGND VPWR VGND sky130_ef_sc_hd__decap_12
XFILLER_0_39_797 VGND VGND VPWR VPWR sky130_fd_sc_hd__decap_8
XFILLER_0_93_391 VGND VGND VPWR VPWR sky130_fd_sc_hd__fill_1
XFILLER_0_81_542 VPWR VGND VPWR VGND sky130_ef_sc_hd__decap_12
XFILLER_0_81_520 VGND VGND VPWR VPWR sky130_fd_sc_hd__decap_3
XFILLER_0_109_685 VPWR VGND VPWR VGND sky130_ef_sc_hd__decap_12
XFILLER_0_26_469 VGND VGND VPWR VPWR sky130_fd_sc_hd__decap_6
XFILLER_0_108_195 VGND VGND VPWR VPWR sky130_fd_sc_hd__fill_1
XFILLER_0_124_699 VGND VGND VPWR VPWR sky130_fd_sc_hd__fill_1
XFILLER_0_111_305 VPWR VGND VPWR VGND sky130_ef_sc_hd__decap_12
XTAP_TAPCELL_ROW_74_1403 VGND VPWR sky130_fd_sc_hd__tapvpwrvgnd_1
XFILLER_0_1_503 VGND VGND VPWR VPWR sky130_fd_sc_hd__fill_1
XFILLER_0_111_349 VPWR VGND VPWR VGND sky130_ef_sc_hd__decap_12
XTAP_TAPCELL_ROW_74_1414 VGND VPWR sky130_fd_sc_hd__tapvpwrvgnd_1
X_3310_ _1102_ _1264_ VGND VGND VPWR VPWR _1273_ sky130_fd_sc_hd__nor2_1
XFILLER_0_10_837 VGND VGND VPWR VPWR sky130_fd_sc_hd__decap_4
XFILLER_0_6_27 VGND VGND VPWR VPWR sky130_fd_sc_hd__fill_1
X_4290_ _2087_ VGND VGND VPWR VPWR _0157_ sky130_fd_sc_hd__clkbuf_1
XFILLER_0_67_57 VPWR VGND VPWR VGND sky130_ef_sc_hd__decap_12
X_3241_ _1004_ _1015_ _1159_ VGND VGND VPWR VPWR _1206_ sky130_fd_sc_hd__and3_1
X_3172_ _1049_ _1135_ _1111_ VGND VGND VPWR VPWR _1137_ sky130_fd_sc_hd__nand3_1
XPHY_EDGE_ROW_60_Left_199 VGND VGND VPWR VPWR sky130_fd_sc_hd__decap_3
XFILLER_0_89_631 VGND VGND VPWR VPWR sky130_fd_sc_hd__decap_3
Xrebuffer16 net30 VGND VGND VPWR VPWR net29 sky130_fd_sc_hd__dlygate4sd1_1
Xrebuffer27 _0536_ VGND VGND VPWR VPWR net40 sky130_fd_sc_hd__clkbuf_1
XFILLER_0_88_141 VPWR VGND VPWR VGND sky130_ef_sc_hd__decap_12
XTAP_TAPCELL_ROW_85_1576 VGND VPWR sky130_fd_sc_hd__tapvpwrvgnd_1
XFILLER_0_16_83 VGND VGND VPWR VPWR sky130_fd_sc_hd__fill_1
XFILLER_0_119_405 VPWR VGND VPWR VGND sky130_ef_sc_hd__decap_12
XFILLER_0_123_51 VGND VGND VPWR VPWR sky130_fd_sc_hd__decap_4
XFILLER_0_119_449 VPWR VGND VPWR VGND sky130_ef_sc_hd__decap_12
XFILLER_0_91_317 VPWR VGND VPWR VGND sky130_ef_sc_hd__decap_12
XFILLER_0_134_419 VGND VGND VPWR VPWR sky130_fd_sc_hd__fill_1
X_2956_ _0669_ VGND VGND VPWR VPWR _0921_ sky130_fd_sc_hd__buf_4
XFILLER_0_17_447 VGND VGND VPWR VPWR sky130_fd_sc_hd__fill_1
X_2887_ cpu_inst.regfile_inst.registers\[1\]\[12\] _0820_ _0821_ cpu_inst.regfile_inst.registers\[5\]\[12\]
+ VGND VGND VPWR VPWR _0852_ sky130_fd_sc_hd__o22a_1
XFILLER_0_44_233 VPWR VGND VPWR VGND sky130_ef_sc_hd__decap_12
XFILLER_0_45_789 VGND VGND VPWR VPWR sky130_fd_sc_hd__fill_2
XTAP_TAPCELL_ROW_116_2042 VGND VPWR sky130_fd_sc_hd__tapvpwrvgnd_1
XFILLER_0_114_121 VPWR VGND VPWR VGND sky130_ef_sc_hd__decap_12
XFILLER_0_89_3 VPWR VGND VPWR VGND sky130_ef_sc_hd__decap_12
X_4626_ cpu_inst.regfile_inst.registers\[10\]\[31\] _2252_ VGND VGND VPWR VPWR _2262_
+ sky130_fd_sc_hd__and2_1
XFILLER_0_44_277 VPWR VGND VPWR VGND sky130_ef_sc_hd__decap_12
XFILLER_0_130_625 VPWR VGND VPWR VGND sky130_ef_sc_hd__decap_12
XFILLER_0_114_165 VPWR VGND VPWR VGND sky130_ef_sc_hd__decap_12
XFILLER_0_103_839 VGND VGND VPWR VPWR sky130_fd_sc_hd__fill_1
XFILLER_0_4_363 VGND VGND VPWR VPWR sky130_fd_sc_hd__fill_1
XFILLER_0_13_653 VPWR VGND VPWR VGND sky130_ef_sc_hd__decap_12
XFILLER_0_130_669 VPWR VGND VPWR VGND sky130_ef_sc_hd__decap_12
X_4557_ _2226_ VGND VGND VPWR VPWR _0285_ sky130_fd_sc_hd__clkbuf_1
XFILLER_0_12_141 VPWR VGND VPWR VGND sky130_ef_sc_hd__decap_12
X_4488_ _1792_ cpu_inst.regfile_inst.registers\[7\]\[27\] _2186_ VGND VGND VPWR VPWR
+ _2192_ sky130_fd_sc_hd__mux2_1
X_3508_ _1443_ _1444_ VGND VGND VPWR VPWR _1445_ sky130_fd_sc_hd__nand2_1
XFILLER_0_13_697 VPWR VGND VPWR VGND sky130_ef_sc_hd__decap_12
X_3439_ _1253_ _1356_ _1060_ VGND VGND VPWR VPWR _1378_ sky130_fd_sc_hd__mux2_1
X_5109_ clknet_leaf_6_clk _0029_ VGND VGND VPWR VPWR cpu_inst.regfile_inst.registers\[6\]\[29\]
+ sky130_fd_sc_hd__dfxtp_1
XFILLER_0_99_439 VGND VGND VPWR VPWR sky130_fd_sc_hd__fill_1
XFILLER_0_138_725 VGND VGND VPWR VPWR sky130_fd_sc_hd__decap_3
XFILLER_0_94_133 VGND VGND VPWR VPWR sky130_fd_sc_hd__decap_6
XTAP_TAPCELL_ROW_0_284 VGND VPWR sky130_fd_sc_hd__tapvpwrvgnd_1
XTAP_TAPCELL_ROW_0_295 VGND VPWR sky130_fd_sc_hd__tapvpwrvgnd_1
XFILLER_0_138_769 VPWR VGND VPWR VGND sky130_ef_sc_hd__decap_12
XFILLER_0_94_177 VPWR VGND VPWR VGND sky130_ef_sc_hd__decap_12
XFILLER_0_137_279 VGND VGND VPWR VPWR sky130_fd_sc_hd__fill_1
XFILLER_0_36_745 VGND VGND VPWR VPWR sky130_fd_sc_hd__decap_8
XFILLER_0_106_611 VGND VGND VPWR VPWR sky130_fd_sc_hd__decap_8
XFILLER_0_63_575 VGND VGND VPWR VPWR sky130_fd_sc_hd__decap_4
XFILLER_0_133_441 VGND VGND VPWR VPWR sky130_fd_sc_hd__decap_6
XFILLER_0_23_417 VPWR VGND VPWR VGND sky130_ef_sc_hd__decap_12
XFILLER_0_133_485 VPWR VGND VPWR VGND sky130_ef_sc_hd__decap_12
Xoutput6 net6 VGND VGND VPWR VPWR an[3] sky130_fd_sc_hd__buf_1
XFILLER_0_31_461 VPWR VGND VPWR VGND sky130_ef_sc_hd__decap_12
XTAP_TAPCELL_ROW_56_1144 VGND VPWR sky130_fd_sc_hd__tapvpwrvgnd_1
XTAP_TAPCELL_ROW_56_1133 VGND VPWR sky130_fd_sc_hd__tapvpwrvgnd_1
XFILLER_0_128_29 VPWR VGND VPWR VGND sky130_ef_sc_hd__decap_12
XFILLER_0_101_393 VPWR VGND VPWR VGND sky130_ef_sc_hd__decap_12
XFILLER_0_37_27 VPWR VGND VPWR VGND sky130_ef_sc_hd__decap_12
XFILLER_0_53_15 VPWR VGND VPWR VGND sky130_ef_sc_hd__decap_12
XFILLER_0_98_494 VGND VGND VPWR VPWR sky130_fd_sc_hd__fill_1
XFILLER_0_98_461 VGND VGND VPWR VPWR sky130_fd_sc_hd__fill_1
XFILLER_0_85_111 VGND VGND VPWR VPWR sky130_fd_sc_hd__fill_1
XFILLER_0_116_419 VGND VGND VPWR VPWR sky130_fd_sc_hd__fill_1
X_3790_ _1708_ _1719_ VGND VGND VPWR VPWR _1720_ sky130_fd_sc_hd__xor2_2
X_2810_ cpu_inst.regfile_inst.registers\[0\]\[4\] _0592_ _0603_ cpu_inst.regfile_inst.registers\[4\]\[4\]
+ _0705_ VGND VGND VPWR VPWR _0775_ sky130_fd_sc_hd__o221a_1
XTAP_TAPCELL_ROW_80_1495 VGND VPWR sky130_fd_sc_hd__tapvpwrvgnd_1
XFILLER_0_5_105 VGND VGND VPWR VPWR sky130_fd_sc_hd__decap_6
XFILLER_0_26_233 VPWR VGND VPWR VGND sky130_ef_sc_hd__decap_12
X_2741_ cpu_inst.regfile_inst.registers\[0\]\[10\] _0627_ _0702_ cpu_inst.regfile_inst.registers\[4\]\[10\]
+ _0705_ VGND VGND VPWR VPWR _0706_ sky130_fd_sc_hd__o221a_1
X_5460_ clknet_leaf_7_clk _0380_ VGND VGND VPWR VPWR cpu_inst.regfile_inst.registers\[0\]\[28\]
+ sky130_fd_sc_hd__dfxtp_1
XFILLER_0_81_361 VPWR VGND VPWR VGND sky130_ef_sc_hd__decap_12
XFILLER_0_5_149 VPWR VGND VPWR VGND sky130_ef_sc_hd__decap_12
XFILLER_0_26_277 VPWR VGND VPWR VGND sky130_ef_sc_hd__decap_12
XFILLER_0_42_726 VPWR VGND VPWR VGND sky130_ef_sc_hd__decap_12
XFILLER_0_112_625 VPWR VGND VPWR VGND sky130_ef_sc_hd__decap_12
X_4411_ cpu_inst.regfile_inst.registers\[1\]\[23\] VGND VGND VPWR VPWR _2151_ sky130_fd_sc_hd__clkbuf_1
X_2672_ _0636_ VGND VGND VPWR VPWR _0637_ sky130_fd_sc_hd__buf_6
XFILLER_0_41_225 VPWR VGND VPWR VGND sky130_ef_sc_hd__decap_12
XFILLER_0_111_113 VPWR VGND VPWR VGND sky130_ef_sc_hd__decap_12
X_5391_ clknet_leaf_14_clk _0311_ VGND VGND VPWR VPWR cpu_inst.regfile_inst.registers\[10\]\[23\]
+ sky130_fd_sc_hd__dfxtp_1
XFILLER_0_10_601 VPWR VGND VPWR VGND sky130_ef_sc_hd__decap_12
XFILLER_0_112_669 VPWR VGND VPWR VGND sky130_ef_sc_hd__decap_12
X_4342_ _1574_ cpu_inst.regfile_inst.registers\[5\]\[21\] _2105_ VGND VGND VPWR VPWR
+ _2116_ sky130_fd_sc_hd__mux2_1
XFILLER_0_10_645 VPWR VGND VPWR VGND sky130_ef_sc_hd__decap_12
X_4273_ cpu_inst.regfile_inst.registers\[24\]\[21\] VGND VGND VPWR VPWR _2079_ sky130_fd_sc_hd__clkbuf_1
X_3224_ _1144_ _1188_ VGND VGND VPWR VPWR _1189_ sky130_fd_sc_hd__nor2_1
.ends
