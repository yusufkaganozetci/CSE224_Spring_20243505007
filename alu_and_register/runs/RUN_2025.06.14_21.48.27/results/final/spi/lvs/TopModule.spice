* NGSPICE file created from TopModule.ext - technology: sky130A

* Black-box entry subcircuit for sky130_fd_sc_hd__tapvpwrvgnd_1 abstract view
.subckt sky130_fd_sc_hd__tapvpwrvgnd_1 VGND VPWR
.ends

* Black-box entry subcircuit for sky130_fd_sc_hd__clkbuf_1 abstract view
.subckt sky130_fd_sc_hd__clkbuf_1 A VGND VNB VPB VPWR X
.ends

* Black-box entry subcircuit for sky130_fd_sc_hd__clkbuf_2 abstract view
.subckt sky130_fd_sc_hd__clkbuf_2 A VGND VNB VPB VPWR X
.ends

* Black-box entry subcircuit for sky130_fd_sc_hd__mux2_1 abstract view
.subckt sky130_fd_sc_hd__mux2_1 A0 A1 S VGND VNB VPB VPWR X
.ends

* Black-box entry subcircuit for sky130_ef_sc_hd__decap_12 abstract view
.subckt sky130_ef_sc_hd__decap_12 VPWR VGND VPB VNB
.ends

* Black-box entry subcircuit for sky130_fd_sc_hd__fill_1 abstract view
.subckt sky130_fd_sc_hd__fill_1 VGND VNB VPB VPWR
.ends

* Black-box entry subcircuit for sky130_fd_sc_hd__dfxtp_1 abstract view
.subckt sky130_fd_sc_hd__dfxtp_1 CLK D VGND VNB VPB VPWR Q
.ends

* Black-box entry subcircuit for sky130_fd_sc_hd__decap_3 abstract view
.subckt sky130_fd_sc_hd__decap_3 VGND VNB VPB VPWR
.ends

* Black-box entry subcircuit for sky130_fd_sc_hd__o21a_1 abstract view
.subckt sky130_fd_sc_hd__o21a_1 A1 A2 B1 VGND VNB VPB VPWR X
.ends

* Black-box entry subcircuit for sky130_fd_sc_hd__nor2_1 abstract view
.subckt sky130_fd_sc_hd__nor2_1 A B VGND VNB VPB VPWR Y
.ends

* Black-box entry subcircuit for sky130_fd_sc_hd__o211a_1 abstract view
.subckt sky130_fd_sc_hd__o211a_1 A1 A2 B1 C1 VGND VNB VPB VPWR X
.ends

* Black-box entry subcircuit for sky130_fd_sc_hd__decap_8 abstract view
.subckt sky130_fd_sc_hd__decap_8 VGND VNB VPB VPWR
.ends

* Black-box entry subcircuit for sky130_fd_sc_hd__or3_2 abstract view
.subckt sky130_fd_sc_hd__or3_2 A B C VGND VNB VPB VPWR X
.ends

* Black-box entry subcircuit for sky130_fd_sc_hd__decap_6 abstract view
.subckt sky130_fd_sc_hd__decap_6 VGND VNB VPB VPWR
.ends

* Black-box entry subcircuit for sky130_fd_sc_hd__fill_2 abstract view
.subckt sky130_fd_sc_hd__fill_2 VGND VNB VPB VPWR
.ends

* Black-box entry subcircuit for sky130_fd_sc_hd__clkbuf_8 abstract view
.subckt sky130_fd_sc_hd__clkbuf_8 A VGND VNB VPB VPWR X
.ends

* Black-box entry subcircuit for sky130_fd_sc_hd__decap_4 abstract view
.subckt sky130_fd_sc_hd__decap_4 VGND VNB VPB VPWR
.ends

* Black-box entry subcircuit for sky130_fd_sc_hd__mux4_1 abstract view
.subckt sky130_fd_sc_hd__mux4_1 A0 A1 A2 A3 S0 S1 VGND VNB VPB VPWR X
.ends

* Black-box entry subcircuit for sky130_fd_sc_hd__buf_4 abstract view
.subckt sky130_fd_sc_hd__buf_4 A VGND VNB VPB VPWR X
.ends

* Black-box entry subcircuit for sky130_fd_sc_hd__buf_2 abstract view
.subckt sky130_fd_sc_hd__buf_2 A VGND VNB VPB VPWR X
.ends

* Black-box entry subcircuit for sky130_fd_sc_hd__nand2_4 abstract view
.subckt sky130_fd_sc_hd__nand2_4 A B VGND VNB VPB VPWR Y
.ends

* Black-box entry subcircuit for sky130_fd_sc_hd__clkinv_4 abstract view
.subckt sky130_fd_sc_hd__clkinv_4 A VGND VNB VPB VPWR Y
.ends

* Black-box entry subcircuit for sky130_fd_sc_hd__inv_2 abstract view
.subckt sky130_fd_sc_hd__inv_2 A VGND VNB VPB VPWR Y
.ends

* Black-box entry subcircuit for sky130_fd_sc_hd__a21o_1 abstract view
.subckt sky130_fd_sc_hd__a21o_1 A1 A2 B1 VGND VNB VPB VPWR X
.ends

* Black-box entry subcircuit for sky130_fd_sc_hd__nand2_1 abstract view
.subckt sky130_fd_sc_hd__nand2_1 A B VGND VNB VPB VPWR Y
.ends

* Black-box entry subcircuit for sky130_fd_sc_hd__a2bb2o_1 abstract view
.subckt sky130_fd_sc_hd__a2bb2o_1 A1_N A2_N B1 B2 VGND VNB VPB VPWR X
.ends

* Black-box entry subcircuit for sky130_fd_sc_hd__xnor2_1 abstract view
.subckt sky130_fd_sc_hd__xnor2_1 A B VGND VNB VPB VPWR Y
.ends

* Black-box entry subcircuit for sky130_fd_sc_hd__bufinv_16 abstract view
.subckt sky130_fd_sc_hd__bufinv_16 A VGND VNB VPB VPWR Y
.ends

* Black-box entry subcircuit for sky130_fd_sc_hd__and2_1 abstract view
.subckt sky130_fd_sc_hd__and2_1 A B VGND VNB VPB VPWR X
.ends

* Black-box entry subcircuit for sky130_fd_sc_hd__a21oi_1 abstract view
.subckt sky130_fd_sc_hd__a21oi_1 A1 A2 B1 VGND VNB VPB VPWR Y
.ends

* Black-box entry subcircuit for sky130_fd_sc_hd__xnor2_2 abstract view
.subckt sky130_fd_sc_hd__xnor2_2 A B VGND VNB VPB VPWR Y
.ends

* Black-box entry subcircuit for sky130_fd_sc_hd__o41a_1 abstract view
.subckt sky130_fd_sc_hd__o41a_1 A1 A2 A3 A4 B1 VGND VNB VPB VPWR X
.ends

* Black-box entry subcircuit for sky130_fd_sc_hd__diode_2 abstract view
.subckt sky130_fd_sc_hd__diode_2 DIODE VGND VNB VPB VPWR
.ends

* Black-box entry subcircuit for sky130_fd_sc_hd__a211o_1 abstract view
.subckt sky130_fd_sc_hd__a211o_1 A1 A2 B1 C1 VGND VNB VPB VPWR X
.ends

* Black-box entry subcircuit for sky130_fd_sc_hd__nor2_2 abstract view
.subckt sky130_fd_sc_hd__nor2_2 A B VGND VNB VPB VPWR Y
.ends

* Black-box entry subcircuit for sky130_fd_sc_hd__o21ai_1 abstract view
.subckt sky130_fd_sc_hd__o21ai_1 A1 A2 B1 VGND VNB VPB VPWR Y
.ends

* Black-box entry subcircuit for sky130_fd_sc_hd__o21ba_1 abstract view
.subckt sky130_fd_sc_hd__o21ba_1 A1 A2 B1_N VGND VNB VPB VPWR X
.ends

* Black-box entry subcircuit for sky130_fd_sc_hd__buf_1 abstract view
.subckt sky130_fd_sc_hd__buf_1 A VGND VNB VPB VPWR X
.ends

* Black-box entry subcircuit for sky130_fd_sc_hd__a21oi_2 abstract view
.subckt sky130_fd_sc_hd__a21oi_2 A1 A2 B1 VGND VNB VPB VPWR Y
.ends

* Black-box entry subcircuit for sky130_fd_sc_hd__or2_1 abstract view
.subckt sky130_fd_sc_hd__or2_1 A B VGND VNB VPB VPWR X
.ends

* Black-box entry subcircuit for sky130_fd_sc_hd__or2_4 abstract view
.subckt sky130_fd_sc_hd__or2_4 A B VGND VNB VPB VPWR X
.ends

* Black-box entry subcircuit for sky130_fd_sc_hd__clkbuf_4 abstract view
.subckt sky130_fd_sc_hd__clkbuf_4 A VGND VNB VPB VPWR X
.ends

* Black-box entry subcircuit for sky130_fd_sc_hd__o21ai_4 abstract view
.subckt sky130_fd_sc_hd__o21ai_4 A1 A2 B1 VGND VNB VPB VPWR Y
.ends

* Black-box entry subcircuit for sky130_fd_sc_hd__inv_6 abstract view
.subckt sky130_fd_sc_hd__inv_6 A VGND VNB VPB VPWR Y
.ends

* Black-box entry subcircuit for sky130_fd_sc_hd__a22o_1 abstract view
.subckt sky130_fd_sc_hd__a22o_1 A1 A2 B1 B2 VGND VNB VPB VPWR X
.ends

* Black-box entry subcircuit for sky130_fd_sc_hd__or3b_1 abstract view
.subckt sky130_fd_sc_hd__or3b_1 A B C_N VGND VNB VPB VPWR X
.ends

* Black-box entry subcircuit for sky130_fd_sc_hd__a2bb2o_2 abstract view
.subckt sky130_fd_sc_hd__a2bb2o_2 A1_N A2_N B1 B2 VGND VNB VPB VPWR X
.ends

* Black-box entry subcircuit for sky130_fd_sc_hd__or4_1 abstract view
.subckt sky130_fd_sc_hd__or4_1 A B C D VGND VNB VPB VPWR X
.ends

* Black-box entry subcircuit for sky130_fd_sc_hd__or4bb_1 abstract view
.subckt sky130_fd_sc_hd__or4bb_1 A B C_N D_N VGND VNB VPB VPWR X
.ends

* Black-box entry subcircuit for sky130_fd_sc_hd__nor2_4 abstract view
.subckt sky130_fd_sc_hd__nor2_4 A B VGND VNB VPB VPWR Y
.ends

* Black-box entry subcircuit for sky130_fd_sc_hd__a221o_1 abstract view
.subckt sky130_fd_sc_hd__a221o_1 A1 A2 B1 B2 C1 VGND VNB VPB VPWR X
.ends

* Black-box entry subcircuit for sky130_fd_sc_hd__a31o_1 abstract view
.subckt sky130_fd_sc_hd__a31o_1 A1 A2 A3 B1 VGND VNB VPB VPWR X
.ends

* Black-box entry subcircuit for sky130_fd_sc_hd__a21o_2 abstract view
.subckt sky130_fd_sc_hd__a21o_2 A1 A2 B1 VGND VNB VPB VPWR X
.ends

* Black-box entry subcircuit for sky130_fd_sc_hd__o22a_1 abstract view
.subckt sky130_fd_sc_hd__o22a_1 A1 A2 B1 B2 VGND VNB VPB VPWR X
.ends

* Black-box entry subcircuit for sky130_fd_sc_hd__o221ai_1 abstract view
.subckt sky130_fd_sc_hd__o221ai_1 A1 A2 B1 B2 C1 VGND VNB VPB VPWR Y
.ends

* Black-box entry subcircuit for sky130_fd_sc_hd__and3_4 abstract view
.subckt sky130_fd_sc_hd__and3_4 A B C VGND VNB VPB VPWR X
.ends

* Black-box entry subcircuit for sky130_fd_sc_hd__o221a_1 abstract view
.subckt sky130_fd_sc_hd__o221a_1 A1 A2 B1 B2 C1 VGND VNB VPB VPWR X
.ends

* Black-box entry subcircuit for sky130_fd_sc_hd__o2bb2a_1 abstract view
.subckt sky130_fd_sc_hd__o2bb2a_1 A1_N A2_N B1 B2 VGND VNB VPB VPWR X
.ends

* Black-box entry subcircuit for sky130_fd_sc_hd__and3b_1 abstract view
.subckt sky130_fd_sc_hd__and3b_1 A_N B C VGND VNB VPB VPWR X
.ends

* Black-box entry subcircuit for sky130_fd_sc_hd__or2_2 abstract view
.subckt sky130_fd_sc_hd__or2_2 A B VGND VNB VPB VPWR X
.ends

* Black-box entry subcircuit for sky130_fd_sc_hd__clkbuf_16 abstract view
.subckt sky130_fd_sc_hd__clkbuf_16 A VGND VNB VPB VPWR X
.ends

* Black-box entry subcircuit for sky130_fd_sc_hd__o221ai_4 abstract view
.subckt sky130_fd_sc_hd__o221ai_4 A1 A2 B1 B2 C1 VGND VNB VPB VPWR Y
.ends

* Black-box entry subcircuit for sky130_fd_sc_hd__buf_8 abstract view
.subckt sky130_fd_sc_hd__buf_8 A VGND VNB VPB VPWR X
.ends

* Black-box entry subcircuit for sky130_fd_sc_hd__clkinvlp_4 abstract view
.subckt sky130_fd_sc_hd__clkinvlp_4 A VGND VNB VPB VPWR Y
.ends

* Black-box entry subcircuit for sky130_fd_sc_hd__mux2_2 abstract view
.subckt sky130_fd_sc_hd__mux2_2 A0 A1 S VGND VNB VPB VPWR X
.ends

* Black-box entry subcircuit for sky130_fd_sc_hd__a21bo_1 abstract view
.subckt sky130_fd_sc_hd__a21bo_1 A1 A2 B1_N VGND VNB VPB VPWR X
.ends

* Black-box entry subcircuit for sky130_fd_sc_hd__or2b_1 abstract view
.subckt sky130_fd_sc_hd__or2b_1 A B_N VGND VNB VPB VPWR X
.ends

* Black-box entry subcircuit for sky130_fd_sc_hd__nand2_2 abstract view
.subckt sky130_fd_sc_hd__nand2_2 A B VGND VNB VPB VPWR Y
.ends

* Black-box entry subcircuit for sky130_fd_sc_hd__a32o_4 abstract view
.subckt sky130_fd_sc_hd__a32o_4 A1 A2 A3 B1 B2 VGND VNB VPB VPWR X
.ends

* Black-box entry subcircuit for sky130_fd_sc_hd__mux4_2 abstract view
.subckt sky130_fd_sc_hd__mux4_2 A0 A1 A2 A3 S0 S1 VGND VNB VPB VPWR X
.ends

* Black-box entry subcircuit for sky130_fd_sc_hd__a32o_1 abstract view
.subckt sky130_fd_sc_hd__a32o_1 A1 A2 A3 B1 B2 VGND VNB VPB VPWR X
.ends

* Black-box entry subcircuit for sky130_fd_sc_hd__clkinv_8 abstract view
.subckt sky130_fd_sc_hd__clkinv_8 A VGND VNB VPB VPWR Y
.ends

* Black-box entry subcircuit for sky130_fd_sc_hd__clkinv_1 abstract view
.subckt sky130_fd_sc_hd__clkinv_1 A VGND VNB VPB VPWR Y
.ends

* Black-box entry subcircuit for sky130_fd_sc_hd__o32a_1 abstract view
.subckt sky130_fd_sc_hd__o32a_1 A1 A2 A3 B1 B2 VGND VNB VPB VPWR X
.ends

* Black-box entry subcircuit for sky130_fd_sc_hd__xor2_2 abstract view
.subckt sky130_fd_sc_hd__xor2_2 A B VGND VNB VPB VPWR X
.ends

* Black-box entry subcircuit for sky130_fd_sc_hd__a2bb2o_4 abstract view
.subckt sky130_fd_sc_hd__a2bb2o_4 A1_N A2_N B1 B2 VGND VNB VPB VPWR X
.ends

* Black-box entry subcircuit for sky130_fd_sc_hd__and3_1 abstract view
.subckt sky130_fd_sc_hd__and3_1 A B C VGND VNB VPB VPWR X
.ends

* Black-box entry subcircuit for sky130_fd_sc_hd__nand3_1 abstract view
.subckt sky130_fd_sc_hd__nand3_1 A B C VGND VNB VPB VPWR Y
.ends

* Black-box entry subcircuit for sky130_fd_sc_hd__o31a_1 abstract view
.subckt sky130_fd_sc_hd__o31a_1 A1 A2 A3 B1 VGND VNB VPB VPWR X
.ends

* Black-box entry subcircuit for sky130_fd_sc_hd__inv_12 abstract view
.subckt sky130_fd_sc_hd__inv_12 A VGND VNB VPB VPWR Y
.ends

* Black-box entry subcircuit for sky130_fd_sc_hd__inv_8 abstract view
.subckt sky130_fd_sc_hd__inv_8 A VGND VNB VPB VPWR Y
.ends

* Black-box entry subcircuit for sky130_fd_sc_hd__o2bb2a_2 abstract view
.subckt sky130_fd_sc_hd__o2bb2a_2 A1_N A2_N B1 B2 VGND VNB VPB VPWR X
.ends

* Black-box entry subcircuit for sky130_fd_sc_hd__o21bai_1 abstract view
.subckt sky130_fd_sc_hd__o21bai_1 A1 A2 B1_N VGND VNB VPB VPWR Y
.ends

* Black-box entry subcircuit for sky130_fd_sc_hd__xor2_1 abstract view
.subckt sky130_fd_sc_hd__xor2_1 A B VGND VNB VPB VPWR X
.ends

* Black-box entry subcircuit for sky130_fd_sc_hd__nor3_1 abstract view
.subckt sky130_fd_sc_hd__nor3_1 A B C VGND VNB VPB VPWR Y
.ends

* Black-box entry subcircuit for sky130_fd_sc_hd__clkinvlp_2 abstract view
.subckt sky130_fd_sc_hd__clkinvlp_2 A VGND VNB VPB VPWR Y
.ends

* Black-box entry subcircuit for sky130_fd_sc_hd__a311o_1 abstract view
.subckt sky130_fd_sc_hd__a311o_1 A1 A2 A3 B1 C1 VGND VNB VPB VPWR X
.ends

* Black-box entry subcircuit for sky130_fd_sc_hd__and2b_1 abstract view
.subckt sky130_fd_sc_hd__and2b_1 A_N B VGND VNB VPB VPWR X
.ends

* Black-box entry subcircuit for sky130_fd_sc_hd__or3b_4 abstract view
.subckt sky130_fd_sc_hd__or3b_4 A B C_N VGND VNB VPB VPWR X
.ends

* Black-box entry subcircuit for sky130_fd_sc_hd__a21boi_1 abstract view
.subckt sky130_fd_sc_hd__a21boi_1 A1 A2 B1_N VGND VNB VPB VPWR Y
.ends

* Black-box entry subcircuit for sky130_fd_sc_hd__o311a_1 abstract view
.subckt sky130_fd_sc_hd__o311a_1 A1 A2 A3 B1 C1 VGND VNB VPB VPWR X
.ends

* Black-box entry subcircuit for sky130_fd_sc_hd__xnor2_4 abstract view
.subckt sky130_fd_sc_hd__xnor2_4 A B VGND VNB VPB VPWR Y
.ends

* Black-box entry subcircuit for sky130_fd_sc_hd__o211ai_1 abstract view
.subckt sky130_fd_sc_hd__o211ai_1 A1 A2 B1 C1 VGND VNB VPB VPWR Y
.ends

* Black-box entry subcircuit for sky130_fd_sc_hd__a41o_1 abstract view
.subckt sky130_fd_sc_hd__a41o_1 A1 A2 A3 A4 B1 VGND VNB VPB VPWR X
.ends

* Black-box entry subcircuit for sky130_fd_sc_hd__or3_1 abstract view
.subckt sky130_fd_sc_hd__or3_1 A B C VGND VNB VPB VPWR X
.ends

* Black-box entry subcircuit for sky130_fd_sc_hd__nand4_2 abstract view
.subckt sky130_fd_sc_hd__nand4_2 A B C D VGND VNB VPB VPWR Y
.ends

* Black-box entry subcircuit for sky130_fd_sc_hd__nand3b_2 abstract view
.subckt sky130_fd_sc_hd__nand3b_2 A_N B C VGND VNB VPB VPWR Y
.ends

* Black-box entry subcircuit for sky130_fd_sc_hd__and3_2 abstract view
.subckt sky130_fd_sc_hd__and3_2 A B C VGND VNB VPB VPWR X
.ends

* Black-box entry subcircuit for sky130_fd_sc_hd__and3b_4 abstract view
.subckt sky130_fd_sc_hd__and3b_4 A_N B C VGND VNB VPB VPWR X
.ends

* Black-box entry subcircuit for sky130_fd_sc_hd__dlymetal6s2s_1 abstract view
.subckt sky130_fd_sc_hd__dlymetal6s2s_1 A VGND VNB VPB VPWR X
.ends

* Black-box entry subcircuit for sky130_fd_sc_hd__or4b_1 abstract view
.subckt sky130_fd_sc_hd__or4b_1 A B C D_N VGND VNB VPB VPWR X
.ends

* Black-box entry subcircuit for sky130_fd_sc_hd__o21a_2 abstract view
.subckt sky130_fd_sc_hd__o21a_2 A1 A2 B1 VGND VNB VPB VPWR X
.ends

* Black-box entry subcircuit for sky130_fd_sc_hd__and4_1 abstract view
.subckt sky130_fd_sc_hd__and4_1 A B C D VGND VNB VPB VPWR X
.ends

* Black-box entry subcircuit for sky130_fd_sc_hd__buf_6 abstract view
.subckt sky130_fd_sc_hd__buf_6 A VGND VNB VPB VPWR X
.ends

* Black-box entry subcircuit for sky130_fd_sc_hd__o21ai_2 abstract view
.subckt sky130_fd_sc_hd__o21ai_2 A1 A2 B1 VGND VNB VPB VPWR Y
.ends

* Black-box entry subcircuit for sky130_fd_sc_hd__o21bai_2 abstract view
.subckt sky130_fd_sc_hd__o21bai_2 A1 A2 B1_N VGND VNB VPB VPWR Y
.ends

* Black-box entry subcircuit for sky130_fd_sc_hd__o22a_2 abstract view
.subckt sky130_fd_sc_hd__o22a_2 A1 A2 B1 B2 VGND VNB VPB VPWR X
.ends

* Black-box entry subcircuit for sky130_fd_sc_hd__a31oi_4 abstract view
.subckt sky130_fd_sc_hd__a31oi_4 A1 A2 A3 B1 VGND VNB VPB VPWR Y
.ends

* Black-box entry subcircuit for sky130_fd_sc_hd__o32a_2 abstract view
.subckt sky130_fd_sc_hd__o32a_2 A1 A2 A3 B1 B2 VGND VNB VPB VPWR X
.ends

* Black-box entry subcircuit for sky130_fd_sc_hd__nor2b_4 abstract view
.subckt sky130_fd_sc_hd__nor2b_4 A B_N VGND VNB VPB VPWR Y
.ends

* Black-box entry subcircuit for sky130_fd_sc_hd__and3b_2 abstract view
.subckt sky130_fd_sc_hd__and3b_2 A_N B C VGND VNB VPB VPWR X
.ends

* Black-box entry subcircuit for sky130_fd_sc_hd__or3_4 abstract view
.subckt sky130_fd_sc_hd__or3_4 A B C VGND VNB VPB VPWR X
.ends

* Black-box entry subcircuit for sky130_fd_sc_hd__o2bb2a_4 abstract view
.subckt sky130_fd_sc_hd__o2bb2a_4 A1_N A2_N B1 B2 VGND VNB VPB VPWR X
.ends

* Black-box entry subcircuit for sky130_fd_sc_hd__a21oi_4 abstract view
.subckt sky130_fd_sc_hd__a21oi_4 A1 A2 B1 VGND VNB VPB VPWR Y
.ends

* Black-box entry subcircuit for sky130_fd_sc_hd__nand3_4 abstract view
.subckt sky130_fd_sc_hd__nand3_4 A B C VGND VNB VPB VPWR Y
.ends

* Black-box entry subcircuit for sky130_fd_sc_hd__a32o_2 abstract view
.subckt sky130_fd_sc_hd__a32o_2 A1 A2 A3 B1 B2 VGND VNB VPB VPWR X
.ends

* Black-box entry subcircuit for sky130_fd_sc_hd__a211oi_1 abstract view
.subckt sky130_fd_sc_hd__a211oi_1 A1 A2 B1 C1 VGND VNB VPB VPWR Y
.ends

* Black-box entry subcircuit for sky130_fd_sc_hd__nor4_1 abstract view
.subckt sky130_fd_sc_hd__nor4_1 A B C D VGND VNB VPB VPWR Y
.ends

* Black-box entry subcircuit for sky130_fd_sc_hd__o211ai_4 abstract view
.subckt sky130_fd_sc_hd__o211ai_4 A1 A2 B1 C1 VGND VNB VPB VPWR Y
.ends

* Black-box entry subcircuit for sky130_fd_sc_hd__inv_4 abstract view
.subckt sky130_fd_sc_hd__inv_4 A VGND VNB VPB VPWR Y
.ends

* Black-box entry subcircuit for sky130_fd_sc_hd__and4_2 abstract view
.subckt sky130_fd_sc_hd__and4_2 A B C D VGND VNB VPB VPWR X
.ends

* Black-box entry subcircuit for sky130_fd_sc_hd__nand3b_4 abstract view
.subckt sky130_fd_sc_hd__nand3b_4 A_N B C VGND VNB VPB VPWR Y
.ends

* Black-box entry subcircuit for sky130_fd_sc_hd__o211ai_2 abstract view
.subckt sky130_fd_sc_hd__o211ai_2 A1 A2 B1 C1 VGND VNB VPB VPWR Y
.ends

* Black-box entry subcircuit for sky130_fd_sc_hd__nand2b_4 abstract view
.subckt sky130_fd_sc_hd__nand2b_4 A_N B VGND VNB VPB VPWR Y
.ends

* Black-box entry subcircuit for sky130_fd_sc_hd__a22oi_4 abstract view
.subckt sky130_fd_sc_hd__a22oi_4 A1 A2 B1 B2 VGND VNB VPB VPWR Y
.ends

* Black-box entry subcircuit for sky130_fd_sc_hd__a21bo_2 abstract view
.subckt sky130_fd_sc_hd__a21bo_2 A1 A2 B1_N VGND VNB VPB VPWR X
.ends

* Black-box entry subcircuit for sky130_fd_sc_hd__nand3b_1 abstract view
.subckt sky130_fd_sc_hd__nand3b_1 A_N B C VGND VNB VPB VPWR Y
.ends

* Black-box entry subcircuit for sky130_fd_sc_hd__a221oi_2 abstract view
.subckt sky130_fd_sc_hd__a221oi_2 A1 A2 B1 B2 C1 VGND VNB VPB VPWR Y
.ends

* Black-box entry subcircuit for sky130_fd_sc_hd__a2111o_1 abstract view
.subckt sky130_fd_sc_hd__a2111o_1 A1 A2 B1 C1 D1 VGND VNB VPB VPWR X
.ends

.subckt TopModule A1[0] A1[1] A1[2] A1[3] A1[4] A2[0] A2[1] A2[2] A2[3] A2[4] A3[0]
+ A3[1] A3[2] A3[3] A3[4] CLK RD1[0] RD1[10] RD1[11] RD1[12] RD1[13] RD1[14] RD1[15]
+ RD1[16] RD1[17] RD1[18] RD1[19] RD1[1] RD1[20] RD1[21] RD1[22] RD1[23] RD1[24] RD1[25]
+ RD1[26] RD1[27] RD1[28] RD1[29] RD1[2] RD1[30] RD1[31] RD1[3] RD1[4] RD1[5] RD1[6]
+ RD1[7] RD1[8] RD1[9] RD2[0] RD2[10] RD2[11] RD2[12] RD2[13] RD2[14] RD2[15] RD2[16]
+ RD2[17] RD2[18] RD2[19] RD2[1] RD2[20] RD2[21] RD2[22] RD2[23] RD2[24] RD2[25] RD2[26]
+ RD2[27] RD2[28] RD2[29] RD2[2] RD2[30] RD2[31] RD2[3] RD2[4] RD2[5] RD2[6] RD2[7]
+ RD2[8] RD2[9] VGND VPWR WD3[0] WD3[10] WD3[11] WD3[12] WD3[13] WD3[14] WD3[15] WD3[16]
+ WD3[17] WD3[18] WD3[19] WD3[1] WD3[20] WD3[21] WD3[22] WD3[23] WD3[24] WD3[25] WD3[26]
+ WD3[27] WD3[28] WD3[29] WD3[2] WD3[30] WD3[31] WD3[3] WD3[4] WD3[5] WD3[6] WD3[7]
+ WD3[8] WD3[9] WE3 alu_opcode[0] alu_opcode[1] alu_result[0] alu_result[10] alu_result[11]
+ alu_result[12] alu_result[13] alu_result[14] alu_result[15] alu_result[16] alu_result[17]
+ alu_result[18] alu_result[19] alu_result[1] alu_result[20] alu_result[21] alu_result[22]
+ alu_result[23] alu_result[24] alu_result[25] alu_result[26] alu_result[27] alu_result[28]
+ alu_result[29] alu_result[2] alu_result[30] alu_result[31] alu_result[3] alu_result[4]
+ alu_result[5] alu_result[6] alu_result[7] alu_result[8] alu_result[9]
XTAP_TAPCELL_ROW_87_1605 VGND VPWR sky130_fd_sc_hd__tapvpwrvgnd_1
X_7963_ _3917_ VGND VGND VPWR VPWR _0386_ sky130_fd_sc_hd__clkbuf_1
X_6914_ net25 VGND VGND VPWR VPWR _3349_ sky130_fd_sc_hd__clkbuf_2
X_7894_ _3349_ rf.registers\[23\]\[1\] _3879_ VGND VGND VPWR VPWR _3881_ sky130_fd_sc_hd__mux2_1
XFILLER_0_77_656 VPWR VGND VPWR VGND sky130_ef_sc_hd__decap_12
XFILLER_0_134_83 VGND VGND VPWR VPWR sky130_fd_sc_hd__fill_1
X_6845_ rf.registers\[16\]\[11\] _3301_ _3299_ VGND VGND VPWR VPWR _3302_ sky130_fd_sc_hd__mux2_1
XFILLER_0_18_701 VGND VGND VPWR VPWR sky130_fd_sc_hd__fill_1
XTAP_TAPCELL_ROW_46_990 VGND VPWR sky130_fd_sc_hd__tapvpwrvgnd_1
X_9564_ clknet_leaf_30_CLK _0652_ VGND VGND VPWR VPWR rf.registers\[13\]\[11\] sky130_fd_sc_hd__dfxtp_1
X_6776_ _3259_ VGND VGND VPWR VPWR _0881_ sky130_fd_sc_hd__clkbuf_1
XFILLER_0_57_391 VGND VGND VPWR VPWR sky130_fd_sc_hd__fill_1
XFILLER_0_18_745 VGND VGND VPWR VPWR sky130_fd_sc_hd__decap_3
XFILLER_0_119_279 VGND VGND VPWR VPWR sky130_fd_sc_hd__fill_1
XFILLER_0_91_169 VGND VGND VPWR VPWR sky130_fd_sc_hd__fill_1
X_9495_ clknet_leaf_56_CLK _0583_ VGND VGND VPWR VPWR rf.registers\[18\]\[6\] sky130_fd_sc_hd__dfxtp_1
X_8515_ _2999_ rf.registers\[13\]\[6\] _4205_ VGND VGND VPWR VPWR _4209_ sky130_fd_sc_hd__mux2_1
X_5727_ _2320_ _2454_ _2263_ VGND VGND VPWR VPWR _2455_ sky130_fd_sc_hd__o21a_1
X_8446_ _2997_ rf.registers\[14\]\[5\] _4167_ VGND VGND VPWR VPWR _4173_ sky130_fd_sc_hd__mux2_1
XFILLER_0_33_737 VPWR VGND VPWR VGND sky130_ef_sc_hd__decap_12
XTAP_TAPCELL_ROW_98_1767 VGND VPWR sky130_fd_sc_hd__tapvpwrvgnd_1
X_5658_ _2269_ _2387_ VGND VGND VPWR VPWR _2388_ sky130_fd_sc_hd__nor2_1
XPHY_EDGE_ROW_107_Left_246 VGND VGND VPWR VPWR sky130_fd_sc_hd__decap_3
X_8377_ _4136_ VGND VGND VPWR VPWR _0581_ sky130_fd_sc_hd__clkbuf_1
X_4609_ _1381_ _1384_ _1386_ _1291_ VGND VGND VPWR VPWR _1387_ sky130_fd_sc_hd__o211a_1
XFILLER_0_60_589 VGND VGND VPWR VPWR sky130_fd_sc_hd__decap_8
XFILLER_0_13_461 VPWR VGND VPWR VGND sky130_ef_sc_hd__decap_12
X_5589_ net107 _2318_ _2319_ VGND VGND VPWR VPWR _2320_ sky130_fd_sc_hd__or3_2
XFILLER_0_103_669 VGND VGND VPWR VPWR sky130_fd_sc_hd__decap_3
XFILLER_0_7_81 VPWR VGND VPWR VGND sky130_ef_sc_hd__decap_12
X_7328_ _3579_ VGND VGND VPWR VPWR _0089_ sky130_fd_sc_hd__clkbuf_1
X_7259_ rf.registers\[19\]\[24\] _3328_ _3538_ VGND VGND VPWR VPWR _3543_ sky130_fd_sc_hd__mux2_1
XTAP_TAPCELL_ROW_129_2233 VGND VPWR sky130_fd_sc_hd__tapvpwrvgnd_1
XTAP_TAPCELL_ROW_51_1063 VGND VPWR sky130_fd_sc_hd__tapvpwrvgnd_1
XTAP_TAPCELL_ROW_5_376 VGND VPWR sky130_fd_sc_hd__tapvpwrvgnd_1
XPHY_EDGE_ROW_116_Left_255 VGND VGND VPWR VPWR sky130_fd_sc_hd__decap_3
XFILLER_0_95_420 VGND VGND VPWR VPWR sky130_fd_sc_hd__decap_8
XFILLER_0_68_645 VPWR VGND VPWR VGND sky130_ef_sc_hd__decap_12
XFILLER_0_23_18 VPWR VGND VPWR VGND sky130_ef_sc_hd__decap_12
XFILLER_0_138_533 VPWR VGND VPWR VGND sky130_ef_sc_hd__decap_12
XFILLER_0_55_306 VPWR VGND VPWR VGND sky130_ef_sc_hd__decap_12
XTAP_TAPCELL_ROW_24_662 VGND VPWR sky130_fd_sc_hd__tapvpwrvgnd_1
XFILLER_0_125_205 VPWR VGND VPWR VGND sky130_ef_sc_hd__decap_12
XFILLER_0_125_249 VPWR VGND VPWR VGND sky130_ef_sc_hd__decap_12
XFILLER_0_3_609 VGND VGND VPWR VPWR sky130_fd_sc_hd__decap_6
XFILLER_0_36_597 VGND VGND VPWR VPWR sky130_fd_sc_hd__fill_1
XPHY_EDGE_ROW_125_Left_264 VGND VGND VPWR VPWR sky130_fd_sc_hd__decap_3
XFILLER_0_106_474 VGND VGND VPWR VPWR sky130_fd_sc_hd__fill_2
XFILLER_0_24_748 VGND VGND VPWR VPWR sky130_fd_sc_hd__fill_1
XFILLER_0_133_293 VPWR VGND VPWR VGND sky130_ef_sc_hd__decap_12
XFILLER_0_32_781 VGND VGND VPWR VPWR sky130_fd_sc_hd__fill_2
XFILLER_0_48_15 VPWR VGND VPWR VGND sky130_ef_sc_hd__decap_12
XPHY_EDGE_ROW_134_Left_273 VGND VGND VPWR VPWR sky130_fd_sc_hd__decap_3
XTAP_TAPCELL_ROW_69_1335 VGND VPWR sky130_fd_sc_hd__tapvpwrvgnd_1
Xclkbuf_leaf_6_CLK clknet_3_1__leaf_CLK VGND VGND VPWR VPWR clknet_leaf_6_CLK sky130_fd_sc_hd__clkbuf_8
XFILLER_0_129_500 VGND VGND VPWR VPWR sky130_fd_sc_hd__decap_4
X_4960_ rf.registers\[8\]\[4\] rf.registers\[9\]\[4\] rf.registers\[10\]\[4\] rf.registers\[11\]\[4\]
+ _1652_ _1653_ VGND VGND VPWR VPWR _1719_ sky130_fd_sc_hd__mux4_1
XTAP_TAPCELL_ROW_82_1524 VGND VPWR sky130_fd_sc_hd__tapvpwrvgnd_1
XFILLER_0_59_645 VPWR VGND VPWR VGND sky130_ef_sc_hd__decap_12
XFILLER_0_58_122 VGND VGND VPWR VPWR sky130_fd_sc_hd__fill_2
X_4891_ _1625_ VGND VGND VPWR VPWR _1653_ sky130_fd_sc_hd__buf_4
XTAP_TAPCELL_ROW_82_1535 VGND VPWR sky130_fd_sc_hd__tapvpwrvgnd_1
XFILLER_0_46_306 VGND VGND VPWR VPWR sky130_fd_sc_hd__fill_2
X_6630_ rf.registers\[24\]\[12\] _3012_ _3179_ VGND VGND VPWR VPWR _3182_ sky130_fd_sc_hd__mux2_1
XFILLER_0_104_53 VPWR VGND VPWR VGND sky130_ef_sc_hd__decap_12
XFILLER_0_80_79 VGND VGND VPWR VPWR sky130_fd_sc_hd__decap_4
XFILLER_0_13_51 VGND VGND VPWR VPWR sky130_fd_sc_hd__decap_4
X_6561_ rf.registers\[1\]\[12\] _3012_ _3142_ VGND VGND VPWR VPWR _3145_ sky130_fd_sc_hd__mux2_1
XFILLER_0_39_391 VGND VGND VPWR VPWR sky130_fd_sc_hd__fill_1
X_8300_ rf.registers\[20\]\[0\] net14 _4095_ VGND VGND VPWR VPWR _4096_ sky130_fd_sc_hd__mux2_1
XFILLER_0_6_469 VGND VGND VPWR VPWR sky130_fd_sc_hd__decap_6
XFILLER_0_27_597 VPWR VGND VPWR VGND sky130_ef_sc_hd__decap_12
X_5512_ _1056_ VGND VGND VPWR VPWR _2243_ sky130_fd_sc_hd__buf_2
XFILLER_0_125_783 VGND VGND VPWR VPWR sky130_fd_sc_hd__fill_1
XFILLER_0_120_41 VPWR VGND VPWR VGND sky130_ef_sc_hd__decap_12
XTAP_TAPCELL_ROW_113_2001 VGND VPWR sky130_fd_sc_hd__tapvpwrvgnd_1
X_6492_ rf.registers\[17\]\[12\] _3012_ _3105_ VGND VGND VPWR VPWR _3108_ sky130_fd_sc_hd__mux2_1
X_9280_ clknet_leaf_22_CLK _0368_ VGND VGND VPWR VPWR rf.registers\[23\]\[15\] sky130_fd_sc_hd__dfxtp_1
XFILLER_0_89_55 VGND VGND VPWR VPWR sky130_fd_sc_hd__fill_1
X_8231_ _4058_ VGND VGND VPWR VPWR _4059_ sky130_fd_sc_hd__buf_4
X_5443_ rf.registers\[12\]\[30\] rf.registers\[13\]\[30\] rf.registers\[14\]\[30\]
+ rf.registers\[15\]\[30\] _1951_ _1952_ VGND VGND VPWR VPWR _2176_ sky130_fd_sc_hd__mux4_1
XFILLER_0_120_85 VPWR VGND VPWR VGND sky130_ef_sc_hd__decap_12
X_8162_ _2966_ _3877_ VGND VGND VPWR VPWR _4022_ sky130_fd_sc_hd__nand2_4
X_5374_ rf.registers\[4\]\[26\] rf.registers\[5\]\[26\] rf.registers\[6\]\[26\] rf.registers\[7\]\[26\]
+ _2109_ _2110_ VGND VGND VPWR VPWR _2111_ sky130_fd_sc_hd__mux4_1
X_4325_ _1052_ VGND VGND VPWR VPWR _1116_ sky130_fd_sc_hd__clkinv_4
XFILLER_0_100_639 VGND VGND VPWR VPWR sky130_fd_sc_hd__decap_4
X_7113_ _3465_ VGND VGND VPWR VPWR _1012_ sky130_fd_sc_hd__clkbuf_1
XTAP_TAPCELL_ROW_93_1697 VGND VPWR sky130_fd_sc_hd__tapvpwrvgnd_1
X_8093_ _3985_ VGND VGND VPWR VPWR _0448_ sky130_fd_sc_hd__clkbuf_1
XFILLER_0_10_475 VGND VGND VPWR VPWR sky130_fd_sc_hd__fill_1
X_4256_ _1049_ _1050_ _1031_ VGND VGND VPWR VPWR _1051_ sky130_fd_sc_hd__mux2_1
X_7044_ rf.registers\[6\]\[19\] _3317_ _3419_ VGND VGND VPWR VPWR _3429_ sky130_fd_sc_hd__mux2_1
XTAP_TAPCELL_ROW_2_335 VGND VPWR sky130_fd_sc_hd__tapvpwrvgnd_1
XTAP_TAPCELL_ROW_2_324 VGND VPWR sky130_fd_sc_hd__tapvpwrvgnd_1
XTAP_TAPCELL_ROW_124_2163 VGND VPWR sky130_fd_sc_hd__tapvpwrvgnd_1
XFILLER_0_97_729 VPWR VGND VPWR VGND sky130_ef_sc_hd__decap_12
X_8995_ clknet_leaf_7_CLK _0083_ VGND VGND VPWR VPWR rf.registers\[3\]\[18\] sky130_fd_sc_hd__dfxtp_1
XFILLER_0_77_420 VGND VGND VPWR VPWR sky130_fd_sc_hd__fill_1
X_7946_ _2970_ rf.registers\[23\]\[26\] _3901_ VGND VGND VPWR VPWR _3908_ sky130_fd_sc_hd__mux2_1
X_7877_ _2970_ rf.registers\[28\]\[26\] _3864_ VGND VGND VPWR VPWR _3871_ sky130_fd_sc_hd__mux2_1
XFILLER_0_135_503 VGND VGND VPWR VPWR sky130_fd_sc_hd__fill_1
X_6828_ net42 VGND VGND VPWR VPWR _3290_ sky130_fd_sc_hd__clkbuf_2
XTAP_TAPCELL_ROW_41_908 VGND VPWR sky130_fd_sc_hd__tapvpwrvgnd_1
XTAP_TAPCELL_ROW_41_919 VGND VPWR sky130_fd_sc_hd__tapvpwrvgnd_1
XFILLER_0_80_618 VGND VGND VPWR VPWR sky130_fd_sc_hd__decap_3
XFILLER_0_52_309 VGND VGND VPWR VPWR sky130_fd_sc_hd__decap_6
XFILLER_0_18_531 VGND VGND VPWR VPWR sky130_fd_sc_hd__fill_1
XTAP_TAPCELL_ROW_21_610 VGND VPWR sky130_fd_sc_hd__tapvpwrvgnd_1
XTAP_TAPCELL_ROW_21_621 VGND VPWR sky130_fd_sc_hd__tapvpwrvgnd_1
XFILLER_0_123_709 VPWR VGND VPWR VGND sky130_ef_sc_hd__decap_12
X_6759_ _3250_ VGND VGND VPWR VPWR _0873_ sky130_fd_sc_hd__clkbuf_1
XFILLER_0_61_821 VPWR VGND VPWR VGND sky130_ef_sc_hd__decap_12
XFILLER_0_18_586 VGND VGND VPWR VPWR sky130_fd_sc_hd__fill_2
X_9547_ clknet_leaf_70_CLK _0635_ VGND VGND VPWR VPWR rf.registers\[14\]\[26\] sky130_fd_sc_hd__dfxtp_1
X_9478_ clknet_leaf_83_CLK _0566_ VGND VGND VPWR VPWR rf.registers\[20\]\[21\] sky130_fd_sc_hd__dfxtp_1
XFILLER_0_21_729 VPWR VGND VPWR VGND sky130_ef_sc_hd__decap_12
X_8429_ _4163_ VGND VGND VPWR VPWR _0606_ sky130_fd_sc_hd__clkbuf_1
XFILLER_0_131_753 VPWR VGND VPWR VGND sky130_ef_sc_hd__decap_12
XFILLER_0_103_455 VGND VGND VPWR VPWR sky130_fd_sc_hd__fill_1
XFILLER_0_14_781 VPWR VGND VPWR VGND sky130_ef_sc_hd__decap_12
XFILLER_0_131_797 VPWR VGND VPWR VGND sky130_ef_sc_hd__decap_12
XFILLER_0_18_29 VPWR VGND VPWR VGND sky130_ef_sc_hd__decap_12
XTAP_TAPCELL_ROW_109_1936 VGND VPWR sky130_fd_sc_hd__tapvpwrvgnd_1
XTAP_TAPCELL_ROW_29_732 VGND VPWR sky130_fd_sc_hd__tapvpwrvgnd_1
XTAP_TAPCELL_ROW_64_1265 VGND VPWR sky130_fd_sc_hd__tapvpwrvgnd_1
XTAP_TAPCELL_ROW_64_1254 VGND VPWR sky130_fd_sc_hd__tapvpwrvgnd_1
XFILLER_0_50_49 VGND VGND VPWR VPWR sky130_fd_sc_hd__fill_1
XFILLER_0_50_27 VGND VGND VPWR VPWR sky130_fd_sc_hd__fill_1
XFILLER_0_119_7 VPWR VGND VPWR VGND sky130_ef_sc_hd__decap_12
XFILLER_0_64_681 VPWR VGND VPWR VGND sky130_ef_sc_hd__decap_12
XFILLER_0_55_169 VGND VGND VPWR VPWR sky130_fd_sc_hd__fill_1
XFILLER_0_107_783 VGND VGND VPWR VPWR sky130_fd_sc_hd__fill_1
XFILLER_0_3_417 VPWR VGND VPWR VGND sky130_ef_sc_hd__decap_12
XFILLER_0_24_545 VGND VGND VPWR VPWR sky130_fd_sc_hd__decap_4
XFILLER_0_12_707 VPWR VGND VPWR VGND sky130_ef_sc_hd__decap_12
XFILLER_0_24_589 VGND VGND VPWR VPWR sky130_fd_sc_hd__fill_2
XFILLER_0_11_217 VGND VGND VPWR VPWR sky130_fd_sc_hd__decap_6
XFILLER_0_59_69 VPWR VGND VPWR VGND sky130_ef_sc_hd__decap_12
X_5090_ _1842_ VGND VGND VPWR VPWR net50 sky130_fd_sc_hd__inv_2
XFILLER_0_75_57 VGND VGND VPWR VPWR sky130_fd_sc_hd__decap_8
XFILLER_0_79_729 VPWR VGND VPWR VGND sky130_ef_sc_hd__decap_12
X_7800_ _3830_ VGND VGND VPWR VPWR _0310_ sky130_fd_sc_hd__clkbuf_1
X_8780_ clknet_leaf_87_CLK _0892_ VGND VGND VPWR VPWR rf.registers\[0\]\[27\] sky130_fd_sc_hd__dfxtp_1
X_5992_ _2678_ _2704_ _2706_ VGND VGND VPWR VPWR _2707_ sky130_fd_sc_hd__o21a_1
X_4943_ _1631_ VGND VGND VPWR VPWR _1703_ sky130_fd_sc_hd__clkbuf_8
X_7731_ _3391_ rf.registers\[30\]\[21\] _3792_ VGND VGND VPWR VPWR _3794_ sky130_fd_sc_hd__mux2_1
X_7662_ rf.registers\[2\]\[21\] _3322_ _3755_ VGND VGND VPWR VPWR _3757_ sky130_fd_sc_hd__mux2_1
XFILLER_0_129_385 VGND VGND VPWR VPWR sky130_fd_sc_hd__decap_6
X_4874_ _1635_ _1636_ net4 VGND VGND VPWR VPWR _1637_ sky130_fd_sc_hd__o21a_1
XFILLER_0_117_503 VGND VGND VPWR VPWR sky130_fd_sc_hd__fill_1
X_9401_ clknet_leaf_38_CLK _0489_ VGND VGND VPWR VPWR rf.registers\[21\]\[8\] sky130_fd_sc_hd__dfxtp_1
X_6613_ rf.registers\[24\]\[4\] _2995_ _3168_ VGND VGND VPWR VPWR _3173_ sky130_fd_sc_hd__mux2_1
XFILLER_0_47_659 VGND VGND VPWR VPWR sky130_fd_sc_hd__fill_2
XFILLER_0_105_709 VPWR VGND VPWR VGND sky130_ef_sc_hd__decap_12
XFILLER_0_74_489 VGND VGND VPWR VPWR sky130_fd_sc_hd__fill_2
XFILLER_0_62_629 VGND VGND VPWR VPWR sky130_fd_sc_hd__fill_2
XFILLER_0_6_233 VPWR VGND VPWR VGND sky130_ef_sc_hd__decap_12
XFILLER_0_34_309 VGND VGND VPWR VPWR sky130_fd_sc_hd__decap_3
X_7593_ _3720_ VGND VGND VPWR VPWR _0213_ sky130_fd_sc_hd__clkbuf_1
XFILLER_0_43_821 VPWR VGND VPWR VGND sky130_ef_sc_hd__decap_12
X_9332_ clknet_leaf_35_CLK _0420_ VGND VGND VPWR VPWR rf.registers\[7\]\[3\] sky130_fd_sc_hd__dfxtp_1
X_6544_ rf.registers\[1\]\[4\] _2995_ _3131_ VGND VGND VPWR VPWR _3136_ sky130_fd_sc_hd__mux2_1
XFILLER_0_6_277 VPWR VGND VPWR VGND sky130_ef_sc_hd__decap_12
X_6475_ rf.registers\[17\]\[4\] _2995_ _3094_ VGND VGND VPWR VPWR _3099_ sky130_fd_sc_hd__mux2_1
XTAP_TAPCELL_ROW_95_1726 VGND VPWR sky130_fd_sc_hd__tapvpwrvgnd_1
X_9263_ clknet_leaf_62_CLK _0351_ VGND VGND VPWR VPWR rf.registers\[28\]\[30\] sky130_fd_sc_hd__dfxtp_1
XFILLER_0_113_753 VPWR VGND VPWR VGND sky130_ef_sc_hd__decap_12
XFILLER_0_112_241 VGND VGND VPWR VPWR sky130_fd_sc_hd__fill_2
X_5426_ _1958_ _2159_ VGND VGND VPWR VPWR _2160_ sky130_fd_sc_hd__nor2_1
X_8214_ _3397_ rf.registers\[21\]\[24\] _4045_ VGND VGND VPWR VPWR _4050_ sky130_fd_sc_hd__mux2_1
XFILLER_0_42_386 VGND VGND VPWR VPWR sky130_fd_sc_hd__fill_1
XFILLER_0_113_797 VPWR VGND VPWR VGND sky130_ef_sc_hd__decap_12
XTAP_TAPCELL_ROW_7_405 VGND VPWR sky130_fd_sc_hd__tapvpwrvgnd_1
X_9194_ clknet_leaf_85_CLK _0282_ VGND VGND VPWR VPWR rf.registers\[30\]\[25\] sky130_fd_sc_hd__dfxtp_1
X_8145_ _4013_ VGND VGND VPWR VPWR _0472_ sky130_fd_sc_hd__clkbuf_1
XFILLER_0_11_773 VGND VGND VPWR VPWR sky130_fd_sc_hd__decap_8
X_5357_ _2074_ _2094_ _1771_ VGND VGND VPWR VPWR _2095_ sky130_fd_sc_hd__a21o_1
X_4308_ _1025_ _1099_ VGND VGND VPWR VPWR _1100_ sky130_fd_sc_hd__nand2_1
X_5288_ _2028_ _2029_ _1955_ VGND VGND VPWR VPWR _2030_ sky130_fd_sc_hd__mux2_1
X_8076_ rf.registers\[7\]\[23\] _3326_ _3973_ VGND VGND VPWR VPWR _3977_ sky130_fd_sc_hd__mux2_1
X_4239_ net7 VGND VGND VPWR VPWR _1034_ sky130_fd_sc_hd__buf_4
X_7027_ _3420_ VGND VGND VPWR VPWR _0971_ sky130_fd_sc_hd__clkbuf_1
X_8978_ clknet_leaf_46_CLK _0066_ VGND VGND VPWR VPWR rf.registers\[3\]\[1\] sky130_fd_sc_hd__dfxtp_1
X_7929_ _3384_ rf.registers\[23\]\[18\] _3890_ VGND VGND VPWR VPWR _3899_ sky130_fd_sc_hd__mux2_1
XTAP_TAPCELL_ROW_104_1866 VGND VPWR sky130_fd_sc_hd__tapvpwrvgnd_1
XTAP_TAPCELL_ROW_104_1855 VGND VPWR sky130_fd_sc_hd__tapvpwrvgnd_1
XFILLER_0_93_721 VGND VGND VPWR VPWR sky130_fd_sc_hd__decap_6
XFILLER_0_38_637 VGND VGND VPWR VPWR sky130_fd_sc_hd__fill_2
XFILLER_0_93_765 VPWR VGND VPWR VGND sky130_ef_sc_hd__decap_12
XPHY_EDGE_ROW_137_Right_137 VGND VGND VPWR VPWR sky130_fd_sc_hd__decap_3
XTAP_TAPCELL_ROW_137_2354 VGND VPWR sky130_fd_sc_hd__tapvpwrvgnd_1
XFILLER_0_45_180 VPWR VGND VPWR VGND sky130_ef_sc_hd__decap_12
XFILLER_0_61_673 VPWR VGND VPWR VGND sky130_ef_sc_hd__decap_12
XFILLER_0_33_375 VGND VGND VPWR VPWR sky130_fd_sc_hd__fill_1
XFILLER_0_131_561 VGND VGND VPWR VPWR sky130_fd_sc_hd__fill_1
XFILLER_0_29_39 VGND VGND VPWR VPWR sky130_fd_sc_hd__decap_8
XFILLER_0_136_29 VPWR VGND VPWR VGND sky130_ef_sc_hd__decap_12
XFILLER_0_45_27 VPWR VGND VPWR VGND sky130_ef_sc_hd__decap_12
XFILLER_0_61_15 VPWR VGND VPWR VGND sky130_ef_sc_hd__decap_12
XFILLER_0_0_29 VGND VGND VPWR VPWR sky130_fd_sc_hd__fill_2
XFILLER_0_96_570 VGND VGND VPWR VPWR sky130_fd_sc_hd__fill_1
XFILLER_0_138_193 VGND VGND VPWR VPWR sky130_fd_sc_hd__decap_3
XFILLER_0_126_333 VPWR VGND VPWR VGND sky130_ef_sc_hd__decap_12
XFILLER_0_16_309 VPWR VGND VPWR VGND sky130_ef_sc_hd__decap_12
XFILLER_0_43_117 VGND VGND VPWR VPWR sky130_fd_sc_hd__fill_2
XFILLER_0_126_377 VGND VGND VPWR VPWR sky130_fd_sc_hd__fill_2
XPHY_EDGE_ROW_104_Right_104 VGND VGND VPWR VPWR sky130_fd_sc_hd__decap_3
X_4590_ _1367_ _1368_ _1312_ VGND VGND VPWR VPWR _1369_ sky130_fd_sc_hd__mux2_1
XFILLER_0_9_27 VPWR VGND VPWR VGND sky130_ef_sc_hd__decap_12
XFILLER_0_52_662 VGND VGND VPWR VPWR sky130_fd_sc_hd__decap_4
XTAP_TAPCELL_ROW_12_484 VGND VPWR sky130_fd_sc_hd__tapvpwrvgnd_1
XTAP_TAPCELL_ROW_12_473 VGND VPWR sky130_fd_sc_hd__tapvpwrvgnd_1
XFILLER_0_4_737 VPWR VGND VPWR VGND sky130_ef_sc_hd__decap_12
XFILLER_0_3_225 VPWR VGND VPWR VGND sky130_ef_sc_hd__decap_12
XFILLER_0_40_813 VPWR VGND VPWR VGND sky130_ef_sc_hd__decap_12
XTAP_TAPCELL_ROW_77_1456 VGND VPWR sky130_fd_sc_hd__tapvpwrvgnd_1
XFILLER_0_52_684 VPWR VGND VPWR VGND sky130_ef_sc_hd__decap_12
XFILLER_0_10_41 VPWR VGND VPWR VGND sky130_ef_sc_hd__decap_12
XFILLER_0_110_701 VPWR VGND VPWR VGND sky130_ef_sc_hd__decap_12
XFILLER_0_10_85 VPWR VGND VPWR VGND sky130_ef_sc_hd__decap_12
X_6260_ _2920_ _2894_ VGND VGND VPWR VPWR _2960_ sky130_fd_sc_hd__nor2_1
XFILLER_0_86_45 VGND VGND VPWR VPWR sky130_fd_sc_hd__fill_1
X_5211_ _1950_ _1956_ VGND VGND VPWR VPWR _1957_ sky130_fd_sc_hd__nand2_1
XFILLER_0_20_570 VGND VGND VPWR VPWR sky130_fd_sc_hd__decap_4
X_6191_ _2318_ _2894_ _2833_ _2239_ VGND VGND VPWR VPWR _2895_ sky130_fd_sc_hd__a2bb2o_1
X_5142_ rf.registers\[28\]\[14\] rf.registers\[29\]\[14\] rf.registers\[30\]\[14\]
+ rf.registers\[31\]\[14\] _1795_ _1797_ VGND VGND VPWR VPWR _1891_ sky130_fd_sc_hd__mux4_1
XTAP_TAPCELL_ROW_90_1656 VGND VPWR sky130_fd_sc_hd__tapvpwrvgnd_1
XTAP_TAPCELL_ROW_90_1645 VGND VPWR sky130_fd_sc_hd__tapvpwrvgnd_1
XFILLER_0_86_78 VGND VGND VPWR VPWR sky130_fd_sc_hd__fill_2
XFILLER_0_43_7 VPWR VGND VPWR VGND sky130_ef_sc_hd__decap_12
X_5073_ _1826_ VGND VGND VPWR VPWR net80 sky130_fd_sc_hd__inv_2
X_8901_ clknet_leaf_75_CLK _1013_ VGND VGND VPWR VPWR rf.registers\[5\]\[20\] sky130_fd_sc_hd__dfxtp_1
XTAP_TAPCELL_ROW_121_2111 VGND VPWR sky130_fd_sc_hd__tapvpwrvgnd_1
X_8832_ clknet_leaf_22_CLK _0944_ VGND VGND VPWR VPWR rf.registers\[15\]\[15\] sky130_fd_sc_hd__dfxtp_1
XTAP_TAPCELL_ROW_121_2122 VGND VPWR sky130_fd_sc_hd__tapvpwrvgnd_1
XFILLER_0_94_507 VGND VGND VPWR VPWR sky130_fd_sc_hd__fill_1
XFILLER_0_137_609 VGND VGND VPWR VPWR sky130_fd_sc_hd__decap_6
X_8763_ clknet_leaf_33_CLK _0875_ VGND VGND VPWR VPWR rf.registers\[0\]\[10\] sky130_fd_sc_hd__dfxtp_1
XFILLER_0_75_721 VGND VGND VPWR VPWR sky130_fd_sc_hd__decap_6
XFILLER_0_59_272 VGND VGND VPWR VPWR sky130_fd_sc_hd__decap_3
XFILLER_0_59_250 VGND VGND VPWR VPWR sky130_fd_sc_hd__decap_8
X_5975_ net55 _2690_ VGND VGND VPWR VPWR _2691_ sky130_fd_sc_hd__xnor2_1
X_4926_ rf.registers\[20\]\[3\] rf.registers\[21\]\[3\] rf.registers\[22\]\[3\] rf.registers\[23\]\[3\]
+ _1684_ _1685_ VGND VGND VPWR VPWR _1686_ sky130_fd_sc_hd__mux4_1
X_7714_ _3374_ rf.registers\[30\]\[13\] _3781_ VGND VGND VPWR VPWR _3785_ sky130_fd_sc_hd__mux2_1
XFILLER_0_75_765 VPWR VGND VPWR VGND sky130_ef_sc_hd__decap_12
X_8694_ clknet_leaf_60_CLK _0806_ VGND VGND VPWR VPWR rf.registers\[24\]\[5\] sky130_fd_sc_hd__dfxtp_1
XFILLER_0_19_125 VPWR VGND VPWR VGND sky130_ef_sc_hd__decap_12
XFILLER_0_47_434 VPWR VGND VPWR VGND sky130_ef_sc_hd__decap_12
XFILLER_0_129_193 VPWR VGND VPWR VGND sky130_ef_sc_hd__decap_12
X_4857_ rf.registers\[16\]\[0\] rf.registers\[17\]\[0\] rf.registers\[18\]\[0\] rf.registers\[19\]\[0\]
+ _1617_ _1618_ VGND VGND VPWR VPWR _1620_ sky130_fd_sc_hd__mux4_1
XFILLER_0_90_713 VPWR VGND VPWR VGND sky130_ef_sc_hd__decap_12
X_7645_ rf.registers\[2\]\[13\] _3305_ _3744_ VGND VGND VPWR VPWR _3748_ sky130_fd_sc_hd__mux2_1
XFILLER_0_117_355 VGND VGND VPWR VPWR sky130_fd_sc_hd__fill_2
X_7576_ _3711_ VGND VGND VPWR VPWR _0205_ sky130_fd_sc_hd__clkbuf_1
XFILLER_0_90_757 VPWR VGND VPWR VGND sky130_ef_sc_hd__decap_12
XFILLER_0_7_553 VGND VGND VPWR VPWR sky130_fd_sc_hd__decap_6
XTAP_TAPCELL_ROW_31_760 VGND VPWR sky130_fd_sc_hd__tapvpwrvgnd_1
XTAP_TAPCELL_ROW_31_771 VGND VPWR sky130_fd_sc_hd__tapvpwrvgnd_1
XTAP_TAPCELL_ROW_119_2084 VGND VPWR sky130_fd_sc_hd__tapvpwrvgnd_1
X_9315_ clknet_leaf_5_CLK _0403_ VGND VGND VPWR VPWR rf.registers\[22\]\[18\] sky130_fd_sc_hd__dfxtp_1
XFILLER_0_7_586 VPWR VGND VPWR VGND sky130_ef_sc_hd__decap_12
X_6527_ rf.registers\[17\]\[29\] _3047_ _3116_ VGND VGND VPWR VPWR _3126_ sky130_fd_sc_hd__mux2_1
X_4788_ rf.registers\[16\]\[28\] rf.registers\[17\]\[28\] rf.registers\[18\]\[28\]
+ rf.registers\[19\]\[28\] _1294_ _1295_ VGND VGND VPWR VPWR _1555_ sky130_fd_sc_hd__mux4_1
XFILLER_0_70_481 VGND VGND VPWR VPWR sky130_fd_sc_hd__fill_1
XTAP_TAPCELL_ROW_132_2273 VGND VPWR sky130_fd_sc_hd__tapvpwrvgnd_1
X_9246_ clknet_leaf_27_CLK _0334_ VGND VGND VPWR VPWR rf.registers\[28\]\[13\] sky130_fd_sc_hd__dfxtp_1
X_6458_ _3088_ VGND VGND VPWR VPWR _0734_ sky130_fd_sc_hd__clkbuf_1
XTAP_TAPCELL_ROW_132_2284 VGND VPWR sky130_fd_sc_hd__tapvpwrvgnd_1
X_9177_ clknet_leaf_37_CLK _0265_ VGND VGND VPWR VPWR rf.registers\[30\]\[8\] sky130_fd_sc_hd__dfxtp_1
Xclkload90 clknet_leaf_47_CLK VGND VGND VPWR VPWR clkload90/Y sky130_fd_sc_hd__bufinv_16
X_6389_ _3050_ VGND VGND VPWR VPWR _0703_ sky130_fd_sc_hd__clkbuf_1
X_5409_ _1958_ _2143_ VGND VGND VPWR VPWR _2144_ sky130_fd_sc_hd__nor2_1
X_8128_ _4004_ VGND VGND VPWR VPWR _0464_ sky130_fd_sc_hd__clkbuf_1
X_8059_ rf.registers\[7\]\[15\] _3309_ _3962_ VGND VGND VPWR VPWR _3968_ sky130_fd_sc_hd__mux2_1
XFILLER_0_98_813 VPWR VGND VPWR VGND sky130_ef_sc_hd__decap_12
XTAP_TAPCELL_ROW_48_1013 VGND VPWR sky130_fd_sc_hd__tapvpwrvgnd_1
XTAP_TAPCELL_ROW_48_1024 VGND VPWR sky130_fd_sc_hd__tapvpwrvgnd_1
XTAP_TAPCELL_ROW_39_882 VGND VPWR sky130_fd_sc_hd__tapvpwrvgnd_1
XFILLER_0_65_220 VGND VGND VPWR VPWR sky130_fd_sc_hd__decap_4
XTAP_TAPCELL_ROW_61_1213 VGND VPWR sky130_fd_sc_hd__tapvpwrvgnd_1
XFILLER_0_108_377 VGND VGND VPWR VPWR sky130_fd_sc_hd__fill_1
XFILLER_0_124_837 VGND VGND VPWR VPWR sky130_fd_sc_hd__fill_2
XFILLER_0_34_662 VPWR VGND VPWR VGND sky130_ef_sc_hd__decap_12
XFILLER_0_22_813 VPWR VGND VPWR VGND sky130_ef_sc_hd__decap_12
XFILLER_0_0_217 VGND VGND VPWR VPWR sky130_fd_sc_hd__decap_3
XFILLER_0_1_729 VPWR VGND VPWR VGND sky130_ef_sc_hd__decap_12
XFILLER_0_131_391 VGND VGND VPWR VPWR sky130_fd_sc_hd__fill_1
XTAP_TAPCELL_ROW_59_1186 VGND VPWR sky130_fd_sc_hd__tapvpwrvgnd_1
XTAP_TAPCELL_ROW_72_1386 VGND VPWR sky130_fd_sc_hd__tapvpwrvgnd_1
XTAP_TAPCELL_ROW_72_1375 VGND VPWR sky130_fd_sc_hd__tapvpwrvgnd_1
XFILLER_0_56_15 VPWR VGND VPWR VGND sky130_ef_sc_hd__decap_12
XFILLER_0_57_721 VGND VGND VPWR VPWR sky130_fd_sc_hd__decap_6
XTAP_TAPCELL_ROW_17_554 VGND VPWR sky130_fd_sc_hd__tapvpwrvgnd_1
XFILLER_0_57_765 VPWR VGND VPWR VGND sky130_ef_sc_hd__decap_12
X_5760_ _2476_ _2477_ _2485_ VGND VGND VPWR VPWR _2486_ sky130_fd_sc_hd__a21o_1
XFILLER_0_72_713 VPWR VGND VPWR VGND sky130_ef_sc_hd__decap_12
XFILLER_0_56_253 VPWR VGND VPWR VGND sky130_ef_sc_hd__decap_12
X_4711_ _1479_ _1482_ _1190_ VGND VGND VPWR VPWR _1483_ sky130_fd_sc_hd__mux2_1
X_5691_ _2418_ _2419_ _2416_ VGND VGND VPWR VPWR _2420_ sky130_fd_sc_hd__mux2_1
XFILLER_0_44_415 VGND VGND VPWR VPWR sky130_fd_sc_hd__decap_4
XFILLER_0_126_141 VPWR VGND VPWR VGND sky130_ef_sc_hd__decap_12
X_7430_ _3363_ rf.registers\[29\]\[8\] _3625_ VGND VGND VPWR VPWR _3634_ sky130_fd_sc_hd__mux2_1
XFILLER_0_112_53 VPWR VGND VPWR VGND sky130_ef_sc_hd__decap_12
X_4642_ rf.registers\[28\]\[19\] rf.registers\[29\]\[19\] rf.registers\[30\]\[19\]
+ rf.registers\[31\]\[19\] _1403_ _1404_ VGND VGND VPWR VPWR _1418_ sky130_fd_sc_hd__mux4_1
XFILLER_0_72_757 VPWR VGND VPWR VGND sky130_ef_sc_hd__decap_12
XFILLER_0_4_501 VPWR VGND VPWR VGND sky130_ef_sc_hd__decap_12
XFILLER_0_16_139 VGND VGND VPWR VPWR sky130_fd_sc_hd__fill_1
XFILLER_0_127_697 VPWR VGND VPWR VGND sky130_ef_sc_hd__decap_12
XFILLER_0_21_51 VGND VGND VPWR VPWR sky130_fd_sc_hd__decap_4
XFILLER_0_44_459 VGND VGND VPWR VPWR sky130_fd_sc_hd__fill_1
XFILLER_0_112_97 VPWR VGND VPWR VGND sky130_ef_sc_hd__decap_12
X_7361_ rf.registers\[8\]\[8\] _3294_ _3588_ VGND VGND VPWR VPWR _3597_ sky130_fd_sc_hd__mux2_1
X_4573_ _1293_ _1352_ VGND VGND VPWR VPWR _1353_ sky130_fd_sc_hd__nand2_1
XFILLER_0_12_301 VGND VGND VPWR VPWR sky130_fd_sc_hd__decap_6
XFILLER_0_4_545 VPWR VGND VPWR VGND sky130_ef_sc_hd__decap_12
XFILLER_0_24_150 VGND VGND VPWR VPWR sky130_fd_sc_hd__decap_6
XFILLER_0_25_673 VPWR VGND VPWR VGND sky130_ef_sc_hd__decap_12
XFILLER_0_97_55 VGND VGND VPWR VPWR sky130_fd_sc_hd__fill_1
X_7292_ _3560_ VGND VGND VPWR VPWR _0072_ sky130_fd_sc_hd__clkbuf_1
X_6312_ _2998_ VGND VGND VPWR VPWR _0678_ sky130_fd_sc_hd__clkbuf_1
XFILLER_0_12_345 VPWR VGND VPWR VGND sky130_ef_sc_hd__decap_12
XFILLER_0_4_589 VPWR VGND VPWR VGND sky130_ef_sc_hd__decap_12
X_9100_ clknet_leaf_87_CLK _0188_ VGND VGND VPWR VPWR rf.registers\[31\]\[27\] sky130_fd_sc_hd__dfxtp_1
XFILLER_0_40_643 VGND VGND VPWR VPWR sky130_fd_sc_hd__fill_1
X_9031_ clknet_leaf_10_CLK _0119_ VGND VGND VPWR VPWR rf.registers\[8\]\[22\] sky130_fd_sc_hd__dfxtp_1
XFILLER_0_12_389 VPWR VGND VPWR VGND sky130_ef_sc_hd__decap_12
X_6243_ _2179_ _2943_ VGND VGND VPWR VPWR _2944_ sky130_fd_sc_hd__and2_1
XFILLER_0_40_698 VGND VGND VPWR VPWR sky130_fd_sc_hd__fill_2
XFILLER_0_110_564 VGND VGND VPWR VPWR sky130_fd_sc_hd__fill_2
X_6174_ _2854_ _2860_ _2878_ VGND VGND VPWR VPWR _2879_ sky130_fd_sc_hd__a21oi_1
X_5125_ _1873_ _1874_ _1707_ VGND VGND VPWR VPWR _1875_ sky130_fd_sc_hd__mux2_1
XFILLER_0_34_3 VPWR VGND VPWR VGND sky130_ef_sc_hd__decap_12
X_5056_ _1810_ VGND VGND VPWR VPWR net79 sky130_fd_sc_hd__inv_2
XFILLER_0_79_334 VGND VGND VPWR VPWR sky130_fd_sc_hd__fill_2
XTAP_TAPCELL_ROW_36_841 VGND VPWR sky130_fd_sc_hd__tapvpwrvgnd_1
X_8815_ clknet_leaf_74_CLK _0927_ VGND VGND VPWR VPWR rf.registers\[16\]\[30\] sky130_fd_sc_hd__dfxtp_1
XFILLER_0_137_417 VPWR VGND VPWR VGND sky130_ef_sc_hd__decap_12
XTAP_TAPCELL_ROW_101_1814 VGND VPWR sky130_fd_sc_hd__tapvpwrvgnd_1
XFILLER_0_94_359 VGND VGND VPWR VPWR sky130_fd_sc_hd__decap_4
X_5958_ net86 _2674_ VGND VGND VPWR VPWR _2675_ sky130_fd_sc_hd__xnor2_2
X_8746_ clknet_leaf_71_CLK _0858_ VGND VGND VPWR VPWR rf.registers\[10\]\[25\] sky130_fd_sc_hd__dfxtp_1
X_4909_ rf.registers\[28\]\[2\] rf.registers\[29\]\[2\] rf.registers\[30\]\[2\] rf.registers\[31\]\[2\]
+ _1624_ _1625_ VGND VGND VPWR VPWR _1670_ sky130_fd_sc_hd__mux4_1
X_5889_ _2609_ _2201_ _2473_ _2531_ _2392_ VGND VGND VPWR VPWR _2610_ sky130_fd_sc_hd__o41a_1
X_8677_ clknet_leaf_71_CLK _0789_ VGND VGND VPWR VPWR rf.registers\[1\]\[20\] sky130_fd_sc_hd__dfxtp_1
XTAP_TAPCELL_ROW_134_2313 VGND VPWR sky130_fd_sc_hd__tapvpwrvgnd_1
XFILLER_0_106_837 VGND VGND VPWR VPWR sky130_fd_sc_hd__fill_2
X_7628_ rf.registers\[2\]\[5\] _3288_ _3733_ VGND VGND VPWR VPWR _3739_ sky130_fd_sc_hd__mux2_1
XFILLER_0_7_361 VPWR VGND VPWR VGND sky130_ef_sc_hd__decap_12
XFILLER_0_132_133 VGND VGND VPWR VPWR sky130_fd_sc_hd__decap_6
XFILLER_0_90_587 VGND VGND VPWR VPWR sky130_fd_sc_hd__fill_1
X_7559_ _3702_ VGND VGND VPWR VPWR _0197_ sky130_fd_sc_hd__clkbuf_1
XFILLER_0_15_161 VGND VGND VPWR VPWR sky130_fd_sc_hd__decap_6
XFILLER_0_132_177 VPWR VGND VPWR VGND sky130_ef_sc_hd__decap_12
X_9229_ clknet_leaf_91_CLK _0317_ VGND VGND VPWR VPWR rf.registers\[9\]\[28\] sky130_fd_sc_hd__dfxtp_1
XTAP_TAPCELL_ROW_112_1987 VGND VPWR sky130_fd_sc_hd__tapvpwrvgnd_1
XTAP_TAPCELL_ROW_112_1976 VGND VPWR sky130_fd_sc_hd__tapvpwrvgnd_1
XFILLER_0_26_29 VPWR VGND VPWR VGND sky130_ef_sc_hd__decap_12
XFILLER_0_86_805 VGND VGND VPWR VPWR sky130_fd_sc_hd__decap_6
XFILLER_0_98_698 VGND VGND VPWR VPWR sky130_fd_sc_hd__fill_2
XTAP_TAPCELL_ROW_14_513 VGND VPWR sky130_fd_sc_hd__tapvpwrvgnd_1
XFILLER_0_54_713 VPWR VGND VPWR VGND sky130_ef_sc_hd__decap_12
XFILLER_0_38_253 VGND VGND VPWR VPWR sky130_fd_sc_hd__fill_2
XFILLER_0_81_521 VGND VGND VPWR VPWR sky130_fd_sc_hd__fill_2
XFILLER_0_54_757 VPWR VGND VPWR VGND sky130_ef_sc_hd__decap_12
XFILLER_0_123_111 VGND VGND VPWR VPWR sky130_fd_sc_hd__fill_1
XFILLER_0_124_678 VPWR VGND VPWR VGND sky130_ef_sc_hd__decap_12
XANTENNA_5 _1773_ VGND VGND VPWR VPWR sky130_fd_sc_hd__diode_2
XTAP_TAPCELL_ROW_74_1404 VGND VPWR sky130_fd_sc_hd__tapvpwrvgnd_1
XFILLER_0_22_643 VGND VGND VPWR VPWR sky130_fd_sc_hd__fill_1
XTAP_TAPCELL_ROW_74_1415 VGND VPWR sky130_fd_sc_hd__tapvpwrvgnd_1
XFILLER_0_10_805 VGND VGND VPWR VPWR sky130_fd_sc_hd__decap_6
XFILLER_0_1_559 VGND VGND VPWR VPWR sky130_fd_sc_hd__fill_1
XFILLER_0_22_698 VGND VGND VPWR VPWR sky130_fd_sc_hd__fill_2
XFILLER_0_107_31 VPWR VGND VPWR VGND sky130_ef_sc_hd__decap_12
X_6930_ _3359_ rf.registers\[15\]\[6\] _3347_ VGND VGND VPWR VPWR _3360_ sky130_fd_sc_hd__mux2_1
XFILLER_0_107_97 VGND VGND VPWR VPWR sky130_fd_sc_hd__decap_3
X_6861_ _3312_ VGND VGND VPWR VPWR _0913_ sky130_fd_sc_hd__clkbuf_1
XTAP_TAPCELL_ROW_85_1577 VGND VPWR sky130_fd_sc_hd__tapvpwrvgnd_1
X_8600_ clknet_leaf_50_CLK _0712_ VGND VGND VPWR VPWR rf.registers\[11\]\[7\] sky130_fd_sc_hd__dfxtp_1
XFILLER_0_76_337 VGND VGND VPWR VPWR sky130_fd_sc_hd__decap_6
X_6792_ rf.registers\[0\]\[24\] _3037_ _3263_ VGND VGND VPWR VPWR _3268_ sky130_fd_sc_hd__mux2_1
XTAP_TAPCELL_ROW_33_800 VGND VPWR sky130_fd_sc_hd__tapvpwrvgnd_1
X_5812_ _2535_ _2536_ VGND VGND VPWR VPWR _2537_ sky130_fd_sc_hd__nor2_1
X_8531_ _4217_ VGND VGND VPWR VPWR _0654_ sky130_fd_sc_hd__clkbuf_1
X_5743_ net106 _2468_ _2469_ _2358_ VGND VGND VPWR VPWR _2470_ sky130_fd_sc_hd__a211o_1
XFILLER_0_45_702 VGND VGND VPWR VPWR sky130_fd_sc_hd__decap_8
X_8462_ _4181_ VGND VGND VPWR VPWR _0621_ sky130_fd_sc_hd__clkbuf_1
XFILLER_0_5_821 VPWR VGND VPWR VGND sky130_ef_sc_hd__decap_12
X_5674_ _2383_ _2402_ VGND VGND VPWR VPWR _2403_ sky130_fd_sc_hd__nand2_1
XTAP_TAPCELL_ROW_116_2043 VGND VPWR sky130_fd_sc_hd__tapvpwrvgnd_1
XFILLER_0_114_133 VGND VGND VPWR VPWR sky130_fd_sc_hd__decap_6
X_8393_ rf.registers\[18\]\[12\] net17 _4142_ VGND VGND VPWR VPWR _4145_ sky130_fd_sc_hd__mux2_1
X_7413_ _3624_ VGND VGND VPWR VPWR _3625_ sky130_fd_sc_hd__clkbuf_8
X_4625_ _1398_ _1401_ _1293_ VGND VGND VPWR VPWR _1402_ sky130_fd_sc_hd__mux2_1
XFILLER_0_60_749 VGND VGND VPWR VPWR sky130_fd_sc_hd__decap_6
XFILLER_0_32_407 VGND VGND VPWR VPWR sky130_fd_sc_hd__decap_8
XFILLER_0_115_689 VPWR VGND VPWR VGND sky130_ef_sc_hd__decap_12
XFILLER_0_114_177 VPWR VGND VPWR VGND sky130_ef_sc_hd__decap_12
X_4556_ rf.registers\[12\]\[14\] rf.registers\[13\]\[14\] rf.registers\[14\]\[14\]
+ rf.registers\[15\]\[14\] _1302_ _1303_ VGND VGND VPWR VPWR _1337_ sky130_fd_sc_hd__mux4_1
X_7344_ _3587_ VGND VGND VPWR VPWR _3588_ sky130_fd_sc_hd__buf_4
XFILLER_0_12_153 VPWR VGND VPWR VGND sky130_ef_sc_hd__decap_12
X_4487_ rf.registers\[24\]\[11\] rf.registers\[25\]\[11\] rf.registers\[26\]\[11\]
+ rf.registers\[27\]\[11\] _1138_ _1121_ VGND VGND VPWR VPWR _1271_ sky130_fd_sc_hd__mux4_1
X_7275_ _3054_ _3129_ VGND VGND VPWR VPWR _3551_ sky130_fd_sc_hd__nor2_2
XFILLER_0_12_197 VPWR VGND VPWR VGND sky130_ef_sc_hd__decap_12
X_9014_ clknet_leaf_65_CLK _0102_ VGND VGND VPWR VPWR rf.registers\[8\]\[5\] sky130_fd_sc_hd__dfxtp_1
X_6226_ net101 _2885_ _2479_ VGND VGND VPWR VPWR _2928_ sky130_fd_sc_hd__o21ai_1
X_6157_ _2831_ _2862_ _2348_ VGND VGND VPWR VPWR _2863_ sky130_fd_sc_hd__mux2_1
X_5108_ _1857_ _1858_ _1707_ VGND VGND VPWR VPWR _1859_ sky130_fd_sc_hd__mux2_1
X_6088_ _2399_ _2790_ _2797_ VGND VGND VPWR VPWR net126 sky130_fd_sc_hd__o21ba_1
XFILLER_0_68_805 VGND VGND VPWR VPWR sky130_fd_sc_hd__decap_6
X_5039_ _1794_ VGND VGND VPWR VPWR net78 sky130_fd_sc_hd__inv_2
XFILLER_0_138_726 VGND VGND VPWR VPWR sky130_fd_sc_hd__fill_2
XTAP_TAPCELL_ROW_0_285 VGND VPWR sky130_fd_sc_hd__tapvpwrvgnd_1
XTAP_TAPCELL_ROW_0_296 VGND VPWR sky130_fd_sc_hd__tapvpwrvgnd_1
XFILLER_0_137_225 VPWR VGND VPWR VGND sky130_ef_sc_hd__decap_12
X_8729_ clknet_leaf_49_CLK _0841_ VGND VGND VPWR VPWR rf.registers\[10\]\[8\] sky130_fd_sc_hd__dfxtp_1
XFILLER_0_91_841 VGND VGND VPWR VPWR sky130_fd_sc_hd__fill_1
XFILLER_0_36_735 VGND VGND VPWR VPWR sky130_fd_sc_hd__fill_1
XFILLER_0_8_681 VGND VGND VPWR VPWR sky130_fd_sc_hd__decap_3
XFILLER_0_8_670 VGND VGND VPWR VPWR sky130_fd_sc_hd__decap_3
XFILLER_0_36_757 VGND VGND VPWR VPWR sky130_fd_sc_hd__fill_2
XFILLER_0_36_768 VPWR VGND VPWR VGND sky130_ef_sc_hd__decap_12
XTAP_TAPCELL_ROW_56_1145 VGND VPWR sky130_fd_sc_hd__tapvpwrvgnd_1
XTAP_TAPCELL_ROW_56_1134 VGND VPWR sky130_fd_sc_hd__tapvpwrvgnd_1
Xoutput75 net75 VGND VGND VPWR VPWR RD1[4] sky130_fd_sc_hd__buf_1
Xoutput64 net64 VGND VGND VPWR VPWR RD1[23] sky130_fd_sc_hd__buf_1
Xoutput53 net53 VGND VGND VPWR VPWR RD1[13] sky130_fd_sc_hd__buf_1
Xoutput86 net86 VGND VGND VPWR VPWR RD2[14] sky130_fd_sc_hd__buf_1
Xoutput97 net97 VGND VGND VPWR VPWR RD2[24] sky130_fd_sc_hd__buf_1
XFILLER_0_37_39 VPWR VGND VPWR VGND sky130_ef_sc_hd__decap_12
XFILLER_0_53_27 VPWR VGND VPWR VGND sky130_ef_sc_hd__decap_12
XFILLER_0_73_307 VGND VGND VPWR VPWR sky130_fd_sc_hd__decap_8
XFILLER_0_27_713 VGND VGND VPWR VPWR sky130_fd_sc_hd__decap_4
XTAP_TAPCELL_ROW_80_1496 VGND VPWR sky130_fd_sc_hd__tapvpwrvgnd_1
XFILLER_0_54_565 VGND VGND VPWR VPWR sky130_fd_sc_hd__decap_4
XFILLER_0_26_245 VGND VGND VPWR VPWR sky130_fd_sc_hd__fill_2
XFILLER_0_42_705 VGND VGND VPWR VPWR sky130_fd_sc_hd__fill_1
X_4410_ _1148_ VGND VGND VPWR VPWR _1199_ sky130_fd_sc_hd__buf_4
XFILLER_0_2_813 VPWR VGND VPWR VGND sky130_ef_sc_hd__decap_12
X_5390_ _1955_ _2125_ VGND VGND VPWR VPWR _2126_ sky130_fd_sc_hd__and2_1
XFILLER_0_111_169 VGND VGND VPWR VPWR sky130_fd_sc_hd__decap_3
X_4341_ rf.registers\[20\]\[4\] rf.registers\[21\]\[4\] rf.registers\[22\]\[4\] rf.registers\[23\]\[4\]
+ _1120_ _1123_ VGND VGND VPWR VPWR _1132_ sky130_fd_sc_hd__mux4_1
XFILLER_0_50_793 VPWR VGND VPWR VGND sky130_ef_sc_hd__decap_12
X_4272_ rf.registers\[4\]\[1\] rf.registers\[5\]\[1\] rf.registers\[6\]\[1\] rf.registers\[7\]\[1\]
+ _1041_ _1043_ VGND VGND VPWR VPWR _1066_ sky130_fd_sc_hd__mux4_1
X_7060_ _3437_ VGND VGND VPWR VPWR _0987_ sky130_fd_sc_hd__clkbuf_1
X_6011_ _2626_ _2661_ _2348_ VGND VGND VPWR VPWR _2725_ sky130_fd_sc_hd__mux2_1
XFILLER_0_118_41 VPWR VGND VPWR VGND sky130_ef_sc_hd__decap_12
XFILLER_0_118_85 VPWR VGND VPWR VGND sky130_ef_sc_hd__decap_12
XTAP_TAPCELL_ROW_87_1606 VGND VPWR sky130_fd_sc_hd__tapvpwrvgnd_1
X_7962_ _3349_ rf.registers\[22\]\[1\] _3915_ VGND VGND VPWR VPWR _3917_ sky130_fd_sc_hd__mux2_1
X_6913_ _3348_ VGND VGND VPWR VPWR _0929_ sky130_fd_sc_hd__clkbuf_1
XFILLER_0_76_101 VPWR VGND VPWR VGND sky130_ef_sc_hd__decap_12
X_7893_ _3880_ VGND VGND VPWR VPWR _0353_ sky130_fd_sc_hd__clkbuf_1
XFILLER_0_77_646 VGND VGND VPWR VPWR sky130_fd_sc_hd__fill_1
XFILLER_0_119_225 VPWR VGND VPWR VGND sky130_ef_sc_hd__decap_12
X_6844_ net16 VGND VGND VPWR VPWR _3301_ sky130_fd_sc_hd__clkbuf_2
XFILLER_0_77_668 VGND VGND VPWR VPWR sky130_fd_sc_hd__decap_4
XTAP_TAPCELL_ROW_46_991 VGND VPWR sky130_fd_sc_hd__tapvpwrvgnd_1
X_9563_ clknet_leaf_33_CLK _0651_ VGND VGND VPWR VPWR rf.registers\[13\]\[10\] sky130_fd_sc_hd__dfxtp_1
X_6775_ rf.registers\[0\]\[16\] _3020_ _3252_ VGND VGND VPWR VPWR _3259_ sky130_fd_sc_hd__mux2_1
XFILLER_0_43_93 VGND VGND VPWR VPWR sky130_fd_sc_hd__fill_1
XFILLER_0_135_729 VPWR VGND VPWR VGND sky130_ef_sc_hd__decap_12
XFILLER_0_128_781 VPWR VGND VPWR VGND sky130_ef_sc_hd__decap_12
X_9494_ clknet_leaf_58_CLK _0582_ VGND VGND VPWR VPWR rf.registers\[18\]\[5\] sky130_fd_sc_hd__dfxtp_1
X_8514_ _4208_ VGND VGND VPWR VPWR _0646_ sky130_fd_sc_hd__clkbuf_1
XFILLER_0_73_841 VGND VGND VPWR VPWR sky130_fd_sc_hd__fill_1
XFILLER_0_18_757 VPWR VGND VPWR VGND sky130_ef_sc_hd__decap_12
X_5726_ net92 _2324_ _2453_ VGND VGND VPWR VPWR _2454_ sky130_fd_sc_hd__a21oi_2
X_8445_ _4172_ VGND VGND VPWR VPWR _0613_ sky130_fd_sc_hd__clkbuf_1
XFILLER_0_72_362 VGND VGND VPWR VPWR sky130_fd_sc_hd__fill_2
XFILLER_0_130_401 VPWR VGND VPWR VGND sky130_ef_sc_hd__decap_12
XFILLER_0_103_615 VGND VGND VPWR VPWR sky130_fd_sc_hd__fill_1
XTAP_TAPCELL_ROW_98_1768 VGND VPWR sky130_fd_sc_hd__tapvpwrvgnd_1
XFILLER_0_5_673 VPWR VGND VPWR VGND sky130_ef_sc_hd__decap_12
X_5657_ _2373_ _2385_ _2386_ VGND VGND VPWR VPWR _2387_ sky130_fd_sc_hd__mux2_1
XFILLER_0_33_749 VGND VGND VPWR VPWR sky130_fd_sc_hd__fill_1
X_8376_ rf.registers\[18\]\[4\] net40 _4131_ VGND VGND VPWR VPWR _4136_ sky130_fd_sc_hd__mux2_1
X_4608_ _1312_ _1385_ VGND VGND VPWR VPWR _1386_ sky130_fd_sc_hd__or2_1
XFILLER_0_5_695 VPWR VGND VPWR VGND sky130_ef_sc_hd__decap_12
X_5588_ net47 _2264_ VGND VGND VPWR VPWR _2319_ sky130_fd_sc_hd__or2_4
XFILLER_0_41_760 VGND VGND VPWR VPWR sky130_fd_sc_hd__decap_3
X_4539_ _1160_ VGND VGND VPWR VPWR _1321_ sky130_fd_sc_hd__buf_4
XFILLER_0_13_473 VPWR VGND VPWR VGND sky130_ef_sc_hd__decap_12
X_7327_ rf.registers\[3\]\[24\] _3328_ _3574_ VGND VGND VPWR VPWR _3579_ sky130_fd_sc_hd__mux2_1
XFILLER_0_41_782 VGND VGND VPWR VPWR sky130_fd_sc_hd__fill_2
XFILLER_0_111_670 VGND VGND VPWR VPWR sky130_fd_sc_hd__fill_2
XFILLER_0_7_93 VPWR VGND VPWR VGND sky130_ef_sc_hd__decap_12
X_7258_ _3542_ VGND VGND VPWR VPWR _0056_ sky130_fd_sc_hd__clkbuf_1
X_6209_ _2847_ _2850_ _2911_ VGND VGND VPWR VPWR _2912_ sky130_fd_sc_hd__a21oi_1
XTAP_TAPCELL_ROW_129_2234 VGND VPWR sky130_fd_sc_hd__tapvpwrvgnd_1
X_7189_ rf.registers\[4\]\[23\] _3326_ _3502_ VGND VGND VPWR VPWR _3506_ sky130_fd_sc_hd__mux2_1
XTAP_TAPCELL_ROW_51_1064 VGND VPWR sky130_fd_sc_hd__tapvpwrvgnd_1
XTAP_TAPCELL_ROW_5_377 VGND VPWR sky130_fd_sc_hd__tapvpwrvgnd_1
XFILLER_0_138_501 VGND VGND VPWR VPWR sky130_fd_sc_hd__decap_3
XFILLER_0_95_443 VGND VGND VPWR VPWR sky130_fd_sc_hd__fill_2
XFILLER_0_68_657 VPWR VGND VPWR VGND sky130_ef_sc_hd__decap_12
XFILLER_0_138_545 VPWR VGND VPWR VGND sky130_ef_sc_hd__decap_12
XFILLER_0_55_318 VPWR VGND VPWR VGND sky130_ef_sc_hd__decap_12
XTAP_TAPCELL_ROW_24_663 VGND VPWR sky130_fd_sc_hd__tapvpwrvgnd_1
XFILLER_0_138_589 VGND VGND VPWR VPWR sky130_fd_sc_hd__decap_4
XFILLER_0_125_217 VGND VGND VPWR VPWR sky130_fd_sc_hd__decap_6
XFILLER_0_24_727 VGND VGND VPWR VPWR sky130_fd_sc_hd__decap_3
XFILLER_0_36_565 VGND VGND VPWR VPWR sky130_fd_sc_hd__fill_1
XFILLER_0_133_261 VPWR VGND VPWR VGND sky130_ef_sc_hd__decap_12
XFILLER_0_51_557 VGND VGND VPWR VPWR sky130_fd_sc_hd__decap_3
XFILLER_0_2_109 VPWR VGND VPWR VGND sky130_ef_sc_hd__decap_12
XFILLER_0_106_486 VGND VGND VPWR VPWR sky130_fd_sc_hd__decap_8
XFILLER_0_48_27 VGND VGND VPWR VPWR sky130_fd_sc_hd__fill_1
XFILLER_0_64_15 VPWR VGND VPWR VGND sky130_ef_sc_hd__decap_12
XTAP_TAPCELL_ROW_69_1336 VGND VPWR sky130_fd_sc_hd__tapvpwrvgnd_1
XFILLER_0_59_602 VGND VGND VPWR VPWR sky130_fd_sc_hd__decap_3
XFILLER_0_86_421 VGND VGND VPWR VPWR sky130_fd_sc_hd__decap_8
XFILLER_0_59_657 VPWR VGND VPWR VGND sky130_ef_sc_hd__decap_12
XFILLER_0_58_112 VGND VGND VPWR VPWR sky130_fd_sc_hd__fill_1
X_4890_ _1624_ VGND VGND VPWR VPWR _1652_ sky130_fd_sc_hd__buf_4
XTAP_TAPCELL_ROW_82_1536 VGND VPWR sky130_fd_sc_hd__tapvpwrvgnd_1
XTAP_TAPCELL_ROW_82_1525 VGND VPWR sky130_fd_sc_hd__tapvpwrvgnd_1
XFILLER_0_74_638 VGND VGND VPWR VPWR sky130_fd_sc_hd__fill_2
XTAP_TAPCELL_ROW_43_950 VGND VPWR sky130_fd_sc_hd__tapvpwrvgnd_1
XFILLER_0_117_729 VPWR VGND VPWR VGND sky130_ef_sc_hd__decap_12
XFILLER_0_104_65 VPWR VGND VPWR VGND sky130_ef_sc_hd__decap_12
X_6560_ _3144_ VGND VGND VPWR VPWR _0780_ sky130_fd_sc_hd__clkbuf_1
XFILLER_0_55_841 VGND VGND VPWR VPWR sky130_fd_sc_hd__fill_1
XFILLER_0_70_811 VGND VGND VPWR VPWR sky130_fd_sc_hd__fill_1
XFILLER_0_15_705 VGND VGND VPWR VPWR sky130_fd_sc_hd__fill_2
X_5511_ _1778_ _2206_ VGND VGND VPWR VPWR _2242_ sky130_fd_sc_hd__or2_1
X_6491_ _3107_ VGND VGND VPWR VPWR _0748_ sky130_fd_sc_hd__clkbuf_1
XFILLER_0_81_192 VGND VGND VPWR VPWR sky130_fd_sc_hd__fill_2
XFILLER_0_120_53 VPWR VGND VPWR VGND sky130_ef_sc_hd__decap_12
XTAP_TAPCELL_ROW_113_2002 VGND VPWR sky130_fd_sc_hd__tapvpwrvgnd_1
XFILLER_0_112_412 VGND VGND VPWR VPWR sky130_fd_sc_hd__fill_1
X_8230_ _2966_ _3166_ VGND VGND VPWR VPWR _4058_ sky130_fd_sc_hd__nand2_4
X_5442_ rf.registers\[8\]\[30\] rf.registers\[9\]\[30\] rf.registers\[10\]\[30\] rf.registers\[11\]\[30\]
+ _1951_ _1952_ VGND VGND VPWR VPWR _2175_ sky130_fd_sc_hd__mux4_1
XFILLER_0_120_97 VPWR VGND VPWR VGND sky130_ef_sc_hd__decap_12
X_8161_ _4021_ VGND VGND VPWR VPWR _0480_ sky130_fd_sc_hd__clkbuf_1
XFILLER_0_2_643 VGND VGND VPWR VPWR sky130_fd_sc_hd__fill_1
X_5373_ _2009_ VGND VGND VPWR VPWR _2110_ sky130_fd_sc_hd__clkbuf_4
X_7112_ rf.registers\[5\]\[19\] _3317_ _3455_ VGND VGND VPWR VPWR _3465_ sky130_fd_sc_hd__mux2_1
X_8092_ rf.registers\[7\]\[31\] _3342_ _3950_ VGND VGND VPWR VPWR _3985_ sky130_fd_sc_hd__mux2_1
XFILLER_0_10_421 VPWR VGND VPWR VGND sky130_ef_sc_hd__decap_12
X_4324_ _1115_ VGND VGND VPWR VPWR net106 sky130_fd_sc_hd__buf_4
XFILLER_0_129_51 VGND VGND VPWR VPWR sky130_fd_sc_hd__decap_4
XTAP_TAPCELL_ROW_93_1698 VGND VPWR sky130_fd_sc_hd__tapvpwrvgnd_1
X_7043_ _3428_ VGND VGND VPWR VPWR _0979_ sky130_fd_sc_hd__clkbuf_1
X_4255_ rf.registers\[0\]\[0\] rf.registers\[1\]\[0\] rf.registers\[2\]\[0\] rf.registers\[3\]\[0\]
+ _1026_ _1027_ VGND VGND VPWR VPWR _1050_ sky130_fd_sc_hd__mux4_1
XTAP_TAPCELL_ROW_2_336 VGND VPWR sky130_fd_sc_hd__tapvpwrvgnd_1
XTAP_TAPCELL_ROW_2_325 VGND VPWR sky130_fd_sc_hd__tapvpwrvgnd_1
XTAP_TAPCELL_ROW_124_2153 VGND VPWR sky130_fd_sc_hd__tapvpwrvgnd_1
X_8994_ clknet_leaf_12_CLK _0082_ VGND VGND VPWR VPWR rf.registers\[3\]\[17\] sky130_fd_sc_hd__dfxtp_1
XTAP_TAPCELL_ROW_124_2164 VGND VPWR sky130_fd_sc_hd__tapvpwrvgnd_1
XPHY_EDGE_ROW_118_Right_118 VGND VGND VPWR VPWR sky130_fd_sc_hd__decap_3
XFILLER_0_89_281 VGND VGND VPWR VPWR sky130_fd_sc_hd__fill_1
X_7945_ _3907_ VGND VGND VPWR VPWR _0378_ sky130_fd_sc_hd__clkbuf_1
XFILLER_0_49_134 VGND VGND VPWR VPWR sky130_fd_sc_hd__decap_3
X_7876_ _3870_ VGND VGND VPWR VPWR _0346_ sky130_fd_sc_hd__clkbuf_1
XFILLER_0_77_498 VGND VGND VPWR VPWR sky130_fd_sc_hd__decap_6
X_6827_ _3289_ VGND VGND VPWR VPWR _0902_ sky130_fd_sc_hd__clkbuf_1
XFILLER_0_49_178 VGND VGND VPWR VPWR sky130_fd_sc_hd__decap_4
XFILLER_0_37_318 VGND VGND VPWR VPWR sky130_fd_sc_hd__fill_2
XTAP_TAPCELL_ROW_41_909 VGND VPWR sky130_fd_sc_hd__tapvpwrvgnd_1
XTAP_TAPCELL_ROW_21_611 VGND VPWR sky130_fd_sc_hd__tapvpwrvgnd_1
X_9546_ clknet_leaf_71_CLK _0634_ VGND VGND VPWR VPWR rf.registers\[14\]\[25\] sky130_fd_sc_hd__dfxtp_1
X_6758_ rf.registers\[0\]\[8\] _3003_ _3241_ VGND VGND VPWR VPWR _3250_ sky130_fd_sc_hd__mux2_1
XFILLER_0_73_682 VPWR VGND VPWR VGND sky130_ef_sc_hd__decap_12
XTAP_TAPCELL_ROW_21_622 VGND VPWR sky130_fd_sc_hd__tapvpwrvgnd_1
XFILLER_0_122_209 VPWR VGND VPWR VGND sky130_ef_sc_hd__decap_12
X_6689_ _3213_ VGND VGND VPWR VPWR _0840_ sky130_fd_sc_hd__clkbuf_1
XFILLER_0_72_192 VGND VGND VPWR VPWR sky130_fd_sc_hd__decap_4
XFILLER_0_61_833 VGND VGND VPWR VPWR sky130_fd_sc_hd__decap_6
X_5709_ _2366_ _2369_ _2332_ VGND VGND VPWR VPWR _2437_ sky130_fd_sc_hd__mux2_1
X_9477_ clknet_leaf_82_CLK _0565_ VGND VGND VPWR VPWR rf.registers\[20\]\[20\] sky130_fd_sc_hd__dfxtp_1
XFILLER_0_131_721 VGND VGND VPWR VPWR sky130_fd_sc_hd__decap_6
XFILLER_0_60_365 VGND VGND VPWR VPWR sky130_fd_sc_hd__decap_4
X_8428_ rf.registers\[18\]\[29\] net35 _4153_ VGND VGND VPWR VPWR _4163_ sky130_fd_sc_hd__mux2_1
XFILLER_0_21_708 VGND VGND VPWR VPWR sky130_fd_sc_hd__decap_8
XFILLER_0_33_579 VPWR VGND VPWR VGND sky130_ef_sc_hd__decap_12
XFILLER_0_131_765 VPWR VGND VPWR VGND sky130_ef_sc_hd__decap_12
XFILLER_0_130_253 VPWR VGND VPWR VGND sky130_ef_sc_hd__decap_12
XFILLER_0_14_793 VPWR VGND VPWR VGND sky130_ef_sc_hd__decap_12
X_8359_ _4126_ VGND VGND VPWR VPWR _0573_ sky130_fd_sc_hd__clkbuf_1
XFILLER_0_13_281 VPWR VGND VPWR VGND sky130_ef_sc_hd__decap_12
XTAP_TAPCELL_ROW_109_1937 VGND VPWR sky130_fd_sc_hd__tapvpwrvgnd_1
XTAP_TAPCELL_ROW_29_733 VGND VPWR sky130_fd_sc_hd__tapvpwrvgnd_1
XFILLER_0_68_421 VPWR VGND VPWR VGND sky130_ef_sc_hd__decap_12
XFILLER_0_34_29 VPWR VGND VPWR VGND sky130_ef_sc_hd__decap_12
XTAP_TAPCELL_ROW_64_1266 VGND VPWR sky130_fd_sc_hd__tapvpwrvgnd_1
XTAP_TAPCELL_ROW_64_1255 VGND VPWR sky130_fd_sc_hd__tapvpwrvgnd_1
XFILLER_0_56_638 VGND VGND VPWR VPWR sky130_fd_sc_hd__decap_6
XFILLER_0_28_307 VGND VGND VPWR VPWR sky130_fd_sc_hd__fill_1
XFILLER_0_37_841 VGND VGND VPWR VPWR sky130_fd_sc_hd__fill_1
XFILLER_0_52_811 VGND VGND VPWR VPWR sky130_fd_sc_hd__fill_1
XFILLER_0_36_362 VGND VGND VPWR VPWR sky130_fd_sc_hd__fill_2
XFILLER_0_64_693 VGND VGND VPWR VPWR sky130_fd_sc_hd__decap_6
XFILLER_0_52_833 VGND VGND VPWR VPWR sky130_fd_sc_hd__fill_1
XFILLER_0_51_343 VGND VGND VPWR VPWR sky130_fd_sc_hd__decap_4
XFILLER_0_3_429 VPWR VGND VPWR VGND sky130_ef_sc_hd__decap_12
XFILLER_0_12_719 VPWR VGND VPWR VGND sky130_ef_sc_hd__decap_12
XFILLER_0_87_741 VPWR VGND VPWR VGND sky130_ef_sc_hd__decap_12
X_5991_ _2215_ _2690_ _2705_ VGND VGND VPWR VPWR _2706_ sky130_fd_sc_hd__o21a_1
XFILLER_0_115_53 VGND VGND VPWR VPWR sky130_fd_sc_hd__decap_3
X_4942_ _1698_ _1701_ _1628_ VGND VGND VPWR VPWR _1702_ sky130_fd_sc_hd__o21a_1
X_7730_ _3793_ VGND VGND VPWR VPWR _0277_ sky130_fd_sc_hd__clkbuf_1
XFILLER_0_87_785 VPWR VGND VPWR VGND sky130_ef_sc_hd__decap_12
XFILLER_0_86_284 VGND VGND VPWR VPWR sky130_fd_sc_hd__decap_3
X_7661_ _3756_ VGND VGND VPWR VPWR _0245_ sky130_fd_sc_hd__clkbuf_1
XFILLER_0_47_638 VGND VGND VPWR VPWR sky130_fd_sc_hd__decap_3
X_6612_ _3172_ VGND VGND VPWR VPWR _0804_ sky130_fd_sc_hd__clkbuf_1
X_4873_ rf.registers\[12\]\[0\] rf.registers\[13\]\[0\] rf.registers\[14\]\[0\] rf.registers\[15\]\[0\]
+ _1631_ _1632_ VGND VGND VPWR VPWR _1636_ sky130_fd_sc_hd__mux4_1
X_9400_ clknet_leaf_52_CLK _0488_ VGND VGND VPWR VPWR rf.registers\[21\]\[7\] sky130_fd_sc_hd__dfxtp_1
XFILLER_0_46_126 VGND VGND VPWR VPWR sky130_fd_sc_hd__decap_3
XFILLER_0_55_660 VPWR VGND VPWR VGND sky130_ef_sc_hd__decap_12
XFILLER_0_27_362 VGND VGND VPWR VPWR sky130_fd_sc_hd__fill_1
X_7592_ _3388_ rf.registers\[27\]\[20\] _3719_ VGND VGND VPWR VPWR _3720_ sky130_fd_sc_hd__mux2_1
X_6543_ _3135_ VGND VGND VPWR VPWR _0772_ sky130_fd_sc_hd__clkbuf_1
X_9331_ clknet_leaf_41_CLK _0419_ VGND VGND VPWR VPWR rf.registers\[7\]\[2\] sky130_fd_sc_hd__dfxtp_1
XFILLER_0_6_245 VGND VGND VPWR VPWR sky130_fd_sc_hd__decap_6
XFILLER_0_43_833 VGND VGND VPWR VPWR sky130_fd_sc_hd__decap_6
X_6474_ _3098_ VGND VGND VPWR VPWR _0740_ sky130_fd_sc_hd__clkbuf_1
XTAP_TAPCELL_ROW_95_1727 VGND VPWR sky130_fd_sc_hd__tapvpwrvgnd_1
XFILLER_0_6_289 VPWR VGND VPWR VGND sky130_ef_sc_hd__decap_12
X_9262_ clknet_leaf_93_CLK _0350_ VGND VGND VPWR VPWR rf.registers\[28\]\[29\] sky130_fd_sc_hd__dfxtp_1
XFILLER_0_113_765 VPWR VGND VPWR VGND sky130_ef_sc_hd__decap_12
X_8213_ _4049_ VGND VGND VPWR VPWR _0504_ sky130_fd_sc_hd__clkbuf_1
XPHY_EDGE_ROW_12_Right_12 VGND VGND VPWR VPWR sky130_fd_sc_hd__decap_3
X_5425_ _2157_ _2158_ _2074_ VGND VGND VPWR VPWR _2159_ sky130_fd_sc_hd__mux2_1
XFILLER_0_112_253 VGND VGND VPWR VPWR sky130_fd_sc_hd__fill_2
XFILLER_0_64_3 VPWR VGND VPWR VGND sky130_ef_sc_hd__decap_12
XFILLER_0_11_752 VGND VGND VPWR VPWR sky130_fd_sc_hd__decap_3
XFILLER_0_11_741 VGND VGND VPWR VPWR sky130_fd_sc_hd__decap_4
XTAP_TAPCELL_ROW_7_406 VGND VPWR sky130_fd_sc_hd__tapvpwrvgnd_1
X_9193_ clknet_leaf_83_CLK _0281_ VGND VGND VPWR VPWR rf.registers\[30\]\[24\] sky130_fd_sc_hd__dfxtp_1
X_8144_ _3395_ rf.registers\[26\]\[23\] _4009_ VGND VGND VPWR VPWR _4013_ sky130_fd_sc_hd__mux2_1
XFILLER_0_11_785 VPWR VGND VPWR VGND sky130_ef_sc_hd__decap_12
XFILLER_0_10_251 VGND VGND VPWR VPWR sky130_fd_sc_hd__fill_1
X_5356_ rf.registers\[12\]\[25\] rf.registers\[13\]\[25\] rf.registers\[14\]\[25\]
+ rf.registers\[15\]\[25\] _1959_ _1960_ VGND VGND VPWR VPWR _2094_ sky130_fd_sc_hd__mux4_1
X_4307_ _1097_ _1098_ _1031_ VGND VGND VPWR VPWR _1099_ sky130_fd_sc_hd__mux2_1
X_5287_ rf.registers\[0\]\[21\] rf.registers\[1\]\[21\] rf.registers\[2\]\[21\] rf.registers\[3\]\[21\]
+ _1959_ _1960_ VGND VGND VPWR VPWR _2029_ sky130_fd_sc_hd__mux4_1
X_8075_ _3976_ VGND VGND VPWR VPWR _0439_ sky130_fd_sc_hd__clkbuf_1
X_4238_ _1025_ _1032_ VGND VGND VPWR VPWR _1033_ sky130_fd_sc_hd__nand2_1
X_7026_ rf.registers\[6\]\[10\] _3298_ _3419_ VGND VGND VPWR VPWR _3420_ sky130_fd_sc_hd__mux2_1
XFILLER_0_4_83 VGND VGND VPWR VPWR sky130_fd_sc_hd__fill_1
X_8977_ clknet_leaf_40_CLK _0065_ VGND VGND VPWR VPWR rf.registers\[3\]\[0\] sky130_fd_sc_hd__dfxtp_1
XPHY_EDGE_ROW_21_Right_21 VGND VGND VPWR VPWR sky130_fd_sc_hd__decap_3
X_7928_ _3898_ VGND VGND VPWR VPWR _0370_ sky130_fd_sc_hd__clkbuf_1
XTAP_TAPCELL_ROW_104_1867 VGND VPWR sky130_fd_sc_hd__tapvpwrvgnd_1
XTAP_TAPCELL_ROW_104_1856 VGND VPWR sky130_fd_sc_hd__tapvpwrvgnd_1
XFILLER_0_38_616 VGND VGND VPWR VPWR sky130_fd_sc_hd__fill_1
XFILLER_0_136_813 VPWR VGND VPWR VGND sky130_ef_sc_hd__decap_12
XFILLER_0_65_446 VGND VGND VPWR VPWR sky130_fd_sc_hd__fill_2
X_7859_ _3861_ VGND VGND VPWR VPWR _0338_ sky130_fd_sc_hd__clkbuf_1
XFILLER_0_19_841 VGND VGND VPWR VPWR sky130_fd_sc_hd__fill_1
XFILLER_0_37_137 VGND VGND VPWR VPWR sky130_fd_sc_hd__fill_1
XFILLER_0_93_777 VGND VGND VPWR VPWR sky130_fd_sc_hd__decap_6
XFILLER_0_65_479 VGND VGND VPWR VPWR sky130_fd_sc_hd__decap_6
XFILLER_0_34_811 VGND VGND VPWR VPWR sky130_fd_sc_hd__fill_1
XTAP_TAPCELL_ROW_137_2355 VGND VPWR sky130_fd_sc_hd__tapvpwrvgnd_1
X_9529_ clknet_leaf_46_CLK _0617_ VGND VGND VPWR VPWR rf.registers\[14\]\[8\] sky130_fd_sc_hd__dfxtp_1
XFILLER_0_61_630 VGND VGND VPWR VPWR sky130_fd_sc_hd__decap_3
XFILLER_0_34_833 VGND VGND VPWR VPWR sky130_fd_sc_hd__fill_1
XFILLER_0_21_505 VPWR VGND VPWR VGND sky130_ef_sc_hd__decap_12
XPHY_EDGE_ROW_30_Right_30 VGND VGND VPWR VPWR sky130_fd_sc_hd__decap_3
XFILLER_0_33_343 VGND VGND VPWR VPWR sky130_fd_sc_hd__fill_2
XFILLER_0_45_192 VGND VGND VPWR VPWR sky130_fd_sc_hd__decap_4
XFILLER_0_61_685 VPWR VGND VPWR VGND sky130_ef_sc_hd__decap_12
XFILLER_0_60_195 VGND VGND VPWR VPWR sky130_fd_sc_hd__fill_1
XFILLER_0_21_549 VGND VGND VPWR VPWR sky130_fd_sc_hd__decap_3
XFILLER_0_103_297 VGND VGND VPWR VPWR sky130_fd_sc_hd__fill_2
XFILLER_0_45_39 VGND VGND VPWR VPWR sky130_fd_sc_hd__decap_4
XFILLER_0_69_741 VPWR VGND VPWR VGND sky130_ef_sc_hd__decap_12
XFILLER_0_69_785 VPWR VGND VPWR VGND sky130_ef_sc_hd__decap_12
XFILLER_0_61_27 VPWR VGND VPWR VGND sky130_ef_sc_hd__decap_12
XFILLER_0_131_7 VPWR VGND VPWR VGND sky130_ef_sc_hd__decap_12
XFILLER_0_126_301 VGND VGND VPWR VPWR sky130_fd_sc_hd__decap_6
XFILLER_0_84_755 VGND VGND VPWR VPWR sky130_fd_sc_hd__fill_1
XFILLER_0_37_660 VPWR VGND VPWR VGND sky130_ef_sc_hd__decap_12
XFILLER_0_126_345 VPWR VGND VPWR VGND sky130_ef_sc_hd__decap_12
XFILLER_0_9_39 VPWR VGND VPWR VGND sky130_ef_sc_hd__decap_12
XTAP_TAPCELL_ROW_12_474 VGND VPWR sky130_fd_sc_hd__tapvpwrvgnd_1
XFILLER_0_4_749 VGND VGND VPWR VPWR sky130_fd_sc_hd__decap_6
XTAP_TAPCELL_ROW_12_485 VGND VPWR sky130_fd_sc_hd__tapvpwrvgnd_1
XFILLER_0_101_55 VGND VGND VPWR VPWR sky130_fd_sc_hd__fill_1
XTAP_TAPCELL_ROW_77_1457 VGND VPWR sky130_fd_sc_hd__tapvpwrvgnd_1
XFILLER_0_52_696 VGND VGND VPWR VPWR sky130_fd_sc_hd__decap_4
XFILLER_0_52_674 VGND VGND VPWR VPWR sky130_fd_sc_hd__decap_3
XFILLER_0_10_53 VPWR VGND VPWR VGND sky130_ef_sc_hd__decap_12
XFILLER_0_3_237 VPWR VGND VPWR VGND sky130_ef_sc_hd__decap_12
XFILLER_0_24_365 VGND VGND VPWR VPWR sky130_fd_sc_hd__fill_1
XFILLER_0_24_387 VGND VGND VPWR VPWR sky130_fd_sc_hd__fill_2
XFILLER_0_40_825 VPWR VGND VPWR VGND sky130_ef_sc_hd__decap_12
XFILLER_0_110_713 VPWR VGND VPWR VGND sky130_ef_sc_hd__decap_12
X_5210_ _1953_ _1954_ _1955_ VGND VGND VPWR VPWR _1956_ sky130_fd_sc_hd__mux2_1
XFILLER_0_10_97 VPWR VGND VPWR VGND sky130_ef_sc_hd__decap_12
XFILLER_0_110_757 VPWR VGND VPWR VGND sky130_ef_sc_hd__decap_12
X_6190_ _2862_ _2893_ _2348_ VGND VGND VPWR VPWR _2894_ sky130_fd_sc_hd__mux2_1
X_5141_ rf.registers\[16\]\[14\] rf.registers\[17\]\[14\] rf.registers\[18\]\[14\]
+ rf.registers\[19\]\[14\] _1734_ _1797_ VGND VGND VPWR VPWR _1890_ sky130_fd_sc_hd__mux4_1
XTAP_TAPCELL_ROW_90_1657 VGND VPWR sky130_fd_sc_hd__tapvpwrvgnd_1
XTAP_TAPCELL_ROW_90_1646 VGND VPWR sky130_fd_sc_hd__tapvpwrvgnd_1
X_5072_ _1728_ _1815_ _1825_ VGND VGND VPWR VPWR _1826_ sky130_fd_sc_hd__o21ai_4
X_8900_ clknet_leaf_15_CLK _1012_ VGND VGND VPWR VPWR rf.registers\[5\]\[19\] sky130_fd_sc_hd__dfxtp_1
XFILLER_0_79_505 VGND VGND VPWR VPWR sky130_fd_sc_hd__fill_1
XFILLER_0_126_41 VPWR VGND VPWR VGND sky130_ef_sc_hd__decap_12
X_8831_ clknet_leaf_28_CLK _0943_ VGND VGND VPWR VPWR rf.registers\[15\]\[14\] sky130_fd_sc_hd__dfxtp_1
XFILLER_0_126_85 VPWR VGND VPWR VGND sky130_ef_sc_hd__decap_12
XTAP_TAPCELL_ROW_121_2112 VGND VPWR sky130_fd_sc_hd__tapvpwrvgnd_1
X_8762_ clknet_leaf_55_CLK _0874_ VGND VGND VPWR VPWR rf.registers\[0\]\[9\] sky130_fd_sc_hd__dfxtp_1
X_7713_ _3784_ VGND VGND VPWR VPWR _0269_ sky130_fd_sc_hd__clkbuf_1
X_5974_ net87 _2689_ VGND VGND VPWR VPWR _2690_ sky130_fd_sc_hd__xnor2_2
XFILLER_0_136_109 VPWR VGND VPWR VGND sky130_ef_sc_hd__decap_12
XFILLER_0_129_161 VGND VGND VPWR VPWR sky130_fd_sc_hd__decap_6
X_4925_ _1618_ VGND VGND VPWR VPWR _1685_ sky130_fd_sc_hd__clkbuf_4
XFILLER_0_118_813 VPWR VGND VPWR VGND sky130_ef_sc_hd__decap_12
X_8693_ clknet_leaf_54_CLK _0805_ VGND VGND VPWR VPWR rf.registers\[24\]\[4\] sky130_fd_sc_hd__dfxtp_1
XFILLER_0_19_137 VPWR VGND VPWR VGND sky130_ef_sc_hd__decap_12
XFILLER_0_47_446 VGND VGND VPWR VPWR sky130_fd_sc_hd__fill_2
X_4856_ rf.registers\[20\]\[0\] rf.registers\[21\]\[0\] rf.registers\[22\]\[0\] rf.registers\[23\]\[0\]
+ _1617_ _1618_ VGND VGND VPWR VPWR _1619_ sky130_fd_sc_hd__mux4_1
X_7644_ _3747_ VGND VGND VPWR VPWR _0237_ sky130_fd_sc_hd__clkbuf_1
XFILLER_0_90_725 VPWR VGND VPWR VGND sky130_ef_sc_hd__decap_12
XFILLER_0_75_777 VGND VGND VPWR VPWR sky130_fd_sc_hd__decap_6
XFILLER_0_35_608 VGND VGND VPWR VPWR sky130_fd_sc_hd__decap_8
X_7575_ _3372_ rf.registers\[27\]\[12\] _3708_ VGND VGND VPWR VPWR _3711_ sky130_fd_sc_hd__mux2_1
XFILLER_0_7_565 VGND VGND VPWR VPWR sky130_fd_sc_hd__fill_1
XTAP_TAPCELL_ROW_31_761 VGND VPWR sky130_fd_sc_hd__tapvpwrvgnd_1
XTAP_TAPCELL_ROW_119_2085 VGND VPWR sky130_fd_sc_hd__tapvpwrvgnd_1
XFILLER_0_90_769 VPWR VGND VPWR VGND sky130_ef_sc_hd__decap_12
X_9314_ clknet_leaf_10_CLK _0402_ VGND VGND VPWR VPWR rf.registers\[22\]\[17\] sky130_fd_sc_hd__dfxtp_1
XFILLER_0_7_598 VGND VGND VPWR VPWR sky130_fd_sc_hd__decap_6
XTAP_TAPCELL_ROW_31_772 VGND VPWR sky130_fd_sc_hd__tapvpwrvgnd_1
X_4787_ rf.registers\[20\]\[28\] rf.registers\[21\]\[28\] rf.registers\[22\]\[28\]
+ rf.registers\[23\]\[28\] _1294_ _1295_ VGND VGND VPWR VPWR _1554_ sky130_fd_sc_hd__mux4_1
X_6526_ _3125_ VGND VGND VPWR VPWR _0765_ sky130_fd_sc_hd__clkbuf_1
XFILLER_0_42_151 VPWR VGND VPWR VGND sky130_ef_sc_hd__decap_12
XTAP_TAPCELL_ROW_132_2274 VGND VPWR sky130_fd_sc_hd__tapvpwrvgnd_1
XFILLER_0_113_573 VGND VGND VPWR VPWR sky130_fd_sc_hd__decap_3
X_9245_ clknet_leaf_25_CLK _0333_ VGND VGND VPWR VPWR rf.registers\[28\]\[12\] sky130_fd_sc_hd__dfxtp_1
Xclkload80 clknet_leaf_60_CLK VGND VGND VPWR VPWR clkload80/Y sky130_fd_sc_hd__inv_6
X_6457_ rf.registers\[11\]\[29\] _3047_ _3078_ VGND VGND VPWR VPWR _3088_ sky130_fd_sc_hd__mux2_1
XFILLER_0_42_195 VGND VGND VPWR VPWR sky130_fd_sc_hd__fill_1
XTAP_TAPCELL_ROW_132_2285 VGND VPWR sky130_fd_sc_hd__tapvpwrvgnd_1
X_9176_ clknet_leaf_53_CLK _0264_ VGND VGND VPWR VPWR rf.registers\[30\]\[7\] sky130_fd_sc_hd__dfxtp_1
X_6388_ rf.registers\[12\]\[30\] _3049_ _2986_ VGND VGND VPWR VPWR _3050_ sky130_fd_sc_hd__mux2_1
X_5408_ _2141_ _2142_ _2081_ VGND VGND VPWR VPWR _2143_ sky130_fd_sc_hd__mux2_1
X_8127_ _3378_ rf.registers\[26\]\[15\] _3998_ VGND VGND VPWR VPWR _4004_ sky130_fd_sc_hd__mux2_1
X_5339_ _2009_ VGND VGND VPWR VPWR _2078_ sky130_fd_sc_hd__clkbuf_4
XFILLER_0_100_289 VGND VGND VPWR VPWR sky130_fd_sc_hd__fill_1
X_8058_ _3967_ VGND VGND VPWR VPWR _0431_ sky130_fd_sc_hd__clkbuf_1
X_7009_ rf.registers\[6\]\[2\] _3282_ _3408_ VGND VGND VPWR VPWR _3411_ sky130_fd_sc_hd__mux2_1
XFILLER_0_98_825 VPWR VGND VPWR VGND sky130_ef_sc_hd__decap_12
XTAP_TAPCELL_ROW_48_1025 VGND VPWR sky130_fd_sc_hd__tapvpwrvgnd_1
XTAP_TAPCELL_ROW_39_883 VGND VPWR sky130_fd_sc_hd__tapvpwrvgnd_1
XTAP_TAPCELL_ROW_48_1014 VGND VPWR sky130_fd_sc_hd__tapvpwrvgnd_1
XFILLER_0_93_541 VGND VGND VPWR VPWR sky130_fd_sc_hd__fill_1
XFILLER_0_66_755 VGND VGND VPWR VPWR sky130_fd_sc_hd__fill_1
XTAP_TAPCELL_ROW_61_1214 VGND VPWR sky130_fd_sc_hd__tapvpwrvgnd_1
XFILLER_0_136_643 VGND VGND VPWR VPWR sky130_fd_sc_hd__fill_1
XFILLER_0_19_660 VGND VGND VPWR VPWR sky130_fd_sc_hd__fill_1
XFILLER_0_31_19 VPWR VGND VPWR VGND sky130_ef_sc_hd__decap_12
XFILLER_0_124_805 VGND VGND VPWR VPWR sky130_fd_sc_hd__decap_6
XFILLER_0_19_671 VGND VGND VPWR VPWR sky130_fd_sc_hd__fill_1
XFILLER_0_80_235 VPWR VGND VPWR VGND sky130_ef_sc_hd__decap_12
XFILLER_0_123_337 VPWR VGND VPWR VGND sky130_ef_sc_hd__decap_12
XFILLER_0_22_825 VPWR VGND VPWR VGND sky130_ef_sc_hd__decap_12
XFILLER_0_34_674 VGND VGND VPWR VPWR sky130_fd_sc_hd__decap_6
XTAP_TAPCELL_ROW_59_1187 VGND VPWR sky130_fd_sc_hd__tapvpwrvgnd_1
XTAP_TAPCELL_ROW_72_1387 VGND VPWR sky130_fd_sc_hd__tapvpwrvgnd_1
XTAP_TAPCELL_ROW_72_1376 VGND VPWR sky130_fd_sc_hd__tapvpwrvgnd_1
XFILLER_0_56_27 VGND VGND VPWR VPWR sky130_fd_sc_hd__fill_1
XFILLER_0_72_15 VPWR VGND VPWR VGND sky130_ef_sc_hd__decap_12
XTAP_TAPCELL_ROW_17_555 VGND VPWR sky130_fd_sc_hd__tapvpwrvgnd_1
XFILLER_0_118_109 VPWR VGND VPWR VGND sky130_ef_sc_hd__decap_12
XFILLER_0_8_307 VGND VGND VPWR VPWR sky130_fd_sc_hd__fill_1
XFILLER_0_84_563 VGND VGND VPWR VPWR sky130_fd_sc_hd__decap_4
XFILLER_0_57_777 VGND VGND VPWR VPWR sky130_fd_sc_hd__decap_6
XFILLER_0_56_265 VGND VGND VPWR VPWR sky130_fd_sc_hd__decap_8
X_4710_ _1480_ _1481_ _1298_ VGND VGND VPWR VPWR _1482_ sky130_fd_sc_hd__mux2_1
X_5690_ _2303_ _2308_ _1076_ VGND VGND VPWR VPWR _2419_ sky130_fd_sc_hd__mux2_1
XFILLER_0_29_457 VGND VGND VPWR VPWR sky130_fd_sc_hd__fill_2
XFILLER_0_126_153 VPWR VGND VPWR VGND sky130_ef_sc_hd__decap_12
XFILLER_0_122_3 VPWR VGND VPWR VGND sky130_ef_sc_hd__decap_12
X_4641_ rf.registers\[16\]\[19\] rf.registers\[17\]\[19\] rf.registers\[18\]\[19\]
+ rf.registers\[19\]\[19\] _1403_ _1404_ VGND VGND VPWR VPWR _1417_ sky130_fd_sc_hd__mux4_1
XFILLER_0_72_725 VPWR VGND VPWR VGND sky130_ef_sc_hd__decap_12
XFILLER_0_112_65 VPWR VGND VPWR VGND sky130_ef_sc_hd__decap_12
XFILLER_0_72_769 VPWR VGND VPWR VGND sky130_ef_sc_hd__decap_12
XFILLER_0_4_513 VPWR VGND VPWR VGND sky130_ef_sc_hd__decap_12
XFILLER_0_25_652 VGND VGND VPWR VPWR sky130_fd_sc_hd__decap_3
XFILLER_0_126_197 VPWR VGND VPWR VGND sky130_ef_sc_hd__decap_12
X_4572_ _1350_ _1351_ _1298_ VGND VGND VPWR VPWR _1352_ sky130_fd_sc_hd__mux2_1
X_7360_ _3596_ VGND VGND VPWR VPWR _0104_ sky130_fd_sc_hd__clkbuf_1
XFILLER_0_4_557 VPWR VGND VPWR VGND sky130_ef_sc_hd__decap_12
XFILLER_0_21_96 VGND VGND VPWR VPWR sky130_fd_sc_hd__decap_3
XFILLER_0_24_162 VGND VGND VPWR VPWR sky130_fd_sc_hd__decap_8
XFILLER_0_25_685 VPWR VGND VPWR VGND sky130_ef_sc_hd__decap_12
X_7291_ rf.registers\[3\]\[7\] _3292_ _3552_ VGND VGND VPWR VPWR _3560_ sky130_fd_sc_hd__mux2_1
X_6311_ rf.registers\[12\]\[5\] _2997_ _2987_ VGND VGND VPWR VPWR _2998_ sky130_fd_sc_hd__mux2_1
XFILLER_0_24_195 VGND VGND VPWR VPWR sky130_fd_sc_hd__fill_1
X_9030_ clknet_leaf_76_CLK _0118_ VGND VGND VPWR VPWR rf.registers\[8\]\[21\] sky130_fd_sc_hd__dfxtp_1
X_6242_ _1599_ _2942_ VGND VGND VPWR VPWR _2943_ sky130_fd_sc_hd__xnor2_1
XFILLER_0_12_357 VGND VGND VPWR VPWR sky130_fd_sc_hd__decap_6
XFILLER_0_0_763 VPWR VGND VPWR VGND sky130_ef_sc_hd__decap_12
XFILLER_0_0_785 VGND VGND VPWR VPWR sky130_fd_sc_hd__fill_2
X_6173_ _2100_ _2859_ _2877_ VGND VGND VPWR VPWR _2878_ sky130_fd_sc_hd__a21oi_1
X_5124_ rf.registers\[16\]\[13\] rf.registers\[17\]\[13\] rf.registers\[18\]\[13\]
+ rf.registers\[19\]\[13\] _1684_ _1685_ VGND VGND VPWR VPWR _1874_ sky130_fd_sc_hd__mux4_1
XFILLER_0_137_51 VGND VGND VPWR VPWR sky130_fd_sc_hd__decap_4
X_5055_ _1683_ _1801_ _1809_ VGND VGND VPWR VPWR _1810_ sky130_fd_sc_hd__o21ai_4
X_8814_ clknet_leaf_91_CLK _0926_ VGND VGND VPWR VPWR rf.registers\[16\]\[29\] sky130_fd_sc_hd__dfxtp_1
XFILLER_0_95_839 VGND VGND VPWR VPWR sky130_fd_sc_hd__fill_1
XFILLER_0_1_51 VGND VGND VPWR VPWR sky130_fd_sc_hd__decap_4
XTAP_TAPCELL_ROW_36_842 VGND VPWR sky130_fd_sc_hd__tapvpwrvgnd_1
XTAP_TAPCELL_ROW_101_1815 VGND VPWR sky130_fd_sc_hd__tapvpwrvgnd_1
X_5957_ _2673_ _2645_ _2389_ VGND VGND VPWR VPWR _2674_ sky130_fd_sc_hd__a21o_1
XFILLER_0_48_755 VGND VGND VPWR VPWR sky130_fd_sc_hd__fill_1
X_8745_ clknet_leaf_73_CLK _0857_ VGND VGND VPWR VPWR rf.registers\[10\]\[24\] sky130_fd_sc_hd__dfxtp_1
XFILLER_0_137_429 VPWR VGND VPWR VGND sky130_ef_sc_hd__decap_12
X_4908_ _1667_ _1668_ _1621_ VGND VGND VPWR VPWR _1669_ sky130_fd_sc_hd__mux2_1
X_8676_ clknet_leaf_16_CLK _0788_ VGND VGND VPWR VPWR rf.registers\[1\]\[19\] sky130_fd_sc_hd__dfxtp_1
XFILLER_0_106_805 VGND VGND VPWR VPWR sky130_fd_sc_hd__decap_6
X_7627_ _3738_ VGND VGND VPWR VPWR _0229_ sky130_fd_sc_hd__clkbuf_1
XFILLER_0_90_533 VGND VGND VPWR VPWR sky130_fd_sc_hd__decap_8
XFILLER_0_90_522 VGND VGND VPWR VPWR sky130_fd_sc_hd__fill_1
X_5888_ net111 net112 VGND VGND VPWR VPWR _2609_ sky130_fd_sc_hd__or2_1
XFILLER_0_47_276 VGND VGND VPWR VPWR sky130_fd_sc_hd__fill_1
XTAP_TAPCELL_ROW_134_2314 VGND VPWR sky130_fd_sc_hd__tapvpwrvgnd_1
XTAP_TAPCELL_ROW_134_2303 VGND VPWR sky130_fd_sc_hd__tapvpwrvgnd_1
XFILLER_0_62_235 VGND VGND VPWR VPWR sky130_fd_sc_hd__fill_1
X_4839_ rf.registers\[28\]\[31\] rf.registers\[29\]\[31\] rf.registers\[30\]\[31\]
+ rf.registers\[31\]\[31\] _1183_ _1181_ VGND VGND VPWR VPWR _1603_ sky130_fd_sc_hd__mux4_1
XFILLER_0_7_373 VPWR VGND VPWR VGND sky130_ef_sc_hd__decap_12
XFILLER_0_105_337 VGND VGND VPWR VPWR sky130_fd_sc_hd__fill_2
X_7558_ _3355_ rf.registers\[27\]\[4\] _3697_ VGND VGND VPWR VPWR _3702_ sky130_fd_sc_hd__mux2_1
X_7489_ _3665_ VGND VGND VPWR VPWR _0164_ sky130_fd_sc_hd__clkbuf_1
XFILLER_0_120_307 VGND VGND VPWR VPWR sky130_fd_sc_hd__fill_1
X_6509_ rf.registers\[17\]\[20\] _3028_ _3116_ VGND VGND VPWR VPWR _3117_ sky130_fd_sc_hd__mux2_1
XFILLER_0_43_493 VGND VGND VPWR VPWR sky130_fd_sc_hd__fill_2
XFILLER_0_132_189 VGND VGND VPWR VPWR sky130_fd_sc_hd__decap_6
X_9228_ clknet_leaf_87_CLK _0316_ VGND VGND VPWR VPWR rf.registers\[9\]\[27\] sky130_fd_sc_hd__dfxtp_1
XFILLER_0_30_176 VGND VGND VPWR VPWR sky130_fd_sc_hd__fill_1
XTAP_TAPCELL_ROW_112_1977 VGND VPWR sky130_fd_sc_hd__tapvpwrvgnd_1
X_9159_ clknet_leaf_1_CLK _0247_ VGND VGND VPWR VPWR rf.registers\[2\]\[22\] sky130_fd_sc_hd__dfxtp_1
XFILLER_0_97_110 VGND VGND VPWR VPWR sky130_fd_sc_hd__fill_2
XTAP_TAPCELL_ROW_14_503 VGND VPWR sky130_fd_sc_hd__tapvpwrvgnd_1
XFILLER_0_42_29 VPWR VGND VPWR VGND sky130_ef_sc_hd__decap_12
XTAP_TAPCELL_ROW_14_514 VGND VPWR sky130_fd_sc_hd__tapvpwrvgnd_1
XFILLER_0_93_393 VGND VGND VPWR VPWR sky130_fd_sc_hd__decap_8
XFILLER_0_93_382 VGND VGND VPWR VPWR sky130_fd_sc_hd__decap_8
XFILLER_0_54_725 VPWR VGND VPWR VGND sky130_ef_sc_hd__decap_12
XFILLER_0_54_769 VPWR VGND VPWR VGND sky130_ef_sc_hd__decap_12
XFILLER_0_108_197 VGND VGND VPWR VPWR sky130_fd_sc_hd__fill_1
XFILLER_0_123_167 VGND VGND VPWR VPWR sky130_fd_sc_hd__fill_1
XANTENNA_6 _1918_ VGND VGND VPWR VPWR sky130_fd_sc_hd__diode_2
XFILLER_0_1_505 VPWR VGND VPWR VGND sky130_ef_sc_hd__decap_12
XTAP_TAPCELL_ROW_74_1416 VGND VPWR sky130_fd_sc_hd__tapvpwrvgnd_1
XTAP_TAPCELL_ROW_74_1405 VGND VPWR sky130_fd_sc_hd__tapvpwrvgnd_1
XFILLER_0_6_29 VPWR VGND VPWR VGND sky130_ef_sc_hd__decap_12
XFILLER_0_21_198 VGND VGND VPWR VPWR sky130_fd_sc_hd__fill_1
XFILLER_0_89_633 VGND VGND VPWR VPWR sky130_fd_sc_hd__fill_2
XFILLER_0_107_43 VPWR VGND VPWR VGND sky130_ef_sc_hd__decap_12
XFILLER_0_88_110 VPWR VGND VPWR VGND sky130_ef_sc_hd__decap_12
XFILLER_0_16_41 VPWR VGND VPWR VGND sky130_ef_sc_hd__decap_12
XFILLER_0_77_839 VGND VGND VPWR VPWR sky130_fd_sc_hd__fill_1
X_6860_ rf.registers\[16\]\[16\] _3311_ _3299_ VGND VGND VPWR VPWR _3312_ sky130_fd_sc_hd__mux2_1
XFILLER_0_16_85 VPWR VGND VPWR VGND sky130_ef_sc_hd__decap_12
XTAP_TAPCELL_ROW_85_1578 VGND VPWR sky130_fd_sc_hd__tapvpwrvgnd_1
X_6791_ _3267_ VGND VGND VPWR VPWR _0888_ sky130_fd_sc_hd__clkbuf_1
X_5811_ _1778_ _2533_ VGND VGND VPWR VPWR _2536_ sky130_fd_sc_hd__nor2_1
XTAP_TAPCELL_ROW_33_801 VGND VPWR sky130_fd_sc_hd__tapvpwrvgnd_1
XFILLER_0_123_53 VGND VGND VPWR VPWR sky130_fd_sc_hd__decap_3
X_8530_ _3014_ rf.registers\[13\]\[13\] _4216_ VGND VGND VPWR VPWR _4217_ sky130_fd_sc_hd__mux2_1
X_5742_ _2235_ _2240_ _2250_ _2254_ VGND VGND VPWR VPWR _2469_ sky130_fd_sc_hd__a22o_1
XFILLER_0_9_638 VGND VGND VPWR VPWR sky130_fd_sc_hd__fill_2
XFILLER_0_17_405 VGND VGND VPWR VPWR sky130_fd_sc_hd__decap_8
XFILLER_0_57_596 VGND VGND VPWR VPWR sky130_fd_sc_hd__fill_1
XFILLER_0_32_73 VGND VGND VPWR VPWR sky130_fd_sc_hd__fill_2
XFILLER_0_44_213 VGND VGND VPWR VPWR sky130_fd_sc_hd__fill_1
XFILLER_0_45_747 VPWR VGND VPWR VGND sky130_ef_sc_hd__decap_12
X_8461_ _3012_ rf.registers\[14\]\[12\] _4178_ VGND VGND VPWR VPWR _4181_ sky130_fd_sc_hd__mux2_1
XFILLER_0_72_533 VGND VGND VPWR VPWR sky130_fd_sc_hd__decap_4
XFILLER_0_5_833 VGND VGND VPWR VPWR sky130_fd_sc_hd__decap_6
XFILLER_0_17_449 VPWR VGND VPWR VGND sky130_ef_sc_hd__decap_12
X_5673_ _2256_ _2258_ VGND VGND VPWR VPWR _2402_ sky130_fd_sc_hd__nand2_1
XTAP_TAPCELL_ROW_116_2044 VGND VPWR sky130_fd_sc_hd__tapvpwrvgnd_1
XTAP_TAPCELL_ROW_116_2033 VGND VPWR sky130_fd_sc_hd__tapvpwrvgnd_1
X_8392_ _4144_ VGND VGND VPWR VPWR _0588_ sky130_fd_sc_hd__clkbuf_1
X_4624_ _1399_ _1400_ _1397_ VGND VGND VPWR VPWR _1401_ sky130_fd_sc_hd__mux2_1
X_7412_ _2966_ _3623_ VGND VGND VPWR VPWR _3624_ sky130_fd_sc_hd__nand2_4
XPHY_EDGE_ROW_6_Right_6 VGND VGND VPWR VPWR sky130_fd_sc_hd__decap_3
XFILLER_0_4_321 VPWR VGND VPWR VGND sky130_ef_sc_hd__decap_12
X_4555_ rf.registers\[8\]\[14\] rf.registers\[9\]\[14\] rf.registers\[10\]\[14\] rf.registers\[11\]\[14\]
+ _1302_ _1303_ VGND VGND VPWR VPWR _1336_ sky130_fd_sc_hd__mux4_1
X_7343_ _2985_ _3053_ VGND VGND VPWR VPWR _3587_ sky130_fd_sc_hd__nor2_2
XFILLER_0_12_121 VPWR VGND VPWR VGND sky130_ef_sc_hd__decap_12
XFILLER_0_4_365 VPWR VGND VPWR VGND sky130_ef_sc_hd__decap_12
XFILLER_0_13_633 VPWR VGND VPWR VGND sky130_ef_sc_hd__decap_12
XFILLER_0_114_189 VGND VGND VPWR VPWR sky130_fd_sc_hd__decap_6
X_4486_ rf.registers\[28\]\[11\] rf.registers\[29\]\[11\] rf.registers\[30\]\[11\]
+ rf.registers\[31\]\[11\] _1138_ _1121_ VGND VGND VPWR VPWR _1270_ sky130_fd_sc_hd__mux4_1
XFILLER_0_111_841 VGND VGND VPWR VPWR sky130_fd_sc_hd__fill_1
X_9013_ clknet_leaf_49_CLK _0101_ VGND VGND VPWR VPWR rf.registers\[8\]\[4\] sky130_fd_sc_hd__dfxtp_1
X_7274_ _3550_ VGND VGND VPWR VPWR _0064_ sky130_fd_sc_hd__clkbuf_1
XFILLER_0_12_165 VPWR VGND VPWR VGND sky130_ef_sc_hd__decap_12
X_6225_ _1158_ _2319_ _2665_ VGND VGND VPWR VPWR _2927_ sky130_fd_sc_hd__or3b_1
XFILLER_0_110_395 VGND VGND VPWR VPWR sky130_fd_sc_hd__fill_1
X_6156_ _2491_ _2494_ VGND VGND VPWR VPWR _2862_ sky130_fd_sc_hd__nor2_1
X_5107_ rf.registers\[16\]\[12\] rf.registers\[17\]\[12\] rf.registers\[18\]\[12\]
+ rf.registers\[19\]\[12\] _1694_ _1695_ VGND VGND VPWR VPWR _1858_ sky130_fd_sc_hd__mux4_1
X_6087_ _2463_ _2794_ _2796_ _2326_ VGND VGND VPWR VPWR _2797_ sky130_fd_sc_hd__o211a_1
X_5038_ _1683_ _1785_ _1789_ _1793_ VGND VGND VPWR VPWR _1794_ sky130_fd_sc_hd__a2bb2o_2
XTAP_TAPCELL_ROW_0_286 VGND VPWR sky130_fd_sc_hd__tapvpwrvgnd_1
XTAP_TAPCELL_ROW_0_297 VGND VPWR sky130_fd_sc_hd__tapvpwrvgnd_1
XFILLER_0_137_237 VPWR VGND VPWR VGND sky130_ef_sc_hd__decap_12
XFILLER_0_83_809 VPWR VGND VPWR VGND sky130_ef_sc_hd__decap_12
X_8728_ clknet_leaf_51_CLK _0840_ VGND VGND VPWR VPWR rf.registers\[10\]\[7\] sky130_fd_sc_hd__dfxtp_1
X_6989_ _3399_ VGND VGND VPWR VPWR _0954_ sky130_fd_sc_hd__clkbuf_1
XFILLER_0_35_202 VGND VGND VPWR VPWR sky130_fd_sc_hd__fill_1
X_8659_ clknet_leaf_41_CLK _0771_ VGND VGND VPWR VPWR rf.registers\[1\]\[2\] sky130_fd_sc_hd__dfxtp_1
XFILLER_0_63_555 VGND VGND VPWR VPWR sky130_fd_sc_hd__decap_4
XFILLER_0_7_181 VPWR VGND VPWR VGND sky130_ef_sc_hd__decap_12
XFILLER_0_50_238 VGND VGND VPWR VPWR sky130_fd_sc_hd__decap_8
XFILLER_0_121_638 VGND VGND VPWR VPWR sky130_fd_sc_hd__decap_8
XTAP_TAPCELL_ROW_56_1146 VGND VPWR sky130_fd_sc_hd__tapvpwrvgnd_1
XTAP_TAPCELL_ROW_56_1135 VGND VPWR sky130_fd_sc_hd__tapvpwrvgnd_1
Xoutput76 net76 VGND VGND VPWR VPWR RD1[5] sky130_fd_sc_hd__buf_1
Xoutput65 net65 VGND VGND VPWR VPWR RD1[24] sky130_fd_sc_hd__buf_1
Xoutput54 net54 VGND VGND VPWR VPWR RD1[14] sky130_fd_sc_hd__buf_1
Xoutput87 net87 VGND VGND VPWR VPWR RD2[15] sky130_fd_sc_hd__buf_1
Xoutput98 net98 VGND VGND VPWR VPWR RD2[25] sky130_fd_sc_hd__buf_1
XFILLER_0_98_474 VGND VGND VPWR VPWR sky130_fd_sc_hd__fill_2
XFILLER_0_59_839 VGND VGND VPWR VPWR sky130_fd_sc_hd__fill_1
XFILLER_0_53_39 VGND VGND VPWR VPWR sky130_fd_sc_hd__decap_4
XFILLER_0_98_496 VGND VGND VPWR VPWR sky130_fd_sc_hd__fill_1
XFILLER_0_85_113 VGND VGND VPWR VPWR sky130_fd_sc_hd__decap_3
XFILLER_0_129_727 VGND VGND VPWR VPWR sky130_fd_sc_hd__fill_1
XFILLER_0_85_146 VGND VGND VPWR VPWR sky130_fd_sc_hd__decap_4
XTAP_TAPCELL_ROW_80_1497 VGND VPWR sky130_fd_sc_hd__tapvpwrvgnd_1
XPHY_EDGE_ROW_59_Right_59 VGND VGND VPWR VPWR sky130_fd_sc_hd__decap_3
XFILLER_0_54_544 VGND VGND VPWR VPWR sky130_fd_sc_hd__decap_3
XFILLER_0_14_419 VGND VGND VPWR VPWR sky130_fd_sc_hd__fill_1
XFILLER_0_2_825 VPWR VGND VPWR VGND sky130_ef_sc_hd__decap_12
X_4340_ rf.registers\[16\]\[4\] rf.registers\[17\]\[4\] rf.registers\[18\]\[4\] rf.registers\[19\]\[4\]
+ _1126_ _1129_ VGND VGND VPWR VPWR _1131_ sky130_fd_sc_hd__mux4_1
XFILLER_0_78_69 VPWR VGND VPWR VGND sky130_ef_sc_hd__decap_12
XFILLER_0_1_335 VGND VGND VPWR VPWR sky130_fd_sc_hd__fill_1
X_4271_ _1061_ _1064_ VGND VGND VPWR VPWR _1065_ sky130_fd_sc_hd__nand2_1
X_6010_ _2358_ _2387_ VGND VGND VPWR VPWR _2724_ sky130_fd_sc_hd__nor2_1
XPHY_EDGE_ROW_68_Right_68 VGND VGND VPWR VPWR sky130_fd_sc_hd__decap_3
XFILLER_0_118_53 VPWR VGND VPWR VGND sky130_ef_sc_hd__decap_12
XTAP_TAPCELL_ROW_87_1607 VGND VPWR sky130_fd_sc_hd__tapvpwrvgnd_1
X_7961_ _3916_ VGND VGND VPWR VPWR _0385_ sky130_fd_sc_hd__clkbuf_1
XFILLER_0_118_97 VPWR VGND VPWR VGND sky130_ef_sc_hd__decap_12
X_7892_ _3344_ rf.registers\[23\]\[0\] _3879_ VGND VGND VPWR VPWR _3880_ sky130_fd_sc_hd__mux2_1
X_6912_ _3344_ rf.registers\[15\]\[0\] _3347_ VGND VGND VPWR VPWR _3348_ sky130_fd_sc_hd__mux2_1
XFILLER_0_89_474 VPWR VGND VPWR VGND sky130_ef_sc_hd__decap_12
XFILLER_0_134_41 VPWR VGND VPWR VGND sky130_ef_sc_hd__decap_12
X_6843_ _3300_ VGND VGND VPWR VPWR _0907_ sky130_fd_sc_hd__clkbuf_1
XFILLER_0_76_113 VPWR VGND VPWR VGND sky130_ef_sc_hd__decap_12
XFILLER_0_134_85 VPWR VGND VPWR VGND sky130_ef_sc_hd__decap_12
XFILLER_0_76_168 VGND VGND VPWR VPWR sky130_fd_sc_hd__fill_1
XFILLER_0_65_809 VPWR VGND VPWR VGND sky130_ef_sc_hd__decap_12
XTAP_TAPCELL_ROW_46_992 VGND VPWR sky130_fd_sc_hd__tapvpwrvgnd_1
XFILLER_0_119_237 VPWR VGND VPWR VGND sky130_ef_sc_hd__decap_12
X_9562_ clknet_leaf_33_CLK _0650_ VGND VGND VPWR VPWR rf.registers\[13\]\[9\] sky130_fd_sc_hd__dfxtp_1
X_6774_ _3258_ VGND VGND VPWR VPWR _0880_ sky130_fd_sc_hd__clkbuf_1
XFILLER_0_91_105 VGND VGND VPWR VPWR sky130_fd_sc_hd__decap_4
XPHY_EDGE_ROW_77_Right_77 VGND VGND VPWR VPWR sky130_fd_sc_hd__decap_3
X_9493_ clknet_leaf_47_CLK _0581_ VGND VGND VPWR VPWR rf.registers\[18\]\[4\] sky130_fd_sc_hd__dfxtp_1
X_8513_ _2997_ rf.registers\[13\]\[5\] _4205_ VGND VGND VPWR VPWR _4208_ sky130_fd_sc_hd__mux2_1
XFILLER_0_18_769 VPWR VGND VPWR VGND sky130_ef_sc_hd__decap_12
X_5725_ _2304_ _2452_ VGND VGND VPWR VPWR _2453_ sky130_fd_sc_hd__nor2_1
XFILLER_0_128_793 VPWR VGND VPWR VGND sky130_ef_sc_hd__decap_12
XFILLER_0_127_281 VPWR VGND VPWR VGND sky130_ef_sc_hd__decap_12
XFILLER_0_115_421 VGND VGND VPWR VPWR sky130_fd_sc_hd__decap_8
XFILLER_0_94_3 VPWR VGND VPWR VGND sky130_ef_sc_hd__decap_12
X_8444_ _2995_ rf.registers\[14\]\[4\] _4167_ VGND VGND VPWR VPWR _4172_ sky130_fd_sc_hd__mux2_1
XFILLER_0_72_374 VGND VGND VPWR VPWR sky130_fd_sc_hd__fill_2
XFILLER_0_5_641 VPWR VGND VPWR VGND sky130_ef_sc_hd__decap_12
X_5656_ _1115_ VGND VGND VPWR VPWR _2386_ sky130_fd_sc_hd__buf_2
XTAP_TAPCELL_ROW_98_1769 VGND VPWR sky130_fd_sc_hd__tapvpwrvgnd_1
X_4607_ rf.registers\[12\]\[17\] rf.registers\[13\]\[17\] rf.registers\[14\]\[17\]
+ rf.registers\[15\]\[17\] _1283_ _1284_ VGND VGND VPWR VPWR _1385_ sky130_fd_sc_hd__mux4_1
XFILLER_0_130_413 VGND VGND VPWR VPWR sky130_fd_sc_hd__decap_6
X_8375_ _4135_ VGND VGND VPWR VPWR _0580_ sky130_fd_sc_hd__clkbuf_1
XFILLER_0_103_638 VGND VGND VPWR VPWR sky130_fd_sc_hd__fill_1
XFILLER_0_5_685 VGND VGND VPWR VPWR sky130_fd_sc_hd__fill_1
XFILLER_0_13_441 VGND VGND VPWR VPWR sky130_fd_sc_hd__decap_6
X_5587_ _2317_ VGND VGND VPWR VPWR _2318_ sky130_fd_sc_hd__buf_2
XFILLER_0_25_290 VGND VGND VPWR VPWR sky130_fd_sc_hd__decap_4
X_7326_ _3578_ VGND VGND VPWR VPWR _0088_ sky130_fd_sc_hd__clkbuf_1
XFILLER_0_4_195 VGND VGND VPWR VPWR sky130_fd_sc_hd__fill_1
XFILLER_0_13_485 VPWR VGND VPWR VGND sky130_ef_sc_hd__decap_12
X_4538_ _1183_ VGND VGND VPWR VPWR _1320_ sky130_fd_sc_hd__buf_4
X_4469_ _1252_ _1253_ _1143_ VGND VGND VPWR VPWR _1254_ sky130_fd_sc_hd__mux2_1
X_7257_ rf.registers\[19\]\[23\] _3326_ _3538_ VGND VGND VPWR VPWR _3542_ sky130_fd_sc_hd__mux2_1
XPHY_EDGE_ROW_86_Right_86 VGND VGND VPWR VPWR sky130_fd_sc_hd__decap_3
X_6208_ _2876_ _2888_ _2889_ _2910_ VGND VGND VPWR VPWR _2911_ sky130_fd_sc_hd__or4_1
XTAP_TAPCELL_ROW_129_2235 VGND VPWR sky130_fd_sc_hd__tapvpwrvgnd_1
X_7188_ _3505_ VGND VGND VPWR VPWR _0023_ sky130_fd_sc_hd__clkbuf_1
XTAP_TAPCELL_ROW_51_1065 VGND VPWR sky130_fd_sc_hd__tapvpwrvgnd_1
XTAP_TAPCELL_ROW_5_378 VGND VPWR sky130_fd_sc_hd__tapvpwrvgnd_1
X_6139_ _2743_ _2770_ _2812_ _2845_ VGND VGND VPWR VPWR _2846_ sky130_fd_sc_hd__or4bb_1
XFILLER_0_67_113 VGND VGND VPWR VPWR sky130_fd_sc_hd__decap_6
XTAP_TAPCELL_ROW_107_1898 VGND VPWR sky130_fd_sc_hd__tapvpwrvgnd_1
XPHY_EDGE_ROW_95_Right_95 VGND VGND VPWR VPWR sky130_fd_sc_hd__decap_3
XFILLER_0_68_669 VPWR VGND VPWR VGND sky130_ef_sc_hd__decap_12
XFILLER_0_138_557 VGND VGND VPWR VPWR sky130_fd_sc_hd__decap_3
XTAP_TAPCELL_ROW_24_653 VGND VPWR sky130_fd_sc_hd__tapvpwrvgnd_1
XTAP_TAPCELL_ROW_24_664 VGND VPWR sky130_fd_sc_hd__tapvpwrvgnd_1
XFILLER_0_36_533 VGND VGND VPWR VPWR sky130_fd_sc_hd__decap_6
XFILLER_0_133_273 VGND VGND VPWR VPWR sky130_fd_sc_hd__decap_6
XPHY_EDGE_ROW_2_Left_141 VGND VGND VPWR VPWR sky130_fd_sc_hd__decap_3
XFILLER_0_31_260 VPWR VGND VPWR VGND sky130_ef_sc_hd__decap_12
XPHY_EDGE_ROW_39_Left_178 VGND VGND VPWR VPWR sky130_fd_sc_hd__decap_3
XFILLER_0_64_27 VGND VGND VPWR VPWR sky130_fd_sc_hd__fill_1
XTAP_TAPCELL_ROW_69_1337 VGND VPWR sky130_fd_sc_hd__tapvpwrvgnd_1
XFILLER_0_99_783 VGND VGND VPWR VPWR sky130_fd_sc_hd__fill_1
XPHY_EDGE_ROW_48_Left_187 VGND VGND VPWR VPWR sky130_fd_sc_hd__decap_3
XFILLER_0_86_444 VGND VGND VPWR VPWR sky130_fd_sc_hd__decap_4
XTAP_TAPCELL_ROW_82_1537 VGND VPWR sky130_fd_sc_hd__tapvpwrvgnd_1
XTAP_TAPCELL_ROW_82_1526 VGND VPWR sky130_fd_sc_hd__tapvpwrvgnd_1
XFILLER_0_80_15 VPWR VGND VPWR VGND sky130_ef_sc_hd__decap_12
XFILLER_0_59_669 VGND VGND VPWR VPWR sky130_fd_sc_hd__decap_3
XFILLER_0_47_809 VPWR VGND VPWR VGND sky130_ef_sc_hd__decap_12
XFILLER_0_27_511 VPWR VGND VPWR VGND sky130_ef_sc_hd__decap_12
XTAP_TAPCELL_ROW_43_940 VGND VPWR sky130_fd_sc_hd__tapvpwrvgnd_1
XTAP_TAPCELL_ROW_43_951 VGND VPWR sky130_fd_sc_hd__tapvpwrvgnd_1
XFILLER_0_104_77 VGND VGND VPWR VPWR sky130_fd_sc_hd__decap_6
XFILLER_0_66_190 VGND VGND VPWR VPWR sky130_fd_sc_hd__fill_2
XFILLER_0_125_741 VPWR VGND VPWR VGND sky130_ef_sc_hd__decap_12
X_5510_ _2212_ VGND VGND VPWR VPWR _2241_ sky130_fd_sc_hd__buf_2
XFILLER_0_124_251 VGND VGND VPWR VPWR sky130_fd_sc_hd__fill_1
X_6490_ rf.registers\[17\]\[11\] _3010_ _3105_ VGND VGND VPWR VPWR _3107_ sky130_fd_sc_hd__mux2_1
XFILLER_0_89_57 VGND VGND VPWR VPWR sky130_fd_sc_hd__decap_6
XFILLER_0_54_374 VGND VGND VPWR VPWR sky130_fd_sc_hd__decap_6
XFILLER_0_125_785 VPWR VGND VPWR VGND sky130_ef_sc_hd__decap_12
XFILLER_0_120_65 VPWR VGND VPWR VGND sky130_ef_sc_hd__decap_12
XPHY_EDGE_ROW_57_Left_196 VGND VGND VPWR VPWR sky130_fd_sc_hd__decap_3
X_5441_ _2081_ _2173_ _1948_ VGND VGND VPWR VPWR _2174_ sky130_fd_sc_hd__a21o_1
X_8160_ _2980_ rf.registers\[26\]\[31\] _3986_ VGND VGND VPWR VPWR _4021_ sky130_fd_sc_hd__mux2_1
XFILLER_0_23_783 VGND VGND VPWR VPWR sky130_fd_sc_hd__fill_1
X_5372_ _2008_ VGND VGND VPWR VPWR _2109_ sky130_fd_sc_hd__buf_4
XFILLER_0_100_619 VGND VGND VPWR VPWR sky130_fd_sc_hd__fill_1
X_7111_ _3464_ VGND VGND VPWR VPWR _1011_ sky130_fd_sc_hd__clkbuf_1
X_8091_ _3984_ VGND VGND VPWR VPWR _0447_ sky130_fd_sc_hd__clkbuf_1
XFILLER_0_10_433 VPWR VGND VPWR VGND sky130_ef_sc_hd__decap_12
XFILLER_0_2_699 VGND VGND VPWR VPWR sky130_fd_sc_hd__fill_1
X_4323_ _1114_ VGND VGND VPWR VPWR _1115_ sky130_fd_sc_hd__clkbuf_4
XTAP_TAPCELL_ROW_93_1699 VGND VPWR sky130_fd_sc_hd__tapvpwrvgnd_1
XTAP_TAPCELL_ROW_93_1688 VGND VPWR sky130_fd_sc_hd__tapvpwrvgnd_1
X_7042_ rf.registers\[6\]\[18\] _3315_ _3419_ VGND VGND VPWR VPWR _3428_ sky130_fd_sc_hd__mux2_1
XFILLER_0_10_477 VPWR VGND VPWR VGND sky130_ef_sc_hd__decap_12
X_4254_ rf.registers\[4\]\[0\] rf.registers\[5\]\[0\] rf.registers\[6\]\[0\] rf.registers\[7\]\[0\]
+ _1026_ _1027_ VGND VGND VPWR VPWR _1049_ sky130_fd_sc_hd__mux4_1
XFILLER_0_97_709 VPWR VGND VPWR VGND sky130_ef_sc_hd__decap_12
X_8993_ clknet_leaf_14_CLK _0081_ VGND VGND VPWR VPWR rf.registers\[3\]\[16\] sky130_fd_sc_hd__dfxtp_1
XTAP_TAPCELL_ROW_2_337 VGND VPWR sky130_fd_sc_hd__tapvpwrvgnd_1
XTAP_TAPCELL_ROW_2_326 VGND VPWR sky130_fd_sc_hd__tapvpwrvgnd_1
XTAP_TAPCELL_ROW_124_2154 VGND VPWR sky130_fd_sc_hd__tapvpwrvgnd_1
X_7944_ _2963_ rf.registers\[23\]\[25\] _3901_ VGND VGND VPWR VPWR _3907_ sky130_fd_sc_hd__mux2_1
XTAP_TAPCELL_ROW_124_2165 VGND VPWR sky130_fd_sc_hd__tapvpwrvgnd_1
X_7875_ _2963_ rf.registers\[28\]\[25\] _3864_ VGND VGND VPWR VPWR _3870_ sky130_fd_sc_hd__mux2_1
X_6826_ rf.registers\[16\]\[5\] _3288_ _3278_ VGND VGND VPWR VPWR _3289_ sky130_fd_sc_hd__mux2_1
XFILLER_0_65_617 VPWR VGND VPWR VGND sky130_ef_sc_hd__decap_12
XFILLER_0_135_505 VPWR VGND VPWR VGND sky130_ef_sc_hd__decap_12
X_6757_ _3249_ VGND VGND VPWR VPWR _0872_ sky130_fd_sc_hd__clkbuf_1
XFILLER_0_18_533 VPWR VGND VPWR VGND sky130_ef_sc_hd__decap_12
XTAP_TAPCELL_ROW_21_612 VGND VPWR sky130_fd_sc_hd__tapvpwrvgnd_1
X_9545_ clknet_leaf_73_CLK _0633_ VGND VGND VPWR VPWR rf.registers\[14\]\[24\] sky130_fd_sc_hd__dfxtp_1
XFILLER_0_135_549 VGND VGND VPWR VPWR sky130_fd_sc_hd__fill_2
XFILLER_0_18_577 VGND VGND VPWR VPWR sky130_fd_sc_hd__fill_1
X_5708_ _2433_ _2435_ VGND VGND VPWR VPWR _2436_ sky130_fd_sc_hd__xnor2_1
X_9476_ clknet_leaf_21_CLK _0564_ VGND VGND VPWR VPWR rf.registers\[20\]\[19\] sky130_fd_sc_hd__dfxtp_1
X_6688_ rf.registers\[10\]\[7\] _3001_ _3205_ VGND VGND VPWR VPWR _3213_ sky130_fd_sc_hd__mux2_1
XFILLER_0_73_694 VPWR VGND VPWR VGND sky130_ef_sc_hd__decap_12
XFILLER_0_60_322 VGND VGND VPWR VPWR sky130_fd_sc_hd__fill_1
XFILLER_0_60_300 VGND VGND VPWR VPWR sky130_fd_sc_hd__decap_4
X_8427_ _4162_ VGND VGND VPWR VPWR _0605_ sky130_fd_sc_hd__clkbuf_1
X_5639_ _2241_ _2309_ _2368_ VGND VGND VPWR VPWR _2369_ sky130_fd_sc_hd__o21ai_1
XFILLER_0_130_221 VPWR VGND VPWR VGND sky130_ef_sc_hd__decap_12
XFILLER_0_103_435 VPWR VGND VPWR VGND sky130_ef_sc_hd__decap_12
XFILLER_0_60_388 VGND VGND VPWR VPWR sky130_fd_sc_hd__decap_3
X_8358_ rf.registers\[20\]\[28\] net34 _4117_ VGND VGND VPWR VPWR _4126_ sky130_fd_sc_hd__mux2_1
XFILLER_0_131_777 VGND VGND VPWR VPWR sky130_fd_sc_hd__decap_6
XFILLER_0_130_265 VPWR VGND VPWR VGND sky130_ef_sc_hd__decap_12
X_7309_ _3569_ VGND VGND VPWR VPWR _0080_ sky130_fd_sc_hd__clkbuf_1
XFILLER_0_13_293 VPWR VGND VPWR VGND sky130_ef_sc_hd__decap_12
X_8289_ _4089_ VGND VGND VPWR VPWR _0540_ sky130_fd_sc_hd__clkbuf_1
XTAP_TAPCELL_ROW_109_1938 VGND VPWR sky130_fd_sc_hd__tapvpwrvgnd_1
XTAP_TAPCELL_ROW_29_734 VGND VPWR sky130_fd_sc_hd__tapvpwrvgnd_1
XFILLER_0_68_400 VGND VGND VPWR VPWR sky130_fd_sc_hd__decap_8
XFILLER_0_68_433 VGND VGND VPWR VPWR sky130_fd_sc_hd__decap_8
XFILLER_0_29_809 VPWR VGND VPWR VGND sky130_ef_sc_hd__decap_12
XFILLER_0_68_477 VGND VGND VPWR VPWR sky130_fd_sc_hd__fill_1
XTAP_TAPCELL_ROW_64_1267 VGND VPWR sky130_fd_sc_hd__tapvpwrvgnd_1
XTAP_TAPCELL_ROW_64_1256 VGND VPWR sky130_fd_sc_hd__tapvpwrvgnd_1
XFILLER_0_138_365 VGND VGND VPWR VPWR sky130_fd_sc_hd__fill_1
XFILLER_0_83_447 VGND VGND VPWR VPWR sky130_fd_sc_hd__fill_1
XFILLER_0_50_29 VPWR VGND VPWR VGND sky130_ef_sc_hd__decap_12
XFILLER_0_107_741 VPWR VGND VPWR VGND sky130_ef_sc_hd__decap_12
XFILLER_0_107_785 VPWR VGND VPWR VGND sky130_ef_sc_hd__decap_12
XFILLER_0_122_755 VGND VGND VPWR VPWR sky130_fd_sc_hd__fill_1
XFILLER_0_20_720 VPWR VGND VPWR VGND sky130_ef_sc_hd__decap_12
XFILLER_0_20_742 VPWR VGND VPWR VGND sky130_ef_sc_hd__decap_12
XFILLER_0_20_797 VPWR VGND VPWR VGND sky130_ef_sc_hd__decap_12
XFILLER_0_79_709 VPWR VGND VPWR VGND sky130_ef_sc_hd__decap_12
XFILLER_0_115_21 VPWR VGND VPWR VGND sky130_ef_sc_hd__decap_12
X_5990_ _2215_ _2690_ _2675_ _1902_ VGND VGND VPWR VPWR _2705_ sky130_fd_sc_hd__a211o_1
X_4941_ rf.registers\[12\]\[3\] rf.registers\[13\]\[3\] rf.registers\[14\]\[3\] rf.registers\[15\]\[3\]
+ _1699_ _1700_ VGND VGND VPWR VPWR _1701_ sky130_fd_sc_hd__mux4_1
XFILLER_0_87_753 VPWR VGND VPWR VGND sky130_ef_sc_hd__decap_12
XFILLER_0_24_41 VPWR VGND VPWR VGND sky130_ef_sc_hd__decap_12
X_4872_ _1621_ VGND VGND VPWR VPWR _1635_ sky130_fd_sc_hd__clkbuf_4
XFILLER_0_87_797 VPWR VGND VPWR VGND sky130_ef_sc_hd__decap_12
X_7660_ rf.registers\[2\]\[20\] _3319_ _3755_ VGND VGND VPWR VPWR _3756_ sky130_fd_sc_hd__mux2_1
X_6611_ rf.registers\[24\]\[3\] _2993_ _3168_ VGND VGND VPWR VPWR _3172_ sky130_fd_sc_hd__mux2_1
XFILLER_0_7_725 VGND VGND VPWR VPWR sky130_fd_sc_hd__decap_3
XFILLER_0_46_138 VGND VGND VPWR VPWR sky130_fd_sc_hd__fill_2
XFILLER_0_131_31 VPWR VGND VPWR VGND sky130_ef_sc_hd__decap_12
X_9330_ clknet_leaf_45_CLK _0418_ VGND VGND VPWR VPWR rf.registers\[7\]\[1\] sky130_fd_sc_hd__dfxtp_1
XFILLER_0_15_503 VGND VGND VPWR VPWR sky130_fd_sc_hd__fill_1
X_7591_ _3696_ VGND VGND VPWR VPWR _3719_ sky130_fd_sc_hd__buf_4
X_6542_ rf.registers\[1\]\[3\] _2993_ _3131_ VGND VGND VPWR VPWR _3135_ sky130_fd_sc_hd__mux2_1
XPHY_EDGE_ROW_65_Left_204 VGND VGND VPWR VPWR sky130_fd_sc_hd__decap_3
Xclkbuf_leaf_92_CLK clknet_3_0__leaf_CLK VGND VGND VPWR VPWR clknet_leaf_92_CLK sky130_fd_sc_hd__clkbuf_8
X_6473_ rf.registers\[17\]\[3\] _2993_ _3094_ VGND VGND VPWR VPWR _3098_ sky130_fd_sc_hd__mux2_1
XFILLER_0_113_700 VPWR VGND VPWR VGND sky130_ef_sc_hd__decap_12
XTAP_TAPCELL_ROW_95_1728 VGND VPWR sky130_fd_sc_hd__tapvpwrvgnd_1
XFILLER_0_54_193 VGND VGND VPWR VPWR sky130_fd_sc_hd__decap_3
X_9261_ clknet_leaf_93_CLK _0349_ VGND VGND VPWR VPWR rf.registers\[28\]\[28\] sky130_fd_sc_hd__dfxtp_1
X_9192_ clknet_leaf_3_CLK _0280_ VGND VGND VPWR VPWR rf.registers\[30\]\[23\] sky130_fd_sc_hd__dfxtp_1
X_5424_ rf.registers\[12\]\[29\] rf.registers\[13\]\[29\] rf.registers\[14\]\[29\]
+ rf.registers\[15\]\[29\] _2077_ _2078_ VGND VGND VPWR VPWR _2158_ sky130_fd_sc_hd__mux4_1
X_8212_ _3395_ rf.registers\[21\]\[23\] _4045_ VGND VGND VPWR VPWR _4049_ sky130_fd_sc_hd__mux2_1
XFILLER_0_113_777 VGND VGND VPWR VPWR sky130_fd_sc_hd__decap_6
XFILLER_0_11_720 VGND VGND VPWR VPWR sky130_fd_sc_hd__decap_8
X_8143_ _4012_ VGND VGND VPWR VPWR _0471_ sky130_fd_sc_hd__clkbuf_1
XFILLER_0_57_3 VPWR VGND VPWR VGND sky130_ef_sc_hd__decap_12
XTAP_TAPCELL_ROW_7_407 VGND VPWR sky130_fd_sc_hd__tapvpwrvgnd_1
X_5355_ _1955_ _2092_ VGND VGND VPWR VPWR _2093_ sky130_fd_sc_hd__and2_1
X_4306_ rf.registers\[16\]\[3\] rf.registers\[17\]\[3\] rf.registers\[18\]\[3\] rf.registers\[19\]\[3\]
+ _1077_ _1078_ VGND VGND VPWR VPWR _1098_ sky130_fd_sc_hd__mux4_1
X_8074_ rf.registers\[7\]\[22\] _3324_ _3973_ VGND VGND VPWR VPWR _3976_ sky130_fd_sc_hd__mux2_1
X_5286_ rf.registers\[4\]\[21\] rf.registers\[5\]\[21\] rf.registers\[6\]\[21\] rf.registers\[7\]\[21\]
+ _1959_ _1960_ VGND VGND VPWR VPWR _2028_ sky130_fd_sc_hd__mux4_1
XFILLER_0_11_797 VPWR VGND VPWR VGND sky130_ef_sc_hd__decap_12
X_4237_ _1028_ _1029_ _1031_ VGND VGND VPWR VPWR _1032_ sky130_fd_sc_hd__mux2_1
X_7025_ _3407_ VGND VGND VPWR VPWR _3419_ sky130_fd_sc_hd__buf_4
XPHY_EDGE_ROW_74_Left_213 VGND VGND VPWR VPWR sky130_fd_sc_hd__decap_3
X_8976_ clknet_leaf_62_CLK _0064_ VGND VGND VPWR VPWR rf.registers\[19\]\[31\] sky130_fd_sc_hd__dfxtp_1
X_7927_ _3382_ rf.registers\[23\]\[17\] _3890_ VGND VGND VPWR VPWR _3898_ sky130_fd_sc_hd__mux2_1
XTAP_TAPCELL_ROW_104_1857 VGND VPWR sky130_fd_sc_hd__tapvpwrvgnd_1
XFILLER_0_92_200 VGND VGND VPWR VPWR sky130_fd_sc_hd__fill_1
X_7858_ _3382_ rf.registers\[28\]\[17\] _3853_ VGND VGND VPWR VPWR _3861_ sky130_fd_sc_hd__mux2_1
XFILLER_0_38_606 VGND VGND VPWR VPWR sky130_fd_sc_hd__fill_1
XFILLER_0_136_825 VPWR VGND VPWR VGND sky130_ef_sc_hd__decap_12
X_6809_ _2985_ _3092_ VGND VGND VPWR VPWR _3277_ sky130_fd_sc_hd__nor2_4
XFILLER_0_135_335 VGND VGND VPWR VPWR sky130_fd_sc_hd__fill_1
XPHY_EDGE_ROW_83_Left_222 VGND VGND VPWR VPWR sky130_fd_sc_hd__decap_3
X_7789_ _3824_ VGND VGND VPWR VPWR _0305_ sky130_fd_sc_hd__clkbuf_1
XFILLER_0_53_609 VGND VGND VPWR VPWR sky130_fd_sc_hd__decap_6
XFILLER_0_46_661 VGND VGND VPWR VPWR sky130_fd_sc_hd__decap_6
XTAP_TAPCELL_ROW_137_2356 VGND VPWR sky130_fd_sc_hd__tapvpwrvgnd_1
X_9528_ clknet_leaf_52_CLK _0616_ VGND VGND VPWR VPWR rf.registers\[14\]\[7\] sky130_fd_sc_hd__dfxtp_1
XFILLER_0_18_374 VPWR VGND VPWR VGND sky130_ef_sc_hd__decap_12
Xclkbuf_leaf_83_CLK clknet_3_2__leaf_CLK VGND VGND VPWR VPWR clknet_leaf_83_CLK sky130_fd_sc_hd__clkbuf_8
X_9459_ clknet_leaf_43_CLK _0547_ VGND VGND VPWR VPWR rf.registers\[20\]\[2\] sky130_fd_sc_hd__dfxtp_1
XFILLER_0_104_755 VGND VGND VPWR VPWR sky130_fd_sc_hd__fill_1
XFILLER_0_61_697 VPWR VGND VPWR VGND sky130_ef_sc_hd__decap_12
XFILLER_0_21_517 VPWR VGND VPWR VGND sky130_ef_sc_hd__decap_12
XPHY_EDGE_ROW_92_Left_231 VGND VGND VPWR VPWR sky130_fd_sc_hd__decap_3
XFILLER_0_69_753 VPWR VGND VPWR VGND sky130_ef_sc_hd__decap_12
XFILLER_0_68_230 VPWR VGND VPWR VGND sky130_ef_sc_hd__decap_12
XFILLER_0_96_583 VGND VGND VPWR VPWR sky130_fd_sc_hd__fill_1
XFILLER_0_84_701 VPWR VGND VPWR VGND sky130_ef_sc_hd__decap_12
XFILLER_0_69_797 VPWR VGND VPWR VGND sky130_ef_sc_hd__decap_12
XFILLER_0_61_39 VGND VGND VPWR VPWR sky130_fd_sc_hd__fill_1
XFILLER_0_29_617 VPWR VGND VPWR VGND sky130_ef_sc_hd__decap_12
XFILLER_0_138_151 VPWR VGND VPWR VGND sky130_ef_sc_hd__decap_12
XFILLER_0_83_211 VGND VGND VPWR VPWR sky130_fd_sc_hd__fill_1
XFILLER_0_83_255 VGND VGND VPWR VPWR sky130_fd_sc_hd__fill_1
XFILLER_0_126_357 VGND VGND VPWR VPWR sky130_fd_sc_hd__decap_6
Xclkbuf_leaf_74_CLK clknet_3_3__leaf_CLK VGND VGND VPWR VPWR clknet_leaf_74_CLK sky130_fd_sc_hd__clkbuf_8
XFILLER_0_52_642 VGND VGND VPWR VPWR sky130_fd_sc_hd__fill_2
XTAP_TAPCELL_ROW_12_475 VGND VPWR sky130_fd_sc_hd__tapvpwrvgnd_1
XFILLER_0_3_205 VPWR VGND VPWR VGND sky130_ef_sc_hd__decap_12
XTAP_TAPCELL_ROW_12_486 VGND VPWR sky130_fd_sc_hd__tapvpwrvgnd_1
XFILLER_0_122_530 VGND VGND VPWR VPWR sky130_fd_sc_hd__fill_2
XFILLER_0_3_249 VPWR VGND VPWR VGND sky130_ef_sc_hd__decap_12
XFILLER_0_40_837 VGND VGND VPWR VPWR sky130_fd_sc_hd__fill_2
XTAP_TAPCELL_ROW_77_1458 VGND VPWR sky130_fd_sc_hd__tapvpwrvgnd_1
XFILLER_0_10_65 VPWR VGND VPWR VGND sky130_ef_sc_hd__decap_12
XFILLER_0_110_725 VPWR VGND VPWR VGND sky130_ef_sc_hd__decap_12
XFILLER_0_110_769 VPWR VGND VPWR VGND sky130_ef_sc_hd__decap_12
X_5140_ rf.registers\[20\]\[14\] rf.registers\[21\]\[14\] rf.registers\[22\]\[14\]
+ rf.registers\[23\]\[14\] _1795_ _1736_ VGND VGND VPWR VPWR _1889_ sky130_fd_sc_hd__mux4_1
XTAP_TAPCELL_ROW_90_1647 VGND VPWR sky130_fd_sc_hd__tapvpwrvgnd_1
X_5071_ _1819_ _1821_ _1824_ _1764_ _1709_ VGND VGND VPWR VPWR _1825_ sky130_fd_sc_hd__a221o_1
XFILLER_0_126_53 VPWR VGND VPWR VGND sky130_ef_sc_hd__decap_12
X_8830_ clknet_leaf_29_CLK _0942_ VGND VGND VPWR VPWR rf.registers\[15\]\[13\] sky130_fd_sc_hd__dfxtp_1
XFILLER_0_126_97 VPWR VGND VPWR VGND sky130_ef_sc_hd__decap_12
XTAP_TAPCELL_ROW_121_2113 VGND VPWR sky130_fd_sc_hd__tapvpwrvgnd_1
X_8761_ clknet_leaf_46_CLK _0873_ VGND VGND VPWR VPWR rf.registers\[0\]\[8\] sky130_fd_sc_hd__dfxtp_1
X_5973_ _1344_ _2673_ _2645_ _2389_ VGND VGND VPWR VPWR _2689_ sky130_fd_sc_hd__a31o_1
X_4924_ _1617_ VGND VGND VPWR VPWR _1684_ sky130_fd_sc_hd__buf_4
X_7712_ _3372_ rf.registers\[30\]\[12\] _3781_ VGND VGND VPWR VPWR _3784_ sky130_fd_sc_hd__mux2_1
XFILLER_0_87_561 VGND VGND VPWR VPWR sky130_fd_sc_hd__fill_1
XFILLER_0_19_105 VGND VGND VPWR VPWR sky130_fd_sc_hd__decap_6
XFILLER_0_47_414 VGND VGND VPWR VPWR sky130_fd_sc_hd__decap_8
X_8692_ clknet_leaf_38_CLK _0804_ VGND VGND VPWR VPWR rf.registers\[24\]\[3\] sky130_fd_sc_hd__dfxtp_1
XFILLER_0_118_825 VPWR VGND VPWR VGND sky130_ef_sc_hd__decap_12
X_4855_ net2 VGND VGND VPWR VPWR _1618_ sky130_fd_sc_hd__clkbuf_4
X_7643_ rf.registers\[2\]\[12\] _3303_ _3744_ VGND VGND VPWR VPWR _3747_ sky130_fd_sc_hd__mux2_1
XFILLER_0_19_149 VGND VGND VPWR VPWR sky130_fd_sc_hd__fill_2
X_7574_ _3710_ VGND VGND VPWR VPWR _0204_ sky130_fd_sc_hd__clkbuf_1
XFILLER_0_90_737 VPWR VGND VPWR VGND sky130_ef_sc_hd__decap_12
Xclkbuf_leaf_65_CLK clknet_3_6__leaf_CLK VGND VGND VPWR VPWR clknet_leaf_65_CLK sky130_fd_sc_hd__clkbuf_8
XTAP_TAPCELL_ROW_31_762 VGND VPWR sky130_fd_sc_hd__tapvpwrvgnd_1
X_4786_ _1307_ _1545_ _1553_ VGND VGND VPWR VPWR net100 sky130_fd_sc_hd__a21o_2
XFILLER_0_133_839 VGND VGND VPWR VPWR sky130_fd_sc_hd__fill_1
XTAP_TAPCELL_ROW_119_2086 VGND VPWR sky130_fd_sc_hd__tapvpwrvgnd_1
X_9313_ clknet_leaf_20_CLK _0401_ VGND VGND VPWR VPWR rf.registers\[22\]\[16\] sky130_fd_sc_hd__dfxtp_1
X_6525_ rf.registers\[17\]\[28\] _3045_ _3116_ VGND VGND VPWR VPWR _3125_ sky130_fd_sc_hd__mux2_1
X_9244_ clknet_leaf_26_CLK _0332_ VGND VGND VPWR VPWR rf.registers\[28\]\[11\] sky130_fd_sc_hd__dfxtp_1
XFILLER_0_42_141 VGND VGND VPWR VPWR sky130_fd_sc_hd__decap_6
XFILLER_0_42_163 VGND VGND VPWR VPWR sky130_fd_sc_hd__fill_1
Xclkload70 clknet_leaf_34_CLK VGND VGND VPWR VPWR clkload70/Y sky130_fd_sc_hd__bufinv_16
XFILLER_0_70_494 VGND VGND VPWR VPWR sky130_fd_sc_hd__decap_8
X_6456_ _3087_ VGND VGND VPWR VPWR _0733_ sky130_fd_sc_hd__clkbuf_1
XTAP_TAPCELL_ROW_132_2286 VGND VPWR sky130_fd_sc_hd__tapvpwrvgnd_1
XTAP_TAPCELL_ROW_132_2275 VGND VPWR sky130_fd_sc_hd__tapvpwrvgnd_1
XFILLER_0_100_213 VGND VGND VPWR VPWR sky130_fd_sc_hd__fill_1
X_9175_ clknet_leaf_31_CLK _0263_ VGND VGND VPWR VPWR rf.registers\[30\]\[6\] sky130_fd_sc_hd__dfxtp_1
Xclkload81 clknet_leaf_64_CLK VGND VGND VPWR VPWR clkload81/Y sky130_fd_sc_hd__clkinv_4
XFILLER_0_11_561 VPWR VGND VPWR VGND sky130_ef_sc_hd__decap_12
XFILLER_0_3_783 VGND VGND VPWR VPWR sky130_fd_sc_hd__fill_1
X_5407_ rf.registers\[8\]\[28\] rf.registers\[9\]\[28\] rf.registers\[10\]\[28\] rf.registers\[11\]\[28\]
+ _2070_ _2071_ VGND VGND VPWR VPWR _2142_ sky130_fd_sc_hd__mux4_1
XFILLER_0_30_369 VGND VGND VPWR VPWR sky130_fd_sc_hd__decap_8
X_6387_ net37 VGND VGND VPWR VPWR _3049_ sky130_fd_sc_hd__buf_2
X_8126_ _4003_ VGND VGND VPWR VPWR _0463_ sky130_fd_sc_hd__clkbuf_1
X_5338_ _2008_ VGND VGND VPWR VPWR _2077_ sky130_fd_sc_hd__buf_4
X_8057_ rf.registers\[7\]\[14\] _3307_ _3962_ VGND VGND VPWR VPWR _3967_ sky130_fd_sc_hd__mux2_1
X_7008_ _3410_ VGND VGND VPWR VPWR _0962_ sky130_fd_sc_hd__clkbuf_1
X_5269_ rf.registers\[8\]\[20\] rf.registers\[9\]\[20\] rf.registers\[10\]\[20\] rf.registers\[11\]\[20\]
+ _1922_ _1923_ VGND VGND VPWR VPWR _2012_ sky130_fd_sc_hd__mux4_1
XFILLER_0_98_837 VGND VGND VPWR VPWR sky130_fd_sc_hd__fill_2
XTAP_TAPCELL_ROW_48_1026 VGND VPWR sky130_fd_sc_hd__tapvpwrvgnd_1
XTAP_TAPCELL_ROW_39_884 VGND VPWR sky130_fd_sc_hd__tapvpwrvgnd_1
XTAP_TAPCELL_ROW_48_1015 VGND VPWR sky130_fd_sc_hd__tapvpwrvgnd_1
X_8959_ clknet_leaf_28_CLK _0047_ VGND VGND VPWR VPWR rf.registers\[19\]\[14\] sky130_fd_sc_hd__dfxtp_1
XFILLER_0_66_701 VPWR VGND VPWR VGND sky130_ef_sc_hd__decap_12
XTAP_TAPCELL_ROW_61_1215 VGND VPWR sky130_fd_sc_hd__tapvpwrvgnd_1
Xclkbuf_leaf_56_CLK clknet_3_6__leaf_CLK VGND VGND VPWR VPWR clknet_leaf_56_CLK sky130_fd_sc_hd__clkbuf_8
XFILLER_0_136_699 VGND VGND VPWR VPWR sky130_fd_sc_hd__fill_1
XFILLER_0_123_305 VPWR VGND VPWR VGND sky130_ef_sc_hd__decap_12
XFILLER_0_80_247 VGND VGND VPWR VPWR sky130_fd_sc_hd__decap_4
XFILLER_0_123_349 VPWR VGND VPWR VGND sky130_ef_sc_hd__decap_12
XFILLER_0_22_837 VGND VGND VPWR VPWR sky130_fd_sc_hd__fill_2
XFILLER_0_131_393 VPWR VGND VPWR VGND sky130_ef_sc_hd__decap_12
XTAP_TAPCELL_ROW_59_1188 VGND VPWR sky130_fd_sc_hd__tapvpwrvgnd_1
XTAP_TAPCELL_ROW_72_1377 VGND VPWR sky130_fd_sc_hd__tapvpwrvgnd_1
XFILLER_0_72_27 VGND VGND VPWR VPWR sky130_fd_sc_hd__fill_1
XFILLER_0_69_561 VGND VGND VPWR VPWR sky130_fd_sc_hd__fill_1
XFILLER_0_9_809 VPWR VGND VPWR VGND sky130_ef_sc_hd__decap_12
XFILLER_0_56_211 VGND VGND VPWR VPWR sky130_fd_sc_hd__fill_1
XTAP_TAPCELL_ROW_17_556 VGND VPWR sky130_fd_sc_hd__tapvpwrvgnd_1
XFILLER_0_29_447 VGND VGND VPWR VPWR sky130_fd_sc_hd__fill_1
XFILLER_0_126_121 VPWR VGND VPWR VGND sky130_ef_sc_hd__decap_12
Xclkbuf_leaf_47_CLK clknet_3_7__leaf_CLK VGND VGND VPWR VPWR clknet_leaf_47_CLK sky130_fd_sc_hd__clkbuf_8
XFILLER_0_84_586 VGND VGND VPWR VPWR sky130_fd_sc_hd__fill_2
X_4640_ rf.registers\[20\]\[19\] rf.registers\[21\]\[19\] rf.registers\[22\]\[19\]
+ rf.registers\[23\]\[19\] _1403_ _1404_ VGND VGND VPWR VPWR _1416_ sky130_fd_sc_hd__mux4_1
XFILLER_0_72_737 VPWR VGND VPWR VGND sky130_ef_sc_hd__decap_12
XFILLER_0_126_165 VPWR VGND VPWR VGND sky130_ef_sc_hd__decap_12
XFILLER_0_115_839 VGND VGND VPWR VPWR sky130_fd_sc_hd__fill_1
XFILLER_0_112_77 VGND VGND VPWR VPWR sky130_fd_sc_hd__decap_6
XFILLER_0_4_525 VGND VGND VPWR VPWR sky130_fd_sc_hd__decap_6
XFILLER_0_107_390 VGND VGND VPWR VPWR sky130_fd_sc_hd__fill_2
X_4571_ rf.registers\[8\]\[15\] rf.registers\[9\]\[15\] rf.registers\[10\]\[15\] rf.registers\[11\]\[15\]
+ _1302_ _1303_ VGND VGND VPWR VPWR _1351_ sky130_fd_sc_hd__mux4_1
XFILLER_0_80_781 VPWR VGND VPWR VGND sky130_ef_sc_hd__decap_12
X_6310_ net41 VGND VGND VPWR VPWR _2997_ sky130_fd_sc_hd__buf_2
X_7290_ _3559_ VGND VGND VPWR VPWR _0071_ sky130_fd_sc_hd__clkbuf_1
XFILLER_0_4_569 VPWR VGND VPWR VGND sky130_ef_sc_hd__decap_12
XFILLER_0_13_837 VGND VGND VPWR VPWR sky130_fd_sc_hd__decap_3
XFILLER_0_25_697 VGND VGND VPWR VPWR sky130_fd_sc_hd__decap_8
XFILLER_0_40_645 VGND VGND VPWR VPWR sky130_fd_sc_hd__decap_3
XFILLER_0_97_57 VGND VGND VPWR VPWR sky130_fd_sc_hd__fill_1
X_6241_ _2709_ _2941_ VGND VGND VPWR VPWR _2942_ sky130_fd_sc_hd__nor2_1
X_6172_ _2084_ _2852_ _2859_ _2100_ VGND VGND VPWR VPWR _2877_ sky130_fd_sc_hd__o22a_1
X_5123_ rf.registers\[20\]\[13\] rf.registers\[21\]\[13\] rf.registers\[22\]\[13\]
+ rf.registers\[23\]\[13\] _1703_ _1704_ VGND VGND VPWR VPWR _1873_ sky130_fd_sc_hd__mux4_1
XFILLER_0_0_775 VGND VGND VPWR VPWR sky130_fd_sc_hd__decap_8
X_5054_ _1803_ _1805_ _1808_ _1651_ _1709_ VGND VGND VPWR VPWR _1809_ sky130_fd_sc_hd__a221o_1
XFILLER_0_46_83 VGND VGND VPWR VPWR sky130_fd_sc_hd__fill_1
X_8813_ clknet_leaf_0_CLK _0925_ VGND VGND VPWR VPWR rf.registers\[16\]\[28\] sky130_fd_sc_hd__dfxtp_1
XFILLER_0_94_306 VGND VGND VPWR VPWR sky130_fd_sc_hd__fill_2
XFILLER_0_48_712 VPWR VGND VPWR VGND sky130_ef_sc_hd__decap_12
XFILLER_0_48_701 VGND VGND VPWR VPWR sky130_fd_sc_hd__decap_8
XTAP_TAPCELL_ROW_36_843 VGND VPWR sky130_fd_sc_hd__tapvpwrvgnd_1
XTAP_TAPCELL_ROW_101_1816 VGND VPWR sky130_fd_sc_hd__tapvpwrvgnd_1
X_5956_ net84 net85 VGND VGND VPWR VPWR _2673_ sky130_fd_sc_hd__nor2_1
XFILLER_0_87_391 VGND VGND VPWR VPWR sky130_fd_sc_hd__fill_1
X_8744_ clknet_leaf_8_CLK _0856_ VGND VGND VPWR VPWR rf.registers\[10\]\[23\] sky130_fd_sc_hd__dfxtp_1
XFILLER_0_47_211 VPWR VGND VPWR VGND sky130_ef_sc_hd__decap_12
X_4907_ rf.registers\[16\]\[2\] rf.registers\[17\]\[2\] rf.registers\[18\]\[2\] rf.registers\[19\]\[2\]
+ _1624_ _1625_ VGND VGND VPWR VPWR _1668_ sky130_fd_sc_hd__mux4_1
X_8675_ clknet_leaf_7_CLK _0787_ VGND VGND VPWR VPWR rf.registers\[1\]\[18\] sky130_fd_sc_hd__dfxtp_1
X_5887_ _2407_ _2571_ _2606_ _2560_ _2607_ VGND VGND VPWR VPWR _2608_ sky130_fd_sc_hd__o221ai_1
Xclkbuf_leaf_38_CLK clknet_3_5__leaf_CLK VGND VGND VPWR VPWR clknet_leaf_38_CLK sky130_fd_sc_hd__clkbuf_8
XFILLER_0_118_655 VGND VGND VPWR VPWR sky130_fd_sc_hd__fill_1
X_7626_ rf.registers\[2\]\[4\] _3286_ _3733_ VGND VGND VPWR VPWR _3738_ sky130_fd_sc_hd__mux2_1
XFILLER_0_90_501 VGND VGND VPWR VPWR sky130_fd_sc_hd__decap_4
X_4838_ _1600_ _1601_ _1163_ VGND VGND VPWR VPWR _1602_ sky130_fd_sc_hd__mux2_1
XTAP_TAPCELL_ROW_134_2315 VGND VPWR sky130_fd_sc_hd__tapvpwrvgnd_1
XTAP_TAPCELL_ROW_134_2304 VGND VPWR sky130_fd_sc_hd__tapvpwrvgnd_1
X_7557_ _3701_ VGND VGND VPWR VPWR _0196_ sky130_fd_sc_hd__clkbuf_1
XFILLER_0_121_809 VPWR VGND VPWR VGND sky130_ef_sc_hd__decap_12
XFILLER_0_62_269 VGND VGND VPWR VPWR sky130_fd_sc_hd__fill_1
XFILLER_0_7_385 VGND VGND VPWR VPWR sky130_fd_sc_hd__decap_6
X_4769_ _1203_ _1529_ _1533_ _1537_ VGND VGND VPWR VPWR _1538_ sky130_fd_sc_hd__a22o_1
X_7488_ _3353_ rf.registers\[31\]\[3\] _3661_ VGND VGND VPWR VPWR _3665_ sky130_fd_sc_hd__mux2_1
XFILLER_0_31_645 VPWR VGND VPWR VGND sky130_ef_sc_hd__decap_12
X_6508_ _3093_ VGND VGND VPWR VPWR _3116_ sky130_fd_sc_hd__buf_4
X_6439_ rf.registers\[11\]\[20\] _3028_ _3078_ VGND VGND VPWR VPWR _3079_ sky130_fd_sc_hd__mux2_1
X_9227_ clknet_leaf_69_CLK _0315_ VGND VGND VPWR VPWR rf.registers\[9\]\[26\] sky130_fd_sc_hd__dfxtp_1
XFILLER_0_31_678 VPWR VGND VPWR VGND sky130_ef_sc_hd__decap_12
X_9158_ clknet_leaf_79_CLK _0246_ VGND VGND VPWR VPWR rf.registers\[2\]\[21\] sky130_fd_sc_hd__dfxtp_1
XTAP_TAPCELL_ROW_112_1978 VGND VPWR sky130_fd_sc_hd__tapvpwrvgnd_1
X_8109_ _3994_ VGND VGND VPWR VPWR _0455_ sky130_fd_sc_hd__clkbuf_1
XFILLER_0_11_391 VGND VGND VPWR VPWR sky130_fd_sc_hd__fill_1
X_9089_ clknet_leaf_19_CLK _0177_ VGND VGND VPWR VPWR rf.registers\[31\]\[16\] sky130_fd_sc_hd__dfxtp_1
XFILLER_0_98_645 VGND VGND VPWR VPWR sky130_fd_sc_hd__decap_4
XFILLER_0_97_122 VGND VGND VPWR VPWR sky130_fd_sc_hd__decap_4
XFILLER_0_128_419 VGND VGND VPWR VPWR sky130_fd_sc_hd__fill_1
XTAP_TAPCELL_ROW_14_504 VGND VPWR sky130_fd_sc_hd__tapvpwrvgnd_1
XFILLER_0_109_633 VGND VGND VPWR VPWR sky130_fd_sc_hd__decap_6
XFILLER_0_93_350 VGND VGND VPWR VPWR sky130_fd_sc_hd__decap_6
XTAP_TAPCELL_ROW_14_515 VGND VPWR sky130_fd_sc_hd__tapvpwrvgnd_1
XFILLER_0_54_737 VPWR VGND VPWR VGND sky130_ef_sc_hd__decap_12
XFILLER_0_26_417 VGND VGND VPWR VPWR sky130_fd_sc_hd__decap_3
Xclkbuf_leaf_29_CLK clknet_3_4__leaf_CLK VGND VGND VPWR VPWR clknet_leaf_29_CLK sky130_fd_sc_hd__clkbuf_8
XFILLER_0_123_113 VPWR VGND VPWR VGND sky130_ef_sc_hd__decap_12
XFILLER_0_22_601 VPWR VGND VPWR VGND sky130_ef_sc_hd__decap_12
XANTENNA_7 _4205_ VGND VGND VPWR VPWR sky130_fd_sc_hd__diode_2
XFILLER_0_62_781 VPWR VGND VPWR VGND sky130_ef_sc_hd__decap_12
XFILLER_0_1_517 VPWR VGND VPWR VGND sky130_ef_sc_hd__decap_12
XPHY_EDGE_ROW_20_Left_159 VGND VGND VPWR VPWR sky130_fd_sc_hd__decap_3
XFILLER_0_21_111 VGND VGND VPWR VPWR sky130_fd_sc_hd__fill_1
XFILLER_0_22_645 VGND VGND VPWR VPWR sky130_fd_sc_hd__decap_8
XFILLER_0_34_472 VGND VGND VPWR VPWR sky130_fd_sc_hd__fill_1
XTAP_TAPCELL_ROW_74_1417 VGND VPWR sky130_fd_sc_hd__tapvpwrvgnd_1
XTAP_TAPCELL_ROW_74_1406 VGND VPWR sky130_fd_sc_hd__tapvpwrvgnd_1
XFILLER_0_83_15 VGND VGND VPWR VPWR sky130_fd_sc_hd__decap_3
XFILLER_0_107_55 VGND VGND VPWR VPWR sky130_fd_sc_hd__fill_1
XFILLER_0_88_122 VGND VGND VPWR VPWR sky130_fd_sc_hd__fill_2
XFILLER_0_16_53 VPWR VGND VPWR VGND sky130_ef_sc_hd__decap_12
XFILLER_0_107_77 VGND VGND VPWR VPWR sky130_fd_sc_hd__fill_1
XTAP_TAPCELL_ROW_85_1579 VGND VPWR sky130_fd_sc_hd__tapvpwrvgnd_1
XTAP_TAPCELL_ROW_85_1568 VGND VPWR sky130_fd_sc_hd__tapvpwrvgnd_1
X_6790_ rf.registers\[0\]\[23\] _3035_ _3263_ VGND VGND VPWR VPWR _3267_ sky130_fd_sc_hd__mux2_1
X_5810_ _2534_ VGND VGND VPWR VPWR _2535_ sky130_fd_sc_hd__inv_2
XFILLER_0_16_97 VPWR VGND VPWR VGND sky130_ef_sc_hd__decap_12
XFILLER_0_29_222 VGND VGND VPWR VPWR sky130_fd_sc_hd__fill_2
XTAP_TAPCELL_ROW_33_802 VGND VPWR sky130_fd_sc_hd__tapvpwrvgnd_1
XFILLER_0_123_21 VPWR VGND VPWR VGND sky130_ef_sc_hd__decap_12
X_5741_ _2305_ _2223_ _2237_ VGND VGND VPWR VPWR _2468_ sky130_fd_sc_hd__mux2_1
X_8460_ _4180_ VGND VGND VPWR VPWR _0620_ sky130_fd_sc_hd__clkbuf_1
XFILLER_0_84_361 VGND VGND VPWR VPWR sky130_fd_sc_hd__decap_3
XFILLER_0_32_41 VPWR VGND VPWR VGND sky130_ef_sc_hd__decap_12
XFILLER_0_45_737 VGND VGND VPWR VPWR sky130_fd_sc_hd__fill_2
XFILLER_0_115_614 VGND VGND VPWR VPWR sky130_fd_sc_hd__fill_2
X_7411_ net13 net12 net11 VGND VGND VPWR VPWR _3623_ sky130_fd_sc_hd__and3_4
X_5672_ _2241_ _2400_ VGND VGND VPWR VPWR _2401_ sky130_fd_sc_hd__nand2_1
XFILLER_0_45_759 VPWR VGND VPWR VGND sky130_ef_sc_hd__decap_12
XTAP_TAPCELL_ROW_116_2034 VGND VPWR sky130_fd_sc_hd__tapvpwrvgnd_1
X_8391_ rf.registers\[18\]\[11\] net16 _4142_ VGND VGND VPWR VPWR _4144_ sky130_fd_sc_hd__mux2_1
X_4623_ rf.registers\[24\]\[18\] rf.registers\[25\]\[18\] rf.registers\[26\]\[18\]
+ rf.registers\[27\]\[18\] _1393_ _1394_ VGND VGND VPWR VPWR _1400_ sky130_fd_sc_hd__mux4_1
XFILLER_0_4_333 VPWR VGND VPWR VGND sky130_ef_sc_hd__decap_12
XFILLER_0_13_601 VGND VGND VPWR VPWR sky130_fd_sc_hd__decap_4
XTAP_TAPCELL_ROW_116_2045 VGND VPWR sky130_fd_sc_hd__tapvpwrvgnd_1
XFILLER_0_103_809 VPWR VGND VPWR VGND sky130_ef_sc_hd__decap_12
X_4554_ _1331_ _1332_ _1333_ _1334_ _1134_ _1156_ VGND VGND VPWR VPWR _1335_ sky130_fd_sc_hd__mux4_1
X_7342_ _3586_ VGND VGND VPWR VPWR _0096_ sky130_fd_sc_hd__clkbuf_1
X_7273_ rf.registers\[19\]\[31\] _3342_ _3515_ VGND VGND VPWR VPWR _3550_ sky130_fd_sc_hd__mux2_1
XFILLER_0_12_133 VGND VGND VPWR VPWR sky130_fd_sc_hd__decap_6
XFILLER_0_4_377 VPWR VGND VPWR VGND sky130_ef_sc_hd__decap_12
X_9012_ clknet_leaf_35_CLK _0100_ VGND VGND VPWR VPWR rf.registers\[8\]\[3\] sky130_fd_sc_hd__dfxtp_1
X_4485_ rf.registers\[16\]\[11\] rf.registers\[17\]\[11\] rf.registers\[18\]\[11\]
+ rf.registers\[19\]\[11\] _1138_ _1121_ VGND VGND VPWR VPWR _1269_ sky130_fd_sc_hd__mux4_1
XFILLER_0_12_177 VPWR VGND VPWR VGND sky130_ef_sc_hd__decap_12
X_6224_ _2384_ _2898_ _2925_ _2326_ VGND VGND VPWR VPWR _2926_ sky130_fd_sc_hd__o211a_1
XFILLER_0_40_497 VGND VGND VPWR VPWR sky130_fd_sc_hd__fill_1
XFILLER_0_0_561 VGND VGND VPWR VPWR sky130_fd_sc_hd__decap_8
X_6155_ _2857_ _2860_ VGND VGND VPWR VPWR _2861_ sky130_fd_sc_hd__xnor2_1
X_5106_ rf.registers\[20\]\[12\] rf.registers\[21\]\[12\] rf.registers\[22\]\[12\]
+ rf.registers\[23\]\[12\] _1694_ _1695_ VGND VGND VPWR VPWR _1857_ sky130_fd_sc_hd__mux4_1
X_6086_ _2266_ _2499_ _2663_ _2716_ _2795_ VGND VGND VPWR VPWR _2796_ sky130_fd_sc_hd__o221a_1
X_5037_ _1660_ _1792_ _1709_ VGND VGND VPWR VPWR _1793_ sky130_fd_sc_hd__a21oi_1
XFILLER_0_95_615 VGND VGND VPWR VPWR sky130_fd_sc_hd__fill_1
XFILLER_0_79_166 VGND VGND VPWR VPWR sky130_fd_sc_hd__fill_2
XTAP_TAPCELL_ROW_0_287 VGND VPWR sky130_fd_sc_hd__tapvpwrvgnd_1
XFILLER_0_137_205 VPWR VGND VPWR VGND sky130_ef_sc_hd__decap_12
X_8727_ clknet_leaf_59_CLK _0839_ VGND VGND VPWR VPWR rf.registers\[10\]\[6\] sky130_fd_sc_hd__dfxtp_1
XFILLER_0_48_553 VGND VGND VPWR VPWR sky130_fd_sc_hd__decap_6
XTAP_TAPCELL_ROW_0_298 VGND VPWR sky130_fd_sc_hd__tapvpwrvgnd_1
X_6988_ _2963_ rf.registers\[15\]\[25\] _3389_ VGND VGND VPWR VPWR _3399_ sky130_fd_sc_hd__mux2_1
XFILLER_0_137_249 VPWR VGND VPWR VGND sky130_ef_sc_hd__decap_12
XFILLER_0_118_430 VGND VGND VPWR VPWR sky130_fd_sc_hd__fill_1
XFILLER_0_91_821 VPWR VGND VPWR VGND sky130_ef_sc_hd__decap_12
X_5939_ _2641_ _2644_ _2399_ _2657_ VGND VGND VPWR VPWR net116 sky130_fd_sc_hd__o2bb2a_1
XFILLER_0_36_715 VGND VGND VPWR VPWR sky130_fd_sc_hd__decap_4
XFILLER_0_118_474 VGND VGND VPWR VPWR sky130_fd_sc_hd__fill_2
X_8658_ clknet_leaf_46_CLK _0770_ VGND VGND VPWR VPWR rf.registers\[1\]\[1\] sky130_fd_sc_hd__dfxtp_1
XFILLER_0_8_661 VGND VGND VPWR VPWR sky130_fd_sc_hd__decap_3
XFILLER_0_105_113 VGND VGND VPWR VPWR sky130_fd_sc_hd__fill_2
XFILLER_0_51_729 VPWR VGND VPWR VGND sky130_ef_sc_hd__decap_12
XFILLER_0_7_193 VPWR VGND VPWR VGND sky130_ef_sc_hd__decap_12
X_8589_ clknet_leaf_92_CLK _0701_ VGND VGND VPWR VPWR rf.registers\[12\]\[28\] sky130_fd_sc_hd__dfxtp_1
X_7609_ _3728_ VGND VGND VPWR VPWR _0221_ sky130_fd_sc_hd__clkbuf_1
XFILLER_0_44_770 VPWR VGND VPWR VGND sky130_ef_sc_hd__decap_12
XFILLER_0_114_691 VGND VGND VPWR VPWR sky130_fd_sc_hd__decap_8
XFILLER_0_31_442 VGND VGND VPWR VPWR sky130_fd_sc_hd__decap_6
XFILLER_0_101_330 VGND VGND VPWR VPWR sky130_fd_sc_hd__decap_6
XTAP_TAPCELL_ROW_56_1147 VGND VPWR sky130_fd_sc_hd__tapvpwrvgnd_1
XTAP_TAPCELL_ROW_56_1136 VGND VPWR sky130_fd_sc_hd__tapvpwrvgnd_1
XFILLER_0_31_486 VGND VGND VPWR VPWR sky130_fd_sc_hd__fill_2
XFILLER_0_9_3 VPWR VGND VPWR VGND sky130_ef_sc_hd__decap_12
Xoutput66 net66 VGND VGND VPWR VPWR RD1[25] sky130_fd_sc_hd__buf_1
Xoutput55 net55 VGND VGND VPWR VPWR RD1[15] sky130_fd_sc_hd__buf_1
Xoutput88 net88 VGND VGND VPWR VPWR RD2[16] sky130_fd_sc_hd__buf_1
Xoutput99 net99 VGND VGND VPWR VPWR RD2[26] sky130_fd_sc_hd__buf_1
Xoutput77 net77 VGND VGND VPWR VPWR RD1[6] sky130_fd_sc_hd__buf_1
XTAP_TAPCELL_ROW_67_1298 VGND VPWR sky130_fd_sc_hd__tapvpwrvgnd_1
XFILLER_0_27_737 VGND VGND VPWR VPWR sky130_fd_sc_hd__fill_1
XFILLER_0_137_783 VGND VGND VPWR VPWR sky130_fd_sc_hd__fill_1
XFILLER_0_109_463 VGND VGND VPWR VPWR sky130_fd_sc_hd__fill_1
XFILLER_0_109_452 VGND VGND VPWR VPWR sky130_fd_sc_hd__fill_1
XTAP_TAPCELL_ROW_80_1498 VGND VPWR sky130_fd_sc_hd__tapvpwrvgnd_1
XFILLER_0_54_589 VGND VGND VPWR VPWR sky130_fd_sc_hd__decap_4
XFILLER_0_54_578 VGND VGND VPWR VPWR sky130_fd_sc_hd__decap_8
XFILLER_0_35_770 VPWR VGND VPWR VGND sky130_ef_sc_hd__decap_12
XFILLER_0_42_729 VGND VGND VPWR VPWR sky130_fd_sc_hd__fill_2
XFILLER_0_81_397 VGND VGND VPWR VPWR sky130_fd_sc_hd__fill_1
XFILLER_0_78_15 VGND VGND VPWR VPWR sky130_fd_sc_hd__decap_8
XFILLER_0_111_105 VGND VGND VPWR VPWR sky130_fd_sc_hd__decap_6
XFILLER_0_2_837 VGND VGND VPWR VPWR sky130_fd_sc_hd__decap_4
X_4270_ _1062_ _1063_ _1030_ VGND VGND VPWR VPWR _1064_ sky130_fd_sc_hd__mux2_1
Xclkbuf_leaf_9_CLK clknet_3_1__leaf_CLK VGND VGND VPWR VPWR clknet_leaf_9_CLK sky130_fd_sc_hd__clkbuf_8
XFILLER_0_118_65 VPWR VGND VPWR VGND sky130_ef_sc_hd__decap_12
XTAP_TAPCELL_ROW_87_1608 VGND VPWR sky130_fd_sc_hd__tapvpwrvgnd_1
XFILLER_0_27_30 VPWR VGND VPWR VGND sky130_ef_sc_hd__decap_12
X_7960_ _3344_ rf.registers\[22\]\[0\] _3915_ VGND VGND VPWR VPWR _3916_ sky130_fd_sc_hd__mux2_1
X_7891_ _3878_ VGND VGND VPWR VPWR _3879_ sky130_fd_sc_hd__clkbuf_8
X_6911_ _3346_ VGND VGND VPWR VPWR _3347_ sky130_fd_sc_hd__buf_4
XFILLER_0_134_53 VPWR VGND VPWR VGND sky130_ef_sc_hd__decap_12
X_6842_ rf.registers\[16\]\[10\] _3298_ _3299_ VGND VGND VPWR VPWR _3300_ sky130_fd_sc_hd__mux2_1
XFILLER_0_76_125 VGND VGND VPWR VPWR sky130_fd_sc_hd__decap_4
XFILLER_0_134_97 VPWR VGND VPWR VGND sky130_ef_sc_hd__decap_12
XFILLER_0_119_205 VPWR VGND VPWR VGND sky130_ef_sc_hd__decap_12
XTAP_TAPCELL_ROW_46_993 VGND VPWR sky130_fd_sc_hd__tapvpwrvgnd_1
XFILLER_0_135_709 VPWR VGND VPWR VGND sky130_ef_sc_hd__decap_12
XFILLER_0_119_249 VPWR VGND VPWR VGND sky130_ef_sc_hd__decap_12
X_9561_ clknet_leaf_45_CLK _0649_ VGND VGND VPWR VPWR rf.registers\[13\]\[8\] sky130_fd_sc_hd__dfxtp_1
X_6773_ rf.registers\[0\]\[15\] _3018_ _3252_ VGND VGND VPWR VPWR _3258_ sky130_fd_sc_hd__mux2_1
XFILLER_0_73_821 VPWR VGND VPWR VGND sky130_ef_sc_hd__decap_12
XFILLER_0_9_447 VGND VGND VPWR VPWR sky130_fd_sc_hd__fill_1
XFILLER_0_17_203 VGND VGND VPWR VPWR sky130_fd_sc_hd__decap_3
X_9492_ clknet_leaf_38_CLK _0580_ VGND VGND VPWR VPWR rf.registers\[18\]\[3\] sky130_fd_sc_hd__dfxtp_1
X_8512_ _4207_ VGND VGND VPWR VPWR _0645_ sky130_fd_sc_hd__clkbuf_1
XFILLER_0_17_225 VPWR VGND VPWR VGND sky130_ef_sc_hd__decap_12
X_5724_ _2351_ _2355_ VGND VGND VPWR VPWR _2452_ sky130_fd_sc_hd__nand2_1
XFILLER_0_127_293 VPWR VGND VPWR VGND sky130_ef_sc_hd__decap_12
X_8443_ _4171_ VGND VGND VPWR VPWR _0612_ sky130_fd_sc_hd__clkbuf_1
XFILLER_0_17_258 VGND VGND VPWR VPWR sky130_fd_sc_hd__decap_6
X_5655_ _2378_ _2384_ net103 VGND VGND VPWR VPWR _2385_ sky130_fd_sc_hd__mux2_1
X_8374_ rf.registers\[18\]\[3\] net39 _4131_ VGND VGND VPWR VPWR _4135_ sky130_fd_sc_hd__mux2_1
X_4606_ rf.registers\[8\]\[17\] rf.registers\[9\]\[17\] rf.registers\[10\]\[17\] rf.registers\[11\]\[17\]
+ _1382_ _1383_ VGND VGND VPWR VPWR _1384_ sky130_fd_sc_hd__mux4_1
XFILLER_0_5_653 VPWR VGND VPWR VGND sky130_ef_sc_hd__decap_12
XFILLER_0_4_141 VPWR VGND VPWR VGND sky130_ef_sc_hd__decap_12
XFILLER_0_26_781 VPWR VGND VPWR VGND sky130_ef_sc_hd__decap_12
X_7325_ rf.registers\[3\]\[23\] _3326_ _3574_ VGND VGND VPWR VPWR _3578_ sky130_fd_sc_hd__mux2_1
X_5586_ _2236_ _1113_ VGND VGND VPWR VPWR _2317_ sky130_fd_sc_hd__nand2_1
XFILLER_0_130_447 VGND VGND VPWR VPWR sky130_fd_sc_hd__decap_8
X_4537_ _1298_ _1318_ VGND VGND VPWR VPWR _1319_ sky130_fd_sc_hd__or2_1
X_4468_ rf.registers\[16\]\[10\] rf.registers\[17\]\[10\] rf.registers\[18\]\[10\]
+ rf.registers\[19\]\[10\] _1035_ _1036_ VGND VGND VPWR VPWR _1253_ sky130_fd_sc_hd__mux4_1
XFILLER_0_13_497 VGND VGND VPWR VPWR sky130_fd_sc_hd__decap_6
X_7256_ _3541_ VGND VGND VPWR VPWR _0055_ sky130_fd_sc_hd__clkbuf_1
X_7187_ rf.registers\[4\]\[22\] _3324_ _3502_ VGND VGND VPWR VPWR _3505_ sky130_fd_sc_hd__mux2_1
XFILLER_0_0_380 VGND VGND VPWR VPWR sky130_fd_sc_hd__fill_2
XFILLER_0_0_391 VGND VGND VPWR VPWR sky130_fd_sc_hd__fill_1
X_6207_ _2853_ _2860_ VGND VGND VPWR VPWR _2910_ sky130_fd_sc_hd__nand2_1
XTAP_TAPCELL_ROW_129_2236 VGND VPWR sky130_fd_sc_hd__tapvpwrvgnd_1
X_4399_ _1186_ _1187_ _1163_ VGND VGND VPWR VPWR _1188_ sky130_fd_sc_hd__mux2_1
X_6138_ _2826_ _2811_ _2824_ VGND VGND VPWR VPWR _2845_ sky130_fd_sc_hd__and3b_1
XTAP_TAPCELL_ROW_51_1066 VGND VPWR sky130_fd_sc_hd__tapvpwrvgnd_1
XTAP_TAPCELL_ROW_5_379 VGND VPWR sky130_fd_sc_hd__tapvpwrvgnd_1
XTAP_TAPCELL_ROW_5_368 VGND VPWR sky130_fd_sc_hd__tapvpwrvgnd_1
X_6069_ _1158_ _2319_ VGND VGND VPWR VPWR _2780_ sky130_fd_sc_hd__or2_2
XTAP_TAPCELL_ROW_107_1899 VGND VPWR sky130_fd_sc_hd__tapvpwrvgnd_1
XFILLER_0_67_158 VGND VGND VPWR VPWR sky130_fd_sc_hd__fill_1
XFILLER_0_76_681 VPWR VGND VPWR VGND sky130_ef_sc_hd__decap_12
XTAP_TAPCELL_ROW_24_654 VGND VPWR sky130_fd_sc_hd__tapvpwrvgnd_1
XFILLER_0_36_512 VGND VGND VPWR VPWR sky130_fd_sc_hd__fill_1
XFILLER_0_119_783 VGND VGND VPWR VPWR sky130_fd_sc_hd__fill_1
XFILLER_0_75_180 VGND VGND VPWR VPWR sky130_fd_sc_hd__fill_1
XTAP_TAPCELL_ROW_24_665 VGND VPWR sky130_fd_sc_hd__tapvpwrvgnd_1
XFILLER_0_118_271 VGND VGND VPWR VPWR sky130_fd_sc_hd__decap_8
XFILLER_0_24_707 VPWR VGND VPWR VGND sky130_ef_sc_hd__decap_12
XFILLER_0_32_751 VGND VGND VPWR VPWR sky130_fd_sc_hd__decap_4
Xclkbuf_3_4__f_CLK clknet_0_CLK VGND VGND VPWR VPWR clknet_3_4__leaf_CLK sky130_fd_sc_hd__clkbuf_16
XFILLER_0_102_661 VPWR VGND VPWR VGND sky130_ef_sc_hd__decap_12
XFILLER_0_31_272 VGND VGND VPWR VPWR sky130_fd_sc_hd__decap_8
XFILLER_0_48_29 VPWR VGND VPWR VGND sky130_ef_sc_hd__decap_12
XFILLER_0_98_250 VGND VGND VPWR VPWR sky130_fd_sc_hd__fill_2
XTAP_TAPCELL_ROW_69_1338 VGND VPWR sky130_fd_sc_hd__tapvpwrvgnd_1
XPHY_EDGE_ROW_103_Left_242 VGND VGND VPWR VPWR sky130_fd_sc_hd__decap_3
XFILLER_0_59_615 VGND VGND VPWR VPWR sky130_fd_sc_hd__fill_1
XTAP_TAPCELL_ROW_82_1527 VGND VPWR sky130_fd_sc_hd__tapvpwrvgnd_1
XFILLER_0_80_27 VGND VGND VPWR VPWR sky130_fd_sc_hd__fill_1
XFILLER_0_117_709 VPWR VGND VPWR VGND sky130_ef_sc_hd__decap_12
XFILLER_0_55_821 VPWR VGND VPWR VGND sky130_ef_sc_hd__decap_12
XTAP_TAPCELL_ROW_43_941 VGND VPWR sky130_fd_sc_hd__tapvpwrvgnd_1
XTAP_TAPCELL_ROW_43_952 VGND VPWR sky130_fd_sc_hd__tapvpwrvgnd_1
XFILLER_0_46_309 VGND VGND VPWR VPWR sky130_fd_sc_hd__decap_4
XFILLER_0_27_523 VPWR VGND VPWR VGND sky130_ef_sc_hd__decap_12
XFILLER_0_70_813 VPWR VGND VPWR VGND sky130_ef_sc_hd__decap_12
XPHY_EDGE_ROW_132_Right_132 VGND VGND VPWR VPWR sky130_fd_sc_hd__decap_3
XFILLER_0_125_753 VPWR VGND VPWR VGND sky130_ef_sc_hd__decap_12
X_5440_ rf.registers\[0\]\[30\] rf.registers\[1\]\[30\] rf.registers\[2\]\[30\] rf.registers\[3\]\[30\]
+ _2086_ _2087_ VGND VGND VPWR VPWR _2173_ sky130_fd_sc_hd__mux4_1
XFILLER_0_125_797 VPWR VGND VPWR VGND sky130_ef_sc_hd__decap_12
XFILLER_0_2_601 VPWR VGND VPWR VGND sky130_ef_sc_hd__decap_12
XFILLER_0_120_77 VGND VGND VPWR VPWR sky130_fd_sc_hd__decap_6
XPHY_EDGE_ROW_112_Left_251 VGND VGND VPWR VPWR sky130_fd_sc_hd__decap_3
XFILLER_0_10_401 VPWR VGND VPWR VGND sky130_ef_sc_hd__decap_12
XFILLER_0_1_111 VGND VGND VPWR VPWR sky130_fd_sc_hd__fill_1
XFILLER_0_2_645 VPWR VGND VPWR VGND sky130_ef_sc_hd__decap_12
X_5371_ _1958_ _2107_ VGND VGND VPWR VPWR _2108_ sky130_fd_sc_hd__or2_1
X_7110_ rf.registers\[5\]\[18\] _3315_ _3455_ VGND VGND VPWR VPWR _3464_ sky130_fd_sc_hd__mux2_1
X_8090_ rf.registers\[7\]\[30\] _3340_ _3950_ VGND VGND VPWR VPWR _3984_ sky130_fd_sc_hd__mux2_1
XFILLER_0_10_445 VPWR VGND VPWR VGND sky130_ef_sc_hd__decap_12
X_4322_ _1113_ VGND VGND VPWR VPWR _1114_ sky130_fd_sc_hd__inv_2
X_4253_ _1034_ _1047_ VGND VGND VPWR VPWR _1048_ sky130_fd_sc_hd__nand2_1
XTAP_TAPCELL_ROW_93_1689 VGND VPWR sky130_fd_sc_hd__tapvpwrvgnd_1
X_7041_ _3427_ VGND VGND VPWR VPWR _0978_ sky130_fd_sc_hd__clkbuf_1
XFILLER_0_59_7 VPWR VGND VPWR VGND sky130_ef_sc_hd__decap_12
XFILLER_0_10_489 VPWR VGND VPWR VGND sky130_ef_sc_hd__decap_12
X_8992_ clknet_leaf_16_CLK _0080_ VGND VGND VPWR VPWR rf.registers\[3\]\[15\] sky130_fd_sc_hd__dfxtp_1
XTAP_TAPCELL_ROW_2_327 VGND VPWR sky130_fd_sc_hd__tapvpwrvgnd_1
XPHY_EDGE_ROW_121_Left_260 VGND VGND VPWR VPWR sky130_fd_sc_hd__decap_3
X_7943_ _3906_ VGND VGND VPWR VPWR _0377_ sky130_fd_sc_hd__clkbuf_1
XTAP_TAPCELL_ROW_124_2166 VGND VPWR sky130_fd_sc_hd__tapvpwrvgnd_1
XTAP_TAPCELL_ROW_124_2155 VGND VPWR sky130_fd_sc_hd__tapvpwrvgnd_1
XFILLER_0_65_607 VGND VGND VPWR VPWR sky130_fd_sc_hd__decap_6
X_7874_ _3869_ VGND VGND VPWR VPWR _0345_ sky130_fd_sc_hd__clkbuf_1
X_6825_ net41 VGND VGND VPWR VPWR _3288_ sky130_fd_sc_hd__buf_2
XFILLER_0_65_629 VPWR VGND VPWR VGND sky130_ef_sc_hd__decap_12
XFILLER_0_18_501 VPWR VGND VPWR VGND sky130_ef_sc_hd__decap_12
XFILLER_0_135_517 VPWR VGND VPWR VGND sky130_ef_sc_hd__decap_12
X_6756_ rf.registers\[0\]\[7\] _3001_ _3241_ VGND VGND VPWR VPWR _3249_ sky130_fd_sc_hd__mux2_1
XFILLER_0_58_681 VPWR VGND VPWR VGND sky130_ef_sc_hd__decap_12
X_9544_ clknet_leaf_3_CLK _0632_ VGND VGND VPWR VPWR rf.registers\[14\]\[23\] sky130_fd_sc_hd__dfxtp_1
XFILLER_0_18_545 VPWR VGND VPWR VGND sky130_ef_sc_hd__decap_12
XFILLER_0_73_640 VGND VGND VPWR VPWR sky130_fd_sc_hd__fill_1
XFILLER_0_70_82 VGND VGND VPWR VPWR sky130_fd_sc_hd__fill_2
XFILLER_0_57_191 VPWR VGND VPWR VGND sky130_ef_sc_hd__decap_12
XTAP_TAPCELL_ROW_21_613 VGND VPWR sky130_fd_sc_hd__tapvpwrvgnd_1
X_5707_ _2426_ _2427_ _2434_ VGND VGND VPWR VPWR _2435_ sky130_fd_sc_hd__a21o_1
X_6687_ _3212_ VGND VGND VPWR VPWR _0839_ sky130_fd_sc_hd__clkbuf_1
X_9475_ clknet_leaf_5_CLK _0563_ VGND VGND VPWR VPWR rf.registers\[20\]\[18\] sky130_fd_sc_hd__dfxtp_1
XFILLER_0_18_589 VGND VGND VPWR VPWR sky130_fd_sc_hd__decap_8
XFILLER_0_115_252 VGND VGND VPWR VPWR sky130_fd_sc_hd__fill_1
XFILLER_0_5_461 VPWR VGND VPWR VGND sky130_ef_sc_hd__decap_12
XFILLER_0_14_740 VPWR VGND VPWR VGND sky130_ef_sc_hd__decap_12
X_8426_ rf.registers\[18\]\[28\] net34 _4153_ VGND VGND VPWR VPWR _4162_ sky130_fd_sc_hd__mux2_1
XFILLER_0_33_559 VGND VGND VPWR VPWR sky130_fd_sc_hd__fill_1
X_5638_ _2032_ _2219_ _2229_ VGND VGND VPWR VPWR _2368_ sky130_fd_sc_hd__o21ai_1
XFILLER_0_130_233 VPWR VGND VPWR VGND sky130_ef_sc_hd__decap_12
XFILLER_0_103_447 VGND VGND VPWR VPWR sky130_fd_sc_hd__fill_1
XFILLER_0_13_261 VPWR VGND VPWR VGND sky130_ef_sc_hd__decap_12
X_8357_ _4125_ VGND VGND VPWR VPWR _0572_ sky130_fd_sc_hd__clkbuf_1
X_5569_ _2297_ _2299_ VGND VGND VPWR VPWR _2300_ sky130_fd_sc_hd__nand2_1
XFILLER_0_130_277 VPWR VGND VPWR VGND sky130_ef_sc_hd__decap_12
X_7308_ rf.registers\[3\]\[15\] _3309_ _3563_ VGND VGND VPWR VPWR _3569_ sky130_fd_sc_hd__mux2_1
XFILLER_0_41_581 VGND VGND VPWR VPWR sky130_fd_sc_hd__decap_3
XFILLER_0_0_7 VGND VGND VPWR VPWR sky130_fd_sc_hd__fill_2
X_8288_ _3043_ rf.registers\[25\]\[27\] _4081_ VGND VGND VPWR VPWR _4089_ sky130_fd_sc_hd__mux2_1
X_7239_ _3532_ VGND VGND VPWR VPWR _0047_ sky130_fd_sc_hd__clkbuf_1
XFILLER_0_95_90 VGND VGND VPWR VPWR sky130_fd_sc_hd__fill_1
XTAP_TAPCELL_ROW_109_1928 VGND VPWR sky130_fd_sc_hd__tapvpwrvgnd_1
XTAP_TAPCELL_ROW_109_1939 VGND VPWR sky130_fd_sc_hd__tapvpwrvgnd_1
XTAP_TAPCELL_ROW_29_735 VGND VPWR sky130_fd_sc_hd__tapvpwrvgnd_1
XFILLER_0_138_333 VGND VGND VPWR VPWR sky130_fd_sc_hd__decap_3
XTAP_TAPCELL_ROW_64_1257 VGND VPWR sky130_fd_sc_hd__tapvpwrvgnd_1
XFILLER_0_95_297 VGND VGND VPWR VPWR sky130_fd_sc_hd__fill_1
XFILLER_0_55_128 VGND VGND VPWR VPWR sky130_fd_sc_hd__fill_1
XFILLER_0_49_692 VPWR VGND VPWR VGND sky130_ef_sc_hd__decap_12
XTAP_TAPCELL_ROW_40_900 VGND VPWR sky130_fd_sc_hd__tapvpwrvgnd_1
XFILLER_0_52_813 VPWR VGND VPWR VGND sky130_ef_sc_hd__decap_12
XFILLER_0_107_753 VPWR VGND VPWR VGND sky130_ef_sc_hd__decap_12
XFILLER_0_91_481 VGND VGND VPWR VPWR sky130_fd_sc_hd__decap_6
XFILLER_0_134_583 VGND VGND VPWR VPWR sky130_fd_sc_hd__fill_1
XFILLER_0_134_561 VPWR VGND VPWR VGND sky130_ef_sc_hd__decap_12
XFILLER_0_122_701 VPWR VGND VPWR VGND sky130_ef_sc_hd__decap_12
XFILLER_0_107_797 VPWR VGND VPWR VGND sky130_ef_sc_hd__decap_12
XFILLER_0_20_732 VGND VGND VPWR VPWR sky130_fd_sc_hd__decap_3
XFILLER_0_20_754 VGND VGND VPWR VPWR sky130_fd_sc_hd__fill_2
XFILLER_0_102_491 VGND VGND VPWR VPWR sky130_fd_sc_hd__fill_2
XFILLER_0_115_33 VPWR VGND VPWR VGND sky130_ef_sc_hd__decap_12
X_4940_ _1632_ VGND VGND VPWR VPWR _1700_ sky130_fd_sc_hd__buf_4
XFILLER_0_87_765 VPWR VGND VPWR VGND sky130_ef_sc_hd__decap_12
X_4871_ _1630_ _1633_ VGND VGND VPWR VPWR _1634_ sky130_fd_sc_hd__or2_1
XFILLER_0_24_53 VGND VGND VPWR VPWR sky130_fd_sc_hd__decap_6
XFILLER_0_28_810 VGND VGND VPWR VPWR sky130_fd_sc_hd__fill_2
X_6610_ _3171_ VGND VGND VPWR VPWR _0803_ sky130_fd_sc_hd__clkbuf_1
X_7590_ _3718_ VGND VGND VPWR VPWR _0212_ sky130_fd_sc_hd__clkbuf_1
X_6541_ _3134_ VGND VGND VPWR VPWR _0771_ sky130_fd_sc_hd__clkbuf_1
XFILLER_0_131_43 VPWR VGND VPWR VGND sky130_ef_sc_hd__decap_12
XFILLER_0_55_673 VPWR VGND VPWR VGND sky130_ef_sc_hd__decap_12
XFILLER_0_40_41 VGND VGND VPWR VPWR sky130_fd_sc_hd__decap_8
X_6472_ _3097_ VGND VGND VPWR VPWR _0739_ sky130_fd_sc_hd__clkbuf_1
XFILLER_0_113_712 VPWR VGND VPWR VGND sky130_ef_sc_hd__decap_12
XTAP_TAPCELL_ROW_95_1729 VGND VPWR sky130_fd_sc_hd__tapvpwrvgnd_1
XTAP_TAPCELL_ROW_95_1718 VGND VPWR sky130_fd_sc_hd__tapvpwrvgnd_1
XFILLER_0_70_654 VGND VGND VPWR VPWR sky130_fd_sc_hd__decap_8
XFILLER_0_70_632 VGND VGND VPWR VPWR sky130_fd_sc_hd__fill_1
XFILLER_0_15_559 VGND VGND VPWR VPWR sky130_fd_sc_hd__fill_1
X_9260_ clknet_leaf_86_CLK _0348_ VGND VGND VPWR VPWR rf.registers\[28\]\[27\] sky130_fd_sc_hd__dfxtp_1
XFILLER_0_42_345 VGND VGND VPWR VPWR sky130_fd_sc_hd__fill_1
XFILLER_0_70_698 VGND VGND VPWR VPWR sky130_fd_sc_hd__fill_2
X_5423_ rf.registers\[8\]\[29\] rf.registers\[9\]\[29\] rf.registers\[10\]\[29\] rf.registers\[11\]\[29\]
+ _2077_ _2078_ VGND VGND VPWR VPWR _2157_ sky130_fd_sc_hd__mux4_1
X_9191_ clknet_leaf_94_CLK _0279_ VGND VGND VPWR VPWR rf.registers\[30\]\[22\] sky130_fd_sc_hd__dfxtp_1
X_8211_ _4048_ VGND VGND VPWR VPWR _0503_ sky130_fd_sc_hd__clkbuf_1
XFILLER_0_2_475 VGND VGND VPWR VPWR sky130_fd_sc_hd__fill_1
X_5354_ rf.registers\[8\]\[25\] rf.registers\[9\]\[25\] rf.registers\[10\]\[25\] rf.registers\[11\]\[25\]
+ _1959_ _1960_ VGND VGND VPWR VPWR _2092_ sky130_fd_sc_hd__mux4_1
X_8142_ _3393_ rf.registers\[26\]\[22\] _4009_ VGND VGND VPWR VPWR _4012_ sky130_fd_sc_hd__mux2_1
X_4305_ rf.registers\[20\]\[3\] rf.registers\[21\]\[3\] rf.registers\[22\]\[3\] rf.registers\[23\]\[3\]
+ _1077_ _1078_ VGND VGND VPWR VPWR _1097_ sky130_fd_sc_hd__mux4_1
XFILLER_0_10_253 VPWR VGND VPWR VGND sky130_ef_sc_hd__decap_12
XTAP_TAPCELL_ROW_7_408 VGND VPWR sky130_fd_sc_hd__tapvpwrvgnd_1
X_5285_ _1950_ _2026_ VGND VGND VPWR VPWR _2027_ sky130_fd_sc_hd__nand2_1
X_8073_ _3975_ VGND VGND VPWR VPWR _0438_ sky130_fd_sc_hd__clkbuf_1
X_4236_ _1030_ VGND VGND VPWR VPWR _1031_ sky130_fd_sc_hd__buf_4
X_7024_ _3418_ VGND VGND VPWR VPWR _0970_ sky130_fd_sc_hd__clkbuf_1
XFILLER_0_4_41 VPWR VGND VPWR VGND sky130_ef_sc_hd__decap_12
XFILLER_0_4_85 VPWR VGND VPWR VGND sky130_ef_sc_hd__decap_12
X_8975_ clknet_leaf_74_CLK _0063_ VGND VGND VPWR VPWR rf.registers\[19\]\[30\] sky130_fd_sc_hd__dfxtp_1
X_7926_ _3897_ VGND VGND VPWR VPWR _0369_ sky130_fd_sc_hd__clkbuf_1
XTAP_TAPCELL_ROW_104_1858 VGND VPWR sky130_fd_sc_hd__tapvpwrvgnd_1
X_7857_ _3860_ VGND VGND VPWR VPWR _0337_ sky130_fd_sc_hd__clkbuf_1
XFILLER_0_38_629 VGND VGND VPWR VPWR sky130_fd_sc_hd__decap_8
X_6808_ net14 VGND VGND VPWR VPWR _3276_ sky130_fd_sc_hd__clkbuf_2
XFILLER_0_19_821 VPWR VGND VPWR VGND sky130_ef_sc_hd__decap_12
XFILLER_0_136_837 VGND VGND VPWR VPWR sky130_fd_sc_hd__decap_4
X_7788_ rf.registers\[9\]\[16\] _3311_ _3817_ VGND VGND VPWR VPWR _3824_ sky130_fd_sc_hd__mux2_1
XFILLER_0_46_640 VGND VGND VPWR VPWR sky130_fd_sc_hd__decap_4
XTAP_TAPCELL_ROW_137_2357 VGND VPWR sky130_fd_sc_hd__tapvpwrvgnd_1
XFILLER_0_80_418 VGND VGND VPWR VPWR sky130_fd_sc_hd__fill_2
X_9527_ clknet_leaf_60_CLK _0615_ VGND VGND VPWR VPWR rf.registers\[14\]\[6\] sky130_fd_sc_hd__dfxtp_1
X_6739_ _3239_ VGND VGND VPWR VPWR _0864_ sky130_fd_sc_hd__clkbuf_1
XFILLER_0_18_386 VPWR VGND VPWR VGND sky130_ef_sc_hd__decap_12
XFILLER_0_34_813 VPWR VGND VPWR VGND sky130_ef_sc_hd__decap_12
XFILLER_0_46_695 VGND VGND VPWR VPWR sky130_fd_sc_hd__fill_2
X_9458_ clknet_leaf_43_CLK _0546_ VGND VGND VPWR VPWR rf.registers\[20\]\[1\] sky130_fd_sc_hd__dfxtp_1
XFILLER_0_104_701 VPWR VGND VPWR VGND sky130_ef_sc_hd__decap_12
XFILLER_0_6_781 VPWR VGND VPWR VGND sky130_ef_sc_hd__decap_12
XFILLER_0_21_529 VPWR VGND VPWR VGND sky130_ef_sc_hd__decap_12
X_8409_ _4130_ VGND VGND VPWR VPWR _4153_ sky130_fd_sc_hd__buf_4
XFILLER_0_60_197 VGND VGND VPWR VPWR sky130_fd_sc_hd__fill_2
XFILLER_0_14_570 VGND VGND VPWR VPWR sky130_fd_sc_hd__fill_1
X_9389_ clknet_leaf_93_CLK _0477_ VGND VGND VPWR VPWR rf.registers\[26\]\[28\] sky130_fd_sc_hd__dfxtp_1
XFILLER_0_69_721 VGND VGND VPWR VPWR sky130_fd_sc_hd__decap_6
XFILLER_0_84_713 VPWR VGND VPWR VGND sky130_ef_sc_hd__decap_12
XFILLER_0_69_765 VPWR VGND VPWR VGND sky130_ef_sc_hd__decap_12
XFILLER_0_68_242 VGND VGND VPWR VPWR sky130_fd_sc_hd__decap_3
XFILLER_0_29_629 VGND VGND VPWR VPWR sky130_fd_sc_hd__fill_2
XFILLER_0_84_757 VPWR VGND VPWR VGND sky130_ef_sc_hd__decap_12
XFILLER_0_138_163 VGND VGND VPWR VPWR sky130_fd_sc_hd__decap_4
XFILLER_0_37_640 VGND VGND VPWR VPWR sky130_fd_sc_hd__decap_4
XFILLER_0_83_278 VGND VGND VPWR VPWR sky130_fd_sc_hd__fill_2
XFILLER_0_52_610 VPWR VGND VPWR VGND sky130_ef_sc_hd__decap_12
XTAP_TAPCELL_ROW_12_476 VGND VPWR sky130_fd_sc_hd__tapvpwrvgnd_1
XFILLER_0_3_217 VGND VGND VPWR VPWR sky130_fd_sc_hd__decap_6
XTAP_TAPCELL_ROW_12_487 VGND VPWR sky130_fd_sc_hd__tapvpwrvgnd_1
XFILLER_0_36_194 VGND VGND VPWR VPWR sky130_fd_sc_hd__fill_2
XFILLER_0_101_57 VPWR VGND VPWR VGND sky130_ef_sc_hd__decap_12
XTAP_TAPCELL_ROW_77_1448 VGND VPWR sky130_fd_sc_hd__tapvpwrvgnd_1
XFILLER_0_51_142 VGND VGND VPWR VPWR sky130_fd_sc_hd__fill_1
XFILLER_0_40_805 VGND VGND VPWR VPWR sky130_fd_sc_hd__decap_6
XTAP_TAPCELL_ROW_77_1459 VGND VPWR sky130_fd_sc_hd__tapvpwrvgnd_1
XFILLER_0_10_77 VGND VGND VPWR VPWR sky130_fd_sc_hd__decap_6
XFILLER_0_122_586 VGND VGND VPWR VPWR sky130_fd_sc_hd__fill_2
XFILLER_0_110_737 VPWR VGND VPWR VGND sky130_ef_sc_hd__decap_12
XFILLER_0_86_37 VGND VGND VPWR VPWR sky130_fd_sc_hd__fill_2
XFILLER_0_86_15 VPWR VGND VPWR VGND sky130_ef_sc_hd__decap_12
XTAP_TAPCELL_ROW_90_1648 VGND VPWR sky130_fd_sc_hd__tapvpwrvgnd_1
X_5070_ _1822_ _1823_ _1693_ VGND VGND VPWR VPWR _1824_ sky130_fd_sc_hd__mux2_1
XFILLER_0_19_53 VGND VGND VPWR VPWR sky130_fd_sc_hd__decap_3
XFILLER_0_126_65 VPWR VGND VPWR VGND sky130_ef_sc_hd__decap_12
XTAP_TAPCELL_ROW_121_2114 VGND VPWR sky130_fd_sc_hd__tapvpwrvgnd_1
X_8760_ clknet_leaf_50_CLK _0872_ VGND VGND VPWR VPWR rf.registers\[0\]\[7\] sky130_fd_sc_hd__dfxtp_1
XFILLER_0_59_220 VGND VGND VPWR VPWR sky130_fd_sc_hd__fill_1
X_5972_ _2541_ _2680_ _2684_ _2560_ _2688_ VGND VGND VPWR VPWR net118 sky130_fd_sc_hd__o221ai_4
X_7711_ _3783_ VGND VGND VPWR VPWR _0268_ sky130_fd_sc_hd__clkbuf_1
X_4923_ _1616_ VGND VGND VPWR VPWR _1683_ sky130_fd_sc_hd__buf_8
X_8691_ clknet_leaf_42_CLK _0803_ VGND VGND VPWR VPWR rf.registers\[24\]\[2\] sky130_fd_sc_hd__dfxtp_1
X_4854_ net1 VGND VGND VPWR VPWR _1617_ sky130_fd_sc_hd__buf_4
XFILLER_0_118_837 VGND VGND VPWR VPWR sky130_fd_sc_hd__fill_2
X_7642_ _3746_ VGND VGND VPWR VPWR _0236_ sky130_fd_sc_hd__clkbuf_1
X_7573_ _3370_ rf.registers\[27\]\[11\] _3708_ VGND VGND VPWR VPWR _3710_ sky130_fd_sc_hd__mux2_1
XFILLER_0_90_749 VGND VGND VPWR VPWR sky130_fd_sc_hd__decap_6
XFILLER_0_74_289 VGND VGND VPWR VPWR sky130_fd_sc_hd__decap_6
XFILLER_0_16_813 VPWR VGND VPWR VGND sky130_ef_sc_hd__decap_12
XFILLER_0_34_109 VGND VGND VPWR VPWR sky130_fd_sc_hd__fill_1
X_4785_ _1547_ _1549_ _1552_ _1197_ _1117_ VGND VGND VPWR VPWR _1553_ sky130_fd_sc_hd__o221a_1
XTAP_TAPCELL_ROW_119_2087 VGND VPWR sky130_fd_sc_hd__tapvpwrvgnd_1
X_9312_ clknet_leaf_22_CLK _0400_ VGND VGND VPWR VPWR rf.registers\[22\]\[15\] sky130_fd_sc_hd__dfxtp_1
X_6524_ _3124_ VGND VGND VPWR VPWR _0764_ sky130_fd_sc_hd__clkbuf_1
XTAP_TAPCELL_ROW_31_763 VGND VPWR sky130_fd_sc_hd__tapvpwrvgnd_1
X_9243_ clknet_leaf_37_CLK _0331_ VGND VGND VPWR VPWR rf.registers\[28\]\[10\] sky130_fd_sc_hd__dfxtp_1
XFILLER_0_43_687 VPWR VGND VPWR VGND sky130_ef_sc_hd__decap_12
Xclkload60 clknet_leaf_33_CLK VGND VGND VPWR VPWR clkload60/Y sky130_fd_sc_hd__clkinvlp_4
Xclkload71 clknet_leaf_48_CLK VGND VGND VPWR VPWR clkload71/Y sky130_fd_sc_hd__bufinv_16
X_6455_ rf.registers\[11\]\[28\] _3045_ _3078_ VGND VGND VPWR VPWR _3087_ sky130_fd_sc_hd__mux2_1
XTAP_TAPCELL_ROW_132_2287 VGND VPWR sky130_fd_sc_hd__tapvpwrvgnd_1
XTAP_TAPCELL_ROW_132_2276 VGND VPWR sky130_fd_sc_hd__tapvpwrvgnd_1
Xclkload82 clknet_leaf_65_CLK VGND VGND VPWR VPWR clkload82/Y sky130_fd_sc_hd__clkinv_4
X_9174_ clknet_leaf_78_CLK _0262_ VGND VGND VPWR VPWR rf.registers\[30\]\[5\] sky130_fd_sc_hd__dfxtp_1
X_5406_ rf.registers\[12\]\[28\] rf.registers\[13\]\[28\] rf.registers\[14\]\[28\]
+ rf.registers\[15\]\[28\] _2070_ _2071_ VGND VGND VPWR VPWR _2141_ sky130_fd_sc_hd__mux4_1
X_6386_ _3048_ VGND VGND VPWR VPWR _0702_ sky130_fd_sc_hd__clkbuf_1
X_8125_ _3376_ rf.registers\[26\]\[14\] _3998_ VGND VGND VPWR VPWR _4003_ sky130_fd_sc_hd__mux2_1
XFILLER_0_11_573 VGND VGND VPWR VPWR sky130_fd_sc_hd__decap_6
X_5337_ _1958_ _2075_ VGND VGND VPWR VPWR _2076_ sky130_fd_sc_hd__nor2_1
X_8056_ _3966_ VGND VGND VPWR VPWR _0430_ sky130_fd_sc_hd__clkbuf_1
X_5268_ _1927_ _2010_ _1742_ VGND VGND VPWR VPWR _2011_ sky130_fd_sc_hd__o21a_1
X_7007_ rf.registers\[6\]\[1\] _3280_ _3408_ VGND VGND VPWR VPWR _3410_ sky130_fd_sc_hd__mux2_1
XFILLER_0_98_805 VGND VGND VPWR VPWR sky130_fd_sc_hd__decap_6
X_5199_ rf.registers\[28\]\[17\] rf.registers\[29\]\[17\] rf.registers\[30\]\[17\]
+ rf.registers\[31\]\[17\] _1919_ _1920_ VGND VGND VPWR VPWR _1945_ sky130_fd_sc_hd__mux4_1
X_8958_ clknet_leaf_29_CLK _0046_ VGND VGND VPWR VPWR rf.registers\[19\]\[13\] sky130_fd_sc_hd__dfxtp_1
XFILLER_0_97_337 VPWR VGND VPWR VGND sky130_ef_sc_hd__decap_12
XTAP_TAPCELL_ROW_48_1027 VGND VPWR sky130_fd_sc_hd__tapvpwrvgnd_1
XTAP_TAPCELL_ROW_39_885 VGND VPWR sky130_fd_sc_hd__tapvpwrvgnd_1
XTAP_TAPCELL_ROW_48_1016 VGND VPWR sky130_fd_sc_hd__tapvpwrvgnd_1
X_7909_ _3888_ VGND VGND VPWR VPWR _0361_ sky130_fd_sc_hd__clkbuf_1
XFILLER_0_78_562 VGND VGND VPWR VPWR sky130_fd_sc_hd__fill_2
XFILLER_0_66_713 VPWR VGND VPWR VGND sky130_ef_sc_hd__decap_12
X_8889_ clknet_leaf_47_CLK _1001_ VGND VGND VPWR VPWR rf.registers\[5\]\[8\] sky130_fd_sc_hd__dfxtp_1
XFILLER_0_136_601 VPWR VGND VPWR VGND sky130_ef_sc_hd__decap_12
XFILLER_0_66_757 VPWR VGND VPWR VGND sky130_ef_sc_hd__decap_12
XTAP_TAPCELL_ROW_61_1216 VGND VPWR sky130_fd_sc_hd__tapvpwrvgnd_1
XFILLER_0_136_645 VPWR VGND VPWR VGND sky130_ef_sc_hd__decap_12
XFILLER_0_135_111 VGND VGND VPWR VPWR sky130_fd_sc_hd__fill_1
XFILLER_0_81_727 VGND VGND VPWR VPWR sky130_fd_sc_hd__fill_1
XFILLER_0_18_161 VGND VGND VPWR VPWR sky130_fd_sc_hd__decap_3
XFILLER_0_19_673 VPWR VGND VPWR VGND sky130_ef_sc_hd__decap_12
XFILLER_0_123_317 VPWR VGND VPWR VGND sky130_ef_sc_hd__decap_12
XFILLER_0_80_259 VGND VGND VPWR VPWR sky130_fd_sc_hd__fill_1
XFILLER_0_0_209 VGND VGND VPWR VPWR sky130_fd_sc_hd__decap_8
XFILLER_0_131_361 VPWR VGND VPWR VGND sky130_ef_sc_hd__decap_12
XFILLER_0_104_586 VGND VGND VPWR VPWR sky130_fd_sc_hd__fill_2
XTAP_TAPCELL_ROW_59_1189 VGND VPWR sky130_fd_sc_hd__tapvpwrvgnd_1
XTAP_TAPCELL_ROW_59_1178 VGND VPWR sky130_fd_sc_hd__tapvpwrvgnd_1
XFILLER_0_100_781 VPWR VGND VPWR VGND sky130_ef_sc_hd__decap_12
XTAP_TAPCELL_ROW_72_1378 VGND VPWR sky130_fd_sc_hd__tapvpwrvgnd_1
XFILLER_0_56_29 VPWR VGND VPWR VGND sky130_ef_sc_hd__decap_12
XFILLER_0_88_315 VGND VGND VPWR VPWR sky130_fd_sc_hd__fill_2
XFILLER_0_8_309 VPWR VGND VPWR VGND sky130_ef_sc_hd__decap_12
XTAP_TAPCELL_ROW_17_557 VGND VPWR sky130_fd_sc_hd__tapvpwrvgnd_1
XFILLER_0_126_133 VGND VGND VPWR VPWR sky130_fd_sc_hd__decap_6
XFILLER_0_72_749 VGND VGND VPWR VPWR sky130_fd_sc_hd__decap_6
XFILLER_0_16_109 VPWR VGND VPWR VGND sky130_ef_sc_hd__decap_12
XFILLER_0_126_177 VPWR VGND VPWR VGND sky130_ef_sc_hd__decap_12
X_4570_ rf.registers\[12\]\[15\] rf.registers\[13\]\[15\] rf.registers\[14\]\[15\]
+ rf.registers\[15\]\[15\] _1302_ _1303_ VGND VGND VPWR VPWR _1350_ sky130_fd_sc_hd__mux4_1
XFILLER_0_108_3 VPWR VGND VPWR VGND sky130_ef_sc_hd__decap_12
XFILLER_0_80_793 VPWR VGND VPWR VGND sky130_ef_sc_hd__decap_12
X_6240_ _2202_ _2885_ VGND VGND VPWR VPWR _2941_ sky130_fd_sc_hd__nor2_1
XFILLER_0_0_721 VGND VGND VPWR VPWR sky130_fd_sc_hd__decap_6
XFILLER_0_40_668 VGND VGND VPWR VPWR sky130_fd_sc_hd__fill_1
X_6171_ _2119_ _2875_ VGND VGND VPWR VPWR _2876_ sky130_fd_sc_hd__xnor2_1
X_5122_ _1872_ VGND VGND VPWR VPWR net52 sky130_fd_sc_hd__inv_2
X_5053_ _1806_ _1807_ _1630_ VGND VGND VPWR VPWR _1808_ sky130_fd_sc_hd__mux2_1
XFILLER_0_79_304 VGND VGND VPWR VPWR sky130_fd_sc_hd__decap_4
XFILLER_0_46_62 VGND VGND VPWR VPWR sky130_fd_sc_hd__decap_4
X_8812_ clknet_leaf_89_CLK _0924_ VGND VGND VPWR VPWR rf.registers\[16\]\[27\] sky130_fd_sc_hd__dfxtp_1
XTAP_TAPCELL_ROW_36_833 VGND VPWR sky130_fd_sc_hd__tapvpwrvgnd_1
XTAP_TAPCELL_ROW_36_844 VGND VPWR sky130_fd_sc_hd__tapvpwrvgnd_1
X_8743_ clknet_leaf_7_CLK _0855_ VGND VGND VPWR VPWR rf.registers\[10\]\[22\] sky130_fd_sc_hd__dfxtp_1
X_5955_ _2658_ _2667_ _2672_ _2399_ VGND VGND VPWR VPWR net117 sky130_fd_sc_hd__o22a_1
XFILLER_0_47_223 VGND VGND VPWR VPWR sky130_fd_sc_hd__fill_1
X_4906_ rf.registers\[20\]\[2\] rf.registers\[21\]\[2\] rf.registers\[22\]\[2\] rf.registers\[23\]\[2\]
+ _1624_ _1625_ VGND VGND VPWR VPWR _1667_ sky130_fd_sc_hd__mux4_1
XTAP_TAPCELL_ROW_101_1817 VGND VPWR sky130_fd_sc_hd__tapvpwrvgnd_1
X_8674_ clknet_leaf_12_CLK _0786_ VGND VGND VPWR VPWR rf.registers\[1\]\[17\] sky130_fd_sc_hd__dfxtp_1
XFILLER_0_48_757 VPWR VGND VPWR VGND sky130_ef_sc_hd__decap_12
X_5886_ _2420_ _2568_ _2572_ _2417_ VGND VGND VPWR VPWR _2607_ sky130_fd_sc_hd__o22a_1
XFILLER_0_47_234 VGND VGND VPWR VPWR sky130_fd_sc_hd__fill_2
XFILLER_0_118_645 VGND VGND VPWR VPWR sky130_fd_sc_hd__decap_6
XFILLER_0_117_111 VGND VGND VPWR VPWR sky130_fd_sc_hd__fill_1
X_7625_ _3737_ VGND VGND VPWR VPWR _0228_ sky130_fd_sc_hd__clkbuf_1
XFILLER_0_63_727 VGND VGND VPWR VPWR sky130_fd_sc_hd__fill_1
X_4837_ rf.registers\[16\]\[31\] rf.registers\[17\]\[31\] rf.registers\[18\]\[31\]
+ rf.registers\[19\]\[31\] _1183_ _1181_ VGND VGND VPWR VPWR _1601_ sky130_fd_sc_hd__mux4_1
XTAP_TAPCELL_ROW_134_2316 VGND VPWR sky130_fd_sc_hd__tapvpwrvgnd_1
XTAP_TAPCELL_ROW_134_2305 VGND VPWR sky130_fd_sc_hd__tapvpwrvgnd_1
XFILLER_0_133_615 VGND VGND VPWR VPWR sky130_fd_sc_hd__fill_1
X_7556_ _3353_ rf.registers\[27\]\[3\] _3697_ VGND VGND VPWR VPWR _3701_ sky130_fd_sc_hd__mux2_1
X_4768_ _1291_ _1536_ _1116_ VGND VGND VPWR VPWR _1537_ sky130_fd_sc_hd__o21a_1
X_7487_ _3664_ VGND VGND VPWR VPWR _0163_ sky130_fd_sc_hd__clkbuf_1
XFILLER_0_120_309 VGND VGND VPWR VPWR sky130_fd_sc_hd__decap_4
X_6507_ _3115_ VGND VGND VPWR VPWR _0756_ sky130_fd_sc_hd__clkbuf_1
XFILLER_0_70_281 VGND VGND VPWR VPWR sky130_fd_sc_hd__decap_8
XFILLER_0_31_635 VGND VGND VPWR VPWR sky130_fd_sc_hd__fill_1
X_4699_ rf.registers\[4\]\[22\] rf.registers\[5\]\[22\] rf.registers\[6\]\[22\] rf.registers\[7\]\[22\]
+ _1382_ _1383_ VGND VGND VPWR VPWR _1472_ sky130_fd_sc_hd__mux4_1
X_6438_ _3055_ VGND VGND VPWR VPWR _3078_ sky130_fd_sc_hd__clkbuf_8
X_9226_ clknet_leaf_71_CLK _0314_ VGND VGND VPWR VPWR rf.registers\[9\]\[25\] sky130_fd_sc_hd__dfxtp_1
XFILLER_0_30_145 VGND VGND VPWR VPWR sky130_fd_sc_hd__fill_1
X_9157_ clknet_leaf_72_CLK _0245_ VGND VGND VPWR VPWR rf.registers\[2\]\[20\] sky130_fd_sc_hd__dfxtp_1
XTAP_TAPCELL_ROW_112_1979 VGND VPWR sky130_fd_sc_hd__tapvpwrvgnd_1
X_8108_ _3359_ rf.registers\[26\]\[6\] _3987_ VGND VGND VPWR VPWR _3994_ sky130_fd_sc_hd__mux2_1
X_6369_ net30 VGND VGND VPWR VPWR _3037_ sky130_fd_sc_hd__buf_2
X_9088_ clknet_leaf_24_CLK _0176_ VGND VGND VPWR VPWR rf.registers\[31\]\[15\] sky130_fd_sc_hd__dfxtp_1
X_8039_ _3957_ VGND VGND VPWR VPWR _0422_ sky130_fd_sc_hd__clkbuf_1
XFILLER_0_85_307 VGND VGND VPWR VPWR sky130_fd_sc_hd__decap_8
XFILLER_0_85_318 VGND VGND VPWR VPWR sky130_fd_sc_hd__fill_2
XFILLER_0_39_713 VGND VGND VPWR VPWR sky130_fd_sc_hd__decap_3
XFILLER_0_39_735 VGND VGND VPWR VPWR sky130_fd_sc_hd__fill_1
XTAP_TAPCELL_ROW_14_505 VGND VPWR sky130_fd_sc_hd__tapvpwrvgnd_1
XTAP_TAPCELL_ROW_14_516 VGND VPWR sky130_fd_sc_hd__tapvpwrvgnd_1
XFILLER_0_39_768 VGND VGND VPWR VPWR sky130_fd_sc_hd__fill_1
XFILLER_0_108_122 VGND VGND VPWR VPWR sky130_fd_sc_hd__fill_2
XFILLER_0_66_587 VGND VGND VPWR VPWR sky130_fd_sc_hd__fill_1
XFILLER_0_66_576 VGND VGND VPWR VPWR sky130_fd_sc_hd__fill_2
XFILLER_0_53_204 VGND VGND VPWR VPWR sky130_fd_sc_hd__fill_1
XFILLER_0_26_429 VGND VGND VPWR VPWR sky130_fd_sc_hd__fill_2
XFILLER_0_136_475 VGND VGND VPWR VPWR sky130_fd_sc_hd__fill_1
XFILLER_0_109_667 VGND VGND VPWR VPWR sky130_fd_sc_hd__decap_4
XFILLER_0_54_749 VGND VGND VPWR VPWR sky130_fd_sc_hd__decap_6
XFILLER_0_19_481 VPWR VGND VPWR VGND sky130_ef_sc_hd__decap_12
XFILLER_0_123_125 VPWR VGND VPWR VGND sky130_ef_sc_hd__decap_12
XANTENNA_8 net14 VGND VGND VPWR VPWR sky130_fd_sc_hd__diode_2
XFILLER_0_123_169 VPWR VGND VPWR VGND sky130_ef_sc_hd__decap_12
XFILLER_0_62_793 VPWR VGND VPWR VGND sky130_ef_sc_hd__decap_12
XFILLER_0_61_281 VGND VGND VPWR VPWR sky130_fd_sc_hd__decap_4
XFILLER_0_22_613 VGND VGND VPWR VPWR sky130_fd_sc_hd__fill_1
XFILLER_0_132_681 VPWR VGND VPWR VGND sky130_ef_sc_hd__decap_12
XTAP_TAPCELL_ROW_74_1407 VGND VPWR sky130_fd_sc_hd__tapvpwrvgnd_1
XFILLER_0_1_529 VPWR VGND VPWR VGND sky130_ef_sc_hd__decap_12
XFILLER_0_21_134 VGND VGND VPWR VPWR sky130_fd_sc_hd__fill_1
XFILLER_0_21_178 VGND VGND VPWR VPWR sky130_fd_sc_hd__decap_8
XFILLER_0_88_145 VGND VGND VPWR VPWR sky130_fd_sc_hd__fill_2
XFILLER_0_16_65 VPWR VGND VPWR VGND sky130_ef_sc_hd__decap_12
XTAP_TAPCELL_ROW_85_1569 VGND VPWR sky130_fd_sc_hd__tapvpwrvgnd_1
XFILLER_0_57_521 VGND VGND VPWR VPWR sky130_fd_sc_hd__fill_1
XFILLER_0_123_33 VPWR VGND VPWR VGND sky130_ef_sc_hd__decap_12
XFILLER_0_85_841 VGND VGND VPWR VPWR sky130_fd_sc_hd__fill_1
X_5740_ _2252_ _2466_ _2236_ VGND VGND VPWR VPWR _2467_ sky130_fd_sc_hd__mux2_2
XFILLER_0_8_139 VGND VGND VPWR VPWR sky130_fd_sc_hd__fill_1
XFILLER_0_32_53 VGND VGND VPWR VPWR sky130_fd_sc_hd__fill_1
XFILLER_0_45_716 VPWR VGND VPWR VGND sky130_ef_sc_hd__decap_12
X_7410_ _3622_ VGND VGND VPWR VPWR _0128_ sky130_fd_sc_hd__clkbuf_1
XFILLER_0_38_790 VPWR VGND VPWR VGND sky130_ef_sc_hd__decap_12
X_5671_ _1643_ _2208_ VGND VGND VPWR VPWR _2400_ sky130_fd_sc_hd__nor2_1
XTAP_TAPCELL_ROW_116_2035 VGND VPWR sky130_fd_sc_hd__tapvpwrvgnd_1
X_8390_ _4143_ VGND VGND VPWR VPWR _0587_ sky130_fd_sc_hd__clkbuf_1
X_4622_ rf.registers\[28\]\[18\] rf.registers\[29\]\[18\] rf.registers\[30\]\[18\]
+ rf.registers\[31\]\[18\] _1393_ _1394_ VGND VGND VPWR VPWR _1399_ sky130_fd_sc_hd__mux4_1
XFILLER_0_4_301 VGND VGND VPWR VPWR sky130_fd_sc_hd__decap_6
XTAP_TAPCELL_ROW_116_2046 VGND VPWR sky130_fd_sc_hd__tapvpwrvgnd_1
X_4553_ rf.registers\[20\]\[14\] rf.registers\[21\]\[14\] rf.registers\[22\]\[14\]
+ rf.registers\[23\]\[14\] _1294_ _1295_ VGND VGND VPWR VPWR _1334_ sky130_fd_sc_hd__mux4_1
X_7341_ rf.registers\[3\]\[31\] _3342_ _3551_ VGND VGND VPWR VPWR _3586_ sky130_fd_sc_hd__mux2_1
XFILLER_0_4_345 VPWR VGND VPWR VGND sky130_ef_sc_hd__decap_12
X_4484_ rf.registers\[20\]\[11\] rf.registers\[21\]\[11\] rf.registers\[22\]\[11\]
+ rf.registers\[23\]\[11\] _1138_ _1121_ VGND VGND VPWR VPWR _1268_ sky130_fd_sc_hd__mux4_1
XFILLER_0_111_821 VPWR VGND VPWR VGND sky130_ef_sc_hd__decap_12
XFILLER_0_4_389 VPWR VGND VPWR VGND sky130_ef_sc_hd__decap_12
X_7272_ _3549_ VGND VGND VPWR VPWR _0063_ sky130_fd_sc_hd__clkbuf_1
X_9011_ clknet_leaf_45_CLK _0099_ VGND VGND VPWR VPWR rf.registers\[8\]\[2\] sky130_fd_sc_hd__dfxtp_1
XFILLER_0_13_679 VGND VGND VPWR VPWR sky130_fd_sc_hd__fill_1
X_6223_ net106 _2794_ _2924_ VGND VGND VPWR VPWR _2925_ sky130_fd_sc_hd__a21bo_1
XFILLER_0_12_189 VGND VGND VPWR VPWR sky130_fd_sc_hd__decap_6
X_6154_ net66 _2859_ VGND VGND VPWR VPWR _2860_ sky130_fd_sc_hd__xnor2_1
X_6085_ _2780_ _1115_ _2504_ VGND VGND VPWR VPWR _2795_ sky130_fd_sc_hd__or3b_1
X_5105_ _1856_ VGND VGND VPWR VPWR net51 sky130_fd_sc_hd__inv_2
X_5036_ _1790_ _1791_ _1663_ VGND VGND VPWR VPWR _1792_ sky130_fd_sc_hd__mux2_1
XFILLER_0_32_3 VPWR VGND VPWR VGND sky130_ef_sc_hd__decap_12
XFILLER_0_138_707 VGND VGND VPWR VPWR sky130_fd_sc_hd__fill_1
XTAP_TAPCELL_ROW_0_288 VGND VPWR sky130_fd_sc_hd__tapvpwrvgnd_1
X_6987_ _3398_ VGND VGND VPWR VPWR _0953_ sky130_fd_sc_hd__clkbuf_1
XFILLER_0_138_729 VPWR VGND VPWR VGND sky130_ef_sc_hd__decap_12
XFILLER_0_137_217 VGND VGND VPWR VPWR sky130_fd_sc_hd__decap_6
X_8726_ clknet_leaf_64_CLK _0838_ VGND VGND VPWR VPWR rf.registers\[10\]\[5\] sky130_fd_sc_hd__dfxtp_1
XTAP_TAPCELL_ROW_0_299 VGND VPWR sky130_fd_sc_hd__tapvpwrvgnd_1
X_5938_ _2655_ _2656_ VGND VGND VPWR VPWR _2657_ sky130_fd_sc_hd__nor2_1
X_8657_ clknet_leaf_40_CLK _0769_ VGND VGND VPWR VPWR rf.registers\[1\]\[0\] sky130_fd_sc_hd__dfxtp_1
XFILLER_0_91_833 VGND VGND VPWR VPWR sky130_fd_sc_hd__decap_6
X_5869_ _2589_ _2590_ VGND VGND VPWR VPWR _2591_ sky130_fd_sc_hd__or2b_1
XFILLER_0_106_637 VGND VGND VPWR VPWR sky130_fd_sc_hd__fill_1
XFILLER_0_90_365 VGND VGND VPWR VPWR sky130_fd_sc_hd__fill_1
XFILLER_0_7_161 VGND VGND VPWR VPWR sky130_fd_sc_hd__decap_6
X_8588_ clknet_leaf_86_CLK _0700_ VGND VGND VPWR VPWR rf.registers\[12\]\[27\] sky130_fd_sc_hd__dfxtp_1
X_7608_ _2974_ rf.registers\[27\]\[28\] _3719_ VGND VGND VPWR VPWR _3728_ sky130_fd_sc_hd__mux2_1
X_7539_ _3691_ VGND VGND VPWR VPWR _0188_ sky130_fd_sc_hd__clkbuf_1
XFILLER_0_43_270 VGND VGND VPWR VPWR sky130_fd_sc_hd__decap_8
XFILLER_0_44_782 VPWR VGND VPWR VGND sky130_ef_sc_hd__decap_12
XFILLER_0_105_169 VGND VGND VPWR VPWR sky130_fd_sc_hd__fill_2
XFILLER_0_43_281 VGND VGND VPWR VPWR sky130_fd_sc_hd__fill_1
XFILLER_0_120_139 VGND VGND VPWR VPWR sky130_fd_sc_hd__fill_1
X_9209_ clknet_leaf_48_CLK _0297_ VGND VGND VPWR VPWR rf.registers\[9\]\[8\] sky130_fd_sc_hd__dfxtp_1
XTAP_TAPCELL_ROW_56_1137 VGND VPWR sky130_fd_sc_hd__tapvpwrvgnd_1
XFILLER_0_101_353 VGND VGND VPWR VPWR sky130_fd_sc_hd__fill_1
Xoutput67 net67 VGND VGND VPWR VPWR RD1[26] sky130_fd_sc_hd__buf_1
Xoutput56 net56 VGND VGND VPWR VPWR RD1[16] sky130_fd_sc_hd__buf_1
Xoutput89 net89 VGND VGND VPWR VPWR RD2[17] sky130_fd_sc_hd__buf_1
Xoutput78 net78 VGND VGND VPWR VPWR RD1[7] sky130_fd_sc_hd__buf_1
XFILLER_0_98_421 VGND VGND VPWR VPWR sky130_fd_sc_hd__decap_4
XPHY_EDGE_ROW_113_Right_113 VGND VGND VPWR VPWR sky130_fd_sc_hd__decap_3
XFILLER_0_39_521 VGND VGND VPWR VPWR sky130_fd_sc_hd__fill_2
XFILLER_0_129_729 VPWR VGND VPWR VGND sky130_ef_sc_hd__decap_12
XFILLER_0_67_841 VGND VGND VPWR VPWR sky130_fd_sc_hd__fill_1
XTAP_TAPCELL_ROW_67_1299 VGND VPWR sky130_fd_sc_hd__tapvpwrvgnd_1
XFILLER_0_82_811 VGND VGND VPWR VPWR sky130_fd_sc_hd__fill_1
XFILLER_0_81_332 VGND VGND VPWR VPWR sky130_fd_sc_hd__decap_4
XFILLER_0_81_321 VGND VGND VPWR VPWR sky130_fd_sc_hd__decap_4
XTAP_TAPCELL_ROW_80_1499 VGND VPWR sky130_fd_sc_hd__tapvpwrvgnd_1
XFILLER_0_2_805 VGND VGND VPWR VPWR sky130_fd_sc_hd__decap_6
XFILLER_0_35_782 VGND VGND VPWR VPWR sky130_fd_sc_hd__fill_2
XFILLER_0_41_207 VGND VGND VPWR VPWR sky130_fd_sc_hd__fill_2
XFILLER_0_78_38 VGND VGND VPWR VPWR sky130_fd_sc_hd__decap_6
XFILLER_0_22_421 VPWR VGND VPWR VGND sky130_ef_sc_hd__decap_12
XFILLER_0_1_337 VPWR VGND VPWR VGND sky130_ef_sc_hd__decap_12
XFILLER_0_120_662 VPWR VGND VPWR VGND sky130_ef_sc_hd__decap_12
XFILLER_0_94_15 VPWR VGND VPWR VGND sky130_ef_sc_hd__decap_12
XTAP_TAPCELL_ROW_87_1609 VGND VPWR sky130_fd_sc_hd__tapvpwrvgnd_1
XFILLER_0_27_42 VGND VGND VPWR VPWR sky130_fd_sc_hd__decap_8
XFILLER_0_118_77 VGND VGND VPWR VPWR sky130_fd_sc_hd__decap_6
X_6910_ _2964_ _3345_ VGND VGND VPWR VPWR _3346_ sky130_fd_sc_hd__nand2_2
X_7890_ _3345_ _3877_ VGND VGND VPWR VPWR _3878_ sky130_fd_sc_hd__nand2_4
XFILLER_0_77_638 VGND VGND VPWR VPWR sky130_fd_sc_hd__fill_1
X_6841_ _3277_ VGND VGND VPWR VPWR _3299_ sky130_fd_sc_hd__clkbuf_8
XFILLER_0_134_65 VPWR VGND VPWR VGND sky130_ef_sc_hd__decap_12
XFILLER_0_119_217 VGND VGND VPWR VPWR sky130_fd_sc_hd__decap_6
X_9560_ clknet_leaf_51_CLK _0648_ VGND VGND VPWR VPWR rf.registers\[13\]\[7\] sky130_fd_sc_hd__dfxtp_1
XTAP_TAPCELL_ROW_46_983 VGND VPWR sky130_fd_sc_hd__tapvpwrvgnd_1
XTAP_TAPCELL_ROW_46_994 VGND VPWR sky130_fd_sc_hd__tapvpwrvgnd_1
X_8511_ _2995_ rf.registers\[13\]\[4\] _4205_ VGND VGND VPWR VPWR _4207_ sky130_fd_sc_hd__mux2_1
X_6772_ _3257_ VGND VGND VPWR VPWR _0879_ sky130_fd_sc_hd__clkbuf_1
XFILLER_0_85_682 VPWR VGND VPWR VGND sky130_ef_sc_hd__decap_12
XFILLER_0_18_716 VPWR VGND VPWR VGND sky130_ef_sc_hd__decap_12
XFILLER_0_134_209 VPWR VGND VPWR VGND sky130_ef_sc_hd__decap_12
X_9491_ clknet_leaf_43_CLK _0579_ VGND VGND VPWR VPWR rf.registers\[18\]\[2\] sky130_fd_sc_hd__dfxtp_1
XFILLER_0_73_833 VGND VGND VPWR VPWR sky130_fd_sc_hd__decap_6
XFILLER_0_17_237 VGND VGND VPWR VPWR sky130_fd_sc_hd__decap_4
X_5723_ net106 _2446_ _2450_ VGND VGND VPWR VPWR _2451_ sky130_fd_sc_hd__a21o_1
XFILLER_0_45_546 VGND VGND VPWR VPWR sky130_fd_sc_hd__decap_4
XFILLER_0_127_261 VPWR VGND VPWR VGND sky130_ef_sc_hd__decap_12
X_8442_ _2993_ rf.registers\[14\]\[3\] _4167_ VGND VGND VPWR VPWR _4171_ sky130_fd_sc_hd__mux2_1
X_5654_ _2379_ _2382_ _2383_ VGND VGND VPWR VPWR _2384_ sky130_fd_sc_hd__mux2_1
X_8373_ _4134_ VGND VGND VPWR VPWR _0579_ sky130_fd_sc_hd__clkbuf_1
XFILLER_0_5_665 VGND VGND VPWR VPWR sky130_fd_sc_hd__decap_6
XFILLER_0_26_793 VPWR VGND VPWR VGND sky130_ef_sc_hd__decap_12
X_4605_ _1284_ VGND VGND VPWR VPWR _1383_ sky130_fd_sc_hd__clkbuf_4
X_5585_ net106 _2295_ _2315_ VGND VGND VPWR VPWR _2316_ sky130_fd_sc_hd__a21oi_1
XFILLER_0_4_153 VPWR VGND VPWR VGND sky130_ef_sc_hd__decap_12
X_7324_ _3577_ VGND VGND VPWR VPWR _0087_ sky130_fd_sc_hd__clkbuf_1
X_4536_ rf.registers\[4\]\[13\] rf.registers\[5\]\[13\] rf.registers\[6\]\[13\] rf.registers\[7\]\[13\]
+ _1120_ _1123_ VGND VGND VPWR VPWR _1318_ sky130_fd_sc_hd__mux4_1
XFILLER_0_4_197 VPWR VGND VPWR VGND sky130_ef_sc_hd__decap_12
XFILLER_0_40_251 VGND VGND VPWR VPWR sky130_fd_sc_hd__fill_1
XFILLER_0_41_774 VGND VGND VPWR VPWR sky130_fd_sc_hd__fill_1
XFILLER_0_41_785 VPWR VGND VPWR VGND sky130_ef_sc_hd__decap_12
X_4467_ rf.registers\[20\]\[10\] rf.registers\[21\]\[10\] rf.registers\[22\]\[10\]
+ rf.registers\[23\]\[10\] _1042_ _1044_ VGND VGND VPWR VPWR _1252_ sky130_fd_sc_hd__mux4_1
X_7255_ rf.registers\[19\]\[22\] _3324_ _3538_ VGND VGND VPWR VPWR _3541_ sky130_fd_sc_hd__mux2_1
X_4398_ rf.registers\[24\]\[6\] rf.registers\[25\]\[6\] rf.registers\[26\]\[6\] rf.registers\[27\]\[6\]
+ _1183_ _1181_ VGND VGND VPWR VPWR _1187_ sky130_fd_sc_hd__mux4_1
X_7186_ _3504_ VGND VGND VPWR VPWR _0022_ sky130_fd_sc_hd__clkbuf_1
X_6206_ _2907_ _2908_ VGND VGND VPWR VPWR _2909_ sky130_fd_sc_hd__nor2_1
XTAP_TAPCELL_ROW_129_2237 VGND VPWR sky130_fd_sc_hd__tapvpwrvgnd_1
XFILLER_0_110_194 VGND VGND VPWR VPWR sky130_fd_sc_hd__fill_2
X_6137_ _2566_ _2780_ VGND VGND VPWR VPWR _2844_ sky130_fd_sc_hd__or2_1
XTAP_TAPCELL_ROW_51_1067 VGND VPWR sky130_fd_sc_hd__tapvpwrvgnd_1
XTAP_TAPCELL_ROW_5_369 VGND VPWR sky130_fd_sc_hd__tapvpwrvgnd_1
X_6068_ _2463_ _2778_ _2398_ VGND VGND VPWR VPWR _2779_ sky130_fd_sc_hd__o21ai_1
X_5019_ _1774_ _1775_ _1747_ VGND VGND VPWR VPWR _1776_ sky130_fd_sc_hd__mux2_1
XFILLER_0_68_605 VGND VGND VPWR VPWR sky130_fd_sc_hd__fill_1
XFILLER_0_49_841 VGND VGND VPWR VPWR sky130_fd_sc_hd__fill_1
XFILLER_0_64_811 VGND VGND VPWR VPWR sky130_fd_sc_hd__fill_1
XFILLER_0_76_693 VGND VGND VPWR VPWR sky130_fd_sc_hd__decap_6
XTAP_TAPCELL_ROW_24_655 VGND VPWR sky130_fd_sc_hd__tapvpwrvgnd_1
XTAP_TAPCELL_ROW_24_666 VGND VPWR sky130_fd_sc_hd__tapvpwrvgnd_1
X_8709_ clknet_leaf_83_CLK _0821_ VGND VGND VPWR VPWR rf.registers\[24\]\[20\] sky130_fd_sc_hd__dfxtp_1
XFILLER_0_106_401 VGND VGND VPWR VPWR sky130_fd_sc_hd__decap_3
XFILLER_0_24_719 VGND VGND VPWR VPWR sky130_fd_sc_hd__decap_8
XFILLER_0_23_207 VGND VGND VPWR VPWR sky130_fd_sc_hd__fill_1
XFILLER_0_102_673 VPWR VGND VPWR VGND sky130_ef_sc_hd__decap_12
XTAP_TAPCELL_ROW_69_1328 VGND VPWR sky130_fd_sc_hd__tapvpwrvgnd_1
XFILLER_0_64_29 VGND VGND VPWR VPWR sky130_fd_sc_hd__decap_4
XFILLER_0_99_741 VPWR VGND VPWR VGND sky130_ef_sc_hd__decap_12
XTAP_TAPCELL_ROW_69_1339 VGND VPWR sky130_fd_sc_hd__tapvpwrvgnd_1
XFILLER_0_99_785 VPWR VGND VPWR VGND sky130_ef_sc_hd__decap_12
XTAP_TAPCELL_ROW_82_1528 VGND VPWR sky130_fd_sc_hd__tapvpwrvgnd_1
XFILLER_0_67_671 VGND VGND VPWR VPWR sky130_fd_sc_hd__fill_1
XTAP_TAPCELL_ROW_43_942 VGND VPWR sky130_fd_sc_hd__tapvpwrvgnd_1
XFILLER_0_116_209 VPWR VGND VPWR VGND sky130_ef_sc_hd__decap_12
XFILLER_0_55_833 VGND VGND VPWR VPWR sky130_fd_sc_hd__decap_6
XFILLER_0_13_55 VGND VGND VPWR VPWR sky130_fd_sc_hd__fill_1
XFILLER_0_27_535 VPWR VGND VPWR VGND sky130_ef_sc_hd__decap_12
XFILLER_0_125_721 VGND VGND VPWR VPWR sky130_fd_sc_hd__decap_6
XFILLER_0_89_15 VPWR VGND VPWR VGND sky130_ef_sc_hd__decap_12
XFILLER_0_125_765 VPWR VGND VPWR VGND sky130_ef_sc_hd__decap_12
XFILLER_0_82_685 VPWR VGND VPWR VGND sky130_ef_sc_hd__decap_12
XFILLER_0_81_151 VGND VGND VPWR VPWR sky130_fd_sc_hd__fill_2
XFILLER_0_70_825 VPWR VGND VPWR VGND sky130_ef_sc_hd__decap_12
XFILLER_0_54_387 VGND VGND VPWR VPWR sky130_fd_sc_hd__decap_6
XFILLER_0_124_253 VPWR VGND VPWR VGND sky130_ef_sc_hd__decap_12
XTAP_TAPCELL_ROW_97_1760 VGND VPWR sky130_fd_sc_hd__tapvpwrvgnd_1
XFILLER_0_2_613 VPWR VGND VPWR VGND sky130_ef_sc_hd__decap_12
XFILLER_0_42_549 VGND VGND VPWR VPWR sky130_fd_sc_hd__decap_6
XFILLER_0_2_657 VPWR VGND VPWR VGND sky130_ef_sc_hd__decap_12
XFILLER_0_23_785 VPWR VGND VPWR VGND sky130_ef_sc_hd__decap_12
X_5370_ _2105_ _2106_ _2081_ VGND VGND VPWR VPWR _2107_ sky130_fd_sc_hd__mux2_1
X_4321_ _1052_ _1100_ _1104_ _1108_ _1112_ VGND VGND VPWR VPWR _1113_ sky130_fd_sc_hd__a32o_4
XFILLER_0_10_413 VGND VGND VPWR VPWR sky130_fd_sc_hd__decap_6
XFILLER_0_1_167 VGND VGND VPWR VPWR sky130_fd_sc_hd__fill_1
X_4252_ _1045_ _1046_ net6 VGND VGND VPWR VPWR _1047_ sky130_fd_sc_hd__mux2_1
X_7040_ rf.registers\[6\]\[17\] _3313_ _3419_ VGND VGND VPWR VPWR _3427_ sky130_fd_sc_hd__mux2_1
XFILLER_0_10_457 VPWR VGND VPWR VGND sky130_ef_sc_hd__decap_12
XFILLER_0_38_41 VGND VGND VPWR VPWR sky130_fd_sc_hd__decap_6
XFILLER_0_38_85 VGND VGND VPWR VPWR sky130_fd_sc_hd__fill_2
X_8991_ clknet_leaf_16_CLK _0079_ VGND VGND VPWR VPWR rf.registers\[3\]\[14\] sky130_fd_sc_hd__dfxtp_1
XTAP_TAPCELL_ROW_2_328 VGND VPWR sky130_fd_sc_hd__tapvpwrvgnd_1
X_7942_ _3397_ rf.registers\[23\]\[24\] _3901_ VGND VGND VPWR VPWR _3906_ sky130_fd_sc_hd__mux2_1
XTAP_TAPCELL_ROW_124_2167 VGND VPWR sky130_fd_sc_hd__tapvpwrvgnd_1
XTAP_TAPCELL_ROW_124_2156 VGND VPWR sky130_fd_sc_hd__tapvpwrvgnd_1
XFILLER_0_77_402 VPWR VGND VPWR VGND sky130_ef_sc_hd__decap_12
XFILLER_0_77_446 VGND VGND VPWR VPWR sky130_fd_sc_hd__fill_2
X_7873_ _3397_ rf.registers\[28\]\[24\] _3864_ VGND VGND VPWR VPWR _3869_ sky130_fd_sc_hd__mux2_1
X_6824_ _3287_ VGND VGND VPWR VPWR _0901_ sky130_fd_sc_hd__clkbuf_1
XFILLER_0_9_223 VGND VGND VPWR VPWR sky130_fd_sc_hd__fill_1
XFILLER_0_46_811 VGND VGND VPWR VPWR sky130_fd_sc_hd__fill_1
X_6755_ _3248_ VGND VGND VPWR VPWR _0871_ sky130_fd_sc_hd__clkbuf_1
XFILLER_0_70_61 VGND VGND VPWR VPWR sky130_fd_sc_hd__fill_2
XFILLER_0_64_118 VGND VGND VPWR VPWR sky130_fd_sc_hd__fill_1
X_9543_ clknet_leaf_4_CLK _0631_ VGND VGND VPWR VPWR rf.registers\[14\]\[22\] sky130_fd_sc_hd__dfxtp_1
XFILLER_0_58_693 VGND VGND VPWR VPWR sky130_fd_sc_hd__decap_6
XFILLER_0_18_513 VPWR VGND VPWR VGND sky130_ef_sc_hd__decap_12
XFILLER_0_135_529 VPWR VGND VPWR VGND sky130_ef_sc_hd__decap_12
X_9474_ clknet_leaf_11_CLK _0562_ VGND VGND VPWR VPWR rf.registers\[20\]\[17\] sky130_fd_sc_hd__dfxtp_1
XFILLER_0_18_557 VPWR VGND VPWR VGND sky130_ef_sc_hd__decap_12
XTAP_TAPCELL_ROW_21_614 VGND VPWR sky130_fd_sc_hd__tapvpwrvgnd_1
X_5706_ _1682_ _2425_ VGND VGND VPWR VPWR _2434_ sky130_fd_sc_hd__nor2_1
XFILLER_0_115_220 VGND VGND VPWR VPWR sky130_fd_sc_hd__decap_4
X_6686_ rf.registers\[10\]\[6\] _2999_ _3205_ VGND VGND VPWR VPWR _3212_ sky130_fd_sc_hd__mux2_1
X_8425_ _4161_ VGND VGND VPWR VPWR _0604_ sky130_fd_sc_hd__clkbuf_1
XFILLER_0_5_473 VPWR VGND VPWR VGND sky130_ef_sc_hd__decap_12
X_5637_ _2363_ _2366_ _2332_ VGND VGND VPWR VPWR _2367_ sky130_fd_sc_hd__mux2_1
XFILLER_0_14_752 VGND VGND VPWR VPWR sky130_fd_sc_hd__decap_4
X_8356_ rf.registers\[20\]\[27\] net33 _4117_ VGND VGND VPWR VPWR _4125_ sky130_fd_sc_hd__mux2_1
X_5568_ _2241_ _2298_ VGND VGND VPWR VPWR _2299_ sky130_fd_sc_hd__nand2_1
XFILLER_0_130_245 VGND VGND VPWR VPWR sky130_fd_sc_hd__decap_6
X_7307_ _3568_ VGND VGND VPWR VPWR _0079_ sky130_fd_sc_hd__clkbuf_1
XFILLER_0_13_273 VGND VGND VPWR VPWR sky130_fd_sc_hd__decap_6
X_8287_ _4088_ VGND VGND VPWR VPWR _0539_ sky130_fd_sc_hd__clkbuf_1
X_4519_ _1139_ VGND VGND VPWR VPWR _1302_ sky130_fd_sc_hd__clkbuf_8
XFILLER_0_41_593 VGND VGND VPWR VPWR sky130_fd_sc_hd__fill_2
XFILLER_0_130_289 VPWR VGND VPWR VGND sky130_ef_sc_hd__decap_12
XFILLER_0_111_481 VGND VGND VPWR VPWR sky130_fd_sc_hd__fill_2
X_7238_ rf.registers\[19\]\[14\] _3307_ _3527_ VGND VGND VPWR VPWR _3532_ sky130_fd_sc_hd__mux2_1
X_5499_ _1826_ _2205_ VGND VGND VPWR VPWR _2230_ sky130_fd_sc_hd__nor2_1
X_7169_ _3495_ VGND VGND VPWR VPWR _0014_ sky130_fd_sc_hd__clkbuf_1
XTAP_TAPCELL_ROW_109_1929 VGND VPWR sky130_fd_sc_hd__tapvpwrvgnd_1
XTAP_TAPCELL_ROW_29_736 VGND VPWR sky130_fd_sc_hd__tapvpwrvgnd_1
XFILLER_0_96_755 VGND VGND VPWR VPWR sky130_fd_sc_hd__fill_1
XTAP_TAPCELL_ROW_64_1258 VGND VPWR sky130_fd_sc_hd__tapvpwrvgnd_1
XFILLER_0_37_800 VPWR VGND VPWR VGND sky130_ef_sc_hd__decap_12
XFILLER_0_83_449 VGND VGND VPWR VPWR sky130_fd_sc_hd__decap_8
XTAP_TAPCELL_ROW_40_901 VGND VPWR sky130_fd_sc_hd__tapvpwrvgnd_1
XFILLER_0_138_389 VGND VGND VPWR VPWR sky130_fd_sc_hd__decap_3
XFILLER_0_107_721 VGND VGND VPWR VPWR sky130_fd_sc_hd__decap_6
XFILLER_0_107_765 VPWR VGND VPWR VGND sky130_ef_sc_hd__decap_12
XFILLER_0_52_825 VGND VGND VPWR VPWR sky130_fd_sc_hd__decap_8
XFILLER_0_51_313 VGND VGND VPWR VPWR sky130_fd_sc_hd__decap_6
XFILLER_0_134_573 VGND VGND VPWR VPWR sky130_fd_sc_hd__decap_6
XFILLER_0_122_713 VPWR VGND VPWR VGND sky130_ef_sc_hd__decap_12
XFILLER_0_106_253 VGND VGND VPWR VPWR sky130_fd_sc_hd__fill_1
XFILLER_0_24_549 VGND VGND VPWR VPWR sky130_fd_sc_hd__fill_1
XFILLER_0_122_757 VPWR VGND VPWR VGND sky130_ef_sc_hd__decap_12
XFILLER_0_121_223 VGND VGND VPWR VPWR sky130_fd_sc_hd__fill_1
XTAP_TAPCELL_ROW_79_1490 VGND VPWR sky130_fd_sc_hd__tapvpwrvgnd_1
XFILLER_0_20_777 VGND VGND VPWR VPWR sky130_fd_sc_hd__fill_2
XFILLER_0_115_45 VGND VGND VPWR VPWR sky130_fd_sc_hd__decap_8
X_4870_ rf.registers\[8\]\[0\] rf.registers\[9\]\[0\] rf.registers\[10\]\[0\] rf.registers\[11\]\[0\]
+ _1631_ _1632_ VGND VGND VPWR VPWR _1633_ sky130_fd_sc_hd__mux4_1
XFILLER_0_87_777 VGND VGND VPWR VPWR sky130_fd_sc_hd__decap_6
X_6540_ rf.registers\[1\]\[2\] _2991_ _3131_ VGND VGND VPWR VPWR _3134_ sky130_fd_sc_hd__mux2_1
XFILLER_0_131_55 VGND VGND VPWR VPWR sky130_fd_sc_hd__fill_1
XFILLER_0_55_685 VPWR VGND VPWR VGND sky130_ef_sc_hd__decap_12
XFILLER_0_15_505 VPWR VGND VPWR VGND sky130_ef_sc_hd__decap_12
X_6471_ rf.registers\[17\]\[2\] _2991_ _3094_ VGND VGND VPWR VPWR _3097_ sky130_fd_sc_hd__mux2_1
XFILLER_0_113_724 VGND VGND VPWR VPWR sky130_fd_sc_hd__decap_4
XTAP_TAPCELL_ROW_95_1719 VGND VPWR sky130_fd_sc_hd__tapvpwrvgnd_1
XFILLER_0_71_7 VPWR VGND VPWR VGND sky130_ef_sc_hd__decap_12
X_9190_ clknet_leaf_81_CLK _0278_ VGND VGND VPWR VPWR rf.registers\[30\]\[21\] sky130_fd_sc_hd__dfxtp_1
XFILLER_0_2_421 VPWR VGND VPWR VGND sky130_ef_sc_hd__decap_12
X_5422_ _2152_ _2155_ _1948_ VGND VGND VPWR VPWR _2156_ sky130_fd_sc_hd__mux2_1
X_8210_ _3393_ rf.registers\[21\]\[22\] _4045_ VGND VGND VPWR VPWR _4048_ sky130_fd_sc_hd__mux2_1
X_8141_ _4011_ VGND VGND VPWR VPWR _0470_ sky130_fd_sc_hd__clkbuf_1
X_5353_ _2085_ _2088_ _2089_ _2090_ _1955_ _1948_ VGND VGND VPWR VPWR _2091_ sky130_fd_sc_hd__mux4_2
XFILLER_0_49_73 VGND VGND VPWR VPWR sky130_fd_sc_hd__fill_1
XFILLER_0_10_221 VPWR VGND VPWR VGND sky130_ef_sc_hd__decap_12
XTAP_TAPCELL_ROW_7_409 VGND VPWR sky130_fd_sc_hd__tapvpwrvgnd_1
X_4304_ _1096_ VGND VGND VPWR VPWR net103 sky130_fd_sc_hd__clkbuf_8
X_5284_ _2024_ _2025_ _1927_ VGND VGND VPWR VPWR _2026_ sky130_fd_sc_hd__mux2_1
X_8072_ rf.registers\[7\]\[21\] _3322_ _3973_ VGND VGND VPWR VPWR _3975_ sky130_fd_sc_hd__mux2_1
XFILLER_0_10_265 VPWR VGND VPWR VGND sky130_ef_sc_hd__decap_12
X_4235_ net6 VGND VGND VPWR VPWR _1030_ sky130_fd_sc_hd__inv_2
X_7023_ rf.registers\[6\]\[9\] _3296_ _3408_ VGND VGND VPWR VPWR _3418_ sky130_fd_sc_hd__mux2_1
XFILLER_0_4_53 VPWR VGND VPWR VGND sky130_ef_sc_hd__decap_12
XFILLER_0_4_97 VPWR VGND VPWR VGND sky130_ef_sc_hd__decap_12
X_8974_ clknet_leaf_93_CLK _0062_ VGND VGND VPWR VPWR rf.registers\[19\]\[29\] sky130_fd_sc_hd__dfxtp_1
X_7925_ _3380_ rf.registers\[23\]\[16\] _3890_ VGND VGND VPWR VPWR _3897_ sky130_fd_sc_hd__mux2_1
XFILLER_0_78_755 VGND VGND VPWR VPWR sky130_fd_sc_hd__fill_1
XTAP_TAPCELL_ROW_104_1859 VGND VPWR sky130_fd_sc_hd__tapvpwrvgnd_1
X_7856_ _3380_ rf.registers\[28\]\[16\] _3853_ VGND VGND VPWR VPWR _3860_ sky130_fd_sc_hd__mux2_1
XFILLER_0_136_805 VGND VGND VPWR VPWR sky130_fd_sc_hd__decap_6
X_6807_ _3275_ VGND VGND VPWR VPWR _0896_ sky130_fd_sc_hd__clkbuf_1
XFILLER_0_19_833 VGND VGND VPWR VPWR sky130_fd_sc_hd__decap_6
X_7787_ _3823_ VGND VGND VPWR VPWR _0304_ sky130_fd_sc_hd__clkbuf_1
X_4999_ _1728_ _1743_ _1756_ VGND VGND VPWR VPWR _1757_ sky130_fd_sc_hd__o21ai_4
X_9526_ clknet_leaf_64_CLK _0614_ VGND VGND VPWR VPWR rf.registers\[14\]\[5\] sky130_fd_sc_hd__dfxtp_1
XFILLER_0_46_652 VGND VGND VPWR VPWR sky130_fd_sc_hd__decap_4
XTAP_TAPCELL_ROW_137_2358 VGND VPWR sky130_fd_sc_hd__tapvpwrvgnd_1
XFILLER_0_135_337 VPWR VGND VPWR VGND sky130_ef_sc_hd__decap_12
X_6738_ rf.registers\[10\]\[31\] _3051_ _3204_ VGND VGND VPWR VPWR _3239_ sky130_fd_sc_hd__mux2_1
XFILLER_0_34_825 VGND VGND VPWR VPWR sky130_fd_sc_hd__decap_8
XFILLER_0_45_151 VGND VGND VPWR VPWR sky130_fd_sc_hd__fill_1
X_9457_ clknet_leaf_39_CLK _0545_ VGND VGND VPWR VPWR rf.registers\[20\]\[0\] sky130_fd_sc_hd__dfxtp_1
XFILLER_0_116_573 VGND VGND VPWR VPWR sky130_fd_sc_hd__fill_2
XFILLER_0_104_713 VPWR VGND VPWR VGND sky130_ef_sc_hd__decap_12
XFILLER_0_18_398 VPWR VGND VPWR VGND sky130_ef_sc_hd__decap_12
X_6669_ rf.registers\[24\]\[31\] _3051_ _3167_ VGND VGND VPWR VPWR _3202_ sky130_fd_sc_hd__mux2_1
XFILLER_0_104_757 VPWR VGND VPWR VGND sky130_ef_sc_hd__decap_12
X_8408_ _4152_ VGND VGND VPWR VPWR _0596_ sky130_fd_sc_hd__clkbuf_1
XFILLER_0_6_793 VPWR VGND VPWR VGND sky130_ef_sc_hd__decap_12
XFILLER_0_5_281 VPWR VGND VPWR VGND sky130_ef_sc_hd__decap_12
X_9388_ clknet_leaf_87_CLK _0476_ VGND VGND VPWR VPWR rf.registers\[26\]\[27\] sky130_fd_sc_hd__dfxtp_1
X_8339_ rf.registers\[20\]\[19\] net24 _4106_ VGND VGND VPWR VPWR _4116_ sky130_fd_sc_hd__mux2_1
XFILLER_0_60_187 VGND VGND VPWR VPWR sky130_fd_sc_hd__decap_8
XFILLER_0_69_777 VGND VGND VPWR VPWR sky130_fd_sc_hd__decap_6
XFILLER_0_84_725 VPWR VGND VPWR VGND sky130_ef_sc_hd__decap_12
XFILLER_0_68_287 VGND VGND VPWR VPWR sky130_fd_sc_hd__fill_1
XFILLER_0_84_769 VPWR VGND VPWR VGND sky130_ef_sc_hd__decap_12
XFILLER_0_64_493 VGND VGND VPWR VPWR sky130_fd_sc_hd__decap_6
XFILLER_0_52_622 VPWR VGND VPWR VGND sky130_ef_sc_hd__decap_12
XFILLER_0_51_110 VGND VGND VPWR VPWR sky130_fd_sc_hd__fill_2
XTAP_TAPCELL_ROW_12_477 VGND VPWR sky130_fd_sc_hd__tapvpwrvgnd_1
XFILLER_0_52_666 VGND VGND VPWR VPWR sky130_fd_sc_hd__fill_1
XFILLER_0_51_154 VPWR VGND VPWR VGND sky130_ef_sc_hd__decap_12
XFILLER_0_101_69 VGND VGND VPWR VPWR sky130_fd_sc_hd__decap_4
XTAP_TAPCELL_ROW_77_1449 VGND VPWR sky130_fd_sc_hd__tapvpwrvgnd_1
XFILLER_0_110_749 VGND VGND VPWR VPWR sky130_fd_sc_hd__decap_6
XFILLER_0_86_27 VGND VGND VPWR VPWR sky130_fd_sc_hd__fill_1
XFILLER_0_20_541 VGND VGND VPWR VPWR sky130_fd_sc_hd__fill_1
XTAP_TAPCELL_ROW_90_1649 VGND VPWR sky130_fd_sc_hd__tapvpwrvgnd_1
XFILLER_0_19_21 VPWR VGND VPWR VGND sky130_ef_sc_hd__decap_12
XFILLER_0_20_585 VGND VGND VPWR VPWR sky130_fd_sc_hd__decap_3
XFILLER_0_35_31 VPWR VGND VPWR VGND sky130_ef_sc_hd__decap_12
XFILLER_0_126_77 VGND VGND VPWR VPWR sky130_fd_sc_hd__decap_6
XTAP_TAPCELL_ROW_121_2115 VGND VPWR sky130_fd_sc_hd__tapvpwrvgnd_1
X_5971_ _1158_ _2685_ _2686_ _2358_ _2687_ VGND VGND VPWR VPWR _2688_ sky130_fd_sc_hd__a32o_1
X_8690_ clknet_leaf_42_CLK _0802_ VGND VGND VPWR VPWR rf.registers\[24\]\[1\] sky130_fd_sc_hd__dfxtp_1
X_7710_ _3370_ rf.registers\[30\]\[11\] _3781_ VGND VGND VPWR VPWR _3783_ sky130_fd_sc_hd__mux2_1
X_4922_ _1682_ VGND VGND VPWR VPWR net71 sky130_fd_sc_hd__inv_2
XFILLER_0_118_805 VGND VGND VPWR VPWR sky130_fd_sc_hd__decap_6
X_7641_ rf.registers\[2\]\[11\] _3301_ _3744_ VGND VGND VPWR VPWR _3746_ sky130_fd_sc_hd__mux2_1
X_4853_ net5 VGND VGND VPWR VPWR _1616_ sky130_fd_sc_hd__inv_2
XFILLER_0_117_337 VGND VGND VPWR VPWR sky130_fd_sc_hd__fill_2
X_7572_ _3709_ VGND VGND VPWR VPWR _0203_ sky130_fd_sc_hd__clkbuf_1
XFILLER_0_16_825 VPWR VGND VPWR VGND sky130_ef_sc_hd__decap_12
X_4784_ _1550_ _1551_ _1134_ VGND VGND VPWR VPWR _1552_ sky130_fd_sc_hd__mux2_1
XFILLER_0_132_307 VGND VGND VPWR VPWR sky130_fd_sc_hd__fill_1
X_9311_ clknet_leaf_25_CLK _0399_ VGND VGND VPWR VPWR rf.registers\[22\]\[14\] sky130_fd_sc_hd__dfxtp_1
XFILLER_0_15_335 VGND VGND VPWR VPWR sky130_fd_sc_hd__fill_1
X_6523_ rf.registers\[17\]\[27\] _3043_ _3116_ VGND VGND VPWR VPWR _3124_ sky130_fd_sc_hd__mux2_1
XTAP_TAPCELL_ROW_31_764 VGND VPWR sky130_fd_sc_hd__tapvpwrvgnd_1
XFILLER_0_125_381 VGND VGND VPWR VPWR sky130_fd_sc_hd__fill_2
XTAP_TAPCELL_ROW_119_2088 VGND VPWR sky130_fd_sc_hd__tapvpwrvgnd_1
X_9242_ clknet_leaf_56_CLK _0330_ VGND VGND VPWR VPWR rf.registers\[28\]\[9\] sky130_fd_sc_hd__dfxtp_1
X_6454_ _3086_ VGND VGND VPWR VPWR _0732_ sky130_fd_sc_hd__clkbuf_1
Xclkload61 clknet_leaf_59_CLK VGND VGND VPWR VPWR clkload61/Y sky130_fd_sc_hd__clkinv_8
XFILLER_0_70_474 VGND VGND VPWR VPWR sky130_fd_sc_hd__fill_2
Xclkload50 clknet_leaf_78_CLK VGND VGND VPWR VPWR clkload50/Y sky130_fd_sc_hd__inv_6
XFILLER_0_3_741 VPWR VGND VPWR VGND sky130_ef_sc_hd__decap_12
XFILLER_0_31_839 VGND VGND VPWR VPWR sky130_fd_sc_hd__fill_1
X_5405_ _2136_ _2139_ _1950_ VGND VGND VPWR VPWR _2140_ sky130_fd_sc_hd__mux2_1
XFILLER_0_43_699 VGND VGND VPWR VPWR sky130_fd_sc_hd__decap_4
XTAP_TAPCELL_ROW_132_2277 VGND VPWR sky130_fd_sc_hd__tapvpwrvgnd_1
Xclkload83 clknet_leaf_35_CLK VGND VGND VPWR VPWR clkload83/Y sky130_fd_sc_hd__clkinv_4
XFILLER_0_101_727 VGND VGND VPWR VPWR sky130_fd_sc_hd__fill_1
Xclkload72 clknet_leaf_49_CLK VGND VGND VPWR VPWR clkload72/Y sky130_fd_sc_hd__clkinv_1
X_9173_ clknet_leaf_54_CLK _0261_ VGND VGND VPWR VPWR rf.registers\[30\]\[4\] sky130_fd_sc_hd__dfxtp_1
XFILLER_0_62_3 VPWR VGND VPWR VGND sky130_ef_sc_hd__decap_12
XFILLER_0_11_541 VGND VGND VPWR VPWR sky130_fd_sc_hd__decap_8
XFILLER_0_3_785 VPWR VGND VPWR VGND sky130_ef_sc_hd__decap_12
XFILLER_0_2_251 VGND VGND VPWR VPWR sky130_fd_sc_hd__fill_1
X_6385_ rf.registers\[12\]\[29\] _3047_ _3029_ VGND VGND VPWR VPWR _3048_ sky130_fd_sc_hd__mux2_1
X_8124_ _4002_ VGND VGND VPWR VPWR _0462_ sky130_fd_sc_hd__clkbuf_1
X_5336_ _2072_ _2073_ _2074_ VGND VGND VPWR VPWR _2075_ sky130_fd_sc_hd__mux2_1
X_8055_ rf.registers\[7\]\[13\] _3305_ _3962_ VGND VGND VPWR VPWR _3966_ sky130_fd_sc_hd__mux2_1
X_5267_ rf.registers\[0\]\[20\] rf.registers\[1\]\[20\] rf.registers\[2\]\[20\] rf.registers\[3\]\[20\]
+ _2008_ _2009_ VGND VGND VPWR VPWR _2010_ sky130_fd_sc_hd__mux4_1
X_7006_ _3409_ VGND VGND VPWR VPWR _0961_ sky130_fd_sc_hd__clkbuf_1
X_5198_ _1941_ _1942_ _1943_ VGND VGND VPWR VPWR _1944_ sky130_fd_sc_hd__mux2_1
X_8957_ clknet_leaf_23_CLK _0045_ VGND VGND VPWR VPWR rf.registers\[19\]\[12\] sky130_fd_sc_hd__dfxtp_1
XFILLER_0_97_349 VGND VGND VPWR VPWR sky130_fd_sc_hd__decap_6
XTAP_TAPCELL_ROW_48_1017 VGND VPWR sky130_fd_sc_hd__tapvpwrvgnd_1
XTAP_TAPCELL_ROW_39_886 VGND VPWR sky130_fd_sc_hd__tapvpwrvgnd_1
X_7908_ _3363_ rf.registers\[23\]\[8\] _3879_ VGND VGND VPWR VPWR _3888_ sky130_fd_sc_hd__mux2_1
XFILLER_0_93_522 VGND VGND VPWR VPWR sky130_fd_sc_hd__decap_3
X_8888_ clknet_leaf_50_CLK _1000_ VGND VGND VPWR VPWR rf.registers\[5\]\[7\] sky130_fd_sc_hd__dfxtp_1
XFILLER_0_66_725 VPWR VGND VPWR VGND sky130_ef_sc_hd__decap_12
XFILLER_0_136_613 VPWR VGND VPWR VGND sky130_ef_sc_hd__decap_12
X_7839_ _3363_ rf.registers\[28\]\[8\] _3842_ VGND VGND VPWR VPWR _3851_ sky130_fd_sc_hd__mux2_1
XFILLER_0_66_769 VPWR VGND VPWR VGND sky130_ef_sc_hd__decap_12
XTAP_TAPCELL_ROW_61_1217 VGND VPWR sky130_fd_sc_hd__tapvpwrvgnd_1
XFILLER_0_136_657 VPWR VGND VPWR VGND sky130_ef_sc_hd__decap_12
XFILLER_0_19_685 VGND VGND VPWR VPWR sky130_fd_sc_hd__decap_3
XFILLER_0_135_167 VGND VGND VPWR VPWR sky130_fd_sc_hd__fill_1
X_9509_ clknet_leaf_82_CLK _0597_ VGND VGND VPWR VPWR rf.registers\[18\]\[20\] sky130_fd_sc_hd__dfxtp_1
Xclkload0 clknet_3_0__leaf_CLK VGND VGND VPWR VPWR clkload0/Y sky130_fd_sc_hd__clkinvlp_4
XFILLER_0_123_329 VGND VGND VPWR VPWR sky130_fd_sc_hd__decap_6
XFILLER_0_34_688 VPWR VGND VPWR VGND sky130_ef_sc_hd__decap_12
XFILLER_0_131_373 VPWR VGND VPWR VGND sky130_ef_sc_hd__decap_12
XTAP_TAPCELL_ROW_59_1179 VGND VPWR sky130_fd_sc_hd__tapvpwrvgnd_1
XFILLER_0_100_793 VPWR VGND VPWR VGND sky130_ef_sc_hd__decap_12
XTAP_TAPCELL_ROW_72_1379 VGND VPWR sky130_fd_sc_hd__tapvpwrvgnd_1
XFILLER_0_89_839 VGND VGND VPWR VPWR sky130_fd_sc_hd__fill_1
XFILLER_0_72_29 VPWR VGND VPWR VGND sky130_ef_sc_hd__decap_12
XFILLER_0_84_522 VGND VGND VPWR VPWR sky130_fd_sc_hd__fill_1
XTAP_TAPCELL_ROW_17_558 VGND VPWR sky130_fd_sc_hd__tapvpwrvgnd_1
XFILLER_0_84_544 VGND VGND VPWR VPWR sky130_fd_sc_hd__decap_6
XFILLER_0_29_449 VGND VGND VPWR VPWR sky130_fd_sc_hd__decap_8
XFILLER_0_44_419 VGND VGND VPWR VPWR sky130_fd_sc_hd__fill_1
XFILLER_0_21_55 VGND VGND VPWR VPWR sky130_fd_sc_hd__fill_1
XFILLER_0_25_644 VGND VGND VPWR VPWR sky130_fd_sc_hd__decap_8
XFILLER_0_126_189 VGND VGND VPWR VPWR sky130_fd_sc_hd__decap_6
XFILLER_0_107_370 VPWR VGND VPWR VGND sky130_ef_sc_hd__decap_12
XFILLER_0_123_841 VGND VGND VPWR VPWR sky130_fd_sc_hd__fill_1
XFILLER_0_97_15 VPWR VGND VPWR VGND sky130_ef_sc_hd__decap_12
X_6170_ net99 _2874_ VGND VGND VPWR VPWR _2875_ sky130_fd_sc_hd__xnor2_1
X_5121_ _1683_ _1863_ _1871_ VGND VGND VPWR VPWR _1872_ sky130_fd_sc_hd__o21ai_4
XPHY_EDGE_ROW_127_Right_127 VGND VGND VPWR VPWR sky130_fd_sc_hd__decap_3
X_5052_ rf.registers\[12\]\[8\] rf.registers\[13\]\[8\] rf.registers\[14\]\[8\] rf.registers\[15\]\[8\]
+ _1703_ _1704_ VGND VGND VPWR VPWR _1807_ sky130_fd_sc_hd__mux4_1
XFILLER_0_46_41 VGND VGND VPWR VPWR sky130_fd_sc_hd__decap_4
XFILLER_0_27_6 VPWR VGND VPWR VGND sky130_ef_sc_hd__decap_12
XFILLER_0_46_85 VGND VGND VPWR VPWR sky130_fd_sc_hd__fill_1
X_8811_ clknet_leaf_70_CLK _0923_ VGND VGND VPWR VPWR rf.registers\[16\]\[26\] sky130_fd_sc_hd__dfxtp_1
XFILLER_0_95_809 VPWR VGND VPWR VGND sky130_ef_sc_hd__decap_12
X_8742_ clknet_leaf_78_CLK _0854_ VGND VGND VPWR VPWR rf.registers\[10\]\[21\] sky130_fd_sc_hd__dfxtp_1
XTAP_TAPCELL_ROW_36_834 VGND VPWR sky130_fd_sc_hd__tapvpwrvgnd_1
XTAP_TAPCELL_ROW_36_845 VGND VPWR sky130_fd_sc_hd__tapvpwrvgnd_1
X_5954_ _2670_ _2671_ VGND VGND VPWR VPWR _2672_ sky130_fd_sc_hd__xnor2_1
XTAP_TAPCELL_ROW_101_1818 VGND VPWR sky130_fd_sc_hd__tapvpwrvgnd_1
X_8673_ clknet_leaf_13_CLK _0785_ VGND VGND VPWR VPWR rf.registers\[1\]\[16\] sky130_fd_sc_hd__dfxtp_1
XFILLER_0_75_555 VGND VGND VPWR VPWR sky130_fd_sc_hd__decap_4
XFILLER_0_75_533 VGND VGND VPWR VPWR sky130_fd_sc_hd__fill_1
X_4905_ _1666_ VGND VGND VPWR VPWR net60 sky130_fd_sc_hd__inv_2
XFILLER_0_48_769 VPWR VGND VPWR VGND sky130_ef_sc_hd__decap_12
XFILLER_0_8_811 VGND VGND VPWR VPWR sky130_fd_sc_hd__fill_1
X_5885_ _2404_ _2459_ _2605_ _1115_ VGND VGND VPWR VPWR _2606_ sky130_fd_sc_hd__o22a_1
X_7624_ rf.registers\[2\]\[3\] _3284_ _3733_ VGND VGND VPWR VPWR _3737_ sky130_fd_sc_hd__mux2_1
XFILLER_0_75_588 VGND VGND VPWR VPWR sky130_fd_sc_hd__fill_2
X_4836_ rf.registers\[20\]\[31\] rf.registers\[21\]\[31\] rf.registers\[22\]\[31\]
+ rf.registers\[23\]\[31\] _1183_ _1181_ VGND VGND VPWR VPWR _1600_ sky130_fd_sc_hd__mux4_1
XTAP_TAPCELL_ROW_134_2306 VGND VPWR sky130_fd_sc_hd__tapvpwrvgnd_1
X_7555_ _3700_ VGND VGND VPWR VPWR _0195_ sky130_fd_sc_hd__clkbuf_1
XFILLER_0_117_167 VGND VGND VPWR VPWR sky130_fd_sc_hd__fill_1
XTAP_TAPCELL_ROW_134_2317 VGND VPWR sky130_fd_sc_hd__tapvpwrvgnd_1
X_6506_ rf.registers\[17\]\[19\] _3026_ _3105_ VGND VGND VPWR VPWR _3115_ sky130_fd_sc_hd__mux2_1
XFILLER_0_31_603 VPWR VGND VPWR VGND sky130_ef_sc_hd__decap_12
X_4767_ _1534_ _1535_ _1154_ VGND VGND VPWR VPWR _1536_ sky130_fd_sc_hd__mux2_1
XFILLER_0_43_441 VGND VGND VPWR VPWR sky130_fd_sc_hd__decap_6
X_7486_ _3351_ rf.registers\[31\]\[2\] _3661_ VGND VGND VPWR VPWR _3664_ sky130_fd_sc_hd__mux2_1
XFILLER_0_71_783 VGND VGND VPWR VPWR sky130_fd_sc_hd__fill_1
X_4698_ _1397_ _1468_ _1470_ _1293_ VGND VGND VPWR VPWR _1471_ sky130_fd_sc_hd__o211a_1
XFILLER_0_16_688 VPWR VGND VPWR VGND sky130_ef_sc_hd__decap_12
X_6437_ _3077_ VGND VGND VPWR VPWR _0724_ sky130_fd_sc_hd__clkbuf_1
X_9225_ clknet_leaf_73_CLK _0313_ VGND VGND VPWR VPWR rf.registers\[9\]\[24\] sky130_fd_sc_hd__dfxtp_1
X_9156_ clknet_leaf_18_CLK _0244_ VGND VGND VPWR VPWR rf.registers\[2\]\[19\] sky130_fd_sc_hd__dfxtp_1
X_6368_ _3036_ VGND VGND VPWR VPWR _0696_ sky130_fd_sc_hd__clkbuf_1
X_8107_ _3993_ VGND VGND VPWR VPWR _0454_ sky130_fd_sc_hd__clkbuf_1
X_5319_ rf.registers\[0\]\[23\] rf.registers\[1\]\[23\] rf.registers\[2\]\[23\] rf.registers\[3\]\[23\]
+ _1929_ _1930_ VGND VGND VPWR VPWR _2059_ sky130_fd_sc_hd__mux4_1
XFILLER_0_11_393 VPWR VGND VPWR VGND sky130_ef_sc_hd__decap_12
X_6299_ rf.registers\[12\]\[1\] _2989_ _2987_ VGND VGND VPWR VPWR _2990_ sky130_fd_sc_hd__mux2_1
X_9087_ clknet_leaf_25_CLK _0175_ VGND VGND VPWR VPWR rf.registers\[31\]\[14\] sky130_fd_sc_hd__dfxtp_1
X_8038_ rf.registers\[7\]\[5\] _3288_ _3951_ VGND VGND VPWR VPWR _3957_ sky130_fd_sc_hd__mux2_1
XFILLER_0_66_533 VPWR VGND VPWR VGND sky130_ef_sc_hd__decap_12
XTAP_TAPCELL_ROW_14_506 VGND VPWR sky130_fd_sc_hd__tapvpwrvgnd_1
XTAP_TAPCELL_ROW_14_517 VGND VPWR sky130_fd_sc_hd__tapvpwrvgnd_1
XFILLER_0_38_224 VGND VGND VPWR VPWR sky130_fd_sc_hd__fill_2
XFILLER_0_38_235 VGND VGND VPWR VPWR sky130_fd_sc_hd__fill_1
XFILLER_0_136_421 VPWR VGND VPWR VGND sky130_ef_sc_hd__decap_12
XFILLER_0_81_503 VGND VGND VPWR VPWR sky130_fd_sc_hd__fill_1
XFILLER_0_19_493 VGND VGND VPWR VPWR sky130_fd_sc_hd__decap_8
XANTENNA_9 net14 VGND VGND VPWR VPWR sky130_fd_sc_hd__diode_2
XFILLER_0_123_137 VPWR VGND VPWR VGND sky130_ef_sc_hd__decap_12
XFILLER_0_105_841 VGND VGND VPWR VPWR sky130_fd_sc_hd__fill_1
XFILLER_0_120_811 VGND VGND VPWR VPWR sky130_fd_sc_hd__fill_1
XTAP_TAPCELL_ROW_74_1408 VGND VPWR sky130_fd_sc_hd__tapvpwrvgnd_1
XFILLER_0_132_693 VGND VGND VPWR VPWR sky130_fd_sc_hd__decap_6
XFILLER_0_131_181 VPWR VGND VPWR VGND sky130_ef_sc_hd__decap_12
XFILLER_0_120_833 VGND VGND VPWR VPWR sky130_fd_sc_hd__fill_1
XFILLER_0_67_18 VPWR VGND VPWR VGND sky130_ef_sc_hd__decap_12
XTAP_TAPCELL_ROW_89_1640 VGND VPWR sky130_fd_sc_hd__tapvpwrvgnd_1
XFILLER_0_107_57 VPWR VGND VPWR VGND sky130_ef_sc_hd__decap_12
XFILLER_0_77_809 VPWR VGND VPWR VGND sky130_ef_sc_hd__decap_12
XFILLER_0_16_77 VGND VGND VPWR VPWR sky130_fd_sc_hd__decap_6
XFILLER_0_69_371 VGND VGND VPWR VPWR sky130_fd_sc_hd__fill_2
XFILLER_0_57_500 VGND VGND VPWR VPWR sky130_fd_sc_hd__decap_4
XFILLER_0_84_330 VGND VGND VPWR VPWR sky130_fd_sc_hd__fill_2
XFILLER_0_123_45 VGND VGND VPWR VPWR sky130_fd_sc_hd__decap_8
X_5670_ _2327_ _2360_ _2388_ _2397_ _2399_ VGND VGND VPWR VPWR net124 sky130_fd_sc_hd__o32a_1
XFILLER_0_120_3 VPWR VGND VPWR VGND sky130_ef_sc_hd__decap_12
X_4621_ _1395_ _1396_ _1397_ VGND VGND VPWR VPWR _1398_ sky130_fd_sc_hd__mux2_1
XTAP_TAPCELL_ROW_116_2047 VGND VPWR sky130_fd_sc_hd__tapvpwrvgnd_1
XTAP_TAPCELL_ROW_116_2036 VGND VPWR sky130_fd_sc_hd__tapvpwrvgnd_1
X_4552_ rf.registers\[16\]\[14\] rf.registers\[17\]\[14\] rf.registers\[18\]\[14\]
+ rf.registers\[19\]\[14\] _1294_ _1295_ VGND VGND VPWR VPWR _1333_ sky130_fd_sc_hd__mux4_1
X_7340_ _3585_ VGND VGND VPWR VPWR _0095_ sky130_fd_sc_hd__clkbuf_1
XFILLER_0_53_783 VGND VGND VPWR VPWR sky130_fd_sc_hd__fill_1
XFILLER_0_4_357 VGND VGND VPWR VPWR sky130_fd_sc_hd__decap_6
XFILLER_0_13_614 VGND VGND VPWR VPWR sky130_fd_sc_hd__fill_2
X_4483_ _1267_ VGND VGND VPWR VPWR net82 sky130_fd_sc_hd__buf_2
X_7271_ rf.registers\[19\]\[30\] _3340_ _3515_ VGND VGND VPWR VPWR _3549_ sky130_fd_sc_hd__mux2_1
XFILLER_0_13_658 VGND VGND VPWR VPWR sky130_fd_sc_hd__fill_2
XFILLER_0_13_669 VGND VGND VPWR VPWR sky130_fd_sc_hd__decap_3
X_9010_ clknet_leaf_45_CLK _0098_ VGND VGND VPWR VPWR rf.registers\[8\]\[1\] sky130_fd_sc_hd__dfxtp_1
XFILLER_0_111_833 VGND VGND VPWR VPWR sky130_fd_sc_hd__decap_6
X_6222_ _2920_ _2863_ _2923_ _2462_ VGND VGND VPWR VPWR _2924_ sky130_fd_sc_hd__o211a_1
XFILLER_0_0_541 VGND VGND VPWR VPWR sky130_fd_sc_hd__decap_3
XFILLER_0_0_574 VPWR VGND VPWR VGND sky130_ef_sc_hd__decap_12
XFILLER_0_57_51 VGND VGND VPWR VPWR sky130_fd_sc_hd__fill_1
X_6153_ net98 _2858_ VGND VGND VPWR VPWR _2859_ sky130_fd_sc_hd__xor2_2
X_5104_ _1683_ _1847_ _1851_ _1855_ VGND VGND VPWR VPWR _1856_ sky130_fd_sc_hd__a2bb2o_4
X_6084_ _2791_ _2793_ _2237_ VGND VGND VPWR VPWR _2794_ sky130_fd_sc_hd__mux2_1
X_5035_ rf.registers\[0\]\[7\] rf.registers\[1\]\[7\] rf.registers\[2\]\[7\] rf.registers\[3\]\[7\]
+ _1652_ _1653_ VGND VGND VPWR VPWR _1791_ sky130_fd_sc_hd__mux4_1
XTAP_TAPCELL_ROW_127_2198 VGND VPWR sky130_fd_sc_hd__tapvpwrvgnd_1
XFILLER_0_25_3 VPWR VGND VPWR VGND sky130_ef_sc_hd__decap_12
XTAP_TAPCELL_ROW_0_278 VGND VPWR sky130_fd_sc_hd__tapvpwrvgnd_1
X_6986_ _3397_ rf.registers\[15\]\[24\] _3389_ VGND VGND VPWR VPWR _3398_ sky130_fd_sc_hd__mux2_1
X_8725_ clknet_leaf_49_CLK _0837_ VGND VGND VPWR VPWR rf.registers\[10\]\[4\] sky130_fd_sc_hd__dfxtp_1
XFILLER_0_88_691 VGND VGND VPWR VPWR sky130_fd_sc_hd__decap_8
XTAP_TAPCELL_ROW_0_289 VGND VPWR sky130_fd_sc_hd__tapvpwrvgnd_1
X_5937_ _2649_ _2654_ VGND VGND VPWR VPWR _2656_ sky130_fd_sc_hd__nor2_1
XFILLER_0_75_352 VGND VGND VPWR VPWR sky130_fd_sc_hd__fill_2
X_8656_ clknet_leaf_62_CLK _0768_ VGND VGND VPWR VPWR rf.registers\[17\]\[31\] sky130_fd_sc_hd__dfxtp_1
XFILLER_0_75_396 VGND VGND VPWR VPWR sky130_fd_sc_hd__decap_4
X_5868_ _1826_ _2588_ VGND VGND VPWR VPWR _2590_ sky130_fd_sc_hd__nand2_1
X_7607_ _3727_ VGND VGND VPWR VPWR _0220_ sky130_fd_sc_hd__clkbuf_1
XFILLER_0_36_739 VGND VGND VPWR VPWR sky130_fd_sc_hd__fill_2
X_5799_ _2404_ _2523_ _2340_ VGND VGND VPWR VPWR _2524_ sky130_fd_sc_hd__mux2_1
X_8587_ clknet_leaf_69_CLK _0699_ VGND VGND VPWR VPWR rf.registers\[12\]\[26\] sky130_fd_sc_hd__dfxtp_1
X_4819_ rf.registers\[20\]\[30\] rf.registers\[21\]\[30\] rf.registers\[22\]\[30\]
+ rf.registers\[23\]\[30\] _1125_ _1128_ VGND VGND VPWR VPWR _1584_ sky130_fd_sc_hd__mux4_1
X_7538_ _2972_ rf.registers\[31\]\[27\] _3683_ VGND VGND VPWR VPWR _3691_ sky130_fd_sc_hd__mux2_1
XFILLER_0_44_794 VPWR VGND VPWR VGND sky130_ef_sc_hd__decap_12
XFILLER_0_102_811 VGND VGND VPWR VPWR sky130_fd_sc_hd__fill_1
X_7469_ _3654_ VGND VGND VPWR VPWR _0155_ sky130_fd_sc_hd__clkbuf_1
X_9208_ clknet_leaf_50_CLK _0296_ VGND VGND VPWR VPWR rf.registers\[9\]\[7\] sky130_fd_sc_hd__dfxtp_1
XTAP_TAPCELL_ROW_56_1138 VGND VPWR sky130_fd_sc_hd__tapvpwrvgnd_1
Xoutput57 net57 VGND VGND VPWR VPWR RD1[17] sky130_fd_sc_hd__buf_1
X_9139_ clknet_leaf_41_CLK _0227_ VGND VGND VPWR VPWR rf.registers\[2\]\[2\] sky130_fd_sc_hd__dfxtp_1
Xoutput79 net79 VGND VGND VPWR VPWR RD1[8] sky130_fd_sc_hd__buf_1
Xoutput68 net68 VGND VGND VPWR VPWR RD1[27] sky130_fd_sc_hd__buf_1
XFILLER_0_59_809 VPWR VGND VPWR VGND sky130_ef_sc_hd__decap_12
XPHY_EDGE_ROW_19_Right_19 VGND VGND VPWR VPWR sky130_fd_sc_hd__decap_3
XFILLER_0_78_190 VGND VGND VPWR VPWR sky130_fd_sc_hd__decap_6
XFILLER_0_137_741 VPWR VGND VPWR VGND sky130_ef_sc_hd__decap_12
XFILLER_0_109_421 VGND VGND VPWR VPWR sky130_fd_sc_hd__fill_1
XFILLER_0_66_363 VGND VGND VPWR VPWR sky130_fd_sc_hd__fill_1
XFILLER_0_136_251 VGND VGND VPWR VPWR sky130_fd_sc_hd__fill_1
XFILLER_0_109_443 VGND VGND VPWR VPWR sky130_fd_sc_hd__fill_1
XFILLER_0_81_300 VGND VGND VPWR VPWR sky130_fd_sc_hd__fill_2
XFILLER_0_54_525 VGND VGND VPWR VPWR sky130_fd_sc_hd__decap_6
XFILLER_0_137_785 VPWR VGND VPWR VGND sky130_ef_sc_hd__decap_12
XFILLER_0_42_709 VPWR VGND VPWR VGND sky130_ef_sc_hd__decap_12
XFILLER_0_1_305 VPWR VGND VPWR VGND sky130_ef_sc_hd__decap_12
XFILLER_0_22_433 VGND VGND VPWR VPWR sky130_fd_sc_hd__fill_1
XFILLER_0_34_293 VGND VGND VPWR VPWR sky130_fd_sc_hd__decap_6
XFILLER_0_1_349 VPWR VGND VPWR VGND sky130_ef_sc_hd__decap_12
XPHY_EDGE_ROW_28_Right_28 VGND VGND VPWR VPWR sky130_fd_sc_hd__decap_3
XFILLER_0_120_674 VPWR VGND VPWR VGND sky130_ef_sc_hd__decap_12
XFILLER_0_94_27 VGND VGND VPWR VPWR sky130_fd_sc_hd__fill_1
XFILLER_0_11_9 VPWR VGND VPWR VGND sky130_ef_sc_hd__decap_12
XFILLER_0_27_98 VGND VGND VPWR VPWR sky130_fd_sc_hd__fill_1
XPHY_EDGE_ROW_37_Right_37 VGND VGND VPWR VPWR sky130_fd_sc_hd__decap_3
X_6840_ net15 VGND VGND VPWR VPWR _3298_ sky130_fd_sc_hd__clkbuf_2
XFILLER_0_43_31 VPWR VGND VPWR VGND sky130_ef_sc_hd__decap_12
XFILLER_0_134_77 VGND VGND VPWR VPWR sky130_fd_sc_hd__decap_6
X_6771_ rf.registers\[0\]\[14\] _3016_ _3252_ VGND VGND VPWR VPWR _3257_ sky130_fd_sc_hd__mux2_1
XFILLER_0_9_405 VPWR VGND VPWR VGND sky130_ef_sc_hd__decap_12
XTAP_TAPCELL_ROW_46_984 VGND VPWR sky130_fd_sc_hd__tapvpwrvgnd_1
XTAP_TAPCELL_ROW_46_995 VGND VPWR sky130_fd_sc_hd__tapvpwrvgnd_1
X_8510_ _4206_ VGND VGND VPWR VPWR _0644_ sky130_fd_sc_hd__clkbuf_1
XFILLER_0_85_650 VGND VGND VPWR VPWR sky130_fd_sc_hd__fill_1
XFILLER_0_9_449 VPWR VGND VPWR VGND sky130_ef_sc_hd__decap_12
XFILLER_0_18_706 VGND VGND VPWR VPWR sky130_fd_sc_hd__fill_2
XFILLER_0_18_728 VGND VGND VPWR VPWR sky130_fd_sc_hd__decap_4
X_5722_ _2240_ _2447_ _2449_ _2266_ VGND VGND VPWR VPWR _2450_ sky130_fd_sc_hd__a211o_1
XFILLER_0_43_97 VGND VGND VPWR VPWR sky130_fd_sc_hd__fill_2
X_9490_ clknet_leaf_43_CLK _0578_ VGND VGND VPWR VPWR rf.registers\[18\]\[1\] sky130_fd_sc_hd__dfxtp_1
XFILLER_0_85_694 VPWR VGND VPWR VGND sky130_ef_sc_hd__decap_12
XFILLER_0_57_396 VGND VGND VPWR VPWR sky130_fd_sc_hd__fill_2
XFILLER_0_127_273 VGND VGND VPWR VPWR sky130_fd_sc_hd__decap_6
X_8441_ _4170_ VGND VGND VPWR VPWR _0611_ sky130_fd_sc_hd__clkbuf_1
X_5653_ _2233_ VGND VGND VPWR VPWR _2383_ sky130_fd_sc_hd__clkbuf_4
X_8372_ rf.registers\[18\]\[2\] net36 _4131_ VGND VGND VPWR VPWR _4134_ sky130_fd_sc_hd__mux2_1
X_4604_ _1198_ VGND VGND VPWR VPWR _1382_ sky130_fd_sc_hd__buf_4
X_5584_ _2296_ _2314_ VGND VGND VPWR VPWR _2315_ sky130_fd_sc_hd__nor2_1
XFILLER_0_4_121 VPWR VGND VPWR VGND sky130_ef_sc_hd__decap_12
XPHY_EDGE_ROW_46_Right_46 VGND VGND VPWR VPWR sky130_fd_sc_hd__decap_3
X_4535_ _1313_ _1316_ _1291_ VGND VGND VPWR VPWR _1317_ sky130_fd_sc_hd__mux2_1
XFILLER_0_4_165 VPWR VGND VPWR VGND sky130_ef_sc_hd__decap_12
X_7323_ rf.registers\[3\]\[22\] _3324_ _3574_ VGND VGND VPWR VPWR _3577_ sky130_fd_sc_hd__mux2_1
XFILLER_0_130_438 VGND VGND VPWR VPWR sky130_fd_sc_hd__decap_6
XFILLER_0_123_490 VGND VGND VPWR VPWR sky130_fd_sc_hd__fill_1
XFILLER_0_7_31 VPWR VGND VPWR VGND sky130_ef_sc_hd__decap_12
X_4466_ _1251_ VGND VGND VPWR VPWR net112 sky130_fd_sc_hd__buf_2
XFILLER_0_41_797 VPWR VGND VPWR VGND sky130_ef_sc_hd__decap_12
X_7254_ _3540_ VGND VGND VPWR VPWR _0054_ sky130_fd_sc_hd__clkbuf_1
XFILLER_0_111_685 VPWR VGND VPWR VGND sky130_ef_sc_hd__decap_12
X_4397_ rf.registers\[28\]\[6\] rf.registers\[29\]\[6\] rf.registers\[30\]\[6\] rf.registers\[31\]\[6\]
+ _1183_ _1181_ VGND VGND VPWR VPWR _1186_ sky130_fd_sc_hd__mux4_1
X_7185_ rf.registers\[4\]\[21\] _3322_ _3502_ VGND VGND VPWR VPWR _3504_ sky130_fd_sc_hd__mux2_1
X_6205_ _2149_ _2906_ VGND VGND VPWR VPWR _2908_ sky130_fd_sc_hd__and2_1
XTAP_TAPCELL_ROW_129_2238 VGND VPWR sky130_fd_sc_hd__tapvpwrvgnd_1
X_6136_ _2398_ _2841_ _2842_ VGND VGND VPWR VPWR _2843_ sky130_fd_sc_hd__and3_1
XFILLER_0_0_393 VPWR VGND VPWR VGND sky130_ef_sc_hd__decap_12
XTAP_TAPCELL_ROW_51_1068 VGND VPWR sky130_fd_sc_hd__tapvpwrvgnd_1
XPHY_EDGE_ROW_55_Right_55 VGND VGND VPWR VPWR sky130_fd_sc_hd__decap_3
X_6067_ _2718_ _2777_ _2237_ VGND VGND VPWR VPWR _2778_ sky130_fd_sc_hd__mux2_1
X_5018_ rf.registers\[0\]\[6\] rf.registers\[1\]\[6\] rf.registers\[2\]\[6\] rf.registers\[3\]\[6\]
+ _1772_ _1773_ VGND VGND VPWR VPWR _1775_ sky130_fd_sc_hd__mux4_1
XFILLER_0_138_505 VPWR VGND VPWR VGND sky130_ef_sc_hd__decap_12
X_6969_ net24 VGND VGND VPWR VPWR _3386_ sky130_fd_sc_hd__clkbuf_2
XFILLER_0_119_741 VPWR VGND VPWR VGND sky130_ef_sc_hd__decap_12
X_8708_ clknet_leaf_22_CLK _0820_ VGND VGND VPWR VPWR rf.registers\[24\]\[19\] sky130_fd_sc_hd__dfxtp_1
XTAP_TAPCELL_ROW_24_656 VGND VPWR sky130_fd_sc_hd__tapvpwrvgnd_1
XTAP_TAPCELL_ROW_24_667 VGND VPWR sky130_fd_sc_hd__tapvpwrvgnd_1
XFILLER_0_119_785 VPWR VGND VPWR VGND sky130_ef_sc_hd__decap_12
XFILLER_0_118_251 VGND VGND VPWR VPWR sky130_fd_sc_hd__fill_1
XFILLER_0_106_424 VGND VGND VPWR VPWR sky130_fd_sc_hd__fill_1
X_8639_ clknet_leaf_27_CLK _0751_ VGND VGND VPWR VPWR rf.registers\[17\]\[14\] sky130_fd_sc_hd__dfxtp_1
XFILLER_0_90_141 VGND VGND VPWR VPWR sky130_fd_sc_hd__fill_1
XPHY_EDGE_ROW_64_Right_64 VGND VGND VPWR VPWR sky130_fd_sc_hd__decap_3
XFILLER_0_63_333 VGND VGND VPWR VPWR sky130_fd_sc_hd__decap_3
XFILLER_0_134_755 VGND VGND VPWR VPWR sky130_fd_sc_hd__fill_1
XFILLER_0_63_377 VGND VGND VPWR VPWR sky130_fd_sc_hd__decap_4
XFILLER_0_17_794 VPWR VGND VPWR VGND sky130_ef_sc_hd__decap_12
XFILLER_0_32_786 VPWR VGND VPWR VGND sky130_ef_sc_hd__decap_12
XFILLER_0_31_296 VGND VGND VPWR VPWR sky130_fd_sc_hd__fill_1
XFILLER_0_102_685 VPWR VGND VPWR VGND sky130_ef_sc_hd__decap_12
XPHY_EDGE_ROW_73_Right_73 VGND VGND VPWR VPWR sky130_fd_sc_hd__decap_3
XFILLER_0_99_753 VPWR VGND VPWR VGND sky130_ef_sc_hd__decap_12
XTAP_TAPCELL_ROW_69_1329 VGND VPWR sky130_fd_sc_hd__tapvpwrvgnd_1
XFILLER_0_99_797 VPWR VGND VPWR VGND sky130_ef_sc_hd__decap_12
XFILLER_0_86_403 VGND VGND VPWR VPWR sky130_fd_sc_hd__fill_2
XFILLER_0_129_505 VGND VGND VPWR VPWR sky130_fd_sc_hd__fill_1
XTAP_TAPCELL_ROW_82_1529 VGND VPWR sky130_fd_sc_hd__tapvpwrvgnd_1
XFILLER_0_80_29 VPWR VGND VPWR VGND sky130_ef_sc_hd__decap_12
XFILLER_0_73_108 VGND VGND VPWR VPWR sky130_fd_sc_hd__decap_4
XTAP_TAPCELL_ROW_43_943 VGND VPWR sky130_fd_sc_hd__tapvpwrvgnd_1
XPHY_EDGE_ROW_82_Right_82 VGND VGND VPWR VPWR sky130_fd_sc_hd__decap_3
XFILLER_0_54_300 VGND VGND VPWR VPWR sky130_fd_sc_hd__decap_4
XPHY_EDGE_ROW_17_Left_156 VGND VGND VPWR VPWR sky130_fd_sc_hd__decap_3
XFILLER_0_6_419 VGND VGND VPWR VPWR sky130_fd_sc_hd__fill_1
XFILLER_0_27_547 VPWR VGND VPWR VGND sky130_ef_sc_hd__decap_12
XFILLER_0_124_221 VPWR VGND VPWR VGND sky130_ef_sc_hd__decap_12
XFILLER_0_89_27 VPWR VGND VPWR VGND sky130_ef_sc_hd__decap_12
XFILLER_0_82_697 VGND VGND VPWR VPWR sky130_fd_sc_hd__decap_3
XFILLER_0_70_837 VGND VGND VPWR VPWR sky130_fd_sc_hd__fill_2
XFILLER_0_125_777 VGND VGND VPWR VPWR sky130_fd_sc_hd__decap_6
XFILLER_0_124_265 VPWR VGND VPWR VGND sky130_ef_sc_hd__decap_12
XTAP_TAPCELL_ROW_97_1761 VGND VPWR sky130_fd_sc_hd__tapvpwrvgnd_1
XTAP_TAPCELL_ROW_97_1750 VGND VPWR sky130_fd_sc_hd__tapvpwrvgnd_1
XFILLER_0_1_113 VPWR VGND VPWR VGND sky130_ef_sc_hd__decap_12
XFILLER_0_2_625 VPWR VGND VPWR VGND sky130_ef_sc_hd__decap_12
X_4320_ _1061_ _1111_ _1052_ VGND VGND VPWR VPWR _1112_ sky130_fd_sc_hd__a21oi_1
XFILLER_0_2_669 VPWR VGND VPWR VGND sky130_ef_sc_hd__decap_12
XFILLER_0_23_797 VPWR VGND VPWR VGND sky130_ef_sc_hd__decap_12
X_4251_ rf.registers\[12\]\[0\] rf.registers\[13\]\[0\] rf.registers\[14\]\[0\] rf.registers\[15\]\[0\]
+ _1042_ _1044_ VGND VGND VPWR VPWR _1046_ sky130_fd_sc_hd__mux4_1
XFILLER_0_10_469 VGND VGND VPWR VPWR sky130_fd_sc_hd__decap_6
XFILLER_0_129_55 VGND VGND VPWR VPWR sky130_fd_sc_hd__fill_1
XPHY_EDGE_ROW_91_Right_91 VGND VGND VPWR VPWR sky130_fd_sc_hd__decap_3
XPHY_EDGE_ROW_26_Left_165 VGND VGND VPWR VPWR sky130_fd_sc_hd__decap_3
X_8990_ clknet_leaf_14_CLK _0078_ VGND VGND VPWR VPWR rf.registers\[3\]\[13\] sky130_fd_sc_hd__dfxtp_1
XTAP_TAPCELL_ROW_2_329 VGND VPWR sky130_fd_sc_hd__tapvpwrvgnd_1
X_7941_ _3905_ VGND VGND VPWR VPWR _0376_ sky130_fd_sc_hd__clkbuf_1
XTAP_TAPCELL_ROW_124_2157 VGND VPWR sky130_fd_sc_hd__tapvpwrvgnd_1
XFILLER_0_77_414 VGND VGND VPWR VPWR sky130_fd_sc_hd__decap_6
X_7872_ _3868_ VGND VGND VPWR VPWR _0344_ sky130_fd_sc_hd__clkbuf_1
XTAP_TAPCELL_ROW_106_1890 VGND VPWR sky130_fd_sc_hd__tapvpwrvgnd_1
X_6823_ rf.registers\[16\]\[4\] _3286_ _3278_ VGND VGND VPWR VPWR _3287_ sky130_fd_sc_hd__mux2_1
XPHY_EDGE_ROW_35_Left_174 VGND VGND VPWR VPWR sky130_fd_sc_hd__decap_3
X_6754_ rf.registers\[0\]\[6\] _2999_ _3241_ VGND VGND VPWR VPWR _3248_ sky130_fd_sc_hd__mux2_1
X_9542_ clknet_leaf_79_CLK _0630_ VGND VGND VPWR VPWR rf.registers\[14\]\[21\] sky130_fd_sc_hd__dfxtp_1
XFILLER_0_18_525 VGND VGND VPWR VPWR sky130_fd_sc_hd__decap_6
X_9473_ clknet_leaf_21_CLK _0561_ VGND VGND VPWR VPWR rf.registers\[20\]\[16\] sky130_fd_sc_hd__dfxtp_1
X_6685_ _3211_ VGND VGND VPWR VPWR _0838_ sky130_fd_sc_hd__clkbuf_1
X_5705_ _2431_ _2432_ VGND VGND VPWR VPWR _2433_ sky130_fd_sc_hd__nor2_1
XFILLER_0_9_279 VGND VGND VPWR VPWR sky130_fd_sc_hd__fill_1
XFILLER_0_18_569 VGND VGND VPWR VPWR sky130_fd_sc_hd__decap_8
XTAP_TAPCELL_ROW_21_615 VGND VPWR sky130_fd_sc_hd__tapvpwrvgnd_1
XFILLER_0_116_755 VGND VGND VPWR VPWR sky130_fd_sc_hd__fill_1
XFILLER_0_92_3 VPWR VGND VPWR VGND sky130_ef_sc_hd__decap_12
XFILLER_0_72_141 VGND VGND VPWR VPWR sky130_fd_sc_hd__decap_4
X_8424_ rf.registers\[18\]\[27\] net33 _4153_ VGND VGND VPWR VPWR _4161_ sky130_fd_sc_hd__mux2_1
X_5636_ _2364_ _2365_ VGND VGND VPWR VPWR _2366_ sky130_fd_sc_hd__nand2_1
XFILLER_0_5_441 VGND VGND VPWR VPWR sky130_fd_sc_hd__decap_6
XFILLER_0_26_580 VGND VGND VPWR VPWR sky130_fd_sc_hd__decap_8
XFILLER_0_103_449 VGND VGND VPWR VPWR sky130_fd_sc_hd__decap_6
XFILLER_0_103_427 VGND VGND VPWR VPWR sky130_fd_sc_hd__decap_4
XFILLER_0_5_485 VPWR VGND VPWR VGND sky130_ef_sc_hd__decap_12
X_8355_ _4124_ VGND VGND VPWR VPWR _0571_ sky130_fd_sc_hd__clkbuf_1
X_5567_ _1939_ _2207_ VGND VGND VPWR VPWR _2298_ sky130_fd_sc_hd__or2_1
X_7306_ rf.registers\[3\]\[14\] _3307_ _3563_ VGND VGND VPWR VPWR _3568_ sky130_fd_sc_hd__mux2_1
X_8286_ _3041_ rf.registers\[25\]\[26\] _4081_ VGND VGND VPWR VPWR _4088_ sky130_fd_sc_hd__mux2_1
X_4518_ _1156_ VGND VGND VPWR VPWR _1301_ sky130_fd_sc_hd__clkbuf_4
X_5498_ _2211_ VGND VGND VPWR VPWR _2229_ sky130_fd_sc_hd__buf_2
XPHY_EDGE_ROW_44_Left_183 VGND VGND VPWR VPWR sky130_fd_sc_hd__decap_3
X_4449_ _1235_ VGND VGND VPWR VPWR net111 sky130_fd_sc_hd__buf_2
X_7237_ _3531_ VGND VGND VPWR VPWR _0046_ sky130_fd_sc_hd__clkbuf_1
X_7168_ rf.registers\[4\]\[13\] _3305_ _3491_ VGND VGND VPWR VPWR _3495_ sky130_fd_sc_hd__mux2_1
X_7099_ _3458_ VGND VGND VPWR VPWR _1005_ sky130_fd_sc_hd__clkbuf_1
X_6119_ _2825_ _2826_ VGND VGND VPWR VPWR _2827_ sky130_fd_sc_hd__nor2_1
XTAP_TAPCELL_ROW_29_737 VGND VPWR sky130_fd_sc_hd__tapvpwrvgnd_1
XFILLER_0_96_701 VPWR VGND VPWR VGND sky130_ef_sc_hd__decap_12
XPHY_EDGE_ROW_53_Left_192 VGND VGND VPWR VPWR sky130_fd_sc_hd__decap_3
XFILLER_0_138_313 VPWR VGND VPWR VGND sky130_ef_sc_hd__decap_12
XFILLER_0_83_439 VGND VGND VPWR VPWR sky130_fd_sc_hd__decap_8
XTAP_TAPCELL_ROW_64_1259 VGND VPWR sky130_fd_sc_hd__tapvpwrvgnd_1
Xclkbuf_leaf_86_CLK clknet_3_2__leaf_CLK VGND VGND VPWR VPWR clknet_leaf_86_CLK sky130_fd_sc_hd__clkbuf_8
XFILLER_0_37_812 VPWR VGND VPWR VGND sky130_ef_sc_hd__decap_12
XTAP_TAPCELL_ROW_40_902 VGND VPWR sky130_fd_sc_hd__tapvpwrvgnd_1
XFILLER_0_48_182 VGND VGND VPWR VPWR sky130_fd_sc_hd__decap_4
XFILLER_0_52_837 VGND VGND VPWR VPWR sky130_fd_sc_hd__fill_2
XFILLER_0_107_777 VGND VGND VPWR VPWR sky130_fd_sc_hd__decap_6
XFILLER_0_63_185 VGND VGND VPWR VPWR sky130_fd_sc_hd__fill_2
XFILLER_0_122_725 VPWR VGND VPWR VGND sky130_ef_sc_hd__decap_12
XTAP_TAPCELL_ROW_79_1480 VGND VPWR sky130_fd_sc_hd__tapvpwrvgnd_1
XFILLER_0_59_19 VPWR VGND VPWR VGND sky130_ef_sc_hd__decap_12
XFILLER_0_122_769 VPWR VGND VPWR VGND sky130_ef_sc_hd__decap_12
XTAP_TAPCELL_ROW_79_1491 VGND VPWR sky130_fd_sc_hd__tapvpwrvgnd_1
XFILLER_0_121_279 VGND VGND VPWR VPWR sky130_fd_sc_hd__fill_1
XTAP_TAPCELL_ROW_9_440 VGND VPWR sky130_fd_sc_hd__tapvpwrvgnd_1
XTAP_TAPCELL_ROW_92_1680 VGND VPWR sky130_fd_sc_hd__tapvpwrvgnd_1
XFILLER_0_75_18 VPWR VGND VPWR VGND sky130_ef_sc_hd__decap_12
Xclkbuf_leaf_10_CLK clknet_3_1__leaf_CLK VGND VGND VPWR VPWR clknet_leaf_10_CLK sky130_fd_sc_hd__clkbuf_8
XFILLER_0_87_701 VPWR VGND VPWR VGND sky130_ef_sc_hd__decap_12
XFILLER_0_86_200 VGND VGND VPWR VPWR sky130_fd_sc_hd__fill_1
XFILLER_0_115_57 VPWR VGND VPWR VGND sky130_ef_sc_hd__decap_12
XFILLER_0_129_335 VGND VGND VPWR VPWR sky130_fd_sc_hd__fill_1
Xclkbuf_leaf_77_CLK clknet_3_3__leaf_CLK VGND VGND VPWR VPWR clknet_leaf_77_CLK sky130_fd_sc_hd__clkbuf_8
XFILLER_0_7_717 VGND VGND VPWR VPWR sky130_fd_sc_hd__decap_8
XFILLER_0_15_517 VPWR VGND VPWR VGND sky130_ef_sc_hd__decap_12
X_6470_ _3096_ VGND VGND VPWR VPWR _0738_ sky130_fd_sc_hd__clkbuf_1
XFILLER_0_55_697 VPWR VGND VPWR VGND sky130_ef_sc_hd__decap_12
XFILLER_0_70_678 VPWR VGND VPWR VGND sky130_ef_sc_hd__decap_12
X_5421_ _2153_ _2154_ _1943_ VGND VGND VPWR VPWR _2155_ sky130_fd_sc_hd__mux2_1
XFILLER_0_30_509 VGND VGND VPWR VPWR sky130_fd_sc_hd__decap_4
X_8140_ _3391_ rf.registers\[26\]\[21\] _4009_ VGND VGND VPWR VPWR _4011_ sky130_fd_sc_hd__mux2_1
XFILLER_0_2_433 VPWR VGND VPWR VGND sky130_ef_sc_hd__decap_12
XFILLER_0_23_561 VPWR VGND VPWR VGND sky130_ef_sc_hd__decap_12
X_5352_ rf.registers\[24\]\[25\] rf.registers\[25\]\[25\] rf.registers\[26\]\[25\]
+ rf.registers\[27\]\[25\] _2077_ _2078_ VGND VGND VPWR VPWR _2090_ sky130_fd_sc_hd__mux4_1
X_8071_ _3974_ VGND VGND VPWR VPWR _0437_ sky130_fd_sc_hd__clkbuf_1
XFILLER_0_10_233 VPWR VGND VPWR VGND sky130_ef_sc_hd__decap_12
XFILLER_0_2_477 VPWR VGND VPWR VGND sky130_ef_sc_hd__decap_12
X_4303_ _1095_ VGND VGND VPWR VPWR _1096_ sky130_fd_sc_hd__inv_2
X_7022_ _3417_ VGND VGND VPWR VPWR _0969_ sky130_fd_sc_hd__clkbuf_1
X_5283_ rf.registers\[12\]\[21\] rf.registers\[13\]\[21\] rf.registers\[14\]\[21\]
+ rf.registers\[15\]\[21\] _1999_ _2000_ VGND VGND VPWR VPWR _2025_ sky130_fd_sc_hd__mux4_1
XFILLER_0_10_277 VPWR VGND VPWR VGND sky130_ef_sc_hd__decap_12
X_4234_ rf.registers\[16\]\[0\] rf.registers\[17\]\[0\] rf.registers\[18\]\[0\] rf.registers\[19\]\[0\]
+ _1026_ _1027_ VGND VGND VPWR VPWR _1029_ sky130_fd_sc_hd__mux4_1
XFILLER_0_65_51 VGND VGND VPWR VPWR sky130_fd_sc_hd__fill_2
XFILLER_0_4_65 VPWR VGND VPWR VGND sky130_ef_sc_hd__decap_12
XFILLER_0_78_701 VPWR VGND VPWR VGND sky130_ef_sc_hd__decap_12
X_8973_ clknet_leaf_0_CLK _0061_ VGND VGND VPWR VPWR rf.registers\[19\]\[28\] sky130_fd_sc_hd__dfxtp_1
X_7924_ _3896_ VGND VGND VPWR VPWR _0368_ sky130_fd_sc_hd__clkbuf_1
X_7855_ _3859_ VGND VGND VPWR VPWR _0336_ sky130_fd_sc_hd__clkbuf_1
XFILLER_0_65_417 VPWR VGND VPWR VGND sky130_ef_sc_hd__decap_12
X_6806_ rf.registers\[0\]\[31\] _3051_ _3240_ VGND VGND VPWR VPWR _3275_ sky130_fd_sc_hd__mux2_1
Xclkbuf_leaf_68_CLK clknet_3_2__leaf_CLK VGND VGND VPWR VPWR clknet_leaf_68_CLK sky130_fd_sc_hd__clkbuf_8
XFILLER_0_135_305 VPWR VGND VPWR VGND sky130_ef_sc_hd__decap_12
X_7786_ rf.registers\[9\]\[15\] _3309_ _3817_ VGND VGND VPWR VPWR _3823_ sky130_fd_sc_hd__mux2_1
X_9525_ clknet_leaf_54_CLK _0613_ VGND VGND VPWR VPWR rf.registers\[14\]\[4\] sky130_fd_sc_hd__dfxtp_1
X_4998_ _1744_ _1748_ _1752_ _1754_ _1755_ VGND VGND VPWR VPWR _1756_ sky130_fd_sc_hd__a221o_1
XFILLER_0_58_480 VGND VGND VPWR VPWR sky130_fd_sc_hd__fill_1
XFILLER_0_46_631 VGND VGND VPWR VPWR sky130_fd_sc_hd__fill_2
XTAP_TAPCELL_ROW_137_2359 VGND VPWR sky130_fd_sc_hd__tapvpwrvgnd_1
XTAP_TAPCELL_ROW_137_2348 VGND VPWR sky130_fd_sc_hd__tapvpwrvgnd_1
XFILLER_0_135_349 VPWR VGND VPWR VGND sky130_ef_sc_hd__decap_12
X_6737_ _3238_ VGND VGND VPWR VPWR _0863_ sky130_fd_sc_hd__clkbuf_1
XFILLER_0_46_686 VGND VGND VPWR VPWR sky130_fd_sc_hd__decap_4
XFILLER_0_73_494 VGND VGND VPWR VPWR sky130_fd_sc_hd__decap_8
XFILLER_0_34_837 VGND VGND VPWR VPWR sky130_fd_sc_hd__fill_2
X_6668_ _3201_ VGND VGND VPWR VPWR _0831_ sky130_fd_sc_hd__clkbuf_1
X_9456_ clknet_leaf_67_CLK _0544_ VGND VGND VPWR VPWR rf.registers\[25\]\[31\] sky130_fd_sc_hd__dfxtp_1
XFILLER_0_45_196 VGND VGND VPWR VPWR sky130_fd_sc_hd__fill_1
XFILLER_0_104_725 VPWR VGND VPWR VGND sky130_ef_sc_hd__decap_12
X_8407_ rf.registers\[18\]\[19\] net24 _4142_ VGND VGND VPWR VPWR _4152_ sky130_fd_sc_hd__mux2_1
X_6599_ _3164_ VGND VGND VPWR VPWR _0799_ sky130_fd_sc_hd__clkbuf_1
X_9387_ clknet_leaf_86_CLK _0475_ VGND VGND VPWR VPWR rf.registers\[26\]\[26\] sky130_fd_sc_hd__dfxtp_1
X_5619_ _2344_ _2347_ _2348_ VGND VGND VPWR VPWR _2349_ sky130_fd_sc_hd__mux2_1
XFILLER_0_104_769 VPWR VGND VPWR VGND sky130_ef_sc_hd__decap_12
X_8338_ _4115_ VGND VGND VPWR VPWR _0563_ sky130_fd_sc_hd__clkbuf_1
XFILLER_0_5_293 VPWR VGND VPWR VGND sky130_ef_sc_hd__decap_12
XFILLER_0_41_391 VGND VGND VPWR VPWR sky130_fd_sc_hd__fill_1
X_8269_ _3024_ rf.registers\[25\]\[18\] _4070_ VGND VGND VPWR VPWR _4079_ sky130_fd_sc_hd__mux2_1
XPHY_EDGE_ROW_61_Left_200 VGND VGND VPWR VPWR sky130_fd_sc_hd__decap_3
XFILLER_0_84_737 VPWR VGND VPWR VGND sky130_ef_sc_hd__decap_12
XFILLER_0_83_225 VGND VGND VPWR VPWR sky130_fd_sc_hd__decap_4
Xclkbuf_leaf_59_CLK clknet_3_4__leaf_CLK VGND VGND VPWR VPWR clknet_leaf_59_CLK sky130_fd_sc_hd__clkbuf_8
XFILLER_0_127_839 VGND VGND VPWR VPWR sky130_fd_sc_hd__fill_1
XFILLER_0_83_247 VGND VGND VPWR VPWR sky130_fd_sc_hd__decap_8
XFILLER_0_92_781 VPWR VGND VPWR VGND sky130_ef_sc_hd__decap_12
XFILLER_0_64_472 VGND VGND VPWR VPWR sky130_fd_sc_hd__decap_4
XFILLER_0_36_141 VGND VGND VPWR VPWR sky130_fd_sc_hd__decap_4
XFILLER_0_101_15 VPWR VGND VPWR VGND sky130_ef_sc_hd__decap_12
XFILLER_0_52_645 VPWR VGND VPWR VGND sky130_ef_sc_hd__decap_12
XFILLER_0_52_634 VGND VGND VPWR VPWR sky130_fd_sc_hd__decap_8
XTAP_TAPCELL_ROW_12_478 VGND VPWR sky130_fd_sc_hd__tapvpwrvgnd_1
XPHY_EDGE_ROW_108_Right_108 VGND VGND VPWR VPWR sky130_fd_sc_hd__decap_3
XFILLER_0_51_166 VGND VGND VPWR VPWR sky130_fd_sc_hd__fill_2
XFILLER_0_19_33 VPWR VGND VPWR VGND sky130_ef_sc_hd__decap_12
XFILLER_0_35_43 VPWR VGND VPWR VGND sky130_ef_sc_hd__decap_12
XTAP_TAPCELL_ROW_121_2116 VGND VPWR sky130_fd_sc_hd__tapvpwrvgnd_1
X_5970_ _2265_ _2254_ _2513_ VGND VGND VPWR VPWR _2687_ sky130_fd_sc_hd__nand3_1
X_4921_ _1616_ _1673_ _1681_ VGND VGND VPWR VPWR _1682_ sky130_fd_sc_hd__o21ai_4
X_7640_ _3745_ VGND VGND VPWR VPWR _0235_ sky130_fd_sc_hd__clkbuf_1
XFILLER_0_74_214 VGND VGND VPWR VPWR sky130_fd_sc_hd__fill_2
X_4852_ _1615_ VGND VGND VPWR VPWR net105 sky130_fd_sc_hd__inv_2
XFILLER_0_74_258 VPWR VGND VPWR VGND sky130_ef_sc_hd__decap_12
XFILLER_0_74_225 VGND VGND VPWR VPWR sky130_fd_sc_hd__fill_2
XFILLER_0_7_503 VGND VGND VPWR VPWR sky130_fd_sc_hd__fill_1
X_7571_ _3367_ rf.registers\[27\]\[10\] _3708_ VGND VGND VPWR VPWR _3709_ sky130_fd_sc_hd__mux2_1
XFILLER_0_16_804 VGND VGND VPWR VPWR sky130_fd_sc_hd__decap_8
X_4783_ rf.registers\[12\]\[27\] rf.registers\[13\]\[27\] rf.registers\[14\]\[27\]
+ rf.registers\[15\]\[27\] _1320_ _1321_ VGND VGND VPWR VPWR _1551_ sky130_fd_sc_hd__mux4_1
XFILLER_0_28_675 VGND VGND VPWR VPWR sky130_fd_sc_hd__fill_1
XFILLER_0_133_809 VPWR VGND VPWR VGND sky130_ef_sc_hd__decap_12
XTAP_TAPCELL_ROW_119_2078 VGND VPWR sky130_fd_sc_hd__tapvpwrvgnd_1
X_9310_ clknet_leaf_27_CLK _0398_ VGND VGND VPWR VPWR rf.registers\[22\]\[13\] sky130_fd_sc_hd__dfxtp_1
XFILLER_0_16_837 VGND VGND VPWR VPWR sky130_fd_sc_hd__fill_2
X_6522_ _3123_ VGND VGND VPWR VPWR _0763_ sky130_fd_sc_hd__clkbuf_1
XTAP_TAPCELL_ROW_31_765 VGND VPWR sky130_fd_sc_hd__tapvpwrvgnd_1
XFILLER_0_43_645 VPWR VGND VPWR VGND sky130_ef_sc_hd__decap_12
XTAP_TAPCELL_ROW_119_2089 VGND VPWR sky130_fd_sc_hd__tapvpwrvgnd_1
X_9241_ clknet_leaf_38_CLK _0329_ VGND VGND VPWR VPWR rf.registers\[28\]\[8\] sky130_fd_sc_hd__dfxtp_1
X_6453_ rf.registers\[11\]\[27\] _3043_ _3078_ VGND VGND VPWR VPWR _3086_ sky130_fd_sc_hd__mux2_1
X_9172_ clknet_leaf_38_CLK _0260_ VGND VGND VPWR VPWR rf.registers\[30\]\[3\] sky130_fd_sc_hd__dfxtp_1
Xclkload62 clknet_leaf_23_CLK VGND VGND VPWR VPWR clkload62/X sky130_fd_sc_hd__clkbuf_4
Xclkload51 clknet_leaf_79_CLK VGND VGND VPWR VPWR clkload51/Y sky130_fd_sc_hd__clkinv_4
XFILLER_0_3_753 VPWR VGND VPWR VGND sky130_ef_sc_hd__decap_12
Xclkload40 clknet_leaf_85_CLK VGND VGND VPWR VPWR clkload40/Y sky130_fd_sc_hd__clkinv_4
X_5404_ _2137_ _2138_ _1955_ VGND VGND VPWR VPWR _2139_ sky130_fd_sc_hd__mux2_1
XTAP_TAPCELL_ROW_132_2278 VGND VPWR sky130_fd_sc_hd__tapvpwrvgnd_1
Xclkload84 clknet_leaf_40_CLK VGND VGND VPWR VPWR clkload84/Y sky130_fd_sc_hd__clkinv_1
X_8123_ _3374_ rf.registers\[26\]\[13\] _3998_ VGND VGND VPWR VPWR _4002_ sky130_fd_sc_hd__mux2_1
Xclkload73 clknet_leaf_50_CLK VGND VGND VPWR VPWR clkload73/Y sky130_fd_sc_hd__clkinvlp_4
XFILLER_0_3_797 VPWR VGND VPWR VGND sky130_ef_sc_hd__decap_12
X_6384_ net35 VGND VGND VPWR VPWR _3047_ sky130_fd_sc_hd__buf_2
X_5335_ _1927_ VGND VGND VPWR VPWR _2074_ sky130_fd_sc_hd__buf_4
X_8054_ _3965_ VGND VGND VPWR VPWR _0429_ sky130_fd_sc_hd__clkbuf_1
XFILLER_0_11_586 VPWR VGND VPWR VGND sky130_ef_sc_hd__decap_12
X_5266_ _1732_ VGND VGND VPWR VPWR _2009_ sky130_fd_sc_hd__clkbuf_4
X_7005_ rf.registers\[6\]\[0\] _3276_ _3408_ VGND VGND VPWR VPWR _3409_ sky130_fd_sc_hd__mux2_1
XFILLER_0_76_83 VGND VGND VPWR VPWR sky130_fd_sc_hd__fill_1
X_5197_ _1768_ VGND VGND VPWR VPWR _1943_ sky130_fd_sc_hd__buf_4
X_8956_ clknet_leaf_29_CLK _0044_ VGND VGND VPWR VPWR rf.registers\[19\]\[11\] sky130_fd_sc_hd__dfxtp_1
XFILLER_0_78_531 VGND VGND VPWR VPWR sky130_fd_sc_hd__fill_1
XTAP_TAPCELL_ROW_48_1018 VGND VPWR sky130_fd_sc_hd__tapvpwrvgnd_1
XTAP_TAPCELL_ROW_39_887 VGND VPWR sky130_fd_sc_hd__tapvpwrvgnd_1
X_7907_ _3887_ VGND VGND VPWR VPWR _0360_ sky130_fd_sc_hd__clkbuf_1
XFILLER_0_78_586 VGND VGND VPWR VPWR sky130_fd_sc_hd__fill_2
X_8887_ clknet_leaf_53_CLK _0999_ VGND VGND VPWR VPWR rf.registers\[5\]\[6\] sky130_fd_sc_hd__dfxtp_1
XFILLER_0_66_737 VPWR VGND VPWR VGND sky130_ef_sc_hd__decap_12
XFILLER_0_136_625 VPWR VGND VPWR VGND sky130_ef_sc_hd__decap_12
XFILLER_0_109_839 VGND VGND VPWR VPWR sky130_fd_sc_hd__fill_1
X_7838_ _3850_ VGND VGND VPWR VPWR _0328_ sky130_fd_sc_hd__clkbuf_1
XTAP_TAPCELL_ROW_61_1218 VGND VPWR sky130_fd_sc_hd__tapvpwrvgnd_1
XFILLER_0_19_631 VGND VGND VPWR VPWR sky130_fd_sc_hd__decap_8
XFILLER_0_135_113 VPWR VGND VPWR VGND sky130_ef_sc_hd__decap_12
X_7769_ rf.registers\[9\]\[7\] _3292_ _3806_ VGND VGND VPWR VPWR _3814_ sky130_fd_sc_hd__mux2_1
XFILLER_0_81_729 VPWR VGND VPWR VGND sky130_ef_sc_hd__decap_12
XFILLER_0_18_141 VPWR VGND VPWR VGND sky130_ef_sc_hd__decap_12
XFILLER_0_46_461 VGND VGND VPWR VPWR sky130_fd_sc_hd__decap_8
XFILLER_0_136_669 VPWR VGND VPWR VGND sky130_ef_sc_hd__decap_12
X_9508_ clknet_leaf_20_CLK _0596_ VGND VGND VPWR VPWR rf.registers\[18\]\[19\] sky130_fd_sc_hd__dfxtp_1
XFILLER_0_74_781 VPWR VGND VPWR VGND sky130_ef_sc_hd__decap_12
Xclkload1 clknet_3_1__leaf_CLK VGND VGND VPWR VPWR clkload1/X sky130_fd_sc_hd__clkbuf_8
XFILLER_0_19_697 VGND VGND VPWR VPWR sky130_fd_sc_hd__decap_8
XFILLER_0_34_645 VGND VGND VPWR VPWR sky130_fd_sc_hd__decap_3
XFILLER_0_34_634 VGND VGND VPWR VPWR sky130_fd_sc_hd__fill_1
XFILLER_0_46_472 VGND VGND VPWR VPWR sky130_fd_sc_hd__fill_1
X_9439_ clknet_leaf_28_CLK _0527_ VGND VGND VPWR VPWR rf.registers\[25\]\[14\] sky130_fd_sc_hd__dfxtp_1
XFILLER_0_104_522 VGND VGND VPWR VPWR sky130_fd_sc_hd__fill_1
XFILLER_0_104_533 VGND VGND VPWR VPWR sky130_fd_sc_hd__fill_1
XFILLER_0_131_385 VGND VGND VPWR VPWR sky130_fd_sc_hd__decap_6
XTAP_TAPCELL_ROW_17_548 VGND VPWR sky130_fd_sc_hd__tapvpwrvgnd_1
XTAP_TAPCELL_ROW_17_559 VGND VPWR sky130_fd_sc_hd__tapvpwrvgnd_1
XFILLER_0_84_589 VGND VGND VPWR VPWR sky130_fd_sc_hd__fill_2
XFILLER_0_84_567 VGND VGND VPWR VPWR sky130_fd_sc_hd__fill_1
XFILLER_0_127_669 VGND VGND VPWR VPWR sky130_fd_sc_hd__decap_3
XFILLER_0_115_809 VPWR VGND VPWR VGND sky130_ef_sc_hd__decap_12
XFILLER_0_107_382 VGND VGND VPWR VPWR sky130_fd_sc_hd__decap_8
XFILLER_0_21_89 VGND VGND VPWR VPWR sky130_fd_sc_hd__decap_3
XFILLER_0_107_393 VGND VGND VPWR VPWR sky130_fd_sc_hd__fill_2
XFILLER_0_97_27 VPWR VGND VPWR VGND sky130_ef_sc_hd__decap_12
XFILLER_0_52_475 VGND VGND VPWR VPWR sky130_fd_sc_hd__fill_1
XFILLER_0_40_604 VGND VGND VPWR VPWR sky130_fd_sc_hd__decap_3
XFILLER_0_122_363 VGND VGND VPWR VPWR sky130_fd_sc_hd__fill_1
XFILLER_0_0_701 VGND VGND VPWR VPWR sky130_fd_sc_hd__decap_4
XFILLER_0_40_659 VGND VGND VPWR VPWR sky130_fd_sc_hd__fill_1
XFILLER_0_110_525 VGND VGND VPWR VPWR sky130_fd_sc_hd__fill_1
X_5120_ _1764_ _1866_ _1868_ _1870_ _1709_ VGND VGND VPWR VPWR _1871_ sky130_fd_sc_hd__a221o_1
X_5051_ rf.registers\[8\]\[8\] rf.registers\[9\]\[8\] rf.registers\[10\]\[8\] rf.registers\[11\]\[8\]
+ _1703_ _1704_ VGND VGND VPWR VPWR _1806_ sky130_fd_sc_hd__mux4_1
XFILLER_0_137_55 VGND VGND VPWR VPWR sky130_fd_sc_hd__fill_1
X_8810_ clknet_leaf_71_CLK _0922_ VGND VGND VPWR VPWR rf.registers\[16\]\[25\] sky130_fd_sc_hd__dfxtp_1
XFILLER_0_94_309 VGND VGND VPWR VPWR sky130_fd_sc_hd__decap_4
X_8741_ clknet_leaf_9_CLK _0853_ VGND VGND VPWR VPWR rf.registers\[10\]\[20\] sky130_fd_sc_hd__dfxtp_1
XFILLER_0_1_55 VGND VGND VPWR VPWR sky130_fd_sc_hd__fill_1
XTAP_TAPCELL_ROW_36_835 VGND VPWR sky130_fd_sc_hd__tapvpwrvgnd_1
XFILLER_0_62_41 VGND VGND VPWR VPWR sky130_fd_sc_hd__decap_3
XPHY_EDGE_ROW_9_Left_148 VGND VGND VPWR VPWR sky130_fd_sc_hd__decap_3
XTAP_TAPCELL_ROW_36_846 VGND VPWR sky130_fd_sc_hd__tapvpwrvgnd_1
X_5953_ _1872_ _2648_ _2655_ VGND VGND VPWR VPWR _2671_ sky130_fd_sc_hd__o21ba_1
X_4904_ _1616_ _1650_ _1659_ _1665_ VGND VGND VPWR VPWR _1666_ sky130_fd_sc_hd__a2bb2o_2
XTAP_TAPCELL_ROW_101_1819 VGND VPWR sky130_fd_sc_hd__tapvpwrvgnd_1
XTAP_TAPCELL_ROW_101_1808 VGND VPWR sky130_fd_sc_hd__tapvpwrvgnd_1
X_8672_ clknet_leaf_17_CLK _0784_ VGND VGND VPWR VPWR rf.registers\[1\]\[15\] sky130_fd_sc_hd__dfxtp_1
X_5884_ _2523_ _2604_ _2416_ VGND VGND VPWR VPWR _2605_ sky130_fd_sc_hd__mux2_1
XFILLER_0_117_113 VPWR VGND VPWR VGND sky130_ef_sc_hd__decap_12
X_7623_ _3736_ VGND VGND VPWR VPWR _0227_ sky130_fd_sc_hd__clkbuf_1
XFILLER_0_63_729 VPWR VGND VPWR VGND sky130_ef_sc_hd__decap_12
X_4835_ _1599_ VGND VGND VPWR VPWR net104 sky130_fd_sc_hd__inv_2
XFILLER_0_16_601 VGND VGND VPWR VPWR sky130_fd_sc_hd__decap_4
XTAP_TAPCELL_ROW_134_2307 VGND VPWR sky130_fd_sc_hd__tapvpwrvgnd_1
XFILLER_0_133_617 VPWR VGND VPWR VGND sky130_ef_sc_hd__decap_12
X_7554_ _3351_ rf.registers\[27\]\[2\] _3697_ VGND VGND VPWR VPWR _3700_ sky130_fd_sc_hd__mux2_1
XFILLER_0_56_781 VPWR VGND VPWR VGND sky130_ef_sc_hd__decap_12
XFILLER_0_15_111 VGND VGND VPWR VPWR sky130_fd_sc_hd__fill_1
X_4766_ rf.registers\[0\]\[26\] rf.registers\[1\]\[26\] rf.registers\[2\]\[26\] rf.registers\[3\]\[26\]
+ _1159_ _1160_ VGND VGND VPWR VPWR _1535_ sky130_fd_sc_hd__mux4_1
X_6505_ _3114_ VGND VGND VPWR VPWR _0755_ sky130_fd_sc_hd__clkbuf_1
XFILLER_0_16_645 VPWR VGND VPWR VGND sky130_ef_sc_hd__decap_12
X_7485_ _3663_ VGND VGND VPWR VPWR _0162_ sky130_fd_sc_hd__clkbuf_1
XFILLER_0_70_261 VGND VGND VPWR VPWR sky130_fd_sc_hd__fill_1
X_4697_ _1381_ _1469_ VGND VGND VPWR VPWR _1470_ sky130_fd_sc_hd__or2_1
XFILLER_0_31_615 VGND VGND VPWR VPWR sky130_fd_sc_hd__fill_1
XFILLER_0_113_352 VGND VGND VPWR VPWR sky130_fd_sc_hd__fill_1
X_6436_ rf.registers\[11\]\[19\] _3026_ _3067_ VGND VGND VPWR VPWR _3077_ sky130_fd_sc_hd__mux2_1
X_9224_ clknet_leaf_8_CLK _0312_ VGND VGND VPWR VPWR rf.registers\[9\]\[23\] sky130_fd_sc_hd__dfxtp_1
XFILLER_0_3_561 VPWR VGND VPWR VGND sky130_ef_sc_hd__decap_12
X_9155_ clknet_leaf_6_CLK _0243_ VGND VGND VPWR VPWR rf.registers\[2\]\[18\] sky130_fd_sc_hd__dfxtp_1
X_6367_ rf.registers\[12\]\[23\] _3035_ _3029_ VGND VGND VPWR VPWR _3036_ sky130_fd_sc_hd__mux2_1
XFILLER_0_101_558 VGND VGND VPWR VPWR sky130_fd_sc_hd__fill_2
XFILLER_0_87_93 VGND VGND VPWR VPWR sky130_fd_sc_hd__decap_3
X_8106_ _3357_ rf.registers\[26\]\[5\] _3987_ VGND VGND VPWR VPWR _3993_ sky130_fd_sc_hd__mux2_1
X_5318_ _1768_ _2057_ VGND VGND VPWR VPWR _2058_ sky130_fd_sc_hd__or2_1
XFILLER_0_11_361 VPWR VGND VPWR VGND sky130_ef_sc_hd__decap_12
X_6298_ net25 VGND VGND VPWR VPWR _2989_ sky130_fd_sc_hd__buf_2
X_9086_ clknet_leaf_25_CLK _0174_ VGND VGND VPWR VPWR rf.registers\[31\]\[13\] sky130_fd_sc_hd__dfxtp_1
X_8037_ _3956_ VGND VGND VPWR VPWR _0421_ sky130_fd_sc_hd__clkbuf_1
X_5249_ _1741_ _1992_ _1742_ VGND VGND VPWR VPWR _1993_ sky130_fd_sc_hd__o21a_1
XFILLER_0_97_147 VGND VGND VPWR VPWR sky130_fd_sc_hd__fill_2
XFILLER_0_66_501 VGND VGND VPWR VPWR sky130_fd_sc_hd__decap_6
X_8939_ clknet_leaf_68_CLK _0027_ VGND VGND VPWR VPWR rf.registers\[4\]\[26\] sky130_fd_sc_hd__dfxtp_1
XFILLER_0_66_545 VPWR VGND VPWR VGND sky130_ef_sc_hd__decap_12
XTAP_TAPCELL_ROW_14_507 VGND VPWR sky130_fd_sc_hd__tapvpwrvgnd_1
XFILLER_0_136_433 VPWR VGND VPWR VGND sky130_ef_sc_hd__decap_12
XFILLER_0_66_589 VGND VGND VPWR VPWR sky130_fd_sc_hd__decap_8
XFILLER_0_136_477 VPWR VGND VPWR VGND sky130_ef_sc_hd__decap_12
XFILLER_0_123_105 VGND VGND VPWR VPWR sky130_fd_sc_hd__decap_6
XFILLER_0_123_149 VPWR VGND VPWR VGND sky130_ef_sc_hd__decap_12
XFILLER_0_104_374 VGND VGND VPWR VPWR sky130_fd_sc_hd__fill_2
XTAP_TAPCELL_ROW_74_1409 VGND VPWR sky130_fd_sc_hd__tapvpwrvgnd_1
XFILLER_0_131_193 VPWR VGND VPWR VGND sky130_ef_sc_hd__decap_12
XTAP_TAPCELL_ROW_89_1641 VGND VPWR sky130_fd_sc_hd__tapvpwrvgnd_1
XTAP_TAPCELL_ROW_89_1630 VGND VPWR sky130_fd_sc_hd__tapvpwrvgnd_1
XFILLER_0_107_69 VGND VGND VPWR VPWR sky130_fd_sc_hd__decap_8
XFILLER_0_88_158 VGND VGND VPWR VPWR sky130_fd_sc_hd__decap_6
XFILLER_0_85_821 VPWR VGND VPWR VGND sky130_ef_sc_hd__decap_12
XFILLER_0_76_309 VGND VGND VPWR VPWR sky130_fd_sc_hd__fill_1
XFILLER_0_123_57 VPWR VGND VPWR VGND sky130_ef_sc_hd__decap_12
XFILLER_0_84_353 VGND VGND VPWR VPWR sky130_fd_sc_hd__decap_8
XFILLER_0_45_729 VGND VGND VPWR VPWR sky130_fd_sc_hd__decap_8
XFILLER_0_72_537 VGND VGND VPWR VPWR sky130_fd_sc_hd__fill_1
XFILLER_0_72_515 VGND VGND VPWR VPWR sky130_fd_sc_hd__decap_4
X_4620_ _1312_ VGND VGND VPWR VPWR _1397_ sky130_fd_sc_hd__buf_4
XFILLER_0_113_3 VPWR VGND VPWR VGND sky130_ef_sc_hd__decap_12
XFILLER_0_25_420 VGND VGND VPWR VPWR sky130_fd_sc_hd__decap_8
XTAP_TAPCELL_ROW_116_2037 VGND VPWR sky130_fd_sc_hd__tapvpwrvgnd_1
X_4551_ rf.registers\[28\]\[14\] rf.registers\[29\]\[14\] rf.registers\[30\]\[14\]
+ rf.registers\[31\]\[14\] _1294_ _1295_ VGND VGND VPWR VPWR _1332_ sky130_fd_sc_hd__mux4_1
XFILLER_0_52_272 VGND VGND VPWR VPWR sky130_fd_sc_hd__decap_6
X_4482_ _1116_ _1258_ _1262_ _1266_ VGND VGND VPWR VPWR _1267_ sky130_fd_sc_hd__o22a_1
X_7270_ _3548_ VGND VGND VPWR VPWR _0062_ sky130_fd_sc_hd__clkbuf_1
XFILLER_0_0_520 VPWR VGND VPWR VGND sky130_ef_sc_hd__decap_12
X_6221_ net92 _2893_ _2922_ _2318_ VGND VGND VPWR VPWR _2923_ sky130_fd_sc_hd__a211o_1
XFILLER_0_21_681 VGND VGND VPWR VPWR sky130_fd_sc_hd__decap_6
XFILLER_0_40_489 VGND VGND VPWR VPWR sky130_fd_sc_hd__decap_8
X_6152_ net97 _2203_ _2820_ _2479_ VGND VGND VPWR VPWR _2858_ sky130_fd_sc_hd__o31a_1
X_5103_ _1742_ _1854_ _1709_ VGND VGND VPWR VPWR _1855_ sky130_fd_sc_hd__a21oi_1
XFILLER_0_0_586 VGND VGND VPWR VPWR sky130_fd_sc_hd__fill_2
XFILLER_0_0_597 VGND VGND VPWR VPWR sky130_fd_sc_hd__fill_1
XTAP_TAPCELL_ROW_111_1970 VGND VPWR sky130_fd_sc_hd__tapvpwrvgnd_1
X_6083_ _2763_ _2792_ _2348_ VGND VGND VPWR VPWR _2793_ sky130_fd_sc_hd__mux2_1
X_5034_ rf.registers\[4\]\[7\] rf.registers\[5\]\[7\] rf.registers\[6\]\[7\] rf.registers\[7\]\[7\]
+ _1652_ _1653_ VGND VGND VPWR VPWR _1790_ sky130_fd_sc_hd__mux4_1
XTAP_TAPCELL_ROW_127_2199 VGND VPWR sky130_fd_sc_hd__tapvpwrvgnd_1
XFILLER_0_18_3 VPWR VGND VPWR VGND sky130_ef_sc_hd__decap_12
XFILLER_0_73_84 VGND VGND VPWR VPWR sky130_fd_sc_hd__decap_4
XTAP_TAPCELL_ROW_0_279 VGND VPWR sky130_fd_sc_hd__tapvpwrvgnd_1
X_6985_ net30 VGND VGND VPWR VPWR _3397_ sky130_fd_sc_hd__clkbuf_2
X_8724_ clknet_leaf_36_CLK _0836_ VGND VGND VPWR VPWR rf.registers\[10\]\[3\] sky130_fd_sc_hd__dfxtp_1
X_5936_ _2649_ _2654_ VGND VGND VPWR VPWR _2655_ sky130_fd_sc_hd__and2_1
X_8655_ clknet_leaf_73_CLK _0767_ VGND VGND VPWR VPWR rf.registers\[17\]\[30\] sky130_fd_sc_hd__dfxtp_1
XFILLER_0_75_375 VGND VGND VPWR VPWR sky130_fd_sc_hd__decap_3
X_5867_ _1826_ _2588_ VGND VGND VPWR VPWR _2589_ sky130_fd_sc_hd__nor2_1
XFILLER_0_48_589 VPWR VGND VPWR VGND sky130_ef_sc_hd__decap_12
XFILLER_0_8_653 VGND VGND VPWR VPWR sky130_fd_sc_hd__decap_8
X_7606_ _2972_ rf.registers\[27\]\[27\] _3719_ VGND VGND VPWR VPWR _3727_ sky130_fd_sc_hd__mux2_1
XFILLER_0_35_206 VGND VGND VPWR VPWR sky130_fd_sc_hd__fill_2
XFILLER_0_63_559 VGND VGND VPWR VPWR sky130_fd_sc_hd__fill_1
XFILLER_0_8_697 VGND VGND VPWR VPWR sky130_fd_sc_hd__decap_3
X_5798_ _2304_ _2464_ _2522_ VGND VGND VPWR VPWR _2523_ sky130_fd_sc_hd__a21o_1
X_8586_ clknet_leaf_73_CLK _0698_ VGND VGND VPWR VPWR rf.registers\[12\]\[25\] sky130_fd_sc_hd__dfxtp_1
X_4818_ _1583_ VGND VGND VPWR VPWR net102 sky130_fd_sc_hd__buf_2
XFILLER_0_133_447 VGND VGND VPWR VPWR sky130_fd_sc_hd__fill_1
XFILLER_0_90_378 VGND VGND VPWR VPWR sky130_fd_sc_hd__decap_6
XFILLER_0_50_209 VPWR VGND VPWR VGND sky130_ef_sc_hd__decap_12
XFILLER_0_16_475 VGND VGND VPWR VPWR sky130_fd_sc_hd__fill_1
X_4749_ rf.registers\[0\]\[25\] rf.registers\[1\]\[25\] rf.registers\[2\]\[25\] rf.registers\[3\]\[25\]
+ _1159_ _1160_ VGND VGND VPWR VPWR _1519_ sky130_fd_sc_hd__mux4_1
X_7537_ _3690_ VGND VGND VPWR VPWR _0187_ sky130_fd_sc_hd__clkbuf_1
X_7468_ _2970_ rf.registers\[29\]\[26\] _3647_ VGND VGND VPWR VPWR _3654_ sky130_fd_sc_hd__mux2_1
X_6419_ _3068_ VGND VGND VPWR VPWR _0715_ sky130_fd_sc_hd__clkbuf_1
X_9207_ clknet_leaf_61_CLK _0295_ VGND VGND VPWR VPWR rf.registers\[9\]\[6\] sky130_fd_sc_hd__dfxtp_1
XTAP_TAPCELL_ROW_56_1139 VGND VPWR sky130_fd_sc_hd__tapvpwrvgnd_1
XFILLER_0_3_391 VGND VGND VPWR VPWR sky130_fd_sc_hd__fill_1
X_7399_ rf.registers\[8\]\[26\] _3332_ _3610_ VGND VGND VPWR VPWR _3617_ sky130_fd_sc_hd__mux2_1
Xoutput58 net58 VGND VGND VPWR VPWR RD1[18] sky130_fd_sc_hd__buf_1
X_9138_ clknet_leaf_46_CLK _0226_ VGND VGND VPWR VPWR rf.registers\[2\]\[1\] sky130_fd_sc_hd__dfxtp_1
Xoutput69 net69 VGND VGND VPWR VPWR RD1[28] sky130_fd_sc_hd__buf_1
X_9069_ clknet_leaf_94_CLK _0157_ VGND VGND VPWR VPWR rf.registers\[29\]\[28\] sky130_fd_sc_hd__dfxtp_1
XFILLER_0_129_709 VPWR VGND VPWR VGND sky130_ef_sc_hd__decap_12
XTAP_TAPCELL_ROW_84_1560 VGND VPWR sky130_fd_sc_hd__tapvpwrvgnd_1
XFILLER_0_67_821 VPWR VGND VPWR VGND sky130_ef_sc_hd__decap_12
XFILLER_0_94_673 VPWR VGND VPWR VGND sky130_ef_sc_hd__decap_12
XFILLER_0_82_813 VPWR VGND VPWR VGND sky130_ef_sc_hd__decap_12
XFILLER_0_66_342 VGND VGND VPWR VPWR sky130_fd_sc_hd__decap_6
XTAP_TAPCELL_ROW_27_698 VGND VPWR sky130_fd_sc_hd__tapvpwrvgnd_1
XFILLER_0_137_753 VPWR VGND VPWR VGND sky130_ef_sc_hd__decap_12
XFILLER_0_27_729 VGND VGND VPWR VPWR sky130_fd_sc_hd__decap_8
XFILLER_0_137_797 VPWR VGND VPWR VGND sky130_ef_sc_hd__decap_12
XFILLER_0_81_378 VPWR VGND VPWR VGND sky130_ef_sc_hd__decap_12
XFILLER_0_62_570 VGND VGND VPWR VPWR sky130_fd_sc_hd__decap_4
XFILLER_0_34_250 VGND VGND VPWR VPWR sky130_fd_sc_hd__fill_2
XFILLER_0_1_317 VPWR VGND VPWR VGND sky130_ef_sc_hd__decap_12
XFILLER_0_120_686 VPWR VGND VPWR VGND sky130_ef_sc_hd__decap_12
X_6770_ _3256_ VGND VGND VPWR VPWR _0878_ sky130_fd_sc_hd__clkbuf_1
XFILLER_0_76_139 VGND VGND VPWR VPWR sky130_fd_sc_hd__fill_1
XFILLER_0_9_417 VPWR VGND VPWR VGND sky130_ef_sc_hd__decap_12
XFILLER_0_43_43 VPWR VGND VPWR VGND sky130_ef_sc_hd__decap_12
XTAP_TAPCELL_ROW_46_985 VGND VPWR sky130_fd_sc_hd__tapvpwrvgnd_1
X_5721_ _2260_ _2347_ _2448_ VGND VGND VPWR VPWR _2449_ sky130_fd_sc_hd__o21a_1
XTAP_TAPCELL_ROW_46_996 VGND VPWR sky130_fd_sc_hd__tapvpwrvgnd_1
XPHY_EDGE_ROW_99_Left_238 VGND VGND VPWR VPWR sky130_fd_sc_hd__decap_3
XFILLER_0_84_150 VGND VGND VPWR VPWR sky130_fd_sc_hd__decap_3
XFILLER_0_57_375 VGND VGND VPWR VPWR sky130_fd_sc_hd__decap_4
X_8440_ _2991_ rf.registers\[14\]\[2\] _4167_ VGND VGND VPWR VPWR _4170_ sky130_fd_sc_hd__mux2_1
XFILLER_0_115_414 VGND VGND VPWR VPWR sky130_fd_sc_hd__fill_1
XFILLER_0_72_345 VGND VGND VPWR VPWR sky130_fd_sc_hd__fill_1
X_5652_ _2380_ _2381_ VGND VGND VPWR VPWR _2382_ sky130_fd_sc_hd__nor2_1
X_8371_ _4133_ VGND VGND VPWR VPWR _0578_ sky130_fd_sc_hd__clkbuf_1
XFILLER_0_60_507 VGND VGND VPWR VPWR sky130_fd_sc_hd__decap_3
X_5583_ _2305_ _2313_ net103 VGND VGND VPWR VPWR _2314_ sky130_fd_sc_hd__mux2_1
XFILLER_0_4_133 VGND VGND VPWR VPWR sky130_fd_sc_hd__decap_6
X_4603_ _1137_ VGND VGND VPWR VPWR _1381_ sky130_fd_sc_hd__buf_4
X_4534_ _1314_ _1315_ _1312_ VGND VGND VPWR VPWR _1316_ sky130_fd_sc_hd__mux2_1
X_7322_ _3576_ VGND VGND VPWR VPWR _0086_ sky130_fd_sc_hd__clkbuf_1
XFILLER_0_25_294 VGND VGND VPWR VPWR sky130_fd_sc_hd__fill_1
XFILLER_0_111_620 VGND VGND VPWR VPWR sky130_fd_sc_hd__fill_1
XFILLER_0_7_43 VPWR VGND VPWR VGND sky130_ef_sc_hd__decap_12
XFILLER_0_4_177 VPWR VGND VPWR VGND sky130_ef_sc_hd__decap_12
XFILLER_0_40_253 VGND VGND VPWR VPWR sky130_fd_sc_hd__fill_2
XFILLER_0_111_642 VGND VGND VPWR VPWR sky130_fd_sc_hd__decap_6
X_4465_ _1116_ _1242_ _1246_ _1250_ VGND VGND VPWR VPWR _1251_ sky130_fd_sc_hd__o22a_1
XFILLER_0_68_51 VGND VGND VPWR VPWR sky130_fd_sc_hd__decap_3
X_7253_ rf.registers\[19\]\[21\] _3322_ _3538_ VGND VGND VPWR VPWR _3540_ sky130_fd_sc_hd__mux2_1
XFILLER_0_111_697 VPWR VGND VPWR VGND sky130_ef_sc_hd__decap_12
XFILLER_0_110_174 VGND VGND VPWR VPWR sky130_fd_sc_hd__fill_1
X_4396_ _1182_ _1184_ _1163_ VGND VGND VPWR VPWR _1185_ sky130_fd_sc_hd__mux2_1
X_7184_ _3503_ VGND VGND VPWR VPWR _0021_ sky130_fd_sc_hd__clkbuf_1
X_6204_ _2149_ _2906_ VGND VGND VPWR VPWR _2907_ sky130_fd_sc_hd__nor2_1
XTAP_TAPCELL_ROW_129_2239 VGND VPWR sky130_fd_sc_hd__tapvpwrvgnd_1
XTAP_TAPCELL_ROW_129_2228 VGND VPWR sky130_fd_sc_hd__tapvpwrvgnd_1
X_6135_ _2571_ _2295_ VGND VGND VPWR VPWR _2842_ sky130_fd_sc_hd__or2b_1
XTAP_TAPCELL_ROW_51_1069 VGND VPWR sky130_fd_sc_hd__tapvpwrvgnd_1
XTAP_TAPCELL_ROW_51_1058 VGND VPWR sky130_fd_sc_hd__tapvpwrvgnd_1
X_6066_ _2748_ _2776_ _2383_ VGND VGND VPWR VPWR _2777_ sky130_fd_sc_hd__mux2_1
X_5017_ rf.registers\[4\]\[6\] rf.registers\[5\]\[6\] rf.registers\[6\]\[6\] rf.registers\[7\]\[6\]
+ _1772_ _1773_ VGND VGND VPWR VPWR _1774_ sky130_fd_sc_hd__mux4_1
XFILLER_0_138_517 VPWR VGND VPWR VGND sky130_ef_sc_hd__decap_12
XFILLER_0_49_821 VPWR VGND VPWR VGND sky130_ef_sc_hd__decap_12
XFILLER_0_82_109 VGND VGND VPWR VPWR sky130_fd_sc_hd__fill_1
XTAP_TAPCELL_ROW_66_1290 VGND VPWR sky130_fd_sc_hd__tapvpwrvgnd_1
X_8707_ clknet_leaf_5_CLK _0819_ VGND VGND VPWR VPWR rf.registers\[24\]\[18\] sky130_fd_sc_hd__dfxtp_1
X_6968_ _3385_ VGND VGND VPWR VPWR _0947_ sky130_fd_sc_hd__clkbuf_1
XFILLER_0_119_753 VPWR VGND VPWR VGND sky130_ef_sc_hd__decap_12
XFILLER_0_75_172 VGND VGND VPWR VPWR sky130_fd_sc_hd__decap_8
XFILLER_0_64_813 VPWR VGND VPWR VGND sky130_ef_sc_hd__decap_12
X_5919_ _2637_ VGND VGND VPWR VPWR _2638_ sky130_fd_sc_hd__inv_2
XTAP_TAPCELL_ROW_24_657 VGND VPWR sky130_fd_sc_hd__tapvpwrvgnd_1
X_6899_ net35 VGND VGND VPWR VPWR _3338_ sky130_fd_sc_hd__buf_2
XFILLER_0_134_701 VPWR VGND VPWR VGND sky130_ef_sc_hd__decap_12
XFILLER_0_119_797 VPWR VGND VPWR VGND sky130_ef_sc_hd__decap_12
X_8638_ clknet_leaf_27_CLK _0750_ VGND VGND VPWR VPWR rf.registers\[17\]\[13\] sky130_fd_sc_hd__dfxtp_1
XFILLER_0_36_559 VGND VGND VPWR VPWR sky130_fd_sc_hd__decap_6
X_8569_ clknet_leaf_45_CLK _0681_ VGND VGND VPWR VPWR rf.registers\[12\]\[8\] sky130_fd_sc_hd__dfxtp_1
XFILLER_0_32_798 VPWR VGND VPWR VGND sky130_ef_sc_hd__decap_12
XFILLER_0_102_697 VGND VGND VPWR VPWR sky130_fd_sc_hd__decap_3
XFILLER_0_99_721 VGND VGND VPWR VPWR sky130_fd_sc_hd__decap_6
XTAP_TAPCELL_ROW_4_360 VGND VPWR sky130_fd_sc_hd__tapvpwrvgnd_1
XFILLER_0_99_765 VPWR VGND VPWR VGND sky130_ef_sc_hd__decap_12
XFILLER_0_58_106 VGND VGND VPWR VPWR sky130_fd_sc_hd__decap_6
XFILLER_0_86_448 VGND VGND VPWR VPWR sky130_fd_sc_hd__fill_1
XFILLER_0_104_15 VPWR VGND VPWR VGND sky130_ef_sc_hd__decap_12
XTAP_TAPCELL_ROW_43_944 VGND VPWR sky130_fd_sc_hd__tapvpwrvgnd_1
XFILLER_0_67_673 VPWR VGND VPWR VGND sky130_ef_sc_hd__decap_12
XFILLER_0_13_57 VPWR VGND VPWR VGND sky130_ef_sc_hd__decap_12
XFILLER_0_137_561 VPWR VGND VPWR VGND sky130_ef_sc_hd__decap_12
XFILLER_0_82_643 VGND VGND VPWR VPWR sky130_fd_sc_hd__fill_1
XFILLER_0_70_805 VGND VGND VPWR VPWR sky130_fd_sc_hd__decap_6
XFILLER_0_27_559 VGND VGND VPWR VPWR sky130_fd_sc_hd__fill_1
XFILLER_0_124_233 VPWR VGND VPWR VGND sky130_ef_sc_hd__decap_12
XFILLER_0_89_39 VGND VGND VPWR VPWR sky130_fd_sc_hd__decap_4
XFILLER_0_14_209 VPWR VGND VPWR VGND sky130_ef_sc_hd__decap_12
XTAP_TAPCELL_ROW_97_1751 VGND VPWR sky130_fd_sc_hd__tapvpwrvgnd_1
XFILLER_0_81_175 VGND VGND VPWR VPWR sky130_fd_sc_hd__fill_1
XFILLER_0_23_721 VGND VGND VPWR VPWR sky130_fd_sc_hd__decap_6
XFILLER_0_124_277 VPWR VGND VPWR VGND sky130_ef_sc_hd__decap_12
XTAP_TAPCELL_ROW_97_1762 VGND VPWR sky130_fd_sc_hd__tapvpwrvgnd_1
XFILLER_0_1_125 VPWR VGND VPWR VGND sky130_ef_sc_hd__decap_12
XFILLER_0_2_637 VGND VGND VPWR VPWR sky130_fd_sc_hd__decap_6
XFILLER_0_22_242 VGND VGND VPWR VPWR sky130_fd_sc_hd__fill_1
XFILLER_0_50_584 VGND VGND VPWR VPWR sky130_fd_sc_hd__decap_4
XFILLER_0_22_264 VGND VGND VPWR VPWR sky130_fd_sc_hd__decap_3
X_4250_ rf.registers\[8\]\[0\] rf.registers\[9\]\[0\] rf.registers\[10\]\[0\] rf.registers\[11\]\[0\]
+ _1042_ _1044_ VGND VGND VPWR VPWR _1045_ sky130_fd_sc_hd__mux4_1
XFILLER_0_1_169 VPWR VGND VPWR VGND sky130_ef_sc_hd__decap_12
X_7940_ _3395_ rf.registers\[23\]\[23\] _3901_ VGND VGND VPWR VPWR _3905_ sky130_fd_sc_hd__mux2_1
XTAP_TAPCELL_ROW_124_2158 VGND VPWR sky130_fd_sc_hd__tapvpwrvgnd_1
X_7871_ _3395_ rf.registers\[28\]\[23\] _3864_ VGND VGND VPWR VPWR _3868_ sky130_fd_sc_hd__mux2_1
X_6822_ net40 VGND VGND VPWR VPWR _3286_ sky130_fd_sc_hd__clkbuf_2
XTAP_TAPCELL_ROW_106_1891 VGND VPWR sky130_fd_sc_hd__tapvpwrvgnd_1
XFILLER_0_9_225 VPWR VGND VPWR VGND sky130_ef_sc_hd__decap_12
XFILLER_0_92_418 VGND VGND VPWR VPWR sky130_fd_sc_hd__fill_2
X_6753_ _3247_ VGND VGND VPWR VPWR _0870_ sky130_fd_sc_hd__clkbuf_1
X_9541_ clknet_leaf_9_CLK _0629_ VGND VGND VPWR VPWR rf.registers\[14\]\[20\] sky130_fd_sc_hd__dfxtp_1
XFILLER_0_46_813 VPWR VGND VPWR VGND sky130_ef_sc_hd__decap_12
XFILLER_0_116_701 VPWR VGND VPWR VGND sky130_ef_sc_hd__decap_12
X_9472_ clknet_leaf_22_CLK _0560_ VGND VGND VPWR VPWR rf.registers\[20\]\[15\] sky130_fd_sc_hd__dfxtp_1
XFILLER_0_70_85 VGND VGND VPWR VPWR sky130_fd_sc_hd__decap_6
X_6684_ rf.registers\[10\]\[5\] _2997_ _3205_ VGND VGND VPWR VPWR _3211_ sky130_fd_sc_hd__mux2_1
XTAP_TAPCELL_ROW_21_616 VGND VPWR sky130_fd_sc_hd__tapvpwrvgnd_1
X_5704_ _1711_ _2430_ VGND VGND VPWR VPWR _2432_ sky130_fd_sc_hd__nor2_1
X_8423_ _4160_ VGND VGND VPWR VPWR _0603_ sky130_fd_sc_hd__clkbuf_1
X_5635_ _1998_ _2208_ _2220_ VGND VGND VPWR VPWR _2365_ sky130_fd_sc_hd__o21ai_1
XFILLER_0_85_3 VPWR VGND VPWR VGND sky130_ef_sc_hd__decap_12
XFILLER_0_72_197 VGND VGND VPWR VPWR sky130_fd_sc_hd__fill_1
XFILLER_0_72_175 VGND VGND VPWR VPWR sky130_fd_sc_hd__fill_1
XFILLER_0_14_710 VGND VGND VPWR VPWR sky130_fd_sc_hd__decap_8
XFILLER_0_5_497 VGND VGND VPWR VPWR sky130_fd_sc_hd__decap_6
X_8354_ rf.registers\[20\]\[26\] net32 _4117_ VGND VGND VPWR VPWR _4124_ sky130_fd_sc_hd__mux2_1
X_5566_ _1966_ _2208_ _2209_ VGND VGND VPWR VPWR _2297_ sky130_fd_sc_hd__o21ai_1
X_4517_ _1293_ _1299_ VGND VGND VPWR VPWR _1300_ sky130_fd_sc_hd__nand2_1
X_7305_ _3567_ VGND VGND VPWR VPWR _0078_ sky130_fd_sc_hd__clkbuf_1
XFILLER_0_79_94 VGND VGND VPWR VPWR sky130_fd_sc_hd__fill_2
X_8285_ _4087_ VGND VGND VPWR VPWR _0538_ sky130_fd_sc_hd__clkbuf_1
X_5497_ _1810_ _2206_ VGND VGND VPWR VPWR _2228_ sky130_fd_sc_hd__nor2_1
X_4448_ _1116_ _1226_ _1234_ VGND VGND VPWR VPWR _1235_ sky130_fd_sc_hd__o21a_1
X_7236_ rf.registers\[19\]\[13\] _3305_ _3527_ VGND VGND VPWR VPWR _3531_ sky130_fd_sc_hd__mux2_1
X_7167_ _3494_ VGND VGND VPWR VPWR _0013_ sky130_fd_sc_hd__clkbuf_1
X_4379_ _1164_ _1167_ _1168_ VGND VGND VPWR VPWR _1169_ sky130_fd_sc_hd__mux2_2
X_7098_ rf.registers\[5\]\[12\] _3303_ _3455_ VGND VGND VPWR VPWR _3458_ sky130_fd_sc_hd__mux2_1
X_6118_ net64 _2821_ _2823_ VGND VGND VPWR VPWR _2826_ sky130_fd_sc_hd__and3_1
X_6049_ _2754_ _2755_ _2759_ VGND VGND VPWR VPWR _2761_ sky130_fd_sc_hd__o21a_1
XFILLER_0_96_713 VPWR VGND VPWR VGND sky130_ef_sc_hd__decap_12
XTAP_TAPCELL_ROW_29_738 VGND VPWR sky130_fd_sc_hd__tapvpwrvgnd_1
XFILLER_0_96_757 VPWR VGND VPWR VGND sky130_ef_sc_hd__decap_12
XFILLER_0_68_448 VPWR VGND VPWR VGND sky130_ef_sc_hd__decap_12
XFILLER_0_138_325 VGND VGND VPWR VPWR sky130_fd_sc_hd__decap_8
XFILLER_0_83_418 VGND VGND VPWR VPWR sky130_fd_sc_hd__decap_4
XFILLER_0_37_824 VPWR VGND VPWR VGND sky130_ef_sc_hd__decap_12
XTAP_TAPCELL_ROW_40_903 VGND VPWR sky130_fd_sc_hd__tapvpwrvgnd_1
XFILLER_0_138_369 VPWR VGND VPWR VGND sky130_ef_sc_hd__decap_12
XFILLER_0_52_805 VGND VGND VPWR VPWR sky130_fd_sc_hd__decap_6
XFILLER_0_122_737 VPWR VGND VPWR VGND sky130_ef_sc_hd__decap_12
XFILLER_0_121_225 VPWR VGND VPWR VGND sky130_ef_sc_hd__decap_12
XTAP_TAPCELL_ROW_79_1492 VGND VPWR sky130_fd_sc_hd__tapvpwrvgnd_1
XTAP_TAPCELL_ROW_79_1481 VGND VPWR sky130_fd_sc_hd__tapvpwrvgnd_1
XFILLER_0_130_781 VPWR VGND VPWR VGND sky130_ef_sc_hd__decap_12
XTAP_TAPCELL_ROW_9_441 VGND VPWR sky130_fd_sc_hd__tapvpwrvgnd_1
XTAP_TAPCELL_ROW_9_430 VGND VPWR sky130_fd_sc_hd__tapvpwrvgnd_1
XFILLER_0_20_757 VPWR VGND VPWR VGND sky130_ef_sc_hd__decap_12
XTAP_TAPCELL_ROW_92_1681 VGND VPWR sky130_fd_sc_hd__tapvpwrvgnd_1
XFILLER_0_87_713 VPWR VGND VPWR VGND sky130_ef_sc_hd__decap_12
XFILLER_0_59_404 VGND VGND VPWR VPWR sky130_fd_sc_hd__fill_1
XFILLER_0_115_69 VPWR VGND VPWR VGND sky130_ef_sc_hd__decap_12
XFILLER_0_67_470 VPWR VGND VPWR VGND sky130_ef_sc_hd__decap_12
XFILLER_0_7_707 VGND VGND VPWR VPWR sky130_fd_sc_hd__fill_2
XFILLER_0_28_813 VPWR VGND VPWR VGND sky130_ef_sc_hd__decap_12
XFILLER_0_7_729 VPWR VGND VPWR VGND sky130_ef_sc_hd__decap_12
XFILLER_0_137_391 VGND VGND VPWR VPWR sky130_fd_sc_hd__fill_1
XFILLER_0_131_57 VPWR VGND VPWR VGND sky130_ef_sc_hd__decap_12
XFILLER_0_15_529 VPWR VGND VPWR VGND sky130_ef_sc_hd__decap_12
XFILLER_0_2_401 VPWR VGND VPWR VGND sky130_ef_sc_hd__decap_12
X_5420_ rf.registers\[24\]\[29\] rf.registers\[25\]\[29\] rf.registers\[26\]\[29\]
+ rf.registers\[27\]\[29\] _1959_ _1960_ VGND VGND VPWR VPWR _2154_ sky130_fd_sc_hd__mux4_1
XFILLER_0_40_88 VGND VGND VPWR VPWR sky130_fd_sc_hd__fill_1
XFILLER_0_2_445 VPWR VGND VPWR VGND sky130_ef_sc_hd__decap_12
XFILLER_0_23_573 VGND VGND VPWR VPWR sky130_fd_sc_hd__decap_3
XFILLER_0_23_584 VPWR VGND VPWR VGND sky130_ef_sc_hd__decap_12
X_5351_ rf.registers\[28\]\[25\] rf.registers\[29\]\[25\] rf.registers\[30\]\[25\]
+ rf.registers\[31\]\[25\] _2077_ _2078_ VGND VGND VPWR VPWR _2089_ sky130_fd_sc_hd__mux4_1
X_4302_ _1052_ _1082_ _1086_ _1090_ _1094_ VGND VGND VPWR VPWR _1095_ sky130_fd_sc_hd__a32o_4
X_5282_ rf.registers\[8\]\[21\] rf.registers\[9\]\[21\] rf.registers\[10\]\[21\] rf.registers\[11\]\[21\]
+ _1999_ _2000_ VGND VGND VPWR VPWR _2024_ sky130_fd_sc_hd__mux4_1
X_8070_ rf.registers\[7\]\[20\] _3319_ _3973_ VGND VGND VPWR VPWR _3974_ sky130_fd_sc_hd__mux2_1
XFILLER_0_2_489 VPWR VGND VPWR VGND sky130_ef_sc_hd__decap_12
X_4233_ rf.registers\[20\]\[0\] rf.registers\[21\]\[0\] rf.registers\[22\]\[0\] rf.registers\[23\]\[0\]
+ _1026_ _1027_ VGND VGND VPWR VPWR _1028_ sky130_fd_sc_hd__mux4_1
X_7021_ rf.registers\[6\]\[8\] _3294_ _3408_ VGND VGND VPWR VPWR _3417_ sky130_fd_sc_hd__mux2_1
XFILLER_0_10_245 VGND VGND VPWR VPWR sky130_fd_sc_hd__decap_6
XFILLER_0_10_289 VPWR VGND VPWR VGND sky130_ef_sc_hd__decap_12
XFILLER_0_4_77 VGND VGND VPWR VPWR sky130_fd_sc_hd__decap_6
X_8972_ clknet_leaf_88_CLK _0060_ VGND VGND VPWR VPWR rf.registers\[19\]\[27\] sky130_fd_sc_hd__dfxtp_1
XTAP_TAPCELL_ROW_108_1920 VGND VPWR sky130_fd_sc_hd__tapvpwrvgnd_1
X_7923_ _3378_ rf.registers\[23\]\[15\] _3890_ VGND VGND VPWR VPWR _3896_ sky130_fd_sc_hd__mux2_1
XFILLER_0_78_713 VPWR VGND VPWR VGND sky130_ef_sc_hd__decap_12
X_7854_ _3378_ rf.registers\[28\]\[15\] _3853_ VGND VGND VPWR VPWR _3859_ sky130_fd_sc_hd__mux2_1
XFILLER_0_78_757 VPWR VGND VPWR VGND sky130_ef_sc_hd__decap_12
X_7785_ _3822_ VGND VGND VPWR VPWR _0303_ sky130_fd_sc_hd__clkbuf_1
XFILLER_0_93_727 VGND VGND VPWR VPWR sky130_fd_sc_hd__fill_1
XFILLER_0_65_429 VGND VGND VPWR VPWR sky130_fd_sc_hd__decap_8
X_6805_ _3274_ VGND VGND VPWR VPWR _0895_ sky130_fd_sc_hd__clkbuf_1
XFILLER_0_135_317 VPWR VGND VPWR VGND sky130_ef_sc_hd__decap_12
X_9524_ clknet_leaf_36_CLK _0612_ VGND VGND VPWR VPWR rf.registers\[14\]\[3\] sky130_fd_sc_hd__dfxtp_1
X_4997_ net5 VGND VGND VPWR VPWR _1755_ sky130_fd_sc_hd__clkbuf_8
X_6736_ rf.registers\[10\]\[30\] _3049_ _3204_ VGND VGND VPWR VPWR _3238_ sky130_fd_sc_hd__mux2_1
XFILLER_0_18_312 VGND VGND VPWR VPWR sky130_fd_sc_hd__fill_1
XFILLER_0_46_621 VGND VGND VPWR VPWR sky130_fd_sc_hd__fill_1
XTAP_TAPCELL_ROW_137_2349 VGND VPWR sky130_fd_sc_hd__tapvpwrvgnd_1
XFILLER_0_61_646 VPWR VGND VPWR VGND sky130_ef_sc_hd__decap_12
XFILLER_0_33_315 VGND VGND VPWR VPWR sky130_fd_sc_hd__decap_4
XFILLER_0_33_337 VGND VGND VPWR VPWR sky130_fd_sc_hd__decap_3
X_9455_ clknet_leaf_62_CLK _0543_ VGND VGND VPWR VPWR rf.registers\[25\]\[30\] sky130_fd_sc_hd__dfxtp_1
X_6667_ rf.registers\[24\]\[30\] _3049_ _3167_ VGND VGND VPWR VPWR _3201_ sky130_fd_sc_hd__mux2_1
XFILLER_0_104_737 VPWR VGND VPWR VGND sky130_ef_sc_hd__decap_12
X_8406_ _4151_ VGND VGND VPWR VPWR _0595_ sky130_fd_sc_hd__clkbuf_1
X_6598_ rf.registers\[1\]\[30\] _3049_ _3130_ VGND VGND VPWR VPWR _3164_ sky130_fd_sc_hd__mux2_1
XFILLER_0_5_261 VPWR VGND VPWR VGND sky130_ef_sc_hd__decap_12
X_5618_ _2233_ VGND VGND VPWR VPWR _2348_ sky130_fd_sc_hd__clkbuf_4
X_9386_ clknet_leaf_84_CLK _0474_ VGND VGND VPWR VPWR rf.registers\[26\]\[25\] sky130_fd_sc_hd__dfxtp_1
X_8337_ rf.registers\[20\]\[18\] net23 _4106_ VGND VGND VPWR VPWR _4115_ sky130_fd_sc_hd__mux2_1
X_5549_ _2277_ _2279_ VGND VGND VPWR VPWR _2280_ sky130_fd_sc_hd__or2_1
XFILLER_0_112_781 VPWR VGND VPWR VGND sky130_ef_sc_hd__decap_12
X_8268_ _4078_ VGND VGND VPWR VPWR _0530_ sky130_fd_sc_hd__clkbuf_1
X_7219_ rf.registers\[19\]\[5\] _3288_ _3516_ VGND VGND VPWR VPWR _3522_ sky130_fd_sc_hd__mux2_1
X_8199_ _3382_ rf.registers\[21\]\[17\] _4034_ VGND VGND VPWR VPWR _4042_ sky130_fd_sc_hd__mux2_1
XFILLER_0_68_256 VPWR VGND VPWR VGND sky130_ef_sc_hd__decap_12
XFILLER_0_84_749 VGND VGND VPWR VPWR sky130_fd_sc_hd__decap_6
XFILLER_0_37_676 VGND VGND VPWR VPWR sky130_fd_sc_hd__decap_4
XFILLER_0_92_793 VPWR VGND VPWR VGND sky130_ef_sc_hd__decap_12
XTAP_TAPCELL_ROW_12_479 VGND VPWR sky130_fd_sc_hd__tapvpwrvgnd_1
XFILLER_0_25_838 VGND VGND VPWR VPWR sky130_fd_sc_hd__fill_2
XFILLER_0_37_687 VPWR VGND VPWR VGND sky130_ef_sc_hd__decap_12
XFILLER_0_101_27 VPWR VGND VPWR VGND sky130_ef_sc_hd__decap_12
XFILLER_0_52_657 VGND VGND VPWR VPWR sky130_fd_sc_hd__fill_2
XFILLER_0_122_545 VGND VGND VPWR VPWR sky130_fd_sc_hd__fill_1
XTAP_TAPCELL_ROW_94_1710 VGND VPWR sky130_fd_sc_hd__tapvpwrvgnd_1
XFILLER_0_86_29 VGND VGND VPWR VPWR sky130_fd_sc_hd__decap_8
XFILLER_0_19_45 VGND VGND VPWR VPWR sky130_fd_sc_hd__decap_8
XTAP_TAPCELL_ROW_121_2117 VGND VPWR sky130_fd_sc_hd__tapvpwrvgnd_1
XFILLER_0_87_521 VGND VGND VPWR VPWR sky130_fd_sc_hd__fill_2
XFILLER_0_35_55 VGND VGND VPWR VPWR sky130_fd_sc_hd__fill_1
X_4920_ _1675_ _1677_ _1680_ _1628_ net5 VGND VGND VPWR VPWR _1681_ sky130_fd_sc_hd__a221o_1
XFILLER_0_35_77 VGND VGND VPWR VPWR sky130_fd_sc_hd__decap_4
XFILLER_0_129_111 VGND VGND VPWR VPWR sky130_fd_sc_hd__fill_1
XFILLER_0_75_727 VGND VGND VPWR VPWR sky130_fd_sc_hd__fill_1
XFILLER_0_59_289 VGND VGND VPWR VPWR sky130_fd_sc_hd__fill_1
XFILLER_0_59_278 VGND VGND VPWR VPWR sky130_fd_sc_hd__fill_2
X_4851_ _1203_ _1606_ _1610_ _1614_ VGND VGND VPWR VPWR _1615_ sky130_fd_sc_hd__o2bb2a_1
XTAP_TAPCELL_ROW_103_1850 VGND VPWR sky130_fd_sc_hd__tapvpwrvgnd_1
XFILLER_0_28_632 VPWR VGND VPWR VGND sky130_ef_sc_hd__decap_12
X_7570_ _3696_ VGND VGND VPWR VPWR _3708_ sky130_fd_sc_hd__clkbuf_8
X_4782_ rf.registers\[8\]\[27\] rf.registers\[9\]\[27\] rf.registers\[10\]\[27\] rf.registers\[11\]\[27\]
+ _1320_ _1321_ VGND VGND VPWR VPWR _1550_ sky130_fd_sc_hd__mux4_1
XFILLER_0_132_309 VPWR VGND VPWR VGND sky130_ef_sc_hd__decap_12
XFILLER_0_82_281 VGND VGND VPWR VPWR sky130_fd_sc_hd__decap_8
XFILLER_0_70_421 VGND VGND VPWR VPWR sky130_fd_sc_hd__decap_3
XFILLER_0_7_559 VGND VGND VPWR VPWR sky130_fd_sc_hd__fill_1
XFILLER_0_27_164 VGND VGND VPWR VPWR sky130_fd_sc_hd__fill_1
X_6521_ rf.registers\[17\]\[26\] _3041_ _3116_ VGND VGND VPWR VPWR _3123_ sky130_fd_sc_hd__mux2_1
XTAP_TAPCELL_ROW_31_766 VGND VPWR sky130_fd_sc_hd__tapvpwrvgnd_1
XFILLER_0_43_635 VGND VGND VPWR VPWR sky130_fd_sc_hd__fill_1
XFILLER_0_125_361 VPWR VGND VPWR VGND sky130_ef_sc_hd__decap_12
XTAP_TAPCELL_ROW_119_2079 VGND VPWR sky130_fd_sc_hd__tapvpwrvgnd_1
X_9240_ clknet_leaf_53_CLK _0328_ VGND VGND VPWR VPWR rf.registers\[28\]\[7\] sky130_fd_sc_hd__dfxtp_1
XFILLER_0_3_721 VGND VGND VPWR VPWR sky130_fd_sc_hd__decap_6
XFILLER_0_15_337 VPWR VGND VPWR VGND sky130_ef_sc_hd__decap_12
X_6452_ _3085_ VGND VGND VPWR VPWR _0731_ sky130_fd_sc_hd__clkbuf_1
XFILLER_0_43_657 VGND VGND VPWR VPWR sky130_fd_sc_hd__decap_4
X_9171_ clknet_leaf_43_CLK _0259_ VGND VGND VPWR VPWR rf.registers\[30\]\[2\] sky130_fd_sc_hd__dfxtp_1
Xclkload30 clknet_leaf_20_CLK VGND VGND VPWR VPWR clkload30/X sky130_fd_sc_hd__clkbuf_4
Xclkload52 clknet_leaf_80_CLK VGND VGND VPWR VPWR clkload52/Y sky130_fd_sc_hd__inv_6
Xclkload41 clknet_leaf_86_CLK VGND VGND VPWR VPWR clkload41/Y sky130_fd_sc_hd__clkinv_1
X_5403_ rf.registers\[24\]\[28\] rf.registers\[25\]\[28\] rf.registers\[26\]\[28\]
+ rf.registers\[27\]\[28\] _1951_ _1952_ VGND VGND VPWR VPWR _2138_ sky130_fd_sc_hd__mux4_1
XTAP_TAPCELL_ROW_132_2279 VGND VPWR sky130_fd_sc_hd__tapvpwrvgnd_1
Xclkload85 clknet_leaf_41_CLK VGND VGND VPWR VPWR clkload85/X sky130_fd_sc_hd__clkbuf_4
Xclkload63 clknet_leaf_24_CLK VGND VGND VPWR VPWR clkload63/Y sky130_fd_sc_hd__inv_12
X_8122_ _4001_ VGND VGND VPWR VPWR _0461_ sky130_fd_sc_hd__clkbuf_1
XFILLER_0_101_729 VPWR VGND VPWR VGND sky130_ef_sc_hd__decap_12
Xclkload74 clknet_leaf_51_CLK VGND VGND VPWR VPWR clkload74/Y sky130_fd_sc_hd__clkinv_4
XFILLER_0_51_690 VPWR VGND VPWR VGND sky130_ef_sc_hd__decap_12
XFILLER_0_3_765 VPWR VGND VPWR VGND sky130_ef_sc_hd__decap_12
XFILLER_0_2_253 VPWR VGND VPWR VGND sky130_ef_sc_hd__decap_12
X_6383_ _3046_ VGND VGND VPWR VPWR _0701_ sky130_fd_sc_hd__clkbuf_1
X_5334_ rf.registers\[12\]\[24\] rf.registers\[13\]\[24\] rf.registers\[14\]\[24\]
+ rf.registers\[15\]\[24\] _2070_ _2071_ VGND VGND VPWR VPWR _2073_ sky130_fd_sc_hd__mux4_1
X_8053_ rf.registers\[7\]\[12\] _3303_ _3962_ VGND VGND VPWR VPWR _3965_ sky130_fd_sc_hd__mux2_1
XFILLER_0_11_598 VGND VGND VPWR VPWR sky130_fd_sc_hd__decap_6
X_5265_ _1735_ VGND VGND VPWR VPWR _2008_ sky130_fd_sc_hd__buf_4
X_7004_ _3407_ VGND VGND VPWR VPWR _3408_ sky130_fd_sc_hd__buf_4
X_5196_ rf.registers\[16\]\[17\] rf.registers\[17\]\[17\] rf.registers\[18\]\[17\]
+ rf.registers\[19\]\[17\] _1919_ _1920_ VGND VGND VPWR VPWR _1942_ sky130_fd_sc_hd__mux4_1
XFILLER_0_48_3 VPWR VGND VPWR VGND sky130_ef_sc_hd__decap_12
XFILLER_0_97_307 VGND VGND VPWR VPWR sky130_fd_sc_hd__fill_2
X_8955_ clknet_leaf_33_CLK _0043_ VGND VGND VPWR VPWR rf.registers\[19\]\[10\] sky130_fd_sc_hd__dfxtp_1
XFILLER_0_97_318 VGND VGND VPWR VPWR sky130_fd_sc_hd__decap_3
XTAP_TAPCELL_ROW_48_1019 VGND VPWR sky130_fd_sc_hd__tapvpwrvgnd_1
X_7906_ _3361_ rf.registers\[23\]\[7\] _3879_ VGND VGND VPWR VPWR _3887_ sky130_fd_sc_hd__mux2_1
X_8886_ clknet_leaf_65_CLK _0998_ VGND VGND VPWR VPWR rf.registers\[5\]\[5\] sky130_fd_sc_hd__dfxtp_1
XTAP_TAPCELL_ROW_39_888 VGND VPWR sky130_fd_sc_hd__tapvpwrvgnd_1
X_7837_ _3361_ rf.registers\[28\]\[7\] _3842_ VGND VGND VPWR VPWR _3850_ sky130_fd_sc_hd__mux2_1
XTAP_TAPCELL_ROW_19_590 VGND VPWR sky130_fd_sc_hd__tapvpwrvgnd_1
XFILLER_0_38_418 VGND VGND VPWR VPWR sky130_fd_sc_hd__fill_2
XFILLER_0_66_749 VGND VGND VPWR VPWR sky130_fd_sc_hd__decap_6
XTAP_TAPCELL_ROW_61_1219 VGND VPWR sky130_fd_sc_hd__tapvpwrvgnd_1
XTAP_TAPCELL_ROW_61_1208 VGND VPWR sky130_fd_sc_hd__tapvpwrvgnd_1
XFILLER_0_136_637 VGND VGND VPWR VPWR sky130_fd_sc_hd__decap_6
XFILLER_0_135_125 VPWR VGND VPWR VGND sky130_ef_sc_hd__decap_12
X_7768_ _3813_ VGND VGND VPWR VPWR _0295_ sky130_fd_sc_hd__clkbuf_1
XFILLER_0_18_153 VGND VGND VPWR VPWR sky130_fd_sc_hd__decap_8
XFILLER_0_19_665 VGND VGND VPWR VPWR sky130_fd_sc_hd__decap_6
XFILLER_0_135_169 VPWR VGND VPWR VGND sky130_ef_sc_hd__decap_12
X_7699_ _3359_ rf.registers\[30\]\[6\] _3770_ VGND VGND VPWR VPWR _3777_ sky130_fd_sc_hd__mux2_1
XFILLER_0_74_793 VPWR VGND VPWR VGND sky130_ef_sc_hd__decap_12
XFILLER_0_73_281 VPWR VGND VPWR VGND sky130_ef_sc_hd__decap_12
X_9507_ clknet_leaf_5_CLK _0595_ VGND VGND VPWR VPWR rf.registers\[18\]\[18\] sky130_fd_sc_hd__dfxtp_1
X_6719_ _3229_ VGND VGND VPWR VPWR _0854_ sky130_fd_sc_hd__clkbuf_1
XFILLER_0_33_101 VGND VGND VPWR VPWR sky130_fd_sc_hd__fill_2
Xclkload2 clknet_3_2__leaf_CLK VGND VGND VPWR VPWR clkload2/Y sky130_fd_sc_hd__inv_8
X_9438_ clknet_leaf_27_CLK _0526_ VGND VGND VPWR VPWR rf.registers\[25\]\[13\] sky130_fd_sc_hd__dfxtp_1
XFILLER_0_18_197 VGND VGND VPWR VPWR sky130_fd_sc_hd__decap_4
XFILLER_0_33_167 VGND VGND VPWR VPWR sky130_fd_sc_hd__fill_1
X_9369_ clknet_leaf_36_CLK _0457_ VGND VGND VPWR VPWR rf.registers\[26\]\[8\] sky130_fd_sc_hd__dfxtp_1
XFILLER_0_104_589 VGND VGND VPWR VPWR sky130_fd_sc_hd__fill_2
XTAP_TAPCELL_ROW_76_1440 VGND VPWR sky130_fd_sc_hd__tapvpwrvgnd_1
XFILLER_0_97_841 VGND VGND VPWR VPWR sky130_fd_sc_hd__fill_1
XFILLER_0_96_362 VGND VGND VPWR VPWR sky130_fd_sc_hd__fill_2
XFILLER_0_57_727 VGND VGND VPWR VPWR sky130_fd_sc_hd__fill_1
XTAP_TAPCELL_ROW_17_549 VGND VPWR sky130_fd_sc_hd__tapvpwrvgnd_1
XFILLER_0_29_429 VGND VGND VPWR VPWR sky130_fd_sc_hd__decap_4
XFILLER_0_127_626 VGND VGND VPWR VPWR sky130_fd_sc_hd__decap_3
XFILLER_0_112_15 VPWR VGND VPWR VGND sky130_ef_sc_hd__decap_12
XFILLER_0_123_821 VPWR VGND VPWR VGND sky130_ef_sc_hd__decap_12
XFILLER_0_114_309 VGND VGND VPWR VPWR sky130_fd_sc_hd__fill_1
XFILLER_0_21_57 VPWR VGND VPWR VGND sky130_ef_sc_hd__decap_12
XFILLER_0_52_487 VPWR VGND VPWR VGND sky130_ef_sc_hd__decap_12
XFILLER_0_12_307 VGND VGND VPWR VPWR sky130_fd_sc_hd__fill_1
XFILLER_0_40_616 VGND VGND VPWR VPWR sky130_fd_sc_hd__decap_4
XFILLER_0_40_627 VPWR VGND VPWR VGND sky130_ef_sc_hd__decap_12
XFILLER_0_97_39 VPWR VGND VPWR VGND sky130_ef_sc_hd__decap_12
XFILLER_0_21_841 VGND VGND VPWR VPWR sky130_fd_sc_hd__fill_1
XFILLER_0_0_757 VGND VGND VPWR VPWR sky130_fd_sc_hd__decap_3
X_5050_ _1693_ _1804_ _1641_ VGND VGND VPWR VPWR _1805_ sky130_fd_sc_hd__o21a_1
X_8740_ clknet_leaf_20_CLK _0852_ VGND VGND VPWR VPWR rf.registers\[10\]\[19\] sky130_fd_sc_hd__dfxtp_1
XTAP_TAPCELL_ROW_36_836 VGND VPWR sky130_fd_sc_hd__tapvpwrvgnd_1
X_5952_ net53 _2669_ VGND VGND VPWR VPWR _2670_ sky130_fd_sc_hd__xnor2_1
X_4903_ _1660_ _1664_ net5 VGND VGND VPWR VPWR _1665_ sky130_fd_sc_hd__a21oi_1
XFILLER_0_75_502 VGND VGND VPWR VPWR sky130_fd_sc_hd__fill_2
XFILLER_0_48_727 VPWR VGND VPWR VGND sky130_ef_sc_hd__decap_12
XTAP_TAPCELL_ROW_36_847 VGND VPWR sky130_fd_sc_hd__tapvpwrvgnd_1
XTAP_TAPCELL_ROW_101_1809 VGND VPWR sky130_fd_sc_hd__tapvpwrvgnd_1
X_8671_ clknet_leaf_16_CLK _0783_ VGND VGND VPWR VPWR rf.registers\[1\]\[14\] sky130_fd_sc_hd__dfxtp_1
XPHY_EDGE_ROW_80_Left_219 VGND VGND VPWR VPWR sky130_fd_sc_hd__decap_3
XFILLER_0_8_813 VPWR VGND VPWR VGND sky130_ef_sc_hd__decap_12
X_5883_ _2602_ _2603_ _2233_ VGND VGND VPWR VPWR _2604_ sky130_fd_sc_hd__mux2_1
XFILLER_0_117_125 VPWR VGND VPWR VGND sky130_ef_sc_hd__decap_12
X_7622_ rf.registers\[2\]\[2\] _3282_ _3733_ VGND VGND VPWR VPWR _3736_ sky130_fd_sc_hd__mux2_1
XFILLER_0_90_505 VGND VGND VPWR VPWR sky130_fd_sc_hd__fill_1
X_4834_ _1203_ _1590_ _1594_ _1598_ VGND VGND VPWR VPWR _1599_ sky130_fd_sc_hd__o2bb2a_2
X_7553_ _3699_ VGND VGND VPWR VPWR _0194_ sky130_fd_sc_hd__clkbuf_1
XFILLER_0_62_229 VGND VGND VPWR VPWR sky130_fd_sc_hd__decap_6
XFILLER_0_56_793 VPWR VGND VPWR VGND sky130_ef_sc_hd__decap_12
X_4765_ rf.registers\[4\]\[26\] rf.registers\[5\]\[26\] rf.registers\[6\]\[26\] rf.registers\[7\]\[26\]
+ _1139_ _1140_ VGND VGND VPWR VPWR _1534_ sky130_fd_sc_hd__mux4_1
XTAP_TAPCELL_ROW_134_2308 VGND VPWR sky130_fd_sc_hd__tapvpwrvgnd_1
XFILLER_0_133_629 VPWR VGND VPWR VGND sky130_ef_sc_hd__decap_12
XFILLER_0_117_169 VPWR VGND VPWR VGND sky130_ef_sc_hd__decap_12
XFILLER_0_71_741 VPWR VGND VPWR VGND sky130_ef_sc_hd__decap_12
X_6504_ rf.registers\[17\]\[18\] _3024_ _3105_ VGND VGND VPWR VPWR _3114_ sky130_fd_sc_hd__mux2_1
XFILLER_0_55_281 VGND VGND VPWR VPWR sky130_fd_sc_hd__decap_8
XFILLER_0_16_657 VPWR VGND VPWR VGND sky130_ef_sc_hd__decap_12
XFILLER_0_43_421 VGND VGND VPWR VPWR sky130_fd_sc_hd__decap_8
XFILLER_0_132_139 VGND VGND VPWR VPWR sky130_fd_sc_hd__fill_1
X_7484_ _3349_ rf.registers\[31\]\[1\] _3661_ VGND VGND VPWR VPWR _3663_ sky130_fd_sc_hd__mux2_1
XFILLER_0_71_785 VPWR VGND VPWR VGND sky130_ef_sc_hd__decap_12
X_9223_ clknet_leaf_7_CLK _0311_ VGND VGND VPWR VPWR rf.registers\[9\]\[22\] sky130_fd_sc_hd__dfxtp_1
X_4696_ rf.registers\[8\]\[22\] rf.registers\[9\]\[22\] rf.registers\[10\]\[22\] rf.registers\[11\]\[22\]
+ _1382_ _1383_ VGND VGND VPWR VPWR _1469_ sky130_fd_sc_hd__mux4_1
XFILLER_0_15_167 VGND VGND VPWR VPWR sky130_fd_sc_hd__fill_1
XFILLER_0_113_342 VGND VGND VPWR VPWR sky130_fd_sc_hd__fill_1
X_6435_ _3076_ VGND VGND VPWR VPWR _0723_ sky130_fd_sc_hd__clkbuf_1
XFILLER_0_3_573 VPWR VGND VPWR VGND sky130_ef_sc_hd__decap_12
X_9154_ clknet_leaf_12_CLK _0242_ VGND VGND VPWR VPWR rf.registers\[2\]\[17\] sky130_fd_sc_hd__dfxtp_1
XTAP_TAPCELL_ROW_58_1170 VGND VPWR sky130_fd_sc_hd__tapvpwrvgnd_1
X_6366_ net29 VGND VGND VPWR VPWR _3035_ sky130_fd_sc_hd__buf_2
X_9085_ clknet_leaf_24_CLK _0173_ VGND VGND VPWR VPWR rf.registers\[31\]\[12\] sky130_fd_sc_hd__dfxtp_1
X_8105_ _3992_ VGND VGND VPWR VPWR _0453_ sky130_fd_sc_hd__clkbuf_1
XFILLER_0_11_373 VPWR VGND VPWR VGND sky130_ef_sc_hd__decap_12
X_5317_ rf.registers\[4\]\[23\] rf.registers\[5\]\[23\] rf.registers\[6\]\[23\] rf.registers\[7\]\[23\]
+ _1730_ _1732_ VGND VGND VPWR VPWR _2057_ sky130_fd_sc_hd__mux4_1
X_6297_ _2988_ VGND VGND VPWR VPWR _0673_ sky130_fd_sc_hd__clkbuf_1
X_8036_ rf.registers\[7\]\[4\] _3286_ _3951_ VGND VGND VPWR VPWR _3956_ sky130_fd_sc_hd__mux2_1
X_5248_ rf.registers\[0\]\[19\] rf.registers\[1\]\[19\] rf.registers\[2\]\[19\] rf.registers\[3\]\[19\]
+ _1772_ _1773_ VGND VGND VPWR VPWR _1992_ sky130_fd_sc_hd__mux4_1
XTAP_TAPCELL_ROW_71_1370 VGND VPWR sky130_fd_sc_hd__tapvpwrvgnd_1
XFILLER_0_98_605 VGND VGND VPWR VPWR sky130_fd_sc_hd__decap_3
X_5179_ rf.registers\[20\]\[16\] rf.registers\[21\]\[16\] rf.registers\[22\]\[16\]
+ rf.registers\[23\]\[16\] _1922_ _1923_ VGND VGND VPWR VPWR _1926_ sky130_fd_sc_hd__mux4_1
XFILLER_0_79_841 VGND VGND VPWR VPWR sky130_fd_sc_hd__fill_1
X_8938_ clknet_leaf_68_CLK _0026_ VGND VGND VPWR VPWR rf.registers\[4\]\[25\] sky130_fd_sc_hd__dfxtp_1
XPHY_EDGE_ROW_119_Left_258 VGND VGND VPWR VPWR sky130_fd_sc_hd__decap_3
XFILLER_0_94_811 VGND VGND VPWR VPWR sky130_fd_sc_hd__fill_1
XFILLER_0_78_340 VGND VGND VPWR VPWR sky130_fd_sc_hd__fill_1
XFILLER_0_39_705 VGND VGND VPWR VPWR sky130_fd_sc_hd__decap_8
XFILLER_0_39_727 VGND VGND VPWR VPWR sky130_fd_sc_hd__fill_1
XFILLER_0_109_604 VGND VGND VPWR VPWR sky130_fd_sc_hd__decap_3
XFILLER_0_93_332 VGND VGND VPWR VPWR sky130_fd_sc_hd__decap_4
XTAP_TAPCELL_ROW_14_508 VGND VPWR sky130_fd_sc_hd__tapvpwrvgnd_1
X_8869_ clknet_leaf_76_CLK _0981_ VGND VGND VPWR VPWR rf.registers\[6\]\[20\] sky130_fd_sc_hd__dfxtp_1
XFILLER_0_136_401 VPWR VGND VPWR VGND sky130_ef_sc_hd__decap_12
XFILLER_0_81_505 VGND VGND VPWR VPWR sky130_fd_sc_hd__fill_2
XFILLER_0_66_568 VGND VGND VPWR VPWR sky130_fd_sc_hd__decap_8
XFILLER_0_66_557 VGND VGND VPWR VPWR sky130_fd_sc_hd__fill_2
XFILLER_0_136_445 VPWR VGND VPWR VGND sky130_ef_sc_hd__decap_12
XFILLER_0_136_489 VPWR VGND VPWR VGND sky130_ef_sc_hd__decap_12
XFILLER_0_105_821 VPWR VGND VPWR VGND sky130_ef_sc_hd__decap_12
XFILLER_0_62_741 VGND VGND VPWR VPWR sky130_fd_sc_hd__fill_1
XPHY_EDGE_ROW_128_Left_267 VGND VGND VPWR VPWR sky130_fd_sc_hd__decap_3
XFILLER_0_120_813 VPWR VGND VPWR VGND sky130_ef_sc_hd__decap_12
XFILLER_0_61_295 VGND VGND VPWR VPWR sky130_fd_sc_hd__decap_4
XFILLER_0_21_126 VGND VGND VPWR VPWR sky130_fd_sc_hd__decap_8
XFILLER_0_131_161 VGND VGND VPWR VPWR sky130_fd_sc_hd__decap_6
XFILLER_0_30_682 VPWR VGND VPWR VGND sky130_ef_sc_hd__decap_12
XFILLER_0_100_592 VGND VGND VPWR VPWR sky130_fd_sc_hd__decap_8
XFILLER_0_100_581 VGND VGND VPWR VPWR sky130_fd_sc_hd__decap_6
XTAP_TAPCELL_ROW_89_1631 VGND VPWR sky130_fd_sc_hd__tapvpwrvgnd_1
XTAP_TAPCELL_ROW_89_1642 VGND VPWR sky130_fd_sc_hd__tapvpwrvgnd_1
XPHY_EDGE_ROW_137_Left_276 VGND VGND VPWR VPWR sky130_fd_sc_hd__decap_3
XFILLER_0_97_671 VGND VGND VPWR VPWR sky130_fd_sc_hd__fill_1
XFILLER_0_85_833 VGND VGND VPWR VPWR sky130_fd_sc_hd__decap_6
XFILLER_0_8_109 VPWR VGND VPWR VGND sky130_ef_sc_hd__decap_12
XFILLER_0_123_69 VPWR VGND VPWR VGND sky130_ef_sc_hd__decap_12
XFILLER_0_57_557 VGND VGND VPWR VPWR sky130_fd_sc_hd__decap_3
XFILLER_0_84_376 VPWR VGND VPWR VGND sky130_ef_sc_hd__decap_12
XFILLER_0_53_741 VPWR VGND VPWR VGND sky130_ef_sc_hd__decap_12
XFILLER_0_37_281 VGND VGND VPWR VPWR sky130_fd_sc_hd__fill_1
XTAP_TAPCELL_ROW_116_2038 VGND VPWR sky130_fd_sc_hd__tapvpwrvgnd_1
XFILLER_0_114_139 VGND VGND VPWR VPWR sky130_fd_sc_hd__fill_1
XFILLER_0_106_3 VPWR VGND VPWR VGND sky130_ef_sc_hd__decap_12
X_4550_ rf.registers\[24\]\[14\] rf.registers\[25\]\[14\] rf.registers\[26\]\[14\]
+ rf.registers\[27\]\[14\] _1329_ _1330_ VGND VGND VPWR VPWR _1331_ sky130_fd_sc_hd__mux4_1
XFILLER_0_53_785 VPWR VGND VPWR VGND sky130_ef_sc_hd__decap_12
XFILLER_0_52_262 VGND VGND VPWR VPWR sky130_fd_sc_hd__decap_6
XFILLER_0_52_251 VGND VGND VPWR VPWR sky130_fd_sc_hd__fill_1
XFILLER_0_123_673 VPWR VGND VPWR VGND sky130_ef_sc_hd__decap_12
XFILLER_0_123_640 VPWR VGND VPWR VGND sky130_ef_sc_hd__decap_12
X_4481_ _1135_ _1265_ _1052_ VGND VGND VPWR VPWR _1266_ sky130_fd_sc_hd__a21o_1
XFILLER_0_40_424 VGND VGND VPWR VPWR sky130_fd_sc_hd__decap_4
X_6220_ net92 _2921_ VGND VGND VPWR VPWR _2922_ sky130_fd_sc_hd__nor2_1
XFILLER_0_110_356 VGND VGND VPWR VPWR sky130_fd_sc_hd__decap_8
X_6151_ _2084_ _2852_ _2854_ VGND VGND VPWR VPWR _2857_ sky130_fd_sc_hd__o21bai_1
X_5102_ _1852_ _1853_ _1698_ VGND VGND VPWR VPWR _1854_ sky130_fd_sc_hd__mux2_1
XTAP_TAPCELL_ROW_111_1971 VGND VPWR sky130_fd_sc_hd__tapvpwrvgnd_1
XTAP_TAPCELL_ROW_111_1960 VGND VPWR sky130_fd_sc_hd__tapvpwrvgnd_1
X_6082_ _2364_ _2368_ VGND VGND VPWR VPWR _2792_ sky130_fd_sc_hd__nand2_1
X_5033_ _1764_ _1788_ VGND VGND VPWR VPWR _1789_ sky130_fd_sc_hd__nand2_1
XFILLER_0_76_811 VGND VGND VPWR VPWR sky130_fd_sc_hd__fill_1
X_6984_ _3396_ VGND VGND VPWR VPWR _0952_ sky130_fd_sc_hd__clkbuf_1
X_8723_ clknet_leaf_45_CLK _0835_ VGND VGND VPWR VPWR rf.registers\[10\]\[2\] sky130_fd_sc_hd__dfxtp_1
X_5935_ _2583_ _2650_ _2653_ VGND VGND VPWR VPWR _2654_ sky130_fd_sc_hd__o21bai_1
XFILLER_0_75_343 VGND VGND VPWR VPWR sky130_fd_sc_hd__fill_1
XFILLER_0_63_505 VGND VGND VPWR VPWR sky130_fd_sc_hd__decap_6
X_5866_ net112 _2587_ VGND VGND VPWR VPWR _2588_ sky130_fd_sc_hd__xor2_1
X_8654_ clknet_leaf_93_CLK _0766_ VGND VGND VPWR VPWR rf.registers\[17\]\[29\] sky130_fd_sc_hd__dfxtp_1
XFILLER_0_118_456 VGND VGND VPWR VPWR sky130_fd_sc_hd__fill_2
XFILLER_0_63_538 VGND VGND VPWR VPWR sky130_fd_sc_hd__decap_8
X_7605_ _3726_ VGND VGND VPWR VPWR _0219_ sky130_fd_sc_hd__clkbuf_1
X_4817_ _1307_ _1574_ _1578_ _1582_ VGND VGND VPWR VPWR _1583_ sky130_fd_sc_hd__a22o_1
XFILLER_0_16_421 VPWR VGND VPWR VGND sky130_ef_sc_hd__decap_12
XFILLER_0_28_270 VGND VGND VPWR VPWR sky130_fd_sc_hd__decap_6
X_5797_ _1076_ _2521_ VGND VGND VPWR VPWR _2522_ sky130_fd_sc_hd__nor2_1
X_8585_ clknet_leaf_73_CLK _0697_ VGND VGND VPWR VPWR rf.registers\[12\]\[24\] sky130_fd_sc_hd__dfxtp_1
XFILLER_0_44_752 VGND VGND VPWR VPWR sky130_fd_sc_hd__fill_1
X_7536_ _2970_ rf.registers\[31\]\[26\] _3683_ VGND VGND VPWR VPWR _3690_ sky130_fd_sc_hd__mux2_1
X_4748_ rf.registers\[4\]\[25\] rf.registers\[5\]\[25\] rf.registers\[6\]\[25\] rf.registers\[7\]\[25\]
+ _1159_ _1160_ VGND VGND VPWR VPWR _1518_ sky130_fd_sc_hd__mux4_1
XFILLER_0_120_109 VPWR VGND VPWR VGND sky130_ef_sc_hd__decap_12
XFILLER_0_102_813 VPWR VGND VPWR VGND sky130_ef_sc_hd__decap_12
X_4679_ _1197_ _1452_ VGND VGND VPWR VPWR _1453_ sky130_fd_sc_hd__nand2_1
X_7467_ _3653_ VGND VGND VPWR VPWR _0154_ sky130_fd_sc_hd__clkbuf_1
XFILLER_0_113_161 VGND VGND VPWR VPWR sky130_fd_sc_hd__decap_6
X_6418_ rf.registers\[11\]\[10\] _3007_ _3067_ VGND VGND VPWR VPWR _3068_ sky130_fd_sc_hd__mux2_1
XFILLER_0_98_82 VGND VGND VPWR VPWR sky130_fd_sc_hd__fill_2
X_9206_ clknet_leaf_65_CLK _0294_ VGND VGND VPWR VPWR rf.registers\[9\]\[5\] sky130_fd_sc_hd__dfxtp_1
XPHY_EDGE_ROW_1_Right_1 VGND VGND VPWR VPWR sky130_fd_sc_hd__decap_3
X_9137_ clknet_leaf_40_CLK _0225_ VGND VGND VPWR VPWR rf.registers\[2\]\[0\] sky130_fd_sc_hd__dfxtp_1
X_7398_ _3616_ VGND VGND VPWR VPWR _0122_ sky130_fd_sc_hd__clkbuf_1
X_6349_ _3023_ VGND VGND VPWR VPWR _0690_ sky130_fd_sc_hd__clkbuf_1
XFILLER_0_11_181 VPWR VGND VPWR VGND sky130_ef_sc_hd__decap_12
XFILLER_0_12_693 VGND VGND VPWR VPWR sky130_fd_sc_hd__fill_1
Xoutput59 net59 VGND VGND VPWR VPWR RD1[19] sky130_fd_sc_hd__buf_1
X_9068_ clknet_leaf_87_CLK _0156_ VGND VGND VPWR VPWR rf.registers\[29\]\[27\] sky130_fd_sc_hd__dfxtp_1
X_8019_ _3946_ VGND VGND VPWR VPWR _0413_ sky130_fd_sc_hd__clkbuf_1
XFILLER_0_128_209 VPWR VGND VPWR VGND sky130_ef_sc_hd__decap_12
XTAP_TAPCELL_ROW_84_1561 VGND VPWR sky130_fd_sc_hd__tapvpwrvgnd_1
XFILLER_0_67_833 VGND VGND VPWR VPWR sky130_fd_sc_hd__decap_6
XFILLER_0_137_721 VGND VGND VPWR VPWR sky130_fd_sc_hd__decap_6
XTAP_TAPCELL_ROW_27_699 VGND VPWR sky130_fd_sc_hd__tapvpwrvgnd_1
XFILLER_0_137_765 VPWR VGND VPWR VGND sky130_ef_sc_hd__decap_12
XFILLER_0_94_685 VPWR VGND VPWR VGND sky130_ef_sc_hd__decap_12
XFILLER_0_93_151 VGND VGND VPWR VPWR sky130_fd_sc_hd__fill_1
XFILLER_0_82_825 VPWR VGND VPWR VGND sky130_ef_sc_hd__decap_12
XFILLER_0_66_365 VGND VGND VPWR VPWR sky130_fd_sc_hd__fill_2
XFILLER_0_136_253 VPWR VGND VPWR VGND sky130_ef_sc_hd__decap_12
XFILLER_0_19_270 VGND VGND VPWR VPWR sky130_fd_sc_hd__fill_1
XFILLER_0_81_368 VGND VGND VPWR VPWR sky130_fd_sc_hd__fill_1
XFILLER_0_35_785 VPWR VGND VPWR VGND sky130_ef_sc_hd__decap_12
XFILLER_0_105_673 VPWR VGND VPWR VGND sky130_ef_sc_hd__decap_12
XFILLER_0_50_755 VGND VGND VPWR VPWR sky130_fd_sc_hd__fill_1
XFILLER_0_1_329 VGND VGND VPWR VPWR sky130_fd_sc_hd__decap_6
XFILLER_0_120_698 VGND VGND VPWR VPWR sky130_fd_sc_hd__fill_2
XFILLER_0_94_29 VPWR VGND VPWR VGND sky130_ef_sc_hd__decap_12
XFILLER_0_89_457 VGND VGND VPWR VPWR sky130_fd_sc_hd__fill_1
XFILLER_0_58_811 VGND VGND VPWR VPWR sky130_fd_sc_hd__fill_1
XFILLER_0_76_129 VGND VGND VPWR VPWR sky130_fd_sc_hd__fill_1
XFILLER_0_58_833 VGND VGND VPWR VPWR sky130_fd_sc_hd__fill_1
XFILLER_0_43_55 VGND VGND VPWR VPWR sky130_fd_sc_hd__fill_1
XTAP_TAPCELL_ROW_46_986 VGND VPWR sky130_fd_sc_hd__tapvpwrvgnd_1
XFILLER_0_9_429 VPWR VGND VPWR VGND sky130_ef_sc_hd__decap_12
X_5720_ _2304_ _2352_ _2253_ VGND VGND VPWR VPWR _2448_ sky130_fd_sc_hd__o21a_1
XFILLER_0_43_66 VGND VGND VPWR VPWR sky130_fd_sc_hd__decap_6
XTAP_TAPCELL_ROW_46_997 VGND VPWR sky130_fd_sc_hd__tapvpwrvgnd_1
XFILLER_0_84_173 VGND VGND VPWR VPWR sky130_fd_sc_hd__fill_2
XFILLER_0_17_218 VGND VGND VPWR VPWR sky130_fd_sc_hd__decap_6
X_5651_ _2229_ _2285_ VGND VGND VPWR VPWR _2381_ sky130_fd_sc_hd__and2_1
X_8370_ rf.registers\[18\]\[1\] net25 _4131_ VGND VGND VPWR VPWR _4133_ sky130_fd_sc_hd__mux2_1
X_4602_ _1376_ _1377_ _1378_ _1379_ _1134_ _1156_ VGND VGND VPWR VPWR _1380_ sky130_fd_sc_hd__mux4_1
X_5582_ _2308_ _2312_ _2304_ VGND VGND VPWR VPWR _2313_ sky130_fd_sc_hd__mux2_1
X_4533_ rf.registers\[24\]\[13\] rf.registers\[25\]\[13\] rf.registers\[26\]\[13\]
+ rf.registers\[27\]\[13\] _1126_ _1129_ VGND VGND VPWR VPWR _1315_ sky130_fd_sc_hd__mux4_1
XFILLER_0_87_7 VPWR VGND VPWR VGND sky130_ef_sc_hd__decap_12
X_7321_ rf.registers\[3\]\[21\] _3322_ _3574_ VGND VGND VPWR VPWR _3576_ sky130_fd_sc_hd__mux2_1
XFILLER_0_4_189 VGND VGND VPWR VPWR sky130_fd_sc_hd__decap_6
X_7252_ _3539_ VGND VGND VPWR VPWR _0053_ sky130_fd_sc_hd__clkbuf_1
X_4464_ _1135_ _1249_ _1052_ VGND VGND VPWR VPWR _1250_ sky130_fd_sc_hd__a21o_1
XFILLER_0_7_55 VGND VGND VPWR VPWR sky130_fd_sc_hd__fill_1
XFILLER_0_1_841 VGND VGND VPWR VPWR sky130_fd_sc_hd__fill_1
X_6203_ net101 _2886_ VGND VGND VPWR VPWR _2906_ sky130_fd_sc_hd__xnor2_1
X_4395_ rf.registers\[16\]\[6\] rf.registers\[17\]\[6\] rf.registers\[18\]\[6\] rf.registers\[19\]\[6\]
+ _1183_ _1181_ VGND VGND VPWR VPWR _1184_ sky130_fd_sc_hd__mux4_1
X_7183_ rf.registers\[4\]\[20\] _3319_ _3502_ VGND VGND VPWR VPWR _3503_ sky130_fd_sc_hd__mux2_1
XTAP_TAPCELL_ROW_129_2229 VGND VPWR sky130_fd_sc_hd__tapvpwrvgnd_1
XFILLER_0_110_197 VGND VGND VPWR VPWR sky130_fd_sc_hd__fill_1
X_6134_ _2296_ _2719_ _2840_ _2559_ VGND VGND VPWR VPWR _2841_ sky130_fd_sc_hd__a211o_1
XTAP_TAPCELL_ROW_51_1059 VGND VPWR sky130_fd_sc_hd__tapvpwrvgnd_1
X_6065_ _2301_ _2307_ VGND VGND VPWR VPWR _2776_ sky130_fd_sc_hd__nand2_1
X_5016_ _1700_ VGND VGND VPWR VPWR _1773_ sky130_fd_sc_hd__buf_4
XFILLER_0_30_3 VPWR VGND VPWR VGND sky130_ef_sc_hd__decap_12
XFILLER_0_95_449 VGND VGND VPWR VPWR sky130_fd_sc_hd__fill_1
X_6967_ _3384_ rf.registers\[15\]\[18\] _3368_ VGND VGND VPWR VPWR _3385_ sky130_fd_sc_hd__mux2_1
XFILLER_0_49_833 VGND VGND VPWR VPWR sky130_fd_sc_hd__decap_6
XFILLER_0_138_529 VGND VGND VPWR VPWR sky130_fd_sc_hd__decap_3
XFILLER_0_119_721 VGND VGND VPWR VPWR sky130_fd_sc_hd__decap_6
X_8706_ clknet_leaf_11_CLK _0818_ VGND VGND VPWR VPWR rf.registers\[24\]\[17\] sky130_fd_sc_hd__dfxtp_1
X_5918_ _2635_ _2636_ _1074_ VGND VGND VPWR VPWR _2637_ sky130_fd_sc_hd__mux2_1
XTAP_TAPCELL_ROW_66_1291 VGND VPWR sky130_fd_sc_hd__tapvpwrvgnd_1
XFILLER_0_64_825 VPWR VGND VPWR VGND sky130_ef_sc_hd__decap_12
XTAP_TAPCELL_ROW_24_658 VGND VPWR sky130_fd_sc_hd__tapvpwrvgnd_1
X_6898_ _3337_ VGND VGND VPWR VPWR _0925_ sky130_fd_sc_hd__clkbuf_1
XFILLER_0_134_713 VPWR VGND VPWR VGND sky130_ef_sc_hd__decap_12
XFILLER_0_119_765 VPWR VGND VPWR VGND sky130_ef_sc_hd__decap_12
X_8637_ clknet_leaf_23_CLK _0749_ VGND VGND VPWR VPWR rf.registers\[17\]\[12\] sky130_fd_sc_hd__dfxtp_1
X_5849_ _1115_ _2269_ VGND VGND VPWR VPWR _2572_ sky130_fd_sc_hd__or2_2
XFILLER_0_17_741 VPWR VGND VPWR VGND sky130_ef_sc_hd__decap_12
XFILLER_0_29_590 VPWR VGND VPWR VGND sky130_ef_sc_hd__decap_12
XFILLER_0_134_757 VPWR VGND VPWR VGND sky130_ef_sc_hd__decap_12
XFILLER_0_133_223 VGND VGND VPWR VPWR sky130_fd_sc_hd__fill_1
X_8568_ clknet_leaf_51_CLK _0680_ VGND VGND VPWR VPWR rf.registers\[12\]\[7\] sky130_fd_sc_hd__dfxtp_1
X_7519_ _3384_ rf.registers\[31\]\[18\] _3672_ VGND VGND VPWR VPWR _3681_ sky130_fd_sc_hd__mux2_1
X_8499_ _4200_ VGND VGND VPWR VPWR _0639_ sky130_fd_sc_hd__clkbuf_1
XFILLER_0_32_755 VGND VGND VPWR VPWR sky130_fd_sc_hd__fill_1
XTAP_TAPCELL_ROW_4_361 VGND VPWR sky130_fd_sc_hd__tapvpwrvgnd_1
XFILLER_0_99_777 VGND VGND VPWR VPWR sky130_fd_sc_hd__decap_6
XFILLER_0_104_27 VGND VGND VPWR VPWR sky130_fd_sc_hd__fill_1
XFILLER_0_67_641 VPWR VGND VPWR VGND sky130_ef_sc_hd__decap_12
XTAP_TAPCELL_ROW_43_945 VGND VPWR sky130_fd_sc_hd__tapvpwrvgnd_1
XFILLER_0_67_685 VPWR VGND VPWR VGND sky130_ef_sc_hd__decap_12
XFILLER_0_137_573 VPWR VGND VPWR VGND sky130_ef_sc_hd__decap_12
XFILLER_0_81_121 VGND VGND VPWR VPWR sky130_fd_sc_hd__fill_2
XFILLER_0_66_195 VGND VGND VPWR VPWR sky130_fd_sc_hd__fill_1
XFILLER_0_13_69 VPWR VGND VPWR VGND sky130_ef_sc_hd__decap_12
XFILLER_0_120_15 VPWR VGND VPWR VGND sky130_ef_sc_hd__decap_12
XFILLER_0_109_297 VGND VGND VPWR VPWR sky130_fd_sc_hd__fill_1
XFILLER_0_124_245 VGND VGND VPWR VPWR sky130_fd_sc_hd__decap_6
XTAP_TAPCELL_ROW_97_1752 VGND VPWR sky130_fd_sc_hd__tapvpwrvgnd_1
XFILLER_0_124_289 VPWR VGND VPWR VGND sky130_ef_sc_hd__decap_12
XFILLER_0_23_755 VPWR VGND VPWR VGND sky130_ef_sc_hd__decap_12
XFILLER_0_1_137 VPWR VGND VPWR VGND sky130_ef_sc_hd__decap_12
XFILLER_0_23_777 VGND VGND VPWR VPWR sky130_fd_sc_hd__decap_6
XFILLER_0_120_473 VGND VGND VPWR VPWR sky130_fd_sc_hd__decap_3
XFILLER_0_129_57 VPWR VGND VPWR VGND sky130_ef_sc_hd__decap_12
XTAP_TAPCELL_ROW_124_2159 VGND VPWR sky130_fd_sc_hd__tapvpwrvgnd_1
X_7870_ _3867_ VGND VGND VPWR VPWR _0343_ sky130_fd_sc_hd__clkbuf_1
X_6821_ _3285_ VGND VGND VPWR VPWR _0900_ sky130_fd_sc_hd__clkbuf_1
X_9540_ clknet_leaf_19_CLK _0628_ VGND VGND VPWR VPWR rf.registers\[14\]\[19\] sky130_fd_sc_hd__dfxtp_1
XFILLER_0_58_630 VGND VGND VPWR VPWR sky130_fd_sc_hd__fill_1
XTAP_TAPCELL_ROW_106_1892 VGND VPWR sky130_fd_sc_hd__tapvpwrvgnd_1
X_6752_ rf.registers\[0\]\[5\] _2997_ _3241_ VGND VGND VPWR VPWR _3247_ sky130_fd_sc_hd__mux2_1
XFILLER_0_9_237 VPWR VGND VPWR VGND sky130_ef_sc_hd__decap_12
XFILLER_0_46_825 VPWR VGND VPWR VGND sky130_ef_sc_hd__decap_12
XFILLER_0_116_713 VPWR VGND VPWR VGND sky130_ef_sc_hd__decap_12
X_9471_ clknet_leaf_25_CLK _0559_ VGND VGND VPWR VPWR rf.registers\[20\]\[14\] sky130_fd_sc_hd__dfxtp_1
X_6683_ _3210_ VGND VGND VPWR VPWR _0837_ sky130_fd_sc_hd__clkbuf_1
XFILLER_0_73_644 VGND VGND VPWR VPWR sky130_fd_sc_hd__decap_3
X_5703_ _1711_ _2430_ VGND VGND VPWR VPWR _2431_ sky130_fd_sc_hd__and2_1
XTAP_TAPCELL_ROW_21_617 VGND VPWR sky130_fd_sc_hd__tapvpwrvgnd_1
X_8422_ rf.registers\[18\]\[26\] net32 _4153_ VGND VGND VPWR VPWR _4160_ sky130_fd_sc_hd__mux2_1
X_5634_ _2016_ _2208_ _2209_ VGND VGND VPWR VPWR _2364_ sky130_fd_sc_hd__o21ai_1
XFILLER_0_45_368 VGND VGND VPWR VPWR sky130_fd_sc_hd__fill_2
XFILLER_0_116_757 VPWR VGND VPWR VGND sky130_ef_sc_hd__decap_12
XFILLER_0_61_839 VGND VGND VPWR VPWR sky130_fd_sc_hd__fill_1
X_8353_ _4123_ VGND VGND VPWR VPWR _0570_ sky130_fd_sc_hd__clkbuf_1
XFILLER_0_131_727 VGND VGND VPWR VPWR sky130_fd_sc_hd__fill_1
XFILLER_0_103_418 VGND VGND VPWR VPWR sky130_fd_sc_hd__fill_2
X_7304_ rf.registers\[3\]\[13\] _3305_ _3563_ VGND VGND VPWR VPWR _3567_ sky130_fd_sc_hd__mux2_1
XFILLER_0_78_3 VPWR VGND VPWR VGND sky130_ef_sc_hd__decap_12
X_5565_ _1115_ VGND VGND VPWR VPWR _2296_ sky130_fd_sc_hd__clkbuf_4
X_4516_ _1296_ _1297_ _1298_ VGND VGND VPWR VPWR _1299_ sky130_fd_sc_hd__mux2_1
XFILLER_0_79_73 VPWR VGND VPWR VGND sky130_ef_sc_hd__decap_12
X_8284_ _3039_ rf.registers\[25\]\[25\] _4081_ VGND VGND VPWR VPWR _4087_ sky130_fd_sc_hd__mux2_1
X_5496_ net81 _2224_ _2226_ VGND VGND VPWR VPWR _2227_ sky130_fd_sc_hd__o21ai_1
X_4447_ _1228_ _1230_ _1233_ _1034_ _1052_ VGND VGND VPWR VPWR _1234_ sky130_fd_sc_hd__a221o_1
X_7235_ _3530_ VGND VGND VPWR VPWR _0045_ sky130_fd_sc_hd__clkbuf_1
XFILLER_0_1_671 VGND VGND VPWR VPWR sky130_fd_sc_hd__fill_1
X_7166_ rf.registers\[4\]\[12\] _3303_ _3491_ VGND VGND VPWR VPWR _3494_ sky130_fd_sc_hd__mux2_1
XFILLER_0_1_693 VGND VGND VPWR VPWR sky130_fd_sc_hd__decap_3
X_4378_ _1034_ VGND VGND VPWR VPWR _1168_ sky130_fd_sc_hd__clkbuf_8
XFILLER_0_0_192 VGND VGND VPWR VPWR sky130_fd_sc_hd__fill_1
X_6117_ _2824_ VGND VGND VPWR VPWR _2825_ sky130_fd_sc_hd__inv_2
X_7097_ _3457_ VGND VGND VPWR VPWR _1004_ sky130_fd_sc_hd__clkbuf_1
XTAP_TAPCELL_ROW_29_728 VGND VPWR sky130_fd_sc_hd__tapvpwrvgnd_1
X_6048_ _2754_ _2755_ _2759_ VGND VGND VPWR VPWR _2760_ sky130_fd_sc_hd__nor3_1
XTAP_TAPCELL_ROW_68_1320 VGND VPWR sky130_fd_sc_hd__tapvpwrvgnd_1
XTAP_TAPCELL_ROW_1_320 VGND VPWR sky130_fd_sc_hd__tapvpwrvgnd_1
XTAP_TAPCELL_ROW_29_739 VGND VPWR sky130_fd_sc_hd__tapvpwrvgnd_1
XFILLER_0_96_725 VPWR VGND VPWR VGND sky130_ef_sc_hd__decap_12
XFILLER_0_96_769 VPWR VGND VPWR VGND sky130_ef_sc_hd__decap_12
X_7999_ _3386_ rf.registers\[22\]\[19\] _3926_ VGND VGND VPWR VPWR _3936_ sky130_fd_sc_hd__mux2_1
XFILLER_0_138_337 VPWR VGND VPWR VGND sky130_ef_sc_hd__decap_12
XTAP_TAPCELL_ROW_81_1520 VGND VPWR sky130_fd_sc_hd__tapvpwrvgnd_1
XFILLER_0_64_622 VGND VGND VPWR VPWR sky130_fd_sc_hd__fill_1
XFILLER_0_37_836 VGND VGND VPWR VPWR sky130_fd_sc_hd__decap_4
XTAP_TAPCELL_ROW_40_904 VGND VPWR sky130_fd_sc_hd__tapvpwrvgnd_1
XFILLER_0_64_699 VGND VGND VPWR VPWR sky130_fd_sc_hd__fill_1
XFILLER_0_134_587 VGND VGND VPWR VPWR sky130_fd_sc_hd__fill_1
XFILLER_0_122_749 VGND VGND VPWR VPWR sky130_fd_sc_hd__decap_6
XFILLER_0_32_530 VGND VGND VPWR VPWR sky130_fd_sc_hd__fill_2
XFILLER_0_121_237 VPWR VGND VPWR VGND sky130_ef_sc_hd__decap_12
XTAP_TAPCELL_ROW_79_1482 VGND VPWR sky130_fd_sc_hd__tapvpwrvgnd_1
XTAP_TAPCELL_ROW_9_442 VGND VPWR sky130_fd_sc_hd__tapvpwrvgnd_1
XTAP_TAPCELL_ROW_9_431 VGND VPWR sky130_fd_sc_hd__tapvpwrvgnd_1
XFILLER_0_130_793 VPWR VGND VPWR VGND sky130_ef_sc_hd__decap_12
XTAP_TAPCELL_ROW_92_1682 VGND VPWR sky130_fd_sc_hd__tapvpwrvgnd_1
XFILLER_0_20_769 VGND VGND VPWR VPWR sky130_fd_sc_hd__decap_8
XFILLER_0_91_19 VPWR VGND VPWR VGND sky130_ef_sc_hd__decap_12
XFILLER_0_99_596 VGND VGND VPWR VPWR sky130_fd_sc_hd__fill_1
XFILLER_0_87_725 VGND VGND VPWR VPWR sky130_fd_sc_hd__decap_3
XFILLER_0_129_337 VPWR VGND VPWR VGND sky130_ef_sc_hd__decap_12
XFILLER_0_86_268 VGND VGND VPWR VPWR sky130_fd_sc_hd__fill_1
XFILLER_0_28_825 VPWR VGND VPWR VGND sky130_ef_sc_hd__decap_12
XFILLER_0_39_140 VGND VGND VPWR VPWR sky130_fd_sc_hd__fill_2
XFILLER_0_67_482 VGND VGND VPWR VPWR sky130_fd_sc_hd__fill_2
XFILLER_0_55_644 VGND VGND VPWR VPWR sky130_fd_sc_hd__fill_2
XFILLER_0_54_132 VGND VGND VPWR VPWR sky130_fd_sc_hd__decap_8
XFILLER_0_27_346 VPWR VGND VPWR VGND sky130_ef_sc_hd__decap_12
XFILLER_0_131_69 VPWR VGND VPWR VGND sky130_ef_sc_hd__decap_12
XFILLER_0_82_474 VGND VGND VPWR VPWR sky130_fd_sc_hd__fill_2
XFILLER_0_43_839 VGND VGND VPWR VPWR sky130_fd_sc_hd__fill_1
XFILLER_0_2_413 VGND VGND VPWR VPWR sky130_fd_sc_hd__decap_6
XFILLER_0_23_541 VGND VGND VPWR VPWR sky130_fd_sc_hd__decap_4
XFILLER_0_11_703 VGND VGND VPWR VPWR sky130_fd_sc_hd__decap_3
XFILLER_0_2_457 VPWR VGND VPWR VGND sky130_ef_sc_hd__decap_12
X_5350_ rf.registers\[16\]\[25\] rf.registers\[17\]\[25\] rf.registers\[18\]\[25\]
+ rf.registers\[19\]\[25\] _2086_ _2087_ VGND VGND VPWR VPWR _2088_ sky130_fd_sc_hd__mux4_1
X_4301_ _1061_ _1093_ _1052_ VGND VGND VPWR VPWR _1094_ sky130_fd_sc_hd__a21oi_1
X_5281_ _2019_ _2022_ _1948_ VGND VGND VPWR VPWR _2023_ sky130_fd_sc_hd__mux2_1
XFILLER_0_50_393 VGND VGND VPWR VPWR sky130_fd_sc_hd__decap_8
XFILLER_0_49_43 VGND VGND VPWR VPWR sky130_fd_sc_hd__fill_1
XFILLER_0_23_596 VGND VGND VPWR VPWR sky130_fd_sc_hd__decap_3
X_4232_ A2[1] VGND VGND VPWR VPWR _1027_ sky130_fd_sc_hd__clkbuf_4
X_7020_ _3416_ VGND VGND VPWR VPWR _0968_ sky130_fd_sc_hd__clkbuf_1
X_8971_ clknet_leaf_70_CLK _0059_ VGND VGND VPWR VPWR rf.registers\[19\]\[26\] sky130_fd_sc_hd__dfxtp_1
X_7922_ _3895_ VGND VGND VPWR VPWR _0367_ sky130_fd_sc_hd__clkbuf_1
XTAP_TAPCELL_ROW_108_1921 VGND VPWR sky130_fd_sc_hd__tapvpwrvgnd_1
XFILLER_0_78_725 VPWR VGND VPWR VGND sky130_ef_sc_hd__decap_12
X_7853_ _3858_ VGND VGND VPWR VPWR _0335_ sky130_fd_sc_hd__clkbuf_1
XFILLER_0_81_41 VGND VGND VPWR VPWR sky130_fd_sc_hd__decap_3
XFILLER_0_78_769 VPWR VGND VPWR VGND sky130_ef_sc_hd__decap_12
X_7784_ rf.registers\[9\]\[14\] _3307_ _3817_ VGND VGND VPWR VPWR _3822_ sky130_fd_sc_hd__mux2_1
XFILLER_0_81_85 VGND VGND VPWR VPWR sky130_fd_sc_hd__fill_1
XFILLER_0_77_279 VGND VGND VPWR VPWR sky130_fd_sc_hd__fill_1
X_4996_ _1741_ _1753_ _1660_ VGND VGND VPWR VPWR _1754_ sky130_fd_sc_hd__o21a_1
X_6804_ rf.registers\[0\]\[30\] _3049_ _3240_ VGND VGND VPWR VPWR _3274_ sky130_fd_sc_hd__mux2_1
X_9523_ clknet_leaf_44_CLK _0611_ VGND VGND VPWR VPWR rf.registers\[14\]\[2\] sky130_fd_sc_hd__dfxtp_1
XFILLER_0_73_430 VGND VGND VPWR VPWR sky130_fd_sc_hd__fill_2
XTAP_TAPCELL_ROW_63_1250 VGND VPWR sky130_fd_sc_hd__tapvpwrvgnd_1
X_6735_ _3237_ VGND VGND VPWR VPWR _0862_ sky130_fd_sc_hd__clkbuf_1
XFILLER_0_135_329 VGND VGND VPWR VPWR sky130_fd_sc_hd__decap_6
X_9454_ clknet_leaf_92_CLK _0542_ VGND VGND VPWR VPWR rf.registers\[25\]\[29\] sky130_fd_sc_hd__dfxtp_1
XFILLER_0_61_614 VGND VGND VPWR VPWR sky130_fd_sc_hd__fill_2
X_6666_ _3200_ VGND VGND VPWR VPWR _0830_ sky130_fd_sc_hd__clkbuf_1
X_8405_ rf.registers\[18\]\[18\] net23 _4142_ VGND VGND VPWR VPWR _4151_ sky130_fd_sc_hd__mux2_1
XFILLER_0_61_658 VPWR VGND VPWR VGND sky130_ef_sc_hd__decap_12
XFILLER_0_5_273 VGND VGND VPWR VPWR sky130_fd_sc_hd__decap_6
X_6597_ _3163_ VGND VGND VPWR VPWR _0798_ sky130_fd_sc_hd__clkbuf_1
X_5617_ _2345_ _2346_ VGND VGND VPWR VPWR _2347_ sky130_fd_sc_hd__nand2_1
X_9385_ clknet_leaf_84_CLK _0473_ VGND VGND VPWR VPWR rf.registers\[26\]\[24\] sky130_fd_sc_hd__dfxtp_1
XFILLER_0_104_749 VGND VGND VPWR VPWR sky130_fd_sc_hd__decap_6
X_8336_ _4114_ VGND VGND VPWR VPWR _0562_ sky130_fd_sc_hd__clkbuf_1
X_5548_ _1056_ _2278_ VGND VGND VPWR VPWR _2279_ sky130_fd_sc_hd__nor2_1
X_8267_ _3022_ rf.registers\[25\]\[17\] _4070_ VGND VGND VPWR VPWR _4078_ sky130_fd_sc_hd__mux2_1
XFILLER_0_112_793 VPWR VGND VPWR VGND sky130_ef_sc_hd__decap_12
X_7218_ _3521_ VGND VGND VPWR VPWR _0037_ sky130_fd_sc_hd__clkbuf_1
X_5479_ _1888_ _2208_ _2209_ VGND VGND VPWR VPWR _2210_ sky130_fd_sc_hd__o21ai_1
X_8198_ _4041_ VGND VGND VPWR VPWR _0497_ sky130_fd_sc_hd__clkbuf_1
X_7149_ rf.registers\[4\]\[4\] _3286_ _3480_ VGND VGND VPWR VPWR _3485_ sky130_fd_sc_hd__mux2_1
XPHY_EDGE_ROW_122_Right_122 VGND VGND VPWR VPWR sky130_fd_sc_hd__decap_3
XPHY_EDGE_ROW_100_Left_239 VGND VGND VPWR VPWR sky130_fd_sc_hd__decap_3
XFILLER_0_96_522 VGND VGND VPWR VPWR sky130_fd_sc_hd__fill_1
XFILLER_0_68_213 VGND VGND VPWR VPWR sky130_fd_sc_hd__fill_1
XFILLER_0_138_101 VGND VGND VPWR VPWR sky130_fd_sc_hd__decap_8
XFILLER_0_68_268 VGND VGND VPWR VPWR sky130_fd_sc_hd__decap_3
XFILLER_0_56_419 VGND VGND VPWR VPWR sky130_fd_sc_hd__fill_1
XFILLER_0_138_167 VGND VGND VPWR VPWR sky130_fd_sc_hd__fill_1
XFILLER_0_126_307 VGND VGND VPWR VPWR sky130_fd_sc_hd__fill_1
XFILLER_0_37_644 VGND VGND VPWR VPWR sky130_fd_sc_hd__fill_1
XFILLER_0_25_806 VPWR VGND VPWR VGND sky130_ef_sc_hd__decap_12
XFILLER_0_36_154 VGND VGND VPWR VPWR sky130_fd_sc_hd__fill_1
XFILLER_0_135_841 VGND VGND VPWR VPWR sky130_fd_sc_hd__fill_1
XFILLER_0_107_543 VGND VGND VPWR VPWR sky130_fd_sc_hd__fill_2
XFILLER_0_24_305 VGND VGND VPWR VPWR sky130_fd_sc_hd__decap_3
XFILLER_0_36_176 VGND VGND VPWR VPWR sky130_fd_sc_hd__fill_2
XFILLER_0_37_699 VGND VGND VPWR VPWR sky130_fd_sc_hd__fill_1
XFILLER_0_107_587 VGND VGND VPWR VPWR sky130_fd_sc_hd__decap_4
XFILLER_0_101_39 VPWR VGND VPWR VGND sky130_ef_sc_hd__decap_12
XFILLER_0_10_15 VPWR VGND VPWR VGND sky130_ef_sc_hd__decap_12
XFILLER_0_17_390 VGND VGND VPWR VPWR sky130_fd_sc_hd__fill_2
XTAP_TAPCELL_ROW_94_1711 VGND VPWR sky130_fd_sc_hd__tapvpwrvgnd_1
XFILLER_0_20_533 VGND VGND VPWR VPWR sky130_fd_sc_hd__decap_8
XFILLER_0_19_57 VPWR VGND VPWR VGND sky130_ef_sc_hd__decap_12
XTAP_TAPCELL_ROW_121_2118 VGND VPWR sky130_fd_sc_hd__tapvpwrvgnd_1
XFILLER_0_99_393 VGND VGND VPWR VPWR sky130_fd_sc_hd__decap_8
X_4850_ _1291_ _1613_ _1117_ VGND VGND VPWR VPWR _1614_ sky130_fd_sc_hd__o21ai_1
XFILLER_0_136_3 VPWR VGND VPWR VGND sky130_ef_sc_hd__decap_12
XFILLER_0_129_167 VGND VGND VPWR VPWR sky130_fd_sc_hd__fill_1
XTAP_TAPCELL_ROW_103_1851 VGND VPWR sky130_fd_sc_hd__tapvpwrvgnd_1
XTAP_TAPCELL_ROW_103_1840 VGND VPWR sky130_fd_sc_hd__tapvpwrvgnd_1
XFILLER_0_7_505 VPWR VGND VPWR VGND sky130_ef_sc_hd__decap_12
XFILLER_0_67_290 VGND VGND VPWR VPWR sky130_fd_sc_hd__decap_6
XFILLER_0_51_55 VGND VGND VPWR VPWR sky130_fd_sc_hd__fill_1
X_6520_ _3122_ VGND VGND VPWR VPWR _0762_ sky130_fd_sc_hd__clkbuf_1
XFILLER_0_27_143 VGND VGND VPWR VPWR sky130_fd_sc_hd__fill_2
X_4781_ _1298_ _1548_ _1168_ VGND VGND VPWR VPWR _1549_ sky130_fd_sc_hd__a21o_1
XFILLER_0_83_783 VGND VGND VPWR VPWR sky130_fd_sc_hd__fill_1
XFILLER_0_15_305 VPWR VGND VPWR VGND sky130_ef_sc_hd__decap_12
XFILLER_0_28_699 VGND VGND VPWR VPWR sky130_fd_sc_hd__fill_1
XTAP_TAPCELL_ROW_31_767 VGND VPWR sky130_fd_sc_hd__tapvpwrvgnd_1
XFILLER_0_125_373 VGND VGND VPWR VPWR sky130_fd_sc_hd__decap_8
XFILLER_0_113_502 VGND VGND VPWR VPWR sky130_fd_sc_hd__fill_2
XFILLER_0_70_433 VGND VGND VPWR VPWR sky130_fd_sc_hd__decap_8
Xclkload20 clknet_leaf_4_CLK VGND VGND VPWR VPWR clkload20/Y sky130_fd_sc_hd__bufinv_16
XFILLER_0_15_349 VPWR VGND VPWR VGND sky130_ef_sc_hd__decap_12
X_6451_ rf.registers\[11\]\[26\] _3041_ _3078_ VGND VGND VPWR VPWR _3085_ sky130_fd_sc_hd__mux2_1
XFILLER_0_31_809 VPWR VGND VPWR VGND sky130_ef_sc_hd__decap_12
X_9170_ clknet_leaf_41_CLK _0258_ VGND VGND VPWR VPWR rf.registers\[30\]\[1\] sky130_fd_sc_hd__dfxtp_1
Xclkload53 clknet_leaf_16_CLK VGND VGND VPWR VPWR clkload53/Y sky130_fd_sc_hd__clkinvlp_2
Xclkload31 clknet_leaf_21_CLK VGND VGND VPWR VPWR clkload31/Y sky130_fd_sc_hd__clkinvlp_4
Xclkload42 clknet_leaf_12_CLK VGND VGND VPWR VPWR clkload42/Y sky130_fd_sc_hd__bufinv_16
XFILLER_0_70_477 VGND VGND VPWR VPWR sky130_fd_sc_hd__decap_4
XFILLER_0_70_466 VGND VGND VPWR VPWR sky130_fd_sc_hd__decap_8
XFILLER_0_2_221 VPWR VGND VPWR VGND sky130_ef_sc_hd__decap_12
X_6382_ rf.registers\[12\]\[28\] _3045_ _3029_ VGND VGND VPWR VPWR _3046_ sky130_fd_sc_hd__mux2_1
X_5402_ rf.registers\[28\]\[28\] rf.registers\[29\]\[28\] rf.registers\[30\]\[28\]
+ rf.registers\[31\]\[28\] _1951_ _1952_ VGND VGND VPWR VPWR _2137_ sky130_fd_sc_hd__mux4_1
Xclkload86 clknet_leaf_42_CLK VGND VGND VPWR VPWR clkload86/Y sky130_fd_sc_hd__clkinvlp_4
Xclkload64 clknet_leaf_25_CLK VGND VGND VPWR VPWR clkload64/Y sky130_fd_sc_hd__inv_6
X_8121_ _3372_ rf.registers\[26\]\[12\] _3998_ VGND VGND VPWR VPWR _4001_ sky130_fd_sc_hd__mux2_1
Xclkload75 clknet_leaf_52_CLK VGND VGND VPWR VPWR clkload75/Y sky130_fd_sc_hd__clkinv_4
XFILLER_0_3_777 VGND VGND VPWR VPWR sky130_fd_sc_hd__decap_6
XFILLER_0_2_265 VPWR VGND VPWR VGND sky130_ef_sc_hd__decap_12
XFILLER_0_23_393 VGND VGND VPWR VPWR sky130_fd_sc_hd__decap_4
X_5333_ rf.registers\[8\]\[24\] rf.registers\[9\]\[24\] rf.registers\[10\]\[24\] rf.registers\[11\]\[24\]
+ _2070_ _2071_ VGND VGND VPWR VPWR _2072_ sky130_fd_sc_hd__mux4_1
X_8052_ _3964_ VGND VGND VPWR VPWR _0428_ sky130_fd_sc_hd__clkbuf_1
XFILLER_0_76_41 VGND VGND VPWR VPWR sky130_fd_sc_hd__decap_8
X_5264_ _1943_ _2006_ VGND VGND VPWR VPWR _2007_ sky130_fd_sc_hd__or2_1
XFILLER_0_76_63 VGND VGND VPWR VPWR sky130_fd_sc_hd__fill_1
X_7003_ _3203_ _3406_ VGND VGND VPWR VPWR _3407_ sky130_fd_sc_hd__nor2_2
X_5195_ rf.registers\[20\]\[17\] rf.registers\[21\]\[17\] rf.registers\[22\]\[17\]
+ rf.registers\[23\]\[17\] _1919_ _1920_ VGND VGND VPWR VPWR _1941_ sky130_fd_sc_hd__mux4_1
X_8954_ clknet_leaf_34_CLK _0042_ VGND VGND VPWR VPWR rf.registers\[19\]\[9\] sky130_fd_sc_hd__dfxtp_1
XTAP_TAPCELL_ROW_39_878 VGND VPWR sky130_fd_sc_hd__tapvpwrvgnd_1
X_8885_ clknet_leaf_49_CLK _0997_ VGND VGND VPWR VPWR rf.registers\[5\]\[4\] sky130_fd_sc_hd__dfxtp_1
X_7905_ _3886_ VGND VGND VPWR VPWR _0359_ sky130_fd_sc_hd__clkbuf_1
XFILLER_0_78_533 VGND VGND VPWR VPWR sky130_fd_sc_hd__fill_2
XTAP_TAPCELL_ROW_39_889 VGND VPWR sky130_fd_sc_hd__tapvpwrvgnd_1
X_7836_ _3849_ VGND VGND VPWR VPWR _0327_ sky130_fd_sc_hd__clkbuf_1
XFILLER_0_65_205 VGND VGND VPWR VPWR sky130_fd_sc_hd__fill_1
XTAP_TAPCELL_ROW_19_580 VGND VPWR sky130_fd_sc_hd__tapvpwrvgnd_1
XTAP_TAPCELL_ROW_19_591 VGND VPWR sky130_fd_sc_hd__tapvpwrvgnd_1
XTAP_TAPCELL_ROW_61_1209 VGND VPWR sky130_fd_sc_hd__tapvpwrvgnd_1
X_4979_ _1736_ VGND VGND VPWR VPWR _1737_ sky130_fd_sc_hd__buf_4
XFILLER_0_81_709 VPWR VGND VPWR VGND sky130_ef_sc_hd__decap_12
X_7767_ rf.registers\[9\]\[6\] _3290_ _3806_ VGND VGND VPWR VPWR _3813_ sky130_fd_sc_hd__mux2_1
XFILLER_0_18_121 VPWR VGND VPWR VGND sky130_ef_sc_hd__decap_12
XFILLER_0_135_137 VPWR VGND VPWR VGND sky130_ef_sc_hd__decap_12
XFILLER_0_117_841 VGND VGND VPWR VPWR sky130_fd_sc_hd__fill_1
X_7698_ _3776_ VGND VGND VPWR VPWR _0262_ sky130_fd_sc_hd__clkbuf_1
X_9506_ clknet_leaf_10_CLK _0594_ VGND VGND VPWR VPWR rf.registers\[18\]\[17\] sky130_fd_sc_hd__dfxtp_1
X_6718_ rf.registers\[10\]\[21\] _3031_ _3227_ VGND VGND VPWR VPWR _3229_ sky130_fd_sc_hd__mux2_1
Xclkload3 clknet_3_3__leaf_CLK VGND VGND VPWR VPWR clkload3/Y sky130_fd_sc_hd__clkinv_4
XFILLER_0_132_811 VGND VGND VPWR VPWR sky130_fd_sc_hd__fill_1
X_9437_ clknet_leaf_23_CLK _0525_ VGND VGND VPWR VPWR rf.registers\[25\]\[12\] sky130_fd_sc_hd__dfxtp_1
X_6649_ rf.registers\[24\]\[21\] _3031_ _3190_ VGND VGND VPWR VPWR _3192_ sky130_fd_sc_hd__mux2_1
XFILLER_0_33_113 VGND VGND VPWR VPWR sky130_fd_sc_hd__fill_2
XFILLER_0_6_582 VGND VGND VPWR VPWR sky130_fd_sc_hd__decap_6
X_9368_ clknet_leaf_53_CLK _0456_ VGND VGND VPWR VPWR rf.registers\[26\]\[7\] sky130_fd_sc_hd__dfxtp_1
XTAP_TAPCELL_ROW_76_1441 VGND VPWR sky130_fd_sc_hd__tapvpwrvgnd_1
X_9299_ clknet_leaf_43_CLK _0387_ VGND VGND VPWR VPWR rf.registers\[22\]\[2\] sky130_fd_sc_hd__dfxtp_1
X_8319_ _4105_ VGND VGND VPWR VPWR _0554_ sky130_fd_sc_hd__clkbuf_1
XFILLER_0_89_809 VPWR VGND VPWR VGND sky130_ef_sc_hd__decap_12
XFILLER_0_69_500 VGND VGND VPWR VPWR sky130_fd_sc_hd__decap_4
XFILLER_0_96_374 VGND VGND VPWR VPWR sky130_fd_sc_hd__decap_8
XFILLER_0_127_649 VPWR VGND VPWR VGND sky130_ef_sc_hd__decap_12
XFILLER_0_112_27 VGND VGND VPWR VPWR sky130_fd_sc_hd__fill_1
XFILLER_0_65_783 VGND VGND VPWR VPWR sky130_fd_sc_hd__fill_1
XFILLER_0_135_671 VGND VGND VPWR VPWR sky130_fd_sc_hd__fill_1
XFILLER_0_13_809 VPWR VGND VPWR VGND sky130_ef_sc_hd__decap_12
XFILLER_0_21_69 VPWR VGND VPWR VGND sky130_ef_sc_hd__decap_12
XFILLER_0_25_669 VGND VGND VPWR VPWR sky130_fd_sc_hd__decap_3
XFILLER_0_123_833 VGND VGND VPWR VPWR sky130_fd_sc_hd__decap_6
XFILLER_0_122_321 VPWR VGND VPWR VGND sky130_ef_sc_hd__decap_12
XFILLER_0_52_477 VGND VGND VPWR VPWR sky130_fd_sc_hd__fill_1
XFILLER_0_122_365 VPWR VGND VPWR VGND sky130_ef_sc_hd__decap_12
XFILLER_0_52_499 VGND VGND VPWR VPWR sky130_fd_sc_hd__decap_3
XFILLER_0_40_639 VGND VGND VPWR VPWR sky130_fd_sc_hd__decap_4
XFILLER_0_0_736 VPWR VGND VPWR VGND sky130_ef_sc_hd__decap_12
XFILLER_0_20_374 VGND VGND VPWR VPWR sky130_fd_sc_hd__decap_4
XFILLER_0_137_57 VPWR VGND VPWR VGND sky130_ef_sc_hd__decap_12
XFILLER_0_46_66 VGND VGND VPWR VPWR sky130_fd_sc_hd__fill_1
X_5951_ _1328_ _2668_ VGND VGND VPWR VPWR _2669_ sky130_fd_sc_hd__xnor2_2
X_4902_ _1661_ _1662_ _1663_ VGND VGND VPWR VPWR _1664_ sky130_fd_sc_hd__mux2_1
X_8670_ clknet_leaf_30_CLK _0782_ VGND VGND VPWR VPWR rf.registers\[1\]\[13\] sky130_fd_sc_hd__dfxtp_1
XFILLER_0_75_514 VGND VGND VPWR VPWR sky130_fd_sc_hd__decap_3
XFILLER_0_1_57 VPWR VGND VPWR VGND sky130_ef_sc_hd__decap_12
XTAP_TAPCELL_ROW_36_837 VGND VPWR sky130_fd_sc_hd__tapvpwrvgnd_1
XFILLER_0_87_385 VGND VGND VPWR VPWR sky130_fd_sc_hd__decap_6
XFILLER_0_48_739 VPWR VGND VPWR VGND sky130_ef_sc_hd__decap_12
X_5882_ _2209_ _2224_ _2231_ VGND VGND VPWR VPWR _2603_ sky130_fd_sc_hd__o21bai_1
X_7621_ _3735_ VGND VGND VPWR VPWR _0226_ sky130_fd_sc_hd__clkbuf_1
XFILLER_0_63_709 VPWR VGND VPWR VGND sky130_ef_sc_hd__decap_12
X_4833_ _1156_ _1597_ _1117_ VGND VGND VPWR VPWR _1598_ sky130_fd_sc_hd__o21ai_1
XFILLER_0_8_825 VPWR VGND VPWR VGND sky130_ef_sc_hd__decap_12
XFILLER_0_28_441 VGND VGND VPWR VPWR sky130_fd_sc_hd__decap_4
X_7552_ _3349_ rf.registers\[27\]\[1\] _3697_ VGND VGND VPWR VPWR _3699_ sky130_fd_sc_hd__mux2_1
XFILLER_0_117_137 VPWR VGND VPWR VGND sky130_ef_sc_hd__decap_12
XFILLER_0_7_335 VGND VGND VPWR VPWR sky130_fd_sc_hd__fill_1
XFILLER_0_16_614 VPWR VGND VPWR VGND sky130_ef_sc_hd__decap_12
X_4764_ _1156_ _1532_ VGND VGND VPWR VPWR _1533_ sky130_fd_sc_hd__or2_1
XTAP_TAPCELL_ROW_134_2309 VGND VPWR sky130_fd_sc_hd__tapvpwrvgnd_1
X_7483_ _3662_ VGND VGND VPWR VPWR _0161_ sky130_fd_sc_hd__clkbuf_1
XFILLER_0_114_811 VGND VGND VPWR VPWR sky130_fd_sc_hd__fill_1
X_6503_ _3113_ VGND VGND VPWR VPWR _0754_ sky130_fd_sc_hd__clkbuf_1
XFILLER_0_71_753 VPWR VGND VPWR VGND sky130_ef_sc_hd__decap_12
XFILLER_0_15_113 VPWR VGND VPWR VGND sky130_ef_sc_hd__decap_12
XFILLER_0_125_181 VPWR VGND VPWR VGND sky130_ef_sc_hd__decap_12
X_6434_ rf.registers\[11\]\[18\] _3024_ _3067_ VGND VGND VPWR VPWR _3076_ sky130_fd_sc_hd__mux2_1
X_9222_ clknet_leaf_77_CLK _0310_ VGND VGND VPWR VPWR rf.registers\[9\]\[21\] sky130_fd_sc_hd__dfxtp_1
X_4695_ rf.registers\[12\]\[22\] rf.registers\[13\]\[22\] rf.registers\[14\]\[22\]
+ rf.registers\[15\]\[22\] _1403_ _1404_ VGND VGND VPWR VPWR _1468_ sky130_fd_sc_hd__mux4_1
XFILLER_0_16_669 VPWR VGND VPWR VGND sky130_ef_sc_hd__decap_12
XFILLER_0_31_617 VPWR VGND VPWR VGND sky130_ef_sc_hd__decap_12
XFILLER_0_71_797 VPWR VGND VPWR VGND sky130_ef_sc_hd__decap_12
XFILLER_0_3_541 VPWR VGND VPWR VGND sky130_ef_sc_hd__decap_12
X_9153_ clknet_leaf_14_CLK _0241_ VGND VGND VPWR VPWR rf.registers\[2\]\[16\] sky130_fd_sc_hd__dfxtp_1
X_6365_ _3034_ VGND VGND VPWR VPWR _0695_ sky130_fd_sc_hd__clkbuf_1
XFILLER_0_60_3 VPWR VGND VPWR VGND sky130_ef_sc_hd__decap_12
XTAP_TAPCELL_ROW_58_1171 VGND VPWR sky130_fd_sc_hd__tapvpwrvgnd_1
XFILLER_0_3_585 VPWR VGND VPWR VGND sky130_ef_sc_hd__decap_12
XFILLER_0_23_190 VGND VGND VPWR VPWR sky130_fd_sc_hd__fill_1
X_6296_ rf.registers\[12\]\[0\] _2982_ _2987_ VGND VGND VPWR VPWR _2988_ sky130_fd_sc_hd__mux2_1
X_9084_ clknet_leaf_26_CLK _0172_ VGND VGND VPWR VPWR rf.registers\[31\]\[11\] sky130_fd_sc_hd__dfxtp_1
X_8104_ _3355_ rf.registers\[26\]\[4\] _3987_ VGND VGND VPWR VPWR _3992_ sky130_fd_sc_hd__mux2_1
X_5316_ _2054_ _2055_ _1768_ VGND VGND VPWR VPWR _2056_ sky130_fd_sc_hd__mux2_1
XFILLER_0_11_385 VGND VGND VPWR VPWR sky130_fd_sc_hd__decap_6
X_8035_ _3955_ VGND VGND VPWR VPWR _0420_ sky130_fd_sc_hd__clkbuf_1
X_5247_ _1747_ _1990_ VGND VGND VPWR VPWR _1991_ sky130_fd_sc_hd__or2_1
XTAP_TAPCELL_ROW_71_1371 VGND VPWR sky130_fd_sc_hd__tapvpwrvgnd_1
XTAP_TAPCELL_ROW_71_1360 VGND VPWR sky130_fd_sc_hd__tapvpwrvgnd_1
X_5178_ rf.registers\[16\]\[16\] rf.registers\[17\]\[16\] rf.registers\[18\]\[16\]
+ rf.registers\[19\]\[16\] _1922_ _1923_ VGND VGND VPWR VPWR _1925_ sky130_fd_sc_hd__mux4_1
X_8937_ clknet_leaf_67_CLK _0025_ VGND VGND VPWR VPWR rf.registers\[4\]\[24\] sky130_fd_sc_hd__dfxtp_1
XFILLER_0_78_363 VGND VGND VPWR VPWR sky130_fd_sc_hd__fill_1
X_8868_ clknet_leaf_19_CLK _0980_ VGND VGND VPWR VPWR rf.registers\[6\]\[19\] sky130_fd_sc_hd__dfxtp_1
XFILLER_0_78_374 VPWR VGND VPWR VGND sky130_ef_sc_hd__decap_12
XTAP_TAPCELL_ROW_14_509 VGND VPWR sky130_fd_sc_hd__tapvpwrvgnd_1
XFILLER_0_39_739 VPWR VGND VPWR VGND sky130_ef_sc_hd__decap_12
XFILLER_0_136_413 VGND VGND VPWR VPWR sky130_fd_sc_hd__decap_6
X_8799_ clknet_leaf_28_CLK _0911_ VGND VGND VPWR VPWR rf.registers\[16\]\[14\] sky130_fd_sc_hd__dfxtp_1
X_7819_ rf.registers\[9\]\[31\] _3342_ _3805_ VGND VGND VPWR VPWR _3840_ sky130_fd_sc_hd__mux2_1
XFILLER_0_136_457 VPWR VGND VPWR VGND sky130_ef_sc_hd__decap_12
XFILLER_0_47_783 VGND VGND VPWR VPWR sky130_fd_sc_hd__fill_1
XFILLER_0_62_753 VGND VGND VPWR VPWR sky130_fd_sc_hd__decap_3
XFILLER_0_105_833 VGND VGND VPWR VPWR sky130_fd_sc_hd__decap_6
XFILLER_0_61_285 VGND VGND VPWR VPWR sky130_fd_sc_hd__fill_1
XFILLER_0_21_116 VGND VGND VPWR VPWR sky130_fd_sc_hd__fill_1
XFILLER_0_22_639 VGND VGND VPWR VPWR sky130_fd_sc_hd__decap_4
XFILLER_0_120_825 VGND VGND VPWR VPWR sky130_fd_sc_hd__decap_8
XFILLER_0_104_398 VGND VGND VPWR VPWR sky130_fd_sc_hd__fill_2
XFILLER_0_30_694 VGND VGND VPWR VPWR sky130_fd_sc_hd__decap_6
XFILLER_0_89_606 VGND VGND VPWR VPWR sky130_fd_sc_hd__fill_1
XTAP_TAPCELL_ROW_89_1632 VGND VPWR sky130_fd_sc_hd__tapvpwrvgnd_1
XFILLER_0_69_385 VGND VGND VPWR VPWR sky130_fd_sc_hd__fill_1
XFILLER_0_84_388 VPWR VGND VPWR VGND sky130_ef_sc_hd__decap_12
XFILLER_0_53_753 VPWR VGND VPWR VGND sky130_ef_sc_hd__decap_12
XFILLER_0_5_839 VGND VGND VPWR VPWR sky130_fd_sc_hd__fill_1
XTAP_TAPCELL_ROW_116_2039 VGND VPWR sky130_fd_sc_hd__tapvpwrvgnd_1
XFILLER_0_123_652 VPWR VGND VPWR VGND sky130_ef_sc_hd__decap_12
X_4480_ _1263_ _1264_ _1143_ VGND VGND VPWR VPWR _1265_ sky130_fd_sc_hd__mux2_1
XFILLER_0_53_797 VPWR VGND VPWR VGND sky130_ef_sc_hd__decap_12
XFILLER_0_123_685 VPWR VGND VPWR VGND sky130_ef_sc_hd__decap_12
XFILLER_0_21_650 VGND VGND VPWR VPWR sky130_fd_sc_hd__decap_8
XFILLER_0_122_195 VGND VGND VPWR VPWR sky130_fd_sc_hd__fill_1
X_6150_ _2843_ _2844_ _2856_ VGND VGND VPWR VPWR net129 sky130_fd_sc_hd__a21oi_2
XFILLER_0_0_533 VGND VGND VPWR VPWR sky130_fd_sc_hd__decap_8
X_5101_ rf.registers\[0\]\[11\] rf.registers\[1\]\[11\] rf.registers\[2\]\[11\] rf.registers\[3\]\[11\]
+ _1816_ _1817_ VGND VGND VPWR VPWR _1853_ sky130_fd_sc_hd__mux4_1
XFILLER_0_21_694 VGND VGND VPWR VPWR sky130_fd_sc_hd__decap_4
XTAP_TAPCELL_ROW_111_1972 VGND VPWR sky130_fd_sc_hd__tapvpwrvgnd_1
XTAP_TAPCELL_ROW_111_1961 VGND VPWR sky130_fd_sc_hd__tapvpwrvgnd_1
X_6081_ _2695_ _2726_ _2348_ VGND VGND VPWR VPWR _2791_ sky130_fd_sc_hd__mux2_1
X_5032_ _1786_ _1787_ _1630_ VGND VGND VPWR VPWR _1788_ sky130_fd_sc_hd__mux2_1
XTAP_TAPCELL_ROW_53_1090 VGND VPWR sky130_fd_sc_hd__tapvpwrvgnd_1
XFILLER_0_94_108 VGND VGND VPWR VPWR sky130_fd_sc_hd__fill_1
X_6983_ _3395_ rf.registers\[15\]\[23\] _3389_ VGND VGND VPWR VPWR _3396_ sky130_fd_sc_hd__mux2_1
X_8722_ clknet_leaf_45_CLK _0834_ VGND VGND VPWR VPWR rf.registers\[10\]\[1\] sky130_fd_sc_hd__dfxtp_1
X_5934_ _2614_ _2616_ _2622_ _2651_ _2652_ VGND VGND VPWR VPWR _2653_ sky130_fd_sc_hd__a311o_1
XFILLER_0_48_525 VGND VGND VPWR VPWR sky130_fd_sc_hd__decap_4
X_5865_ net111 _2201_ _2473_ _2531_ _2392_ VGND VGND VPWR VPWR _2587_ sky130_fd_sc_hd__o41a_1
XFILLER_0_36_709 VGND VGND VPWR VPWR sky130_fd_sc_hd__fill_2
X_8653_ clknet_leaf_0_CLK _0765_ VGND VGND VPWR VPWR rf.registers\[17\]\[28\] sky130_fd_sc_hd__dfxtp_1
XFILLER_0_63_528 VGND VGND VPWR VPWR sky130_fd_sc_hd__fill_2
X_7604_ _2970_ rf.registers\[27\]\[26\] _3719_ VGND VGND VPWR VPWR _3726_ sky130_fd_sc_hd__mux2_1
XFILLER_0_29_772 VGND VGND VPWR VPWR sky130_fd_sc_hd__fill_2
XFILLER_0_29_783 VGND VGND VPWR VPWR sky130_fd_sc_hd__fill_1
X_4816_ _1293_ _1581_ _1282_ VGND VGND VPWR VPWR _1582_ sky130_fd_sc_hd__o21a_1
XFILLER_0_133_405 VPWR VGND VPWR VGND sky130_ef_sc_hd__decap_12
XFILLER_0_113_81 VPWR VGND VPWR VGND sky130_ef_sc_hd__decap_12
X_8584_ clknet_leaf_8_CLK _0696_ VGND VGND VPWR VPWR rf.registers\[12\]\[23\] sky130_fd_sc_hd__dfxtp_1
XFILLER_0_16_411 VGND VGND VPWR VPWR sky130_fd_sc_hd__decap_8
XFILLER_0_16_433 VPWR VGND VPWR VGND sky130_ef_sc_hd__decap_12
X_5796_ _2209_ _2242_ _2248_ VGND VGND VPWR VPWR _2521_ sky130_fd_sc_hd__o21ai_1
XFILLER_0_16_477 VPWR VGND VPWR VGND sky130_ef_sc_hd__decap_12
X_7535_ _3689_ VGND VGND VPWR VPWR _0186_ sky130_fd_sc_hd__clkbuf_1
X_4747_ _1135_ _1516_ VGND VGND VPWR VPWR _1517_ sky130_fd_sc_hd__or2_1
XFILLER_0_98_61 VGND VGND VPWR VPWR sky130_fd_sc_hd__fill_2
X_4678_ _1450_ _1451_ _1154_ VGND VGND VPWR VPWR _1452_ sky130_fd_sc_hd__mux2_1
X_7466_ _2963_ rf.registers\[29\]\[25\] _3647_ VGND VGND VPWR VPWR _3653_ sky130_fd_sc_hd__mux2_1
XFILLER_0_43_296 VGND VGND VPWR VPWR sky130_fd_sc_hd__fill_2
XFILLER_0_102_825 VPWR VGND VPWR VGND sky130_ef_sc_hd__decap_12
X_9205_ clknet_leaf_49_CLK _0293_ VGND VGND VPWR VPWR rf.registers\[9\]\[4\] sky130_fd_sc_hd__dfxtp_1
XTAP_TAPCELL_ROW_73_1400 VGND VPWR sky130_fd_sc_hd__tapvpwrvgnd_1
X_6417_ _3055_ VGND VGND VPWR VPWR _3067_ sky130_fd_sc_hd__clkbuf_8
X_7397_ rf.registers\[8\]\[25\] _3330_ _3610_ VGND VGND VPWR VPWR _3616_ sky130_fd_sc_hd__mux2_1
XFILLER_0_113_195 VGND VGND VPWR VPWR sky130_fd_sc_hd__fill_2
Xoutput49 net49 VGND VGND VPWR VPWR RD1[0] sky130_fd_sc_hd__buf_1
X_6348_ rf.registers\[12\]\[17\] _3022_ _3008_ VGND VGND VPWR VPWR _3023_ sky130_fd_sc_hd__mux2_1
X_9136_ clknet_leaf_66_CLK _0224_ VGND VGND VPWR VPWR rf.registers\[27\]\[31\] sky130_fd_sc_hd__dfxtp_1
XFILLER_0_3_393 VPWR VGND VPWR VGND sky130_ef_sc_hd__decap_12
XFILLER_0_11_193 VPWR VGND VPWR VGND sky130_ef_sc_hd__decap_12
X_9067_ clknet_leaf_86_CLK _0155_ VGND VGND VPWR VPWR rf.registers\[29\]\[26\] sky130_fd_sc_hd__dfxtp_1
X_6279_ _2974_ rf.registers\[13\]\[28\] _2968_ VGND VGND VPWR VPWR _2975_ sky130_fd_sc_hd__mux2_1
X_8018_ _2974_ rf.registers\[22\]\[28\] _3937_ VGND VGND VPWR VPWR _3946_ sky130_fd_sc_hd__mux2_1
XFILLER_0_98_403 VGND VGND VPWR VPWR sky130_fd_sc_hd__fill_1
XTAP_TAPCELL_ROW_84_1562 VGND VPWR sky130_fd_sc_hd__tapvpwrvgnd_1
XFILLER_0_39_503 VGND VGND VPWR VPWR sky130_fd_sc_hd__fill_1
XFILLER_0_39_547 VPWR VGND VPWR VGND sky130_ef_sc_hd__decap_12
XFILLER_0_136_221 VPWR VGND VPWR VGND sky130_ef_sc_hd__decap_12
XFILLER_0_94_697 VGND VGND VPWR VPWR sky130_fd_sc_hd__decap_3
XFILLER_0_82_837 VGND VGND VPWR VPWR sky130_fd_sc_hd__fill_2
XFILLER_0_137_777 VGND VGND VPWR VPWR sky130_fd_sc_hd__decap_6
XFILLER_0_136_265 VPWR VGND VPWR VGND sky130_ef_sc_hd__decap_12
XFILLER_0_124_405 VGND VGND VPWR VPWR sky130_fd_sc_hd__decap_3
XFILLER_0_81_325 VGND VGND VPWR VPWR sky130_fd_sc_hd__fill_1
XFILLER_0_66_399 VGND VGND VPWR VPWR sky130_fd_sc_hd__decap_4
XFILLER_0_124_438 VGND VGND VPWR VPWR sky130_fd_sc_hd__fill_2
XFILLER_0_50_701 VPWR VGND VPWR VGND sky130_ef_sc_hd__decap_12
XFILLER_0_35_797 VPWR VGND VPWR VGND sky130_ef_sc_hd__decap_12
XFILLER_0_105_685 VPWR VGND VPWR VGND sky130_ef_sc_hd__decap_12
XFILLER_0_10_609 VPWR VGND VPWR VGND sky130_ef_sc_hd__decap_12
Xclkbuf_leaf_40_CLK clknet_3_7__leaf_CLK VGND VGND VPWR VPWR clknet_leaf_40_CLK sky130_fd_sc_hd__clkbuf_8
XFILLER_0_118_15 VPWR VGND VPWR VGND sky130_ef_sc_hd__decap_12
XFILLER_0_89_447 VGND VGND VPWR VPWR sky130_fd_sc_hd__fill_1
XTAP_TAPCELL_ROW_126_2190 VGND VPWR sky130_fd_sc_hd__tapvpwrvgnd_1
XTAP_TAPCELL_ROW_46_987 VGND VPWR sky130_fd_sc_hd__tapvpwrvgnd_1
XFILLER_0_128_755 VGND VGND VPWR VPWR sky130_fd_sc_hd__fill_1
X_5650_ _2220_ _2290_ VGND VGND VPWR VPWR _2380_ sky130_fd_sc_hd__nor2_1
X_4601_ rf.registers\[20\]\[17\] rf.registers\[21\]\[17\] rf.registers\[22\]\[17\]
+ rf.registers\[23\]\[17\] _1302_ _1303_ VGND VGND VPWR VPWR _1379_ sky130_fd_sc_hd__mux4_1
X_5581_ _2209_ _2309_ _2311_ VGND VGND VPWR VPWR _2312_ sky130_fd_sc_hd__o21bai_1
XFILLER_0_41_701 VGND VGND VPWR VPWR sky130_fd_sc_hd__fill_2
X_4532_ rf.registers\[28\]\[13\] rf.registers\[29\]\[13\] rf.registers\[30\]\[13\]
+ rf.registers\[31\]\[13\] _1126_ _1129_ VGND VGND VPWR VPWR _1314_ sky130_fd_sc_hd__mux4_1
X_7320_ _3575_ VGND VGND VPWR VPWR _0085_ sky130_fd_sc_hd__clkbuf_1
XFILLER_0_130_419 VGND VGND VPWR VPWR sky130_fd_sc_hd__fill_1
X_4463_ _1247_ _1248_ _1143_ VGND VGND VPWR VPWR _1249_ sky130_fd_sc_hd__mux2_1
XFILLER_0_13_447 VGND VGND VPWR VPWR sky130_fd_sc_hd__fill_1
XFILLER_0_40_233 VGND VGND VPWR VPWR sky130_fd_sc_hd__fill_2
X_7251_ rf.registers\[19\]\[20\] _3319_ _3538_ VGND VGND VPWR VPWR _3539_ sky130_fd_sc_hd__mux2_1
X_6202_ _2780_ _2640_ VGND VGND VPWR VPWR _2905_ sky130_fd_sc_hd__and2b_1
Xclkbuf_leaf_31_CLK clknet_3_4__leaf_CLK VGND VGND VPWR VPWR clknet_leaf_31_CLK sky130_fd_sc_hd__clkbuf_8
X_4394_ _1138_ VGND VGND VPWR VPWR _1183_ sky130_fd_sc_hd__clkbuf_8
XFILLER_0_68_75 VGND VGND VPWR VPWR sky130_fd_sc_hd__fill_1
XTAP_TAPCELL_ROW_55_1130 VGND VPWR sky130_fd_sc_hd__tapvpwrvgnd_1
X_7182_ _3479_ VGND VGND VPWR VPWR _3502_ sky130_fd_sc_hd__buf_4
XPHY_EDGE_ROW_15_Right_15 VGND VGND VPWR VPWR sky130_fd_sc_hd__decap_3
XFILLER_0_0_385 VGND VGND VPWR VPWR sky130_fd_sc_hd__decap_6
X_6133_ _2239_ _2777_ _2839_ _2254_ VGND VGND VPWR VPWR _2840_ sky130_fd_sc_hd__a22o_1
X_6064_ _2769_ _2774_ VGND VGND VPWR VPWR _2775_ sky130_fd_sc_hd__xnor2_1
X_5015_ _1699_ VGND VGND VPWR VPWR _1772_ sky130_fd_sc_hd__clkbuf_8
XFILLER_0_84_85 VGND VGND VPWR VPWR sky130_fd_sc_hd__fill_1
X_6966_ net23 VGND VGND VPWR VPWR _3384_ sky130_fd_sc_hd__clkbuf_2
XPHY_EDGE_ROW_24_Right_24 VGND VGND VPWR VPWR sky130_fd_sc_hd__decap_3
X_8705_ clknet_leaf_5_CLK _0817_ VGND VGND VPWR VPWR rf.registers\[24\]\[16\] sky130_fd_sc_hd__dfxtp_1
X_5917_ _2213_ _2226_ VGND VGND VPWR VPWR _2636_ sky130_fd_sc_hd__nand2_1
XFILLER_0_118_221 VPWR VGND VPWR VGND sky130_ef_sc_hd__decap_12
XFILLER_0_75_152 VPWR VGND VPWR VGND sky130_ef_sc_hd__decap_12
XTAP_TAPCELL_ROW_66_1292 VGND VPWR sky130_fd_sc_hd__tapvpwrvgnd_1
XFILLER_0_64_837 VGND VGND VPWR VPWR sky130_fd_sc_hd__fill_2
XTAP_TAPCELL_ROW_24_659 VGND VPWR sky130_fd_sc_hd__tapvpwrvgnd_1
X_6897_ rf.registers\[16\]\[28\] _3336_ _3320_ VGND VGND VPWR VPWR _3337_ sky130_fd_sc_hd__mux2_1
XFILLER_0_119_777 VGND VGND VPWR VPWR sky130_fd_sc_hd__decap_6
X_8636_ clknet_leaf_26_CLK _0748_ VGND VGND VPWR VPWR rf.registers\[17\]\[11\] sky130_fd_sc_hd__dfxtp_1
X_5848_ _2570_ VGND VGND VPWR VPWR _2571_ sky130_fd_sc_hd__buf_2
XFILLER_0_134_725 VPWR VGND VPWR VGND sky130_ef_sc_hd__decap_12
XFILLER_0_91_689 VPWR VGND VPWR VGND sky130_ef_sc_hd__decap_12
X_8567_ clknet_leaf_60_CLK _0679_ VGND VGND VPWR VPWR rf.registers\[12\]\[6\] sky130_fd_sc_hd__dfxtp_1
XFILLER_0_17_753 VPWR VGND VPWR VGND sky130_ef_sc_hd__decap_12
X_5779_ _2463_ VGND VGND VPWR VPWR _2505_ sky130_fd_sc_hd__inv_2
XFILLER_0_32_701 VGND VGND VPWR VPWR sky130_fd_sc_hd__decap_3
XFILLER_0_134_769 VPWR VGND VPWR VGND sky130_ef_sc_hd__decap_12
X_7518_ _3680_ VGND VGND VPWR VPWR _0178_ sky130_fd_sc_hd__clkbuf_1
XFILLER_0_133_279 VGND VGND VPWR VPWR sky130_fd_sc_hd__fill_1
X_8498_ _3049_ rf.registers\[14\]\[30\] _4166_ VGND VGND VPWR VPWR _4200_ sky130_fd_sc_hd__mux2_1
X_7449_ _3382_ rf.registers\[29\]\[17\] _3636_ VGND VGND VPWR VPWR _3644_ sky130_fd_sc_hd__mux2_1
XPHY_EDGE_ROW_33_Right_33 VGND VGND VPWR VPWR sky130_fd_sc_hd__decap_3
Xclkbuf_leaf_22_CLK clknet_3_4__leaf_CLK VGND VGND VPWR VPWR clknet_leaf_22_CLK sky130_fd_sc_hd__clkbuf_8
X_9119_ clknet_leaf_28_CLK _0207_ VGND VGND VPWR VPWR rf.registers\[27\]\[14\] sky130_fd_sc_hd__dfxtp_1
XTAP_TAPCELL_ROW_4_362 VGND VPWR sky130_fd_sc_hd__tapvpwrvgnd_1
XPHY_EDGE_ROW_42_Right_42 VGND VGND VPWR VPWR sky130_fd_sc_hd__decap_3
XFILLER_0_86_417 VGND VGND VPWR VPWR sky130_fd_sc_hd__decap_3
XFILLER_0_79_480 VGND VGND VPWR VPWR sky130_fd_sc_hd__decap_4
Xclkbuf_leaf_89_CLK clknet_3_0__leaf_CLK VGND VGND VPWR VPWR clknet_leaf_89_CLK sky130_fd_sc_hd__clkbuf_8
XFILLER_0_79_491 VPWR VGND VPWR VGND sky130_ef_sc_hd__decap_12
XFILLER_0_67_653 VPWR VGND VPWR VGND sky130_ef_sc_hd__decap_12
XFILLER_0_13_15 VPWR VGND VPWR VGND sky130_ef_sc_hd__decap_12
XTAP_TAPCELL_ROW_43_946 VGND VPWR sky130_fd_sc_hd__tapvpwrvgnd_1
XFILLER_0_137_541 VPWR VGND VPWR VGND sky130_ef_sc_hd__decap_12
XFILLER_0_82_645 VGND VGND VPWR VPWR sky130_fd_sc_hd__decap_3
XFILLER_0_81_111 VGND VGND VPWR VPWR sky130_fd_sc_hd__fill_1
XFILLER_0_67_697 VPWR VGND VPWR VGND sky130_ef_sc_hd__decap_12
XFILLER_0_54_325 VGND VGND VPWR VPWR sky130_fd_sc_hd__decap_4
XFILLER_0_137_585 VPWR VGND VPWR VGND sky130_ef_sc_hd__decap_12
XFILLER_0_120_27 VGND VGND VPWR VPWR sky130_fd_sc_hd__fill_1
XFILLER_0_81_166 VGND VGND VPWR VPWR sky130_fd_sc_hd__fill_2
XPHY_EDGE_ROW_51_Right_51 VGND VGND VPWR VPWR sky130_fd_sc_hd__decap_3
XFILLER_0_112_419 VGND VGND VPWR VPWR sky130_fd_sc_hd__fill_1
XTAP_TAPCELL_ROW_97_1753 VGND VPWR sky130_fd_sc_hd__tapvpwrvgnd_1
XFILLER_0_62_391 VGND VGND VPWR VPWR sky130_fd_sc_hd__fill_1
XFILLER_0_50_531 VGND VGND VPWR VPWR sky130_fd_sc_hd__fill_1
XFILLER_0_1_105 VGND VGND VPWR VPWR sky130_fd_sc_hd__decap_6
XFILLER_0_23_767 VGND VGND VPWR VPWR sky130_fd_sc_hd__fill_1
XPHY_EDGE_ROW_136_Right_136 VGND VGND VPWR VPWR sky130_fd_sc_hd__decap_3
XFILLER_0_1_149 VPWR VGND VPWR VGND sky130_ef_sc_hd__decap_12
Xclkbuf_leaf_13_CLK clknet_3_3__leaf_CLK VGND VGND VPWR VPWR clknet_leaf_13_CLK sky130_fd_sc_hd__clkbuf_8
XFILLER_0_129_69 VPWR VGND VPWR VGND sky130_ef_sc_hd__decap_12
XPHY_EDGE_ROW_60_Right_60 VGND VGND VPWR VPWR sky130_fd_sc_hd__decap_3
X_6820_ rf.registers\[16\]\[3\] _3284_ _3278_ VGND VGND VPWR VPWR _3285_ sky130_fd_sc_hd__mux2_1
XFILLER_0_9_205 VPWR VGND VPWR VGND sky130_ef_sc_hd__decap_12
XFILLER_0_128_530 VGND VGND VPWR VPWR sky130_fd_sc_hd__fill_2
XTAP_TAPCELL_ROW_106_1893 VGND VPWR sky130_fd_sc_hd__tapvpwrvgnd_1
X_6751_ _3246_ VGND VGND VPWR VPWR _0869_ sky130_fd_sc_hd__clkbuf_1
XFILLER_0_9_249 VPWR VGND VPWR VGND sky130_ef_sc_hd__decap_12
X_9470_ clknet_leaf_26_CLK _0558_ VGND VGND VPWR VPWR rf.registers\[20\]\[13\] sky130_fd_sc_hd__dfxtp_1
X_6682_ rf.registers\[10\]\[4\] _2995_ _3205_ VGND VGND VPWR VPWR _3210_ sky130_fd_sc_hd__mux2_1
XFILLER_0_57_185 VGND VGND VPWR VPWR sky130_fd_sc_hd__decap_3
XTAP_TAPCELL_ROW_21_618 VGND VPWR sky130_fd_sc_hd__tapvpwrvgnd_1
X_5702_ _1114_ _2429_ VGND VGND VPWR VPWR _2430_ sky130_fd_sc_hd__xnor2_1
XFILLER_0_46_837 VGND VGND VPWR VPWR sky130_fd_sc_hd__fill_2
XFILLER_0_116_725 VPWR VGND VPWR VGND sky130_ef_sc_hd__decap_12
X_8421_ _4159_ VGND VGND VPWR VPWR _0602_ sky130_fd_sc_hd__clkbuf_1
X_5633_ _2361_ _2362_ VGND VGND VPWR VPWR _2363_ sky130_fd_sc_hd__nand2_1
XFILLER_0_116_769 VPWR VGND VPWR VGND sky130_ef_sc_hd__decap_12
XFILLER_0_60_339 VPWR VGND VPWR VGND sky130_ef_sc_hd__decap_12
X_5564_ _2282_ _2294_ net103 VGND VGND VPWR VPWR _2295_ sky130_fd_sc_hd__mux2_1
X_8352_ rf.registers\[20\]\[25\] net31 _4117_ VGND VGND VPWR VPWR _4123_ sky130_fd_sc_hd__mux2_1
XFILLER_0_26_561 VPWR VGND VPWR VGND sky130_ef_sc_hd__decap_12
X_7303_ _3566_ VGND VGND VPWR VPWR _0077_ sky130_fd_sc_hd__clkbuf_1
X_4515_ _1154_ VGND VGND VPWR VPWR _1298_ sky130_fd_sc_hd__buf_4
XFILLER_0_14_734 VGND VGND VPWR VPWR sky130_fd_sc_hd__fill_2
XPHY_EDGE_ROW_103_Right_103 VGND VGND VPWR VPWR sky130_fd_sc_hd__decap_3
X_8283_ _4086_ VGND VGND VPWR VPWR _0537_ sky130_fd_sc_hd__clkbuf_1
X_5495_ _2211_ _2225_ VGND VGND VPWR VPWR _2226_ sky130_fd_sc_hd__or2_1
X_4446_ _1231_ _1232_ _1133_ VGND VGND VPWR VPWR _1233_ sky130_fd_sc_hd__mux2_1
X_7234_ rf.registers\[19\]\[12\] _3303_ _3527_ VGND VGND VPWR VPWR _3530_ sky130_fd_sc_hd__mux2_1
X_7165_ _3493_ VGND VGND VPWR VPWR _0012_ sky130_fd_sc_hd__clkbuf_1
X_4377_ _1165_ _1166_ _1163_ VGND VGND VPWR VPWR _1167_ sky130_fd_sc_hd__mux2_1
X_6116_ _2821_ _2823_ net64 VGND VGND VPWR VPWR _2824_ sky130_fd_sc_hd__a21o_1
X_7096_ rf.registers\[5\]\[11\] _3301_ _3455_ VGND VGND VPWR VPWR _3457_ sky130_fd_sc_hd__mux2_1
XPHY_EDGE_ROW_13_Left_152 VGND VGND VPWR VPWR sky130_fd_sc_hd__decap_3
X_6047_ net59 _2758_ VGND VGND VPWR VPWR _2759_ sky130_fd_sc_hd__xnor2_1
XTAP_TAPCELL_ROW_68_1321 VGND VPWR sky130_fd_sc_hd__tapvpwrvgnd_1
XTAP_TAPCELL_ROW_1_310 VGND VPWR sky130_fd_sc_hd__tapvpwrvgnd_1
XTAP_TAPCELL_ROW_1_321 VGND VPWR sky130_fd_sc_hd__tapvpwrvgnd_1
XTAP_TAPCELL_ROW_29_729 VGND VPWR sky130_fd_sc_hd__tapvpwrvgnd_1
XFILLER_0_96_737 VPWR VGND VPWR VGND sky130_ef_sc_hd__decap_12
XFILLER_0_138_305 VGND VGND VPWR VPWR sky130_fd_sc_hd__decap_3
XTAP_TAPCELL_ROW_81_1510 VGND VPWR sky130_fd_sc_hd__tapvpwrvgnd_1
X_7998_ _3935_ VGND VGND VPWR VPWR _0403_ sky130_fd_sc_hd__clkbuf_1
XFILLER_0_49_642 VGND VGND VPWR VPWR sky130_fd_sc_hd__decap_6
XFILLER_0_138_349 VPWR VGND VPWR VGND sky130_ef_sc_hd__decap_12
X_6949_ _3372_ rf.registers\[15\]\[12\] _3368_ VGND VGND VPWR VPWR _3373_ sky130_fd_sc_hd__mux2_1
XTAP_TAPCELL_ROW_81_1521 VGND VPWR sky130_fd_sc_hd__tapvpwrvgnd_1
XFILLER_0_64_601 VGND VGND VPWR VPWR sky130_fd_sc_hd__decap_4
XFILLER_0_48_152 VGND VGND VPWR VPWR sky130_fd_sc_hd__fill_1
XFILLER_0_64_645 VPWR VGND VPWR VGND sky130_ef_sc_hd__decap_12
XFILLER_0_64_634 VGND VGND VPWR VPWR sky130_fd_sc_hd__fill_1
XPHY_EDGE_ROW_22_Left_161 VGND VGND VPWR VPWR sky130_fd_sc_hd__decap_3
XTAP_TAPCELL_ROW_40_905 VGND VPWR sky130_fd_sc_hd__tapvpwrvgnd_1
XFILLER_0_48_174 VGND VGND VPWR VPWR sky130_fd_sc_hd__decap_4
XFILLER_0_134_522 VGND VGND VPWR VPWR sky130_fd_sc_hd__fill_1
X_8619_ clknet_leaf_69_CLK _0731_ VGND VGND VPWR VPWR rf.registers\[11\]\[26\] sky130_fd_sc_hd__dfxtp_1
XFILLER_0_91_497 VGND VGND VPWR VPWR sky130_fd_sc_hd__decap_4
XFILLER_0_121_205 VPWR VGND VPWR VGND sky130_ef_sc_hd__decap_12
XFILLER_0_121_249 VPWR VGND VPWR VGND sky130_ef_sc_hd__decap_12
XTAP_TAPCELL_ROW_79_1483 VGND VPWR sky130_fd_sc_hd__tapvpwrvgnd_1
XTAP_TAPCELL_ROW_9_432 VGND VPWR sky130_fd_sc_hd__tapvpwrvgnd_1
XFILLER_0_102_474 VGND VGND VPWR VPWR sky130_fd_sc_hd__fill_2
XTAP_TAPCELL_ROW_92_1683 VGND VPWR sky130_fd_sc_hd__tapvpwrvgnd_1
XPHY_EDGE_ROW_31_Left_170 VGND VGND VPWR VPWR sky130_fd_sc_hd__decap_3
XFILLER_0_129_305 VPWR VGND VPWR VGND sky130_ef_sc_hd__decap_12
XFILLER_0_86_236 VPWR VGND VPWR VGND sky130_ef_sc_hd__decap_12
XFILLER_0_86_225 VGND VGND VPWR VPWR sky130_fd_sc_hd__fill_2
XFILLER_0_129_349 VPWR VGND VPWR VGND sky130_ef_sc_hd__decap_12
XFILLER_0_74_409 VGND VGND VPWR VPWR sky130_fd_sc_hd__fill_2
Xclkbuf_leaf_2_CLK clknet_3_0__leaf_CLK VGND VGND VPWR VPWR clknet_leaf_2_CLK sky130_fd_sc_hd__clkbuf_8
XFILLER_0_138_7 VPWR VGND VPWR VGND sky130_ef_sc_hd__decap_12
XFILLER_0_28_837 VGND VGND VPWR VPWR sky130_fd_sc_hd__fill_2
XFILLER_0_54_122 VGND VGND VPWR VPWR sky130_fd_sc_hd__fill_1
XFILLER_0_27_358 VGND VGND VPWR VPWR sky130_fd_sc_hd__decap_4
XFILLER_0_137_393 VPWR VGND VPWR VGND sky130_ef_sc_hd__decap_12
X_4300_ _1091_ _1092_ _1030_ VGND VGND VPWR VPWR _1093_ sky130_fd_sc_hd__mux2_1
X_5280_ _2020_ _2021_ _1943_ VGND VGND VPWR VPWR _2022_ sky130_fd_sc_hd__mux2_1
XFILLER_0_2_469 VGND VGND VPWR VPWR sky130_fd_sc_hd__decap_6
X_4231_ A2[0] VGND VGND VPWR VPWR _1026_ sky130_fd_sc_hd__buf_4
XFILLER_0_121_783 VGND VGND VPWR VPWR sky130_fd_sc_hd__fill_1
X_8970_ clknet_leaf_85_CLK _0058_ VGND VGND VPWR VPWR rf.registers\[19\]\[25\] sky130_fd_sc_hd__dfxtp_1
X_7921_ _3376_ rf.registers\[23\]\[14\] _3890_ VGND VGND VPWR VPWR _3895_ sky130_fd_sc_hd__mux2_1
XTAP_TAPCELL_ROW_108_1922 VGND VPWR sky130_fd_sc_hd__tapvpwrvgnd_1
XFILLER_0_78_737 VPWR VGND VPWR VGND sky130_ef_sc_hd__decap_12
XFILLER_0_77_203 VGND VGND VPWR VPWR sky130_fd_sc_hd__decap_4
X_7852_ _3376_ rf.registers\[28\]\[14\] _3853_ VGND VGND VPWR VPWR _3858_ sky130_fd_sc_hd__mux2_1
XFILLER_0_81_53 VGND VGND VPWR VPWR sky130_fd_sc_hd__decap_3
X_7783_ _3821_ VGND VGND VPWR VPWR _0302_ sky130_fd_sc_hd__clkbuf_1
XFILLER_0_93_729 VPWR VGND VPWR VGND sky130_ef_sc_hd__decap_12
X_4995_ rf.registers\[0\]\[5\] rf.registers\[1\]\[5\] rf.registers\[2\]\[5\] rf.registers\[3\]\[5\]
+ _1749_ _1750_ VGND VGND VPWR VPWR _1753_ sky130_fd_sc_hd__mux4_1
X_6803_ _3273_ VGND VGND VPWR VPWR _0894_ sky130_fd_sc_hd__clkbuf_1
X_9522_ clknet_leaf_46_CLK _0610_ VGND VGND VPWR VPWR rf.registers\[14\]\[1\] sky130_fd_sc_hd__dfxtp_1
XFILLER_0_86_781 VPWR VGND VPWR VGND sky130_ef_sc_hd__decap_12
XTAP_TAPCELL_ROW_63_1251 VGND VPWR sky130_fd_sc_hd__tapvpwrvgnd_1
XTAP_TAPCELL_ROW_63_1240 VGND VPWR sky130_fd_sc_hd__tapvpwrvgnd_1
X_6734_ rf.registers\[10\]\[29\] _3047_ _3227_ VGND VGND VPWR VPWR _3237_ sky130_fd_sc_hd__mux2_1
XFILLER_0_45_111 VGND VGND VPWR VPWR sky130_fd_sc_hd__fill_1
X_9453_ clknet_leaf_0_CLK _0541_ VGND VGND VPWR VPWR rf.registers\[25\]\[28\] sky130_fd_sc_hd__dfxtp_1
XFILLER_0_46_656 VGND VGND VPWR VPWR sky130_fd_sc_hd__fill_1
XFILLER_0_46_667 VGND VGND VPWR VPWR sky130_fd_sc_hd__fill_1
XFILLER_0_90_3 VPWR VGND VPWR VGND sky130_ef_sc_hd__decap_12
X_8404_ _4150_ VGND VGND VPWR VPWR _0594_ sky130_fd_sc_hd__clkbuf_1
XFILLER_0_60_114 VGND VGND VPWR VPWR sky130_fd_sc_hd__fill_2
X_6665_ rf.registers\[24\]\[29\] _3047_ _3190_ VGND VGND VPWR VPWR _3200_ sky130_fd_sc_hd__mux2_1
XFILLER_0_131_503 VGND VGND VPWR VPWR sky130_fd_sc_hd__fill_1
XFILLER_0_121_81 VPWR VGND VPWR VGND sky130_ef_sc_hd__decap_12
X_9384_ clknet_leaf_2_CLK _0472_ VGND VGND VPWR VPWR rf.registers\[26\]\[23\] sky130_fd_sc_hd__dfxtp_1
XFILLER_0_14_531 VGND VGND VPWR VPWR sky130_fd_sc_hd__fill_1
X_6596_ rf.registers\[1\]\[29\] _3047_ _3153_ VGND VGND VPWR VPWR _3163_ sky130_fd_sc_hd__mux2_1
X_5616_ _2220_ _2247_ VGND VGND VPWR VPWR _2346_ sky130_fd_sc_hd__nand2_1
X_8335_ rf.registers\[20\]\[17\] net22 _4106_ VGND VGND VPWR VPWR _4114_ sky130_fd_sc_hd__mux2_1
XFILLER_0_14_553 VGND VGND VPWR VPWR sky130_fd_sc_hd__decap_3
X_5547_ _2084_ _2218_ VGND VGND VPWR VPWR _2278_ sky130_fd_sc_hd__nor2_1
X_8266_ _4077_ VGND VGND VPWR VPWR _0529_ sky130_fd_sc_hd__clkbuf_1
X_5478_ _1056_ VGND VGND VPWR VPWR _2209_ sky130_fd_sc_hd__buf_2
XFILLER_0_111_260 VGND VGND VPWR VPWR sky130_fd_sc_hd__decap_6
X_7217_ rf.registers\[19\]\[4\] _3286_ _3516_ VGND VGND VPWR VPWR _3521_ sky130_fd_sc_hd__mux2_1
X_4429_ rf.registers\[4\]\[7\] rf.registers\[5\]\[7\] rf.registers\[6\]\[7\] rf.registers\[7\]\[7\]
+ _1172_ _1173_ VGND VGND VPWR VPWR _1217_ sky130_fd_sc_hd__mux4_1
X_8197_ _3380_ rf.registers\[21\]\[16\] _4034_ VGND VGND VPWR VPWR _4041_ sky130_fd_sc_hd__mux2_1
XFILLER_0_10_781 VPWR VGND VPWR VGND sky130_ef_sc_hd__decap_12
X_7148_ _3484_ VGND VGND VPWR VPWR _0004_ sky130_fd_sc_hd__clkbuf_1
X_7079_ rf.registers\[5\]\[3\] _3284_ _3444_ VGND VGND VPWR VPWR _3448_ sky130_fd_sc_hd__mux2_1
XFILLER_0_138_113 VPWR VGND VPWR VGND sky130_ef_sc_hd__decap_12
XFILLER_0_127_809 VPWR VGND VPWR VGND sky130_ef_sc_hd__decap_12
XFILLER_0_37_612 VGND VGND VPWR VPWR sky130_fd_sc_hd__decap_4
XFILLER_0_25_818 VPWR VGND VPWR VGND sky130_ef_sc_hd__decap_12
XFILLER_0_64_486 VGND VGND VPWR VPWR sky130_fd_sc_hd__fill_1
XFILLER_0_134_363 VGND VGND VPWR VPWR sky130_fd_sc_hd__fill_1
XFILLER_0_51_136 VGND VGND VPWR VPWR sky130_fd_sc_hd__decap_6
XFILLER_0_10_27 VGND VGND VPWR VPWR sky130_fd_sc_hd__fill_1
XTAP_TAPCELL_ROW_94_1712 VGND VPWR sky130_fd_sc_hd__tapvpwrvgnd_1
XFILLER_0_51_169 VPWR VGND VPWR VGND sky130_ef_sc_hd__decap_12
XFILLER_0_60_681 VPWR VGND VPWR VGND sky130_ef_sc_hd__decap_12
XFILLER_0_103_783 VGND VGND VPWR VPWR sky130_fd_sc_hd__fill_1
XFILLER_0_20_589 VPWR VGND VPWR VGND sky130_ef_sc_hd__decap_12
XFILLER_0_19_69 VPWR VGND VPWR VGND sky130_ef_sc_hd__decap_12
XFILLER_0_126_15 VPWR VGND VPWR VGND sky130_ef_sc_hd__decap_12
XTAP_TAPCELL_ROW_121_2108 VGND VPWR sky130_fd_sc_hd__tapvpwrvgnd_1
XFILLER_0_35_57 VGND VGND VPWR VPWR sky130_fd_sc_hd__fill_2
XTAP_TAPCELL_ROW_121_2119 VGND VPWR sky130_fd_sc_hd__tapvpwrvgnd_1
XFILLER_0_129_113 VPWR VGND VPWR VGND sky130_ef_sc_hd__decap_12
XFILLER_0_75_729 VPWR VGND VPWR VGND sky130_ef_sc_hd__decap_12
XFILLER_0_59_258 VGND VGND VPWR VPWR sky130_fd_sc_hd__fill_2
XTAP_TAPCELL_ROW_103_1852 VGND VPWR sky130_fd_sc_hd__tapvpwrvgnd_1
XTAP_TAPCELL_ROW_103_1841 VGND VPWR sky130_fd_sc_hd__tapvpwrvgnd_1
XFILLER_0_68_781 VPWR VGND VPWR VGND sky130_ef_sc_hd__decap_12
X_4780_ rf.registers\[0\]\[27\] rf.registers\[1\]\[27\] rf.registers\[2\]\[27\] rf.registers\[3\]\[27\]
+ _1302_ _1303_ VGND VGND VPWR VPWR _1548_ sky130_fd_sc_hd__mux4_1
XFILLER_0_129_3 VPWR VGND VPWR VGND sky130_ef_sc_hd__decap_12
XFILLER_0_7_517 VPWR VGND VPWR VGND sky130_ef_sc_hd__decap_12
XFILLER_0_15_317 VPWR VGND VPWR VGND sky130_ef_sc_hd__decap_12
XTAP_TAPCELL_ROW_31_768 VGND VPWR sky130_fd_sc_hd__tapvpwrvgnd_1
XFILLER_0_43_615 VGND VGND VPWR VPWR sky130_fd_sc_hd__fill_1
XTAP_TAPCELL_ROW_136_2340 VGND VPWR sky130_fd_sc_hd__tapvpwrvgnd_1
XFILLER_0_55_497 VGND VGND VPWR VPWR sky130_fd_sc_hd__decap_3
X_6450_ _3084_ VGND VGND VPWR VPWR _0730_ sky130_fd_sc_hd__clkbuf_1
Xclkload10 clknet_leaf_82_CLK VGND VGND VPWR VPWR clkload10/Y sky130_fd_sc_hd__bufinv_16
Xclkload43 clknet_leaf_13_CLK VGND VGND VPWR VPWR clkload43/Y sky130_fd_sc_hd__clkinv_4
Xclkload21 clknet_leaf_6_CLK VGND VGND VPWR VPWR clkload21/Y sky130_fd_sc_hd__bufinv_16
XTAP_TAPCELL_ROW_11_470 VGND VPWR sky130_fd_sc_hd__tapvpwrvgnd_1
X_6381_ net34 VGND VGND VPWR VPWR _3045_ sky130_fd_sc_hd__buf_2
X_5401_ _2134_ _2135_ _1955_ VGND VGND VPWR VPWR _2136_ sky130_fd_sc_hd__mux2_1
Xclkload32 clknet_leaf_67_CLK VGND VGND VPWR VPWR clkload32/Y sky130_fd_sc_hd__bufinv_16
XFILLER_0_42_147 VGND VGND VPWR VPWR sky130_fd_sc_hd__fill_1
Xclkload87 clknet_leaf_43_CLK VGND VGND VPWR VPWR clkload87/Y sky130_fd_sc_hd__clkinv_1
Xclkload65 clknet_leaf_26_CLK VGND VGND VPWR VPWR clkload65/Y sky130_fd_sc_hd__bufinv_16
XFILLER_0_113_558 VGND VGND VPWR VPWR sky130_fd_sc_hd__fill_2
X_8120_ _4000_ VGND VGND VPWR VPWR _0460_ sky130_fd_sc_hd__clkbuf_1
XFILLER_0_101_709 VPWR VGND VPWR VGND sky130_ef_sc_hd__decap_12
Xclkload54 clknet_leaf_17_CLK VGND VGND VPWR VPWR clkload54/Y sky130_fd_sc_hd__inv_8
Xclkload76 clknet_leaf_53_CLK VGND VGND VPWR VPWR clkload76/Y sky130_fd_sc_hd__bufinv_16
XFILLER_0_2_233 VPWR VGND VPWR VGND sky130_ef_sc_hd__decap_12
X_5332_ _2009_ VGND VGND VPWR VPWR _2071_ sky130_fd_sc_hd__clkbuf_4
XFILLER_0_2_277 VPWR VGND VPWR VGND sky130_ef_sc_hd__decap_12
X_8051_ rf.registers\[7\]\[11\] _3301_ _3962_ VGND VGND VPWR VPWR _3964_ sky130_fd_sc_hd__mux2_1
X_5263_ rf.registers\[4\]\[20\] rf.registers\[5\]\[20\] rf.registers\[6\]\[20\] rf.registers\[7\]\[20\]
+ _1919_ _1920_ VGND VGND VPWR VPWR _2006_ sky130_fd_sc_hd__mux4_1
X_7002_ net13 net12 net11 VGND VGND VPWR VPWR _3406_ sky130_fd_sc_hd__or3b_4
X_5194_ _1728_ VGND VGND VPWR VPWR _1940_ sky130_fd_sc_hd__clkbuf_8
X_8953_ clknet_leaf_36_CLK _0041_ VGND VGND VPWR VPWR rf.registers\[19\]\[8\] sky130_fd_sc_hd__dfxtp_1
XFILLER_0_92_41 VGND VGND VPWR VPWR sky130_fd_sc_hd__decap_8
X_8884_ clknet_leaf_47_CLK _0996_ VGND VGND VPWR VPWR rf.registers\[5\]\[3\] sky130_fd_sc_hd__dfxtp_1
XFILLER_0_92_85 VGND VGND VPWR VPWR sky130_fd_sc_hd__fill_2
X_7904_ _3359_ rf.registers\[23\]\[6\] _3879_ VGND VGND VPWR VPWR _3886_ sky130_fd_sc_hd__mux2_1
XTAP_TAPCELL_ROW_39_879 VGND VPWR sky130_fd_sc_hd__tapvpwrvgnd_1
X_7835_ _3359_ rf.registers\[28\]\[6\] _3842_ VGND VGND VPWR VPWR _3849_ sky130_fd_sc_hd__mux2_1
XFILLER_0_78_589 VGND VGND VPWR VPWR sky130_fd_sc_hd__fill_2
XTAP_TAPCELL_ROW_19_581 VGND VPWR sky130_fd_sc_hd__tapvpwrvgnd_1
XTAP_TAPCELL_ROW_19_592 VGND VPWR sky130_fd_sc_hd__tapvpwrvgnd_1
XFILLER_0_109_809 VPWR VGND VPWR VGND sky130_ef_sc_hd__decap_12
XFILLER_0_65_228 VGND VGND VPWR VPWR sky130_fd_sc_hd__fill_2
XFILLER_0_19_612 VGND VGND VPWR VPWR sky130_fd_sc_hd__decap_4
XFILLER_0_135_105 VGND VGND VPWR VPWR sky130_fd_sc_hd__decap_6
X_4978_ _1653_ VGND VGND VPWR VPWR _1736_ sky130_fd_sc_hd__clkbuf_4
X_9505_ clknet_leaf_20_CLK _0593_ VGND VGND VPWR VPWR rf.registers\[18\]\[16\] sky130_fd_sc_hd__dfxtp_1
X_7766_ _3812_ VGND VGND VPWR VPWR _0294_ sky130_fd_sc_hd__clkbuf_1
XFILLER_0_18_133 VGND VGND VPWR VPWR sky130_fd_sc_hd__decap_6
XFILLER_0_135_149 VPWR VGND VPWR VGND sky130_ef_sc_hd__decap_12
Xclkload4 clknet_3_4__leaf_CLK VGND VGND VPWR VPWR clkload4/Y sky130_fd_sc_hd__clkinv_8
X_7697_ _3357_ rf.registers\[30\]\[5\] _3770_ VGND VGND VPWR VPWR _3776_ sky130_fd_sc_hd__mux2_1
X_6717_ _3228_ VGND VGND VPWR VPWR _0853_ sky130_fd_sc_hd__clkbuf_1
XFILLER_0_34_604 VPWR VGND VPWR VGND sky130_ef_sc_hd__decap_12
X_9436_ clknet_leaf_26_CLK _0524_ VGND VGND VPWR VPWR rf.registers\[25\]\[11\] sky130_fd_sc_hd__dfxtp_1
X_6648_ _3191_ VGND VGND VPWR VPWR _0821_ sky130_fd_sc_hd__clkbuf_1
X_9367_ clknet_leaf_58_CLK _0455_ VGND VGND VPWR VPWR rf.registers\[26\]\[6\] sky130_fd_sc_hd__dfxtp_1
X_8318_ rf.registers\[20\]\[9\] net45 _4095_ VGND VGND VPWR VPWR _4105_ sky130_fd_sc_hd__mux2_1
XTAP_TAPCELL_ROW_76_1442 VGND VPWR sky130_fd_sc_hd__tapvpwrvgnd_1
XFILLER_0_30_810 VGND VGND VPWR VPWR sky130_fd_sc_hd__fill_2
X_6579_ _3154_ VGND VGND VPWR VPWR _0789_ sky130_fd_sc_hd__clkbuf_1
XFILLER_0_42_692 VGND VGND VPWR VPWR sky130_fd_sc_hd__decap_8
X_9298_ clknet_leaf_43_CLK _0386_ VGND VGND VPWR VPWR rf.registers\[22\]\[1\] sky130_fd_sc_hd__dfxtp_1
XFILLER_0_41_191 VGND VGND VPWR VPWR sky130_fd_sc_hd__decap_4
X_8249_ _4068_ VGND VGND VPWR VPWR _0521_ sky130_fd_sc_hd__clkbuf_1
XFILLER_0_97_821 VPWR VGND VPWR VGND sky130_ef_sc_hd__decap_12
XFILLER_0_57_729 VPWR VGND VPWR VGND sky130_ef_sc_hd__decap_12
XFILLER_0_29_409 VGND VGND VPWR VPWR sky130_fd_sc_hd__fill_1
XFILLER_0_37_420 VGND VGND VPWR VPWR sky130_fd_sc_hd__decap_4
XFILLER_0_21_15 VPWR VGND VPWR VGND sky130_ef_sc_hd__decap_12
XFILLER_0_25_615 VGND VGND VPWR VPWR sky130_fd_sc_hd__fill_1
XFILLER_0_115_9 VPWR VGND VPWR VGND sky130_ef_sc_hd__decap_12
XFILLER_0_92_581 VGND VGND VPWR VPWR sky130_fd_sc_hd__decap_6
XFILLER_0_64_272 VGND VGND VPWR VPWR sky130_fd_sc_hd__fill_1
XTAP_TAPCELL_ROW_118_2070 VGND VPWR sky130_fd_sc_hd__tapvpwrvgnd_1
XFILLER_0_12_309 VPWR VGND VPWR VGND sky130_ef_sc_hd__decap_12
XFILLER_0_122_333 VPWR VGND VPWR VGND sky130_ef_sc_hd__decap_12
XFILLER_0_21_821 VPWR VGND VPWR VGND sky130_ef_sc_hd__decap_12
XFILLER_0_122_377 VGND VGND VPWR VPWR sky130_fd_sc_hd__decap_8
XFILLER_0_20_320 VGND VGND VPWR VPWR sky130_fd_sc_hd__fill_2
XTAP_TAPCELL_ROW_131_2270 VGND VPWR sky130_fd_sc_hd__tapvpwrvgnd_1
XFILLER_0_0_748 VGND VGND VPWR VPWR sky130_fd_sc_hd__decap_8
XFILLER_0_137_69 VPWR VGND VPWR VGND sky130_ef_sc_hd__decap_12
XFILLER_0_46_45 VGND VGND VPWR VPWR sky130_fd_sc_hd__fill_1
XFILLER_0_87_331 VGND VGND VPWR VPWR sky130_fd_sc_hd__fill_1
X_5950_ _1309_ _2646_ _2389_ VGND VGND VPWR VPWR _2668_ sky130_fd_sc_hd__a21oi_1
X_4901_ _1621_ VGND VGND VPWR VPWR _1663_ sky130_fd_sc_hd__clkbuf_8
XFILLER_0_1_69 VPWR VGND VPWR VGND sky130_ef_sc_hd__decap_12
XTAP_TAPCELL_ROW_36_838 VGND VPWR sky130_fd_sc_hd__tapvpwrvgnd_1
XTAP_TAPCELL_ROW_47_1010 VGND VPWR sky130_fd_sc_hd__tapvpwrvgnd_1
X_7620_ rf.registers\[2\]\[1\] _3280_ _3733_ VGND VGND VPWR VPWR _3735_ sky130_fd_sc_hd__mux2_1
XTAP_TAPCELL_ROW_16_540 VGND VPWR sky130_fd_sc_hd__tapvpwrvgnd_1
X_5881_ _2209_ _2228_ _2245_ VGND VGND VPWR VPWR _2602_ sky130_fd_sc_hd__o21ai_1
XFILLER_0_117_105 VGND VGND VPWR VPWR sky130_fd_sc_hd__decap_6
XFILLER_0_75_559 VGND VGND VPWR VPWR sky130_fd_sc_hd__fill_1
X_4832_ _1595_ _1596_ _1137_ VGND VGND VPWR VPWR _1597_ sky130_fd_sc_hd__mux2_1
XFILLER_0_8_837 VGND VGND VPWR VPWR sky130_fd_sc_hd__fill_2
X_7551_ _3698_ VGND VGND VPWR VPWR _0193_ sky130_fd_sc_hd__clkbuf_1
XFILLER_0_117_149 VPWR VGND VPWR VGND sky130_ef_sc_hd__decap_12
XFILLER_0_83_570 VGND VGND VPWR VPWR sky130_fd_sc_hd__decap_4
XFILLER_0_55_250 VGND VGND VPWR VPWR sky130_fd_sc_hd__fill_2
XFILLER_0_16_626 VGND VGND VPWR VPWR sky130_fd_sc_hd__decap_3
X_4763_ _1530_ _1531_ _1133_ VGND VGND VPWR VPWR _1532_ sky130_fd_sc_hd__mux2_1
X_7482_ _3344_ rf.registers\[31\]\[0\] _3661_ VGND VGND VPWR VPWR _3662_ sky130_fd_sc_hd__mux2_1
X_6502_ rf.registers\[17\]\[17\] _3022_ _3105_ VGND VGND VPWR VPWR _3113_ sky130_fd_sc_hd__mux2_1
XFILLER_0_55_272 VGND VGND VPWR VPWR sky130_fd_sc_hd__decap_8
XFILLER_0_15_125 VPWR VGND VPWR VGND sky130_ef_sc_hd__decap_12
X_4694_ _1463_ _1464_ _1465_ _1466_ _1381_ _1301_ VGND VGND VPWR VPWR _1467_ sky130_fd_sc_hd__mux4_1
XFILLER_0_71_765 VPWR VGND VPWR VGND sky130_ef_sc_hd__decap_12
X_6433_ _3075_ VGND VGND VPWR VPWR _0722_ sky130_fd_sc_hd__clkbuf_1
XFILLER_0_15_169 VPWR VGND VPWR VGND sky130_ef_sc_hd__decap_12
X_9221_ clknet_leaf_81_CLK _0309_ VGND VGND VPWR VPWR rf.registers\[9\]\[20\] sky130_fd_sc_hd__dfxtp_1
XFILLER_0_125_193 VPWR VGND VPWR VGND sky130_ef_sc_hd__decap_12
XFILLER_0_11_81 VPWR VGND VPWR VGND sky130_ef_sc_hd__decap_12
XFILLER_0_3_553 VGND VGND VPWR VPWR sky130_fd_sc_hd__decap_6
XFILLER_0_31_629 VGND VGND VPWR VPWR sky130_fd_sc_hd__decap_6
X_9152_ clknet_leaf_16_CLK _0240_ VGND VGND VPWR VPWR rf.registers\[2\]\[15\] sky130_fd_sc_hd__dfxtp_1
X_6364_ rf.registers\[12\]\[22\] _3033_ _3029_ VGND VGND VPWR VPWR _3034_ sky130_fd_sc_hd__mux2_1
XFILLER_0_3_597 VPWR VGND VPWR VGND sky130_ef_sc_hd__decap_12
X_8103_ _3991_ VGND VGND VPWR VPWR _0452_ sky130_fd_sc_hd__clkbuf_1
X_9083_ clknet_leaf_26_CLK _0171_ VGND VGND VPWR VPWR rf.registers\[31\]\[10\] sky130_fd_sc_hd__dfxtp_1
X_6295_ _2986_ VGND VGND VPWR VPWR _2987_ sky130_fd_sc_hd__clkbuf_8
XTAP_TAPCELL_ROW_58_1172 VGND VPWR sky130_fd_sc_hd__tapvpwrvgnd_1
X_5315_ rf.registers\[8\]\[23\] rf.registers\[9\]\[23\] rf.registers\[10\]\[23\] rf.registers\[11\]\[23\]
+ _1735_ _1737_ VGND VGND VPWR VPWR _2055_ sky130_fd_sc_hd__mux4_1
X_8034_ rf.registers\[7\]\[3\] _3284_ _3951_ VGND VGND VPWR VPWR _3955_ sky130_fd_sc_hd__mux2_1
X_5246_ rf.registers\[4\]\[19\] rf.registers\[5\]\[19\] rf.registers\[6\]\[19\] rf.registers\[7\]\[19\]
+ _1772_ _1773_ VGND VGND VPWR VPWR _1990_ sky130_fd_sc_hd__mux4_1
XFILLER_0_53_3 VPWR VGND VPWR VGND sky130_ef_sc_hd__decap_12
XPHY_EDGE_ROW_89_Right_89 VGND VGND VPWR VPWR sky130_fd_sc_hd__decap_3
XTAP_TAPCELL_ROW_71_1372 VGND VPWR sky130_fd_sc_hd__tapvpwrvgnd_1
XTAP_TAPCELL_ROW_71_1361 VGND VPWR sky130_fd_sc_hd__tapvpwrvgnd_1
X_5177_ rf.registers\[28\]\[16\] rf.registers\[29\]\[16\] rf.registers\[30\]\[16\]
+ rf.registers\[31\]\[16\] _1922_ _1923_ VGND VGND VPWR VPWR _1924_ sky130_fd_sc_hd__mux4_1
XFILLER_0_79_821 VPWR VGND VPWR VGND sky130_ef_sc_hd__decap_12
X_8936_ clknet_leaf_82_CLK _0024_ VGND VGND VPWR VPWR rf.registers\[4\]\[23\] sky130_fd_sc_hd__dfxtp_1
XFILLER_0_94_813 VPWR VGND VPWR VGND sky130_ef_sc_hd__decap_12
XFILLER_0_93_312 VGND VGND VPWR VPWR sky130_fd_sc_hd__fill_1
XFILLER_0_78_386 VPWR VGND VPWR VGND sky130_ef_sc_hd__decap_12
X_8867_ clknet_leaf_6_CLK _0979_ VGND VGND VPWR VPWR rf.registers\[6\]\[18\] sky130_fd_sc_hd__dfxtp_1
XFILLER_0_39_729 VGND VGND VPWR VPWR sky130_fd_sc_hd__decap_6
X_8798_ clknet_leaf_29_CLK _0910_ VGND VGND VPWR VPWR rf.registers\[16\]\[13\] sky130_fd_sc_hd__dfxtp_1
XPHY_EDGE_ROW_98_Right_98 VGND VGND VPWR VPWR sky130_fd_sc_hd__decap_3
XFILLER_0_93_356 VGND VGND VPWR VPWR sky130_fd_sc_hd__fill_1
XFILLER_0_93_345 VGND VGND VPWR VPWR sky130_fd_sc_hd__fill_2
X_7818_ _3839_ VGND VGND VPWR VPWR _0319_ sky130_fd_sc_hd__clkbuf_1
X_7749_ _2978_ rf.registers\[30\]\[30\] _3769_ VGND VGND VPWR VPWR _3803_ sky130_fd_sc_hd__mux2_1
XFILLER_0_136_469 VGND VGND VPWR VPWR sky130_fd_sc_hd__decap_6
XFILLER_0_46_294 VPWR VGND VPWR VGND sky130_ef_sc_hd__decap_12
XFILLER_0_104_300 VGND VGND VPWR VPWR sky130_fd_sc_hd__fill_1
XFILLER_0_61_253 VGND VGND VPWR VPWR sky130_fd_sc_hd__fill_2
X_9419_ clknet_leaf_70_CLK _0507_ VGND VGND VPWR VPWR rf.registers\[21\]\[26\] sky130_fd_sc_hd__dfxtp_1
XFILLER_0_104_355 VGND VGND VPWR VPWR sky130_fd_sc_hd__decap_6
XFILLER_0_120_837 VGND VGND VPWR VPWR sky130_fd_sc_hd__fill_2
XPHY_EDGE_ROW_5_Left_144 VGND VGND VPWR VPWR sky130_fd_sc_hd__decap_3
XTAP_TAPCELL_ROW_89_1633 VGND VPWR sky130_fd_sc_hd__tapvpwrvgnd_1
XFILLER_0_88_106 VGND VGND VPWR VPWR sky130_fd_sc_hd__fill_1
XFILLER_0_16_15 VPWR VGND VPWR VGND sky130_ef_sc_hd__decap_12
XFILLER_0_69_331 VGND VGND VPWR VPWR sky130_fd_sc_hd__decap_4
XFILLER_0_97_673 VPWR VGND VPWR VGND sky130_ef_sc_hd__decap_12
XTAP_TAPCELL_ROW_100_1800 VGND VPWR sky130_fd_sc_hd__tapvpwrvgnd_1
XFILLER_0_53_710 VGND VGND VPWR VPWR sky130_fd_sc_hd__fill_1
XFILLER_0_108_661 VPWR VGND VPWR VGND sky130_ef_sc_hd__decap_12
XFILLER_0_123_620 VGND VGND VPWR VPWR sky130_fd_sc_hd__fill_1
XFILLER_0_53_765 VPWR VGND VPWR VGND sky130_ef_sc_hd__decap_12
XFILLER_0_123_664 VGND VGND VPWR VPWR sky130_fd_sc_hd__decap_8
XFILLER_0_107_193 VGND VGND VPWR VPWR sky130_fd_sc_hd__fill_2
XFILLER_0_123_697 VPWR VGND VPWR VGND sky130_ef_sc_hd__decap_12
XFILLER_0_122_141 VPWR VGND VPWR VGND sky130_ef_sc_hd__decap_12
XFILLER_0_12_139 VGND VGND VPWR VPWR sky130_fd_sc_hd__fill_1
XFILLER_0_0_501 VGND VGND VPWR VPWR sky130_fd_sc_hd__decap_3
X_5100_ rf.registers\[4\]\[11\] rf.registers\[5\]\[11\] rf.registers\[6\]\[11\] rf.registers\[7\]\[11\]
+ _1816_ _1817_ VGND VGND VPWR VPWR _1852_ sky130_fd_sc_hd__mux4_1
XFILLER_0_0_589 VGND VGND VPWR VPWR sky130_fd_sc_hd__decap_8
X_6080_ _2787_ _2789_ VGND VGND VPWR VPWR _2790_ sky130_fd_sc_hd__xnor2_1
XTAP_TAPCELL_ROW_111_1962 VGND VPWR sky130_fd_sc_hd__tapvpwrvgnd_1
X_5031_ rf.registers\[12\]\[7\] rf.registers\[13\]\[7\] rf.registers\[14\]\[7\] rf.registers\[15\]\[7\]
+ _1703_ _1704_ VGND VGND VPWR VPWR _1787_ sky130_fd_sc_hd__mux4_1
XFILLER_0_57_77 VGND VGND VPWR VPWR sky130_fd_sc_hd__fill_1
XFILLER_0_57_55 VGND VGND VPWR VPWR sky130_fd_sc_hd__fill_1
XFILLER_0_57_99 VGND VGND VPWR VPWR sky130_fd_sc_hd__decap_8
XTAP_TAPCELL_ROW_53_1091 VGND VPWR sky130_fd_sc_hd__tapvpwrvgnd_1
XFILLER_0_73_43 VGND VGND VPWR VPWR sky130_fd_sc_hd__decap_3
X_8721_ clknet_leaf_40_CLK _0833_ VGND VGND VPWR VPWR rf.registers\[10\]\[0\] sky130_fd_sc_hd__dfxtp_1
X_6982_ net29 VGND VGND VPWR VPWR _3395_ sky130_fd_sc_hd__clkbuf_2
XFILLER_0_87_150 VGND VGND VPWR VPWR sky130_fd_sc_hd__decap_4
XFILLER_0_76_813 VPWR VGND VPWR VGND sky130_ef_sc_hd__decap_12
X_5933_ _1856_ _2621_ VGND VGND VPWR VPWR _2652_ sky130_fd_sc_hd__nor2_1
XFILLER_0_48_504 VGND VGND VPWR VPWR sky130_fd_sc_hd__decap_4
X_5864_ _2567_ _2569_ _2574_ _2586_ _2541_ VGND VGND VPWR VPWR net143 sky130_fd_sc_hd__o32a_1
X_8652_ clknet_leaf_88_CLK _0764_ VGND VGND VPWR VPWR rf.registers\[17\]\[27\] sky130_fd_sc_hd__dfxtp_1
X_8583_ clknet_leaf_8_CLK _0695_ VGND VGND VPWR VPWR rf.registers\[12\]\[22\] sky130_fd_sc_hd__dfxtp_1
XFILLER_0_8_645 VGND VGND VPWR VPWR sky130_fd_sc_hd__decap_4
XFILLER_0_7_111 VGND VGND VPWR VPWR sky130_fd_sc_hd__fill_1
X_7603_ _3725_ VGND VGND VPWR VPWR _0218_ sky130_fd_sc_hd__clkbuf_1
X_4815_ _1579_ _1580_ _1298_ VGND VGND VPWR VPWR _1581_ sky130_fd_sc_hd__mux2_1
X_5795_ _2269_ _2519_ VGND VGND VPWR VPWR _2520_ sky130_fd_sc_hd__or2b_1
X_7534_ _2963_ rf.registers\[31\]\[25\] _3683_ VGND VGND VPWR VPWR _3689_ sky130_fd_sc_hd__mux2_1
XFILLER_0_133_417 VPWR VGND VPWR VGND sky130_ef_sc_hd__decap_12
XFILLER_0_113_93 VPWR VGND VPWR VGND sky130_ef_sc_hd__decap_12
XFILLER_0_16_445 VPWR VGND VPWR VGND sky130_ef_sc_hd__decap_12
X_4746_ _1514_ _1515_ _1133_ VGND VGND VPWR VPWR _1516_ sky130_fd_sc_hd__mux2_1
X_4677_ rf.registers\[16\]\[21\] rf.registers\[17\]\[21\] rf.registers\[18\]\[21\]
+ rf.registers\[19\]\[21\] _1172_ _1149_ VGND VGND VPWR VPWR _1451_ sky130_fd_sc_hd__mux4_1
XFILLER_0_16_489 VPWR VGND VPWR VGND sky130_ef_sc_hd__decap_12
X_7465_ _3652_ VGND VGND VPWR VPWR _0153_ sky130_fd_sc_hd__clkbuf_1
X_9204_ clknet_leaf_35_CLK _0292_ VGND VGND VPWR VPWR rf.registers\[9\]\[3\] sky130_fd_sc_hd__dfxtp_1
XFILLER_0_102_837 VGND VGND VPWR VPWR sky130_fd_sc_hd__fill_2
X_6416_ _3066_ VGND VGND VPWR VPWR _0714_ sky130_fd_sc_hd__clkbuf_1
XFILLER_0_12_640 VGND VGND VPWR VPWR sky130_fd_sc_hd__decap_4
XFILLER_0_3_361 VPWR VGND VPWR VGND sky130_ef_sc_hd__decap_12
X_7396_ _3615_ VGND VGND VPWR VPWR _0121_ sky130_fd_sc_hd__clkbuf_1
XTAP_TAPCELL_ROW_73_1401 VGND VPWR sky130_fd_sc_hd__tapvpwrvgnd_1
X_6347_ net22 VGND VGND VPWR VPWR _3022_ sky130_fd_sc_hd__buf_2
X_9135_ clknet_leaf_74_CLK _0223_ VGND VGND VPWR VPWR rf.registers\[27\]\[30\] sky130_fd_sc_hd__dfxtp_1
XFILLER_0_11_161 VGND VGND VPWR VPWR sky130_fd_sc_hd__decap_6
X_6278_ net34 VGND VGND VPWR VPWR _2974_ sky130_fd_sc_hd__clkbuf_2
X_9066_ clknet_leaf_84_CLK _0154_ VGND VGND VPWR VPWR rf.registers\[29\]\[25\] sky130_fd_sc_hd__dfxtp_1
X_5229_ rf.registers\[8\]\[18\] rf.registers\[9\]\[18\] rf.registers\[10\]\[18\] rf.registers\[11\]\[18\]
+ _1919_ _1920_ VGND VGND VPWR VPWR _1974_ sky130_fd_sc_hd__mux4_1
X_8017_ _3945_ VGND VGND VPWR VPWR _0412_ sky130_fd_sc_hd__clkbuf_1
XFILLER_0_79_673 VPWR VGND VPWR VGND sky130_ef_sc_hd__decap_12
X_8919_ clknet_leaf_53_CLK _0007_ VGND VGND VPWR VPWR rf.registers\[4\]\[6\] sky130_fd_sc_hd__dfxtp_1
XTAP_TAPCELL_ROW_84_1563 VGND VPWR sky130_fd_sc_hd__tapvpwrvgnd_1
XFILLER_0_39_559 VGND VGND VPWR VPWR sky130_fd_sc_hd__fill_1
XFILLER_0_136_233 VPWR VGND VPWR VGND sky130_ef_sc_hd__decap_12
XFILLER_0_109_447 VGND VGND VPWR VPWR sky130_fd_sc_hd__fill_1
XFILLER_0_82_805 VGND VGND VPWR VPWR sky130_fd_sc_hd__decap_6
XFILLER_0_66_389 VGND VGND VPWR VPWR sky130_fd_sc_hd__fill_1
XPHY_EDGE_ROW_117_Right_117 VGND VGND VPWR VPWR sky130_fd_sc_hd__decap_3
XFILLER_0_81_348 VPWR VGND VPWR VGND sky130_ef_sc_hd__decap_12
XFILLER_0_35_721 VGND VGND VPWR VPWR sky130_fd_sc_hd__decap_6
XFILLER_0_136_277 VPWR VGND VPWR VGND sky130_ef_sc_hd__decap_12
XFILLER_0_50_713 VPWR VGND VPWR VGND sky130_ef_sc_hd__decap_12
XFILLER_0_22_404 VPWR VGND VPWR VGND sky130_ef_sc_hd__decap_12
XFILLER_0_120_601 VGND VGND VPWR VPWR sky130_fd_sc_hd__fill_2
XFILLER_0_105_697 VPWR VGND VPWR VGND sky130_ef_sc_hd__decap_12
XFILLER_0_104_141 VGND VGND VPWR VPWR sky130_fd_sc_hd__fill_1
XFILLER_0_50_757 VPWR VGND VPWR VGND sky130_ef_sc_hd__decap_12
XFILLER_0_120_645 VGND VGND VPWR VPWR sky130_fd_sc_hd__decap_4
XFILLER_0_118_27 VGND VGND VPWR VPWR sky130_fd_sc_hd__fill_1
XFILLER_0_89_426 VGND VGND VPWR VPWR sky130_fd_sc_hd__decap_4
XFILLER_0_134_15 VPWR VGND VPWR VGND sky130_ef_sc_hd__decap_12
XTAP_TAPCELL_ROW_126_2191 VGND VPWR sky130_fd_sc_hd__tapvpwrvgnd_1
XFILLER_0_58_813 VPWR VGND VPWR VGND sky130_ef_sc_hd__decap_12
XFILLER_0_128_701 VPWR VGND VPWR VGND sky130_ef_sc_hd__decap_12
XFILLER_0_57_334 VGND VGND VPWR VPWR sky130_fd_sc_hd__fill_2
XTAP_TAPCELL_ROW_46_988 VGND VPWR sky130_fd_sc_hd__tapvpwrvgnd_1
XTAP_TAPCELL_ROW_26_690 VGND VPWR sky130_fd_sc_hd__tapvpwrvgnd_1
XFILLER_0_84_197 VGND VGND VPWR VPWR sky130_fd_sc_hd__fill_1
X_4600_ rf.registers\[16\]\[17\] rf.registers\[17\]\[17\] rf.registers\[18\]\[17\]
+ rf.registers\[19\]\[17\] _1320_ _1321_ VGND VGND VPWR VPWR _1378_ sky130_fd_sc_hd__mux4_1
XFILLER_0_26_710 VGND VGND VPWR VPWR sky130_fd_sc_hd__fill_1
XFILLER_0_5_615 VGND VGND VPWR VPWR sky130_fd_sc_hd__fill_1
X_5580_ _2212_ _2310_ VGND VGND VPWR VPWR _2311_ sky130_fd_sc_hd__nor2_1
X_4531_ _1310_ _1311_ _1312_ VGND VGND VPWR VPWR _1313_ sky130_fd_sc_hd__mux2_1
XPHY_EDGE_ROW_68_Left_207 VGND VGND VPWR VPWR sky130_fd_sc_hd__decap_3
X_4462_ rf.registers\[0\]\[9\] rf.registers\[1\]\[9\] rf.registers\[2\]\[9\] rf.registers\[3\]\[9\]
+ _1042_ _1044_ VGND VGND VPWR VPWR _1248_ sky130_fd_sc_hd__mux4_1
X_7250_ _3515_ VGND VGND VPWR VPWR _3538_ sky130_fd_sc_hd__buf_4
X_6201_ net106 _2778_ _2903_ VGND VGND VPWR VPWR _2904_ sky130_fd_sc_hd__a21oi_1
XFILLER_0_7_57 VPWR VGND VPWR VGND sky130_ef_sc_hd__decap_12
XFILLER_0_1_821 VPWR VGND VPWR VGND sky130_ef_sc_hd__decap_12
X_4393_ rf.registers\[20\]\[6\] rf.registers\[21\]\[6\] rf.registers\[22\]\[6\] rf.registers\[23\]\[6\]
+ _1159_ _1181_ VGND VGND VPWR VPWR _1182_ sky130_fd_sc_hd__mux4_1
X_7181_ _3501_ VGND VGND VPWR VPWR _0020_ sky130_fd_sc_hd__clkbuf_1
XTAP_TAPCELL_ROW_55_1131 VGND VPWR sky130_fd_sc_hd__tapvpwrvgnd_1
XTAP_TAPCELL_ROW_55_1120 VGND VPWR sky130_fd_sc_hd__tapvpwrvgnd_1
XFILLER_0_0_331 VGND VGND VPWR VPWR sky130_fd_sc_hd__decap_4
XFILLER_0_0_353 VGND VGND VPWR VPWR sky130_fd_sc_hd__fill_2
X_6132_ _2234_ _2803_ _2838_ VGND VGND VPWR VPWR _2839_ sky130_fd_sc_hd__o21a_1
X_6063_ _2708_ _2743_ _2770_ _2773_ VGND VGND VPWR VPWR _2774_ sky130_fd_sc_hd__o31a_1
X_5014_ _1742_ VGND VGND VPWR VPWR _1771_ sky130_fd_sc_hd__clkbuf_8
XPHY_EDGE_ROW_77_Left_216 VGND VGND VPWR VPWR sky130_fd_sc_hd__decap_3
XFILLER_0_16_3 VPWR VGND VPWR VGND sky130_ef_sc_hd__decap_12
X_6965_ _3383_ VGND VGND VPWR VPWR _0946_ sky130_fd_sc_hd__clkbuf_1
X_8704_ clknet_leaf_23_CLK _0816_ VGND VGND VPWR VPWR rf.registers\[24\]\[15\] sky130_fd_sc_hd__dfxtp_1
XFILLER_0_48_345 VGND VGND VPWR VPWR sky130_fd_sc_hd__decap_3
X_5916_ _2634_ VGND VGND VPWR VPWR _2635_ sky130_fd_sc_hd__inv_2
X_8635_ clknet_leaf_37_CLK _0747_ VGND VGND VPWR VPWR rf.registers\[17\]\[10\] sky130_fd_sc_hd__dfxtp_1
XFILLER_0_75_164 VGND VGND VPWR VPWR sky130_fd_sc_hd__decap_4
XTAP_TAPCELL_ROW_66_1293 VGND VPWR sky130_fd_sc_hd__tapvpwrvgnd_1
XFILLER_0_64_805 VGND VGND VPWR VPWR sky130_fd_sc_hd__decap_6
X_6896_ net34 VGND VGND VPWR VPWR _3336_ sky130_fd_sc_hd__buf_2
XFILLER_0_118_233 VPWR VGND VPWR VGND sky130_ef_sc_hd__decap_12
XFILLER_0_63_337 VGND VGND VPWR VPWR sky130_fd_sc_hd__decap_4
XFILLER_0_48_389 VPWR VGND VPWR VGND sky130_ef_sc_hd__decap_12
X_5847_ _1115_ _2266_ VGND VGND VPWR VPWR _2570_ sky130_fd_sc_hd__or2_1
XFILLER_0_134_737 VPWR VGND VPWR VGND sky130_ef_sc_hd__decap_12
XFILLER_0_133_225 VPWR VGND VPWR VGND sky130_ef_sc_hd__decap_12
XPHY_EDGE_ROW_86_Left_225 VGND VGND VPWR VPWR sky130_fd_sc_hd__decap_3
X_8566_ clknet_leaf_64_CLK _0678_ VGND VGND VPWR VPWR rf.registers\[12\]\[5\] sky130_fd_sc_hd__dfxtp_1
XFILLER_0_8_475 VGND VGND VPWR VPWR sky130_fd_sc_hd__fill_1
XFILLER_0_17_765 VGND VGND VPWR VPWR sky130_fd_sc_hd__fill_2
X_5778_ _2416_ _2501_ _2503_ VGND VGND VPWR VPWR _2504_ sky130_fd_sc_hd__a21oi_2
X_7517_ _3382_ rf.registers\[31\]\[17\] _3672_ VGND VGND VPWR VPWR _3680_ sky130_fd_sc_hd__mux2_1
XFILLER_0_16_253 VPWR VGND VPWR VGND sky130_ef_sc_hd__decap_12
XFILLER_0_17_776 VGND VGND VPWR VPWR sky130_fd_sc_hd__decap_8
X_8497_ _4199_ VGND VGND VPWR VPWR _0638_ sky130_fd_sc_hd__clkbuf_1
X_4729_ rf.registers\[8\]\[24\] rf.registers\[9\]\[24\] rf.registers\[10\]\[24\] rf.registers\[11\]\[24\]
+ _1172_ _1173_ VGND VGND VPWR VPWR _1500_ sky130_fd_sc_hd__mux4_1
X_7448_ _3643_ VGND VGND VPWR VPWR _0145_ sky130_fd_sc_hd__clkbuf_1
XFILLER_0_4_670 VPWR VGND VPWR VGND sky130_ef_sc_hd__decap_12
XFILLER_0_31_223 VGND VGND VPWR VPWR sky130_fd_sc_hd__fill_1
XFILLER_0_32_757 VPWR VGND VPWR VGND sky130_ef_sc_hd__decap_12
X_7379_ _3606_ VGND VGND VPWR VPWR _0113_ sky130_fd_sc_hd__clkbuf_1
X_9118_ clknet_leaf_27_CLK _0206_ VGND VGND VPWR VPWR rf.registers\[27\]\[13\] sky130_fd_sc_hd__dfxtp_1
X_9049_ clknet_leaf_38_CLK _0137_ VGND VGND VPWR VPWR rf.registers\[29\]\[8\] sky130_fd_sc_hd__dfxtp_1
XPHY_EDGE_ROW_95_Left_234 VGND VGND VPWR VPWR sky130_fd_sc_hd__decap_3
XTAP_TAPCELL_ROW_4_363 VGND VPWR sky130_fd_sc_hd__tapvpwrvgnd_1
XFILLER_0_86_429 VGND VGND VPWR VPWR sky130_fd_sc_hd__decap_3
XFILLER_0_39_334 VGND VGND VPWR VPWR sky130_fd_sc_hd__fill_2
XFILLER_0_104_29 VPWR VGND VPWR VGND sky130_ef_sc_hd__decap_12
XFILLER_0_67_665 VGND VGND VPWR VPWR sky130_fd_sc_hd__decap_6
XFILLER_0_54_304 VGND VGND VPWR VPWR sky130_fd_sc_hd__fill_1
XFILLER_0_13_27 VPWR VGND VPWR VGND sky130_ef_sc_hd__decap_12
XTAP_TAPCELL_ROW_43_947 VGND VPWR sky130_fd_sc_hd__tapvpwrvgnd_1
XFILLER_0_137_553 VGND VGND VPWR VPWR sky130_fd_sc_hd__decap_6
XFILLER_0_66_197 VGND VGND VPWR VPWR sky130_fd_sc_hd__fill_1
XFILLER_0_137_597 VPWR VGND VPWR VGND sky130_ef_sc_hd__decap_12
XFILLER_0_81_156 VGND VGND VPWR VPWR sky130_fd_sc_hd__fill_1
XTAP_TAPCELL_ROW_97_1754 VGND VPWR sky130_fd_sc_hd__tapvpwrvgnd_1
XFILLER_0_90_690 VGND VGND VPWR VPWR sky130_fd_sc_hd__decap_8
XFILLER_0_120_431 VGND VGND VPWR VPWR sky130_fd_sc_hd__fill_2
XFILLER_0_129_15 VPWR VGND VPWR VGND sky130_ef_sc_hd__decap_12
XTAP_TAPCELL_ROW_128_2220 VGND VPWR sky130_fd_sc_hd__tapvpwrvgnd_1
XFILLER_0_89_223 VGND VGND VPWR VPWR sky130_fd_sc_hd__fill_1
XTAP_TAPCELL_ROW_50_1050 VGND VPWR sky130_fd_sc_hd__tapvpwrvgnd_1
X_6750_ rf.registers\[0\]\[4\] _2995_ _3241_ VGND VGND VPWR VPWR _3246_ sky130_fd_sc_hd__mux2_1
XTAP_TAPCELL_ROW_106_1894 VGND VPWR sky130_fd_sc_hd__tapvpwrvgnd_1
XTAP_TAPCELL_ROW_106_1883 VGND VPWR sky130_fd_sc_hd__tapvpwrvgnd_1
XFILLER_0_9_217 VGND VGND VPWR VPWR sky130_fd_sc_hd__decap_6
X_5701_ _2211_ _1074_ _1095_ _2389_ VGND VGND VPWR VPWR _2429_ sky130_fd_sc_hd__a31o_1
XFILLER_0_46_805 VGND VGND VPWR VPWR sky130_fd_sc_hd__decap_6
X_6681_ _3209_ VGND VGND VPWR VPWR _0836_ sky130_fd_sc_hd__clkbuf_1
XTAP_TAPCELL_ROW_21_608 VGND VPWR sky130_fd_sc_hd__tapvpwrvgnd_1
XTAP_TAPCELL_ROW_21_619 VGND VPWR sky130_fd_sc_hd__tapvpwrvgnd_1
XFILLER_0_128_586 VGND VGND VPWR VPWR sky130_fd_sc_hd__fill_2
XFILLER_0_116_737 VPWR VGND VPWR VGND sky130_ef_sc_hd__decap_12
XFILLER_0_73_668 VGND VGND VPWR VPWR sky130_fd_sc_hd__decap_4
X_8420_ rf.registers\[18\]\[25\] net31 _4153_ VGND VGND VPWR VPWR _4159_ sky130_fd_sc_hd__mux2_1
X_5632_ _1966_ _2219_ _2220_ VGND VGND VPWR VPWR _2362_ sky130_fd_sc_hd__o21ai_1
XFILLER_0_60_318 VGND VGND VPWR VPWR sky130_fd_sc_hd__decap_4
XFILLER_0_60_307 VGND VGND VPWR VPWR sky130_fd_sc_hd__fill_1
X_5563_ _2293_ VGND VGND VPWR VPWR _2294_ sky130_fd_sc_hd__inv_2
XFILLER_0_26_573 VGND VGND VPWR VPWR sky130_fd_sc_hd__decap_3
X_8351_ _4122_ VGND VGND VPWR VPWR _0569_ sky130_fd_sc_hd__clkbuf_1
XFILLER_0_131_729 VPWR VGND VPWR VGND sky130_ef_sc_hd__decap_12
XFILLER_0_115_269 VGND VGND VPWR VPWR sky130_fd_sc_hd__fill_2
X_4514_ rf.registers\[8\]\[12\] rf.registers\[9\]\[12\] rf.registers\[10\]\[12\] rf.registers\[11\]\[12\]
+ _1294_ _1295_ VGND VGND VPWR VPWR _1297_ sky130_fd_sc_hd__mux4_1
X_7302_ rf.registers\[3\]\[12\] _3303_ _3563_ VGND VGND VPWR VPWR _3566_ sky130_fd_sc_hd__mux2_1
XFILLER_0_13_223 VGND VGND VPWR VPWR sky130_fd_sc_hd__fill_1
XFILLER_0_14_757 VPWR VGND VPWR VGND sky130_ef_sc_hd__decap_12
XFILLER_0_124_781 VPWR VGND VPWR VGND sky130_ef_sc_hd__decap_12
X_8282_ _3037_ rf.registers\[25\]\[24\] _4081_ VGND VGND VPWR VPWR _4086_ sky130_fd_sc_hd__mux2_1
X_5494_ _1856_ _2206_ VGND VGND VPWR VPWR _2225_ sky130_fd_sc_hd__nor2_1
XFILLER_0_110_83 VGND VGND VPWR VPWR sky130_fd_sc_hd__fill_1
X_4445_ rf.registers\[12\]\[8\] rf.registers\[13\]\[8\] rf.registers\[14\]\[8\] rf.registers\[15\]\[8\]
+ _1042_ _1044_ VGND VGND VPWR VPWR _1232_ sky130_fd_sc_hd__mux4_1
X_7233_ _3529_ VGND VGND VPWR VPWR _0044_ sky130_fd_sc_hd__clkbuf_1
X_7164_ rf.registers\[4\]\[11\] _3301_ _3491_ VGND VGND VPWR VPWR _3493_ sky130_fd_sc_hd__mux2_1
X_4376_ rf.registers\[24\]\[5\] rf.registers\[25\]\[5\] rf.registers\[26\]\[5\] rf.registers\[27\]\[5\]
+ _1159_ _1160_ VGND VGND VPWR VPWR _1166_ sky130_fd_sc_hd__mux4_1
XFILLER_0_0_172 VGND VGND VPWR VPWR sky130_fd_sc_hd__fill_2
XFILLER_0_1_673 VPWR VGND VPWR VGND sky130_ef_sc_hd__decap_12
X_6115_ _2822_ _1492_ _2809_ VGND VGND VPWR VPWR _2823_ sky130_fd_sc_hd__or3b_1
XFILLER_0_119_81 VPWR VGND VPWR VGND sky130_ef_sc_hd__decap_12
X_7095_ _3456_ VGND VGND VPWR VPWR _1003_ sky130_fd_sc_hd__clkbuf_1
X_6046_ net91 _2709_ _2756_ _2757_ VGND VGND VPWR VPWR _2758_ sky130_fd_sc_hd__a22o_1
XTAP_TAPCELL_ROW_68_1322 VGND VPWR sky130_fd_sc_hd__tapvpwrvgnd_1
XTAP_TAPCELL_ROW_1_311 VGND VPWR sky130_fd_sc_hd__tapvpwrvgnd_1
XTAP_TAPCELL_ROW_1_322 VGND VPWR sky130_fd_sc_hd__tapvpwrvgnd_1
XFILLER_0_95_215 VGND VGND VPWR VPWR sky130_fd_sc_hd__fill_1
XFILLER_0_96_749 VGND VGND VPWR VPWR sky130_fd_sc_hd__decap_6
XFILLER_0_95_237 VGND VGND VPWR VPWR sky130_fd_sc_hd__fill_1
X_7997_ _3384_ rf.registers\[22\]\[18\] _3926_ VGND VGND VPWR VPWR _3935_ sky130_fd_sc_hd__mux2_1
X_6948_ net17 VGND VGND VPWR VPWR _3372_ sky130_fd_sc_hd__clkbuf_2
XFILLER_0_95_259 VGND VGND VPWR VPWR sky130_fd_sc_hd__fill_1
XTAP_TAPCELL_ROW_81_1522 VGND VPWR sky130_fd_sc_hd__tapvpwrvgnd_1
XTAP_TAPCELL_ROW_81_1511 VGND VPWR sky130_fd_sc_hd__tapvpwrvgnd_1
XTAP_TAPCELL_ROW_40_906 VGND VPWR sky130_fd_sc_hd__tapvpwrvgnd_1
X_6879_ rf.registers\[16\]\[22\] _3324_ _3320_ VGND VGND VPWR VPWR _3325_ sky130_fd_sc_hd__mux2_1
XFILLER_0_48_186 VGND VGND VPWR VPWR sky130_fd_sc_hd__fill_1
XFILLER_0_64_657 VPWR VGND VPWR VGND sky130_ef_sc_hd__decap_12
X_8618_ clknet_leaf_71_CLK _0730_ VGND VGND VPWR VPWR rf.registers\[11\]\[25\] sky130_fd_sc_hd__dfxtp_1
XFILLER_0_91_487 VGND VGND VPWR VPWR sky130_fd_sc_hd__fill_1
X_8549_ _4226_ VGND VGND VPWR VPWR _0663_ sky130_fd_sc_hd__clkbuf_1
XFILLER_0_121_217 VGND VGND VPWR VPWR sky130_fd_sc_hd__decap_6
XTAP_TAPCELL_ROW_79_1484 VGND VPWR sky130_fd_sc_hd__tapvpwrvgnd_1
XTAP_TAPCELL_ROW_9_433 VGND VPWR sky130_fd_sc_hd__tapvpwrvgnd_1
XFILLER_0_32_587 VGND VGND VPWR VPWR sky130_fd_sc_hd__fill_1
XTAP_TAPCELL_ROW_92_1673 VGND VPWR sky130_fd_sc_hd__tapvpwrvgnd_1
XFILLER_0_5_3 VPWR VGND VPWR VGND sky130_ef_sc_hd__decap_12
XTAP_TAPCELL_ROW_92_1684 VGND VPWR sky130_fd_sc_hd__tapvpwrvgnd_1
XTAP_TAPCELL_ROW_123_2150 VGND VPWR sky130_fd_sc_hd__tapvpwrvgnd_1
XFILLER_0_24_15 VPWR VGND VPWR VGND sky130_ef_sc_hd__decap_12
XFILLER_0_86_248 VGND VGND VPWR VPWR sky130_fd_sc_hd__fill_1
XFILLER_0_129_317 VPWR VGND VPWR VGND sky130_ef_sc_hd__decap_12
XFILLER_0_82_421 VGND VGND VPWR VPWR sky130_fd_sc_hd__decap_3
XFILLER_0_67_495 VGND VGND VPWR VPWR sky130_fd_sc_hd__decap_8
XFILLER_0_137_361 VPWR VGND VPWR VGND sky130_ef_sc_hd__decap_12
XFILLER_0_82_443 VGND VGND VPWR VPWR sky130_fd_sc_hd__fill_1
XFILLER_0_6_209 VPWR VGND VPWR VGND sky130_ef_sc_hd__decap_12
XFILLER_0_125_534 VGND VGND VPWR VPWR sky130_fd_sc_hd__fill_1
XFILLER_0_42_307 VGND VGND VPWR VPWR sky130_fd_sc_hd__fill_1
XFILLER_0_113_729 VPWR VGND VPWR VGND sky130_ef_sc_hd__decap_12
XFILLER_0_51_841 VGND VGND VPWR VPWR sky130_fd_sc_hd__fill_1
XFILLER_0_106_781 VPWR VGND VPWR VGND sky130_ef_sc_hd__decap_12
XFILLER_0_50_362 VGND VGND VPWR VPWR sky130_fd_sc_hd__fill_2
XFILLER_0_120_272 VPWR VGND VPWR VGND sky130_ef_sc_hd__decap_12
X_4230_ net7 VGND VGND VPWR VPWR _1025_ sky130_fd_sc_hd__inv_2
X_7920_ _3894_ VGND VGND VPWR VPWR _0366_ sky130_fd_sc_hd__clkbuf_1
XTAP_TAPCELL_ROW_108_1923 VGND VPWR sky130_fd_sc_hd__tapvpwrvgnd_1
X_7851_ _3857_ VGND VGND VPWR VPWR _0334_ sky130_fd_sc_hd__clkbuf_1
XFILLER_0_78_749 VGND VGND VPWR VPWR sky130_fd_sc_hd__decap_6
X_6802_ rf.registers\[0\]\[29\] _3047_ _3263_ VGND VGND VPWR VPWR _3273_ sky130_fd_sc_hd__mux2_1
X_7782_ rf.registers\[9\]\[13\] _3305_ _3817_ VGND VGND VPWR VPWR _3821_ sky130_fd_sc_hd__mux2_1
X_4994_ _1747_ _1751_ VGND VGND VPWR VPWR _1752_ sky130_fd_sc_hd__or2_1
X_9521_ clknet_leaf_40_CLK _0609_ VGND VGND VPWR VPWR rf.registers\[14\]\[0\] sky130_fd_sc_hd__dfxtp_1
XFILLER_0_86_793 VPWR VGND VPWR VGND sky130_ef_sc_hd__decap_12
XTAP_TAPCELL_ROW_63_1252 VGND VPWR sky130_fd_sc_hd__tapvpwrvgnd_1
XTAP_TAPCELL_ROW_63_1241 VGND VPWR sky130_fd_sc_hd__tapvpwrvgnd_1
X_6733_ _3236_ VGND VGND VPWR VPWR _0861_ sky130_fd_sc_hd__clkbuf_1
XFILLER_0_116_501 VGND VGND VPWR VPWR sky130_fd_sc_hd__fill_1
X_9452_ clknet_leaf_87_CLK _0540_ VGND VGND VPWR VPWR rf.registers\[25\]\[27\] sky130_fd_sc_hd__dfxtp_1
X_6664_ _3199_ VGND VGND VPWR VPWR _0829_ sky130_fd_sc_hd__clkbuf_1
X_8403_ rf.registers\[18\]\[17\] net22 _4142_ VGND VGND VPWR VPWR _4150_ sky130_fd_sc_hd__mux2_1
X_5615_ _1056_ _2242_ VGND VGND VPWR VPWR _2345_ sky130_fd_sc_hd__nand2_1
X_6595_ _3162_ VGND VGND VPWR VPWR _0797_ sky130_fd_sc_hd__clkbuf_1
X_9383_ clknet_leaf_0_CLK _0471_ VGND VGND VPWR VPWR rf.registers\[26\]\[22\] sky130_fd_sc_hd__dfxtp_1
XFILLER_0_121_93 VPWR VGND VPWR VGND sky130_ef_sc_hd__decap_12
X_8334_ _4113_ VGND VGND VPWR VPWR _0561_ sky130_fd_sc_hd__clkbuf_1
XFILLER_0_30_91 VGND VGND VPWR VPWR sky130_fd_sc_hd__fill_2
X_5546_ _2212_ _2276_ VGND VGND VPWR VPWR _2277_ sky130_fd_sc_hd__nor2_1
X_8265_ _3020_ rf.registers\[25\]\[16\] _4070_ VGND VGND VPWR VPWR _4077_ sky130_fd_sc_hd__mux2_1
X_5477_ _2207_ VGND VGND VPWR VPWR _2208_ sky130_fd_sc_hd__buf_2
X_7216_ _3520_ VGND VGND VPWR VPWR _0036_ sky130_fd_sc_hd__clkbuf_1
X_4428_ _1190_ _1215_ VGND VGND VPWR VPWR _1216_ sky130_fd_sc_hd__nand2_1
X_8196_ _4040_ VGND VGND VPWR VPWR _0496_ sky130_fd_sc_hd__clkbuf_1
X_7147_ rf.registers\[4\]\[3\] _3284_ _3480_ VGND VGND VPWR VPWR _3484_ sky130_fd_sc_hd__mux2_1
X_4359_ rf.registers\[12\]\[4\] rf.registers\[13\]\[4\] rf.registers\[14\]\[4\] rf.registers\[15\]\[4\]
+ _1147_ _1149_ VGND VGND VPWR VPWR _1150_ sky130_fd_sc_hd__mux4_1
XFILLER_0_10_793 VPWR VGND VPWR VGND sky130_ef_sc_hd__decap_12
X_7078_ _3447_ VGND VGND VPWR VPWR _0995_ sky130_fd_sc_hd__clkbuf_1
X_6029_ _1982_ _2741_ VGND VGND VPWR VPWR _2742_ sky130_fd_sc_hd__xnor2_2
XFILLER_0_69_727 VGND VGND VPWR VPWR sky130_fd_sc_hd__fill_1
XFILLER_0_138_125 VPWR VGND VPWR VGND sky130_ef_sc_hd__decap_12
XFILLER_0_83_207 VGND VGND VPWR VPWR sky130_fd_sc_hd__decap_4
XFILLER_0_138_169 VPWR VGND VPWR VGND sky130_ef_sc_hd__decap_12
XFILLER_0_135_821 VPWR VGND VPWR VGND sky130_ef_sc_hd__decap_12
XFILLER_0_126_309 VPWR VGND VPWR VGND sky130_ef_sc_hd__decap_12
XFILLER_0_64_421 VPWR VGND VPWR VGND sky130_ef_sc_hd__decap_12
XFILLER_0_33_841 VGND VGND VPWR VPWR sky130_fd_sc_hd__fill_1
XTAP_TAPCELL_ROW_94_1713 VGND VPWR sky130_fd_sc_hd__tapvpwrvgnd_1
XFILLER_0_60_693 VGND VGND VPWR VPWR sky130_fd_sc_hd__decap_6
XFILLER_0_126_27 VGND VGND VPWR VPWR sky130_fd_sc_hd__fill_1
XTAP_TAPCELL_ROW_121_2109 VGND VPWR sky130_fd_sc_hd__tapvpwrvgnd_1
XFILLER_0_87_502 VGND VGND VPWR VPWR sky130_fd_sc_hd__fill_2
XFILLER_0_59_215 VGND VGND VPWR VPWR sky130_fd_sc_hd__fill_1
XFILLER_0_129_125 VPWR VGND VPWR VGND sky130_ef_sc_hd__decap_12
XTAP_TAPCELL_ROW_103_1842 VGND VPWR sky130_fd_sc_hd__tapvpwrvgnd_1
XFILLER_0_68_793 VPWR VGND VPWR VGND sky130_ef_sc_hd__decap_12
XFILLER_0_51_13 VPWR VGND VPWR VGND sky130_ef_sc_hd__decap_12
XFILLER_0_129_169 VPWR VGND VPWR VGND sky130_ef_sc_hd__decap_12
XFILLER_0_83_741 VPWR VGND VPWR VGND sky130_ef_sc_hd__decap_12
XFILLER_0_51_68 VGND VGND VPWR VPWR sky130_fd_sc_hd__fill_2
XFILLER_0_51_57 VGND VGND VPWR VPWR sky130_fd_sc_hd__decap_3
XFILLER_0_7_529 VPWR VGND VPWR VGND sky130_ef_sc_hd__decap_12
XFILLER_0_28_657 VPWR VGND VPWR VGND sky130_ef_sc_hd__decap_12
XFILLER_0_83_785 VPWR VGND VPWR VGND sky130_ef_sc_hd__decap_12
XFILLER_0_28_679 VPWR VGND VPWR VGND sky130_ef_sc_hd__decap_12
XTAP_TAPCELL_ROW_31_758 VGND VPWR sky130_fd_sc_hd__tapvpwrvgnd_1
XTAP_TAPCELL_ROW_31_769 VGND VPWR sky130_fd_sc_hd__tapvpwrvgnd_1
XTAP_TAPCELL_ROW_136_2341 VGND VPWR sky130_fd_sc_hd__tapvpwrvgnd_1
XFILLER_0_15_329 VGND VGND VPWR VPWR sky130_fd_sc_hd__decap_6
XFILLER_0_42_137 VGND VGND VPWR VPWR sky130_fd_sc_hd__decap_3
Xclkbuf_3_5__f_CLK clknet_0_CLK VGND VGND VPWR VPWR clknet_3_5__leaf_CLK sky130_fd_sc_hd__clkbuf_16
Xclkload22 clknet_leaf_7_CLK VGND VGND VPWR VPWR clkload22/Y sky130_fd_sc_hd__clkinvlp_2
Xclkload44 clknet_leaf_61_CLK VGND VGND VPWR VPWR clkload44/Y sky130_fd_sc_hd__clkinvlp_4
XTAP_TAPCELL_ROW_11_471 VGND VPWR sky130_fd_sc_hd__tapvpwrvgnd_1
XTAP_TAPCELL_ROW_11_460 VGND VPWR sky130_fd_sc_hd__tapvpwrvgnd_1
X_6380_ _3044_ VGND VGND VPWR VPWR _0700_ sky130_fd_sc_hd__clkbuf_1
Xclkload11 clknet_leaf_87_CLK VGND VGND VPWR VPWR clkload11/Y sky130_fd_sc_hd__clkinv_4
Xclkload33 clknet_leaf_68_CLK VGND VGND VPWR VPWR clkload33/Y sky130_fd_sc_hd__bufinv_16
X_5400_ rf.registers\[16\]\[28\] rf.registers\[17\]\[28\] rf.registers\[18\]\[28\]
+ rf.registers\[19\]\[28\] _1951_ _1952_ VGND VGND VPWR VPWR _2135_ sky130_fd_sc_hd__mux4_1
Xclkload77 clknet_leaf_55_CLK VGND VGND VPWR VPWR clkload77/Y sky130_fd_sc_hd__inv_6
Xclkload66 clknet_leaf_28_CLK VGND VGND VPWR VPWR clkload66/Y sky130_fd_sc_hd__clkinvlp_4
Xclkload55 clknet_leaf_18_CLK VGND VGND VPWR VPWR clkload55/Y sky130_fd_sc_hd__clkinv_4
XFILLER_0_2_245 VGND VGND VPWR VPWR sky130_fd_sc_hd__decap_6
X_5331_ _2008_ VGND VGND VPWR VPWR _2070_ sky130_fd_sc_hd__buf_4
Xclkload88 clknet_leaf_44_CLK VGND VGND VPWR VPWR clkload88/Y sky130_fd_sc_hd__clkinv_4
X_8050_ _3963_ VGND VGND VPWR VPWR _0427_ sky130_fd_sc_hd__clkbuf_1
XFILLER_0_11_557 VGND VGND VPWR VPWR sky130_fd_sc_hd__decap_3
XFILLER_0_2_289 VPWR VGND VPWR VGND sky130_ef_sc_hd__decap_12
X_7001_ _3405_ VGND VGND VPWR VPWR _0960_ sky130_fd_sc_hd__clkbuf_1
XFILLER_0_55_7 VPWR VGND VPWR VGND sky130_ef_sc_hd__decap_12
X_5262_ _2001_ _2002_ _2003_ _2004_ _1927_ _1771_ VGND VGND VPWR VPWR _2005_ sky130_fd_sc_hd__mux4_2
X_5193_ _1939_ VGND VGND VPWR VPWR net56 sky130_fd_sc_hd__inv_2
X_8952_ clknet_leaf_52_CLK _0040_ VGND VGND VPWR VPWR rf.registers\[19\]\[7\] sky130_fd_sc_hd__dfxtp_1
XPHY_EDGE_ROW_50_Left_189 VGND VGND VPWR VPWR sky130_fd_sc_hd__decap_3
X_8883_ clknet_leaf_46_CLK _0995_ VGND VGND VPWR VPWR rf.registers\[5\]\[2\] sky130_fd_sc_hd__dfxtp_1
X_7903_ _3885_ VGND VGND VPWR VPWR _0358_ sky130_fd_sc_hd__clkbuf_1
XFILLER_0_93_505 VGND VGND VPWR VPWR sky130_fd_sc_hd__fill_1
X_7834_ _3848_ VGND VGND VPWR VPWR _0326_ sky130_fd_sc_hd__clkbuf_1
XTAP_TAPCELL_ROW_19_582 VGND VPWR sky130_fd_sc_hd__tapvpwrvgnd_1
X_7765_ rf.registers\[9\]\[5\] _3288_ _3806_ VGND VGND VPWR VPWR _3812_ sky130_fd_sc_hd__mux2_1
XFILLER_0_117_821 VPWR VGND VPWR VGND sky130_ef_sc_hd__decap_12
X_9504_ clknet_leaf_22_CLK _0592_ VGND VGND VPWR VPWR rf.registers\[18\]\[15\] sky130_fd_sc_hd__dfxtp_1
X_4977_ _1734_ VGND VGND VPWR VPWR _1735_ sky130_fd_sc_hd__clkbuf_8
X_6716_ rf.registers\[10\]\[20\] _3028_ _3227_ VGND VGND VPWR VPWR _3228_ sky130_fd_sc_hd__mux2_1
Xclkload5 clknet_3_5__leaf_CLK VGND VGND VPWR VPWR clkload5/Y sky130_fd_sc_hd__inv_12
X_7696_ _3775_ VGND VGND VPWR VPWR _0261_ sky130_fd_sc_hd__clkbuf_1
XFILLER_0_18_167 VPWR VGND VPWR VGND sky130_ef_sc_hd__decap_12
XFILLER_0_34_616 VPWR VGND VPWR VGND sky130_ef_sc_hd__decap_12
XFILLER_0_132_813 VPWR VGND VPWR VGND sky130_ef_sc_hd__decap_12
X_9435_ clknet_leaf_37_CLK _0523_ VGND VGND VPWR VPWR rf.registers\[25\]\[10\] sky130_fd_sc_hd__dfxtp_1
XFILLER_0_34_638 VGND VGND VPWR VPWR sky130_fd_sc_hd__decap_6
X_6647_ rf.registers\[24\]\[20\] _3028_ _3190_ VGND VGND VPWR VPWR _3191_ sky130_fd_sc_hd__mux2_1
X_9366_ clknet_leaf_59_CLK _0454_ VGND VGND VPWR VPWR rf.registers\[26\]\[5\] sky130_fd_sc_hd__dfxtp_1
XFILLER_0_15_841 VGND VGND VPWR VPWR sky130_fd_sc_hd__fill_1
X_6578_ rf.registers\[1\]\[20\] _3028_ _3153_ VGND VGND VPWR VPWR _3154_ sky130_fd_sc_hd__mux2_1
X_8317_ _4104_ VGND VGND VPWR VPWR _0553_ sky130_fd_sc_hd__clkbuf_1
XTAP_TAPCELL_ROW_76_1443 VGND VPWR sky130_fd_sc_hd__tapvpwrvgnd_1
X_5529_ _2259_ VGND VGND VPWR VPWR _2260_ sky130_fd_sc_hd__clkbuf_4
XFILLER_0_30_833 VGND VGND VPWR VPWR sky130_fd_sc_hd__fill_2
X_9297_ clknet_leaf_39_CLK _0385_ VGND VGND VPWR VPWR rf.registers\[22\]\[0\] sky130_fd_sc_hd__dfxtp_1
X_8248_ _3003_ rf.registers\[25\]\[8\] _4059_ VGND VGND VPWR VPWR _4068_ sky130_fd_sc_hd__mux2_1
X_8179_ _4031_ VGND VGND VPWR VPWR _0488_ sky130_fd_sc_hd__clkbuf_1
XFILLER_0_97_833 VGND VGND VPWR VPWR sky130_fd_sc_hd__decap_6
XFILLER_0_69_535 VGND VGND VPWR VPWR sky130_fd_sc_hd__decap_8
XFILLER_0_65_741 VPWR VGND VPWR VGND sky130_ef_sc_hd__decap_12
XFILLER_0_49_292 VGND VGND VPWR VPWR sky130_fd_sc_hd__fill_1
XFILLER_0_49_281 VGND VGND VPWR VPWR sky130_fd_sc_hd__fill_2
XFILLER_0_49_270 VGND VGND VPWR VPWR sky130_fd_sc_hd__fill_2
XFILLER_0_126_139 VGND VGND VPWR VPWR sky130_fd_sc_hd__fill_1
XFILLER_0_112_29 VPWR VGND VPWR VGND sky130_ef_sc_hd__decap_12
XFILLER_0_65_785 VPWR VGND VPWR VGND sky130_ef_sc_hd__decap_12
XFILLER_0_52_402 VGND VGND VPWR VPWR sky130_fd_sc_hd__fill_2
XFILLER_0_21_27 VPWR VGND VPWR VGND sky130_ef_sc_hd__decap_12
XFILLER_0_135_673 VPWR VGND VPWR VGND sky130_ef_sc_hd__decap_12
XFILLER_0_107_353 VGND VGND VPWR VPWR sky130_fd_sc_hd__fill_1
XFILLER_0_52_413 VGND VGND VPWR VPWR sky130_fd_sc_hd__decap_6
XFILLER_0_122_301 VGND VGND VPWR VPWR sky130_fd_sc_hd__decap_6
XTAP_TAPCELL_ROW_118_2071 VGND VPWR sky130_fd_sc_hd__tapvpwrvgnd_1
XFILLER_0_80_755 VGND VGND VPWR VPWR sky130_fd_sc_hd__fill_1
XFILLER_0_24_137 VGND VGND VPWR VPWR sky130_fd_sc_hd__decap_3
XFILLER_0_122_345 VPWR VGND VPWR VGND sky130_ef_sc_hd__decap_12
XFILLER_0_0_705 VGND VGND VPWR VPWR sky130_fd_sc_hd__fill_1
XFILLER_0_21_833 VGND VGND VPWR VPWR sky130_fd_sc_hd__decap_6
XFILLER_0_33_671 VGND VGND VPWR VPWR sky130_fd_sc_hd__fill_1
XTAP_TAPCELL_ROW_131_2260 VGND VPWR sky130_fd_sc_hd__tapvpwrvgnd_1
XFILLER_0_0_727 VGND VGND VPWR VPWR sky130_fd_sc_hd__fill_1
XTAP_TAPCELL_ROW_131_2271 VGND VPWR sky130_fd_sc_hd__tapvpwrvgnd_1
XFILLER_0_137_15 VPWR VGND VPWR VGND sky130_ef_sc_hd__decap_12
XFILLER_0_88_811 VGND VGND VPWR VPWR sky130_fd_sc_hd__fill_1
XFILLER_0_87_310 VGND VGND VPWR VPWR sky130_fd_sc_hd__fill_2
XFILLER_0_1_15 VPWR VGND VPWR VGND sky130_ef_sc_hd__decap_12
X_4900_ rf.registers\[0\]\[1\] rf.registers\[1\]\[1\] rf.registers\[2\]\[1\] rf.registers\[3\]\[1\]
+ _1655_ _1656_ VGND VGND VPWR VPWR _1662_ sky130_fd_sc_hd__mux4_1
X_5880_ _2541_ _2592_ _2593_ _2601_ VGND VGND VPWR VPWR net144 sky130_fd_sc_hd__o31a_1
XTAP_TAPCELL_ROW_36_839 VGND VPWR sky130_fd_sc_hd__tapvpwrvgnd_1
XTAP_TAPCELL_ROW_47_1000 VGND VPWR sky130_fd_sc_hd__tapvpwrvgnd_1
XTAP_TAPCELL_ROW_47_1011 VGND VPWR sky130_fd_sc_hd__tapvpwrvgnd_1
X_4831_ rf.registers\[12\]\[30\] rf.registers\[13\]\[30\] rf.registers\[14\]\[30\]
+ rf.registers\[15\]\[30\] _1147_ _1149_ VGND VGND VPWR VPWR _1596_ sky130_fd_sc_hd__mux4_1
XFILLER_0_8_805 VGND VGND VPWR VPWR sky130_fd_sc_hd__decap_6
XTAP_TAPCELL_ROW_16_541 VGND VPWR sky130_fd_sc_hd__tapvpwrvgnd_1
XFILLER_0_118_618 VGND VGND VPWR VPWR sky130_fd_sc_hd__fill_1
XTAP_TAPCELL_ROW_60_1200 VGND VPWR sky130_fd_sc_hd__tapvpwrvgnd_1
XFILLER_0_28_421 VGND VGND VPWR VPWR sky130_fd_sc_hd__decap_4
X_7550_ _3344_ rf.registers\[27\]\[0\] _3697_ VGND VGND VPWR VPWR _3698_ sky130_fd_sc_hd__mux2_1
XFILLER_0_7_337 VPWR VGND VPWR VGND sky130_ef_sc_hd__decap_12
X_4762_ rf.registers\[12\]\[26\] rf.registers\[13\]\[26\] rf.registers\[14\]\[26\]
+ rf.registers\[15\]\[26\] _1159_ _1160_ VGND VGND VPWR VPWR _1531_ sky130_fd_sc_hd__mux4_1
XFILLER_0_28_454 VGND VGND VPWR VPWR sky130_fd_sc_hd__fill_1
XFILLER_0_43_402 VGND VGND VPWR VPWR sky130_fd_sc_hd__decap_4
XFILLER_0_132_109 VPWR VGND VPWR VGND sky130_ef_sc_hd__decap_12
X_6501_ _3112_ VGND VGND VPWR VPWR _0753_ sky130_fd_sc_hd__clkbuf_1
X_7481_ _3660_ VGND VGND VPWR VPWR _3661_ sky130_fd_sc_hd__clkbuf_8
XFILLER_0_16_638 VGND VGND VPWR VPWR sky130_fd_sc_hd__decap_6
X_4693_ rf.registers\[20\]\[22\] rf.registers\[21\]\[22\] rf.registers\[22\]\[22\]
+ rf.registers\[23\]\[22\] _1410_ _1411_ VGND VGND VPWR VPWR _1466_ sky130_fd_sc_hd__mux4_1
XFILLER_0_125_161 VGND VGND VPWR VPWR sky130_fd_sc_hd__decap_6
XFILLER_0_114_813 VPWR VGND VPWR VGND sky130_ef_sc_hd__decap_12
X_9220_ clknet_leaf_18_CLK _0308_ VGND VGND VPWR VPWR rf.registers\[9\]\[19\] sky130_fd_sc_hd__dfxtp_1
XFILLER_0_71_777 VGND VGND VPWR VPWR sky130_fd_sc_hd__decap_6
X_6432_ rf.registers\[11\]\[17\] _3022_ _3067_ VGND VGND VPWR VPWR _3075_ sky130_fd_sc_hd__mux2_1
XFILLER_0_15_137 VPWR VGND VPWR VGND sky130_ef_sc_hd__decap_12
X_9151_ clknet_leaf_16_CLK _0239_ VGND VGND VPWR VPWR rf.registers\[2\]\[14\] sky130_fd_sc_hd__dfxtp_1
XFILLER_0_11_93 VPWR VGND VPWR VGND sky130_ef_sc_hd__decap_12
XFILLER_0_30_118 VGND VGND VPWR VPWR sky130_fd_sc_hd__fill_1
X_8102_ _3353_ rf.registers\[26\]\[3\] _3987_ VGND VGND VPWR VPWR _3991_ sky130_fd_sc_hd__mux2_1
XFILLER_0_87_31 VGND VGND VPWR VPWR sky130_fd_sc_hd__decap_6
X_6363_ net28 VGND VGND VPWR VPWR _3033_ sky130_fd_sc_hd__buf_2
X_9082_ clknet_leaf_32_CLK _0170_ VGND VGND VPWR VPWR rf.registers\[31\]\[9\] sky130_fd_sc_hd__dfxtp_1
X_6294_ _2983_ _2985_ VGND VGND VPWR VPWR _2986_ sky130_fd_sc_hd__nor2_2
XTAP_TAPCELL_ROW_58_1173 VGND VPWR sky130_fd_sc_hd__tapvpwrvgnd_1
X_5314_ rf.registers\[12\]\[23\] rf.registers\[13\]\[23\] rf.registers\[14\]\[23\]
+ rf.registers\[15\]\[23\] _1735_ _1737_ VGND VGND VPWR VPWR _2054_ sky130_fd_sc_hd__mux4_1
X_8033_ _3954_ VGND VGND VPWR VPWR _0419_ sky130_fd_sc_hd__clkbuf_1
X_5245_ _1985_ _1988_ _1744_ VGND VGND VPWR VPWR _1989_ sky130_fd_sc_hd__mux2_1
XTAP_TAPCELL_ROW_71_1362 VGND VPWR sky130_fd_sc_hd__tapvpwrvgnd_1
XFILLER_0_46_3 VPWR VGND VPWR VGND sky130_ef_sc_hd__decap_12
X_5176_ _1773_ VGND VGND VPWR VPWR _1923_ sky130_fd_sc_hd__clkbuf_4
XFILLER_0_127_81 VPWR VGND VPWR VGND sky130_ef_sc_hd__decap_12
XFILLER_0_79_833 VGND VGND VPWR VPWR sky130_fd_sc_hd__decap_6
X_8935_ clknet_leaf_9_CLK _0023_ VGND VGND VPWR VPWR rf.registers\[4\]\[22\] sky130_fd_sc_hd__dfxtp_1
XFILLER_0_78_332 VGND VGND VPWR VPWR sky130_fd_sc_hd__fill_1
XFILLER_0_39_719 VGND VGND VPWR VPWR sky130_fd_sc_hd__decap_8
XFILLER_0_94_825 VPWR VGND VPWR VGND sky130_ef_sc_hd__decap_12
XFILLER_0_78_365 VGND VGND VPWR VPWR sky130_fd_sc_hd__decap_6
X_8866_ clknet_leaf_12_CLK _0978_ VGND VGND VPWR VPWR rf.registers\[6\]\[17\] sky130_fd_sc_hd__dfxtp_1
X_8797_ clknet_leaf_23_CLK _0909_ VGND VGND VPWR VPWR rf.registers\[16\]\[12\] sky130_fd_sc_hd__dfxtp_1
XFILLER_0_78_398 VPWR VGND VPWR VGND sky130_ef_sc_hd__decap_12
X_7817_ rf.registers\[9\]\[30\] _3340_ _3805_ VGND VGND VPWR VPWR _3839_ sky130_fd_sc_hd__mux2_1
XFILLER_0_19_432 VPWR VGND VPWR VGND sky130_ef_sc_hd__decap_12
XFILLER_0_47_741 VPWR VGND VPWR VGND sky130_ef_sc_hd__decap_12
X_7748_ _3802_ VGND VGND VPWR VPWR _0286_ sky130_fd_sc_hd__clkbuf_1
XFILLER_0_47_785 VPWR VGND VPWR VGND sky130_ef_sc_hd__decap_12
X_7679_ _3765_ VGND VGND VPWR VPWR _0254_ sky130_fd_sc_hd__clkbuf_1
XFILLER_0_117_673 VPWR VGND VPWR VGND sky130_ef_sc_hd__decap_12
X_9418_ clknet_leaf_86_CLK _0506_ VGND VGND VPWR VPWR rf.registers\[21\]\[25\] sky130_fd_sc_hd__dfxtp_1
XFILLER_0_132_643 VGND VGND VPWR VPWR sky130_fd_sc_hd__fill_1
XFILLER_0_120_805 VGND VGND VPWR VPWR sky130_fd_sc_hd__decap_6
XFILLER_0_15_671 VGND VGND VPWR VPWR sky130_fd_sc_hd__fill_1
X_9349_ clknet_leaf_76_CLK _0437_ VGND VGND VPWR VPWR rf.registers\[7\]\[20\] sky130_fd_sc_hd__dfxtp_1
XTAP_TAPCELL_ROW_89_1634 VGND VPWR sky130_fd_sc_hd__tapvpwrvgnd_1
XFILLER_0_16_27 VGND VGND VPWR VPWR sky130_fd_sc_hd__fill_1
XFILLER_0_97_685 VPWR VGND VPWR VGND sky130_ef_sc_hd__decap_12
XFILLER_0_127_404 VGND VGND VPWR VPWR sky130_fd_sc_hd__fill_1
XPHY_EDGE_ROW_106_Left_245 VGND VGND VPWR VPWR sky130_fd_sc_hd__decap_3
XTAP_TAPCELL_ROW_100_1801 VGND VPWR sky130_fd_sc_hd__tapvpwrvgnd_1
XTAP_TAPCELL_ROW_13_500 VGND VPWR sky130_fd_sc_hd__tapvpwrvgnd_1
XFILLER_0_32_15 VPWR VGND VPWR VGND sky130_ef_sc_hd__decap_12
XFILLER_0_127_426 VGND VGND VPWR VPWR sky130_fd_sc_hd__decap_3
XFILLER_0_4_307 VGND VGND VPWR VPWR sky130_fd_sc_hd__fill_1
XFILLER_0_25_402 VGND VGND VPWR VPWR sky130_fd_sc_hd__fill_2
XFILLER_0_135_481 VPWR VGND VPWR VGND sky130_ef_sc_hd__decap_12
XTAP_TAPCELL_ROW_133_2300 VGND VPWR sky130_fd_sc_hd__tapvpwrvgnd_1
XFILLER_0_114_109 VPWR VGND VPWR VGND sky130_ef_sc_hd__decap_12
XFILLER_0_108_673 VPWR VGND VPWR VGND sky130_ef_sc_hd__decap_12
XFILLER_0_53_777 VGND VGND VPWR VPWR sky130_fd_sc_hd__decap_6
XFILLER_0_122_153 VPWR VGND VPWR VGND sky130_ef_sc_hd__decap_12
XFILLER_0_122_197 VPWR VGND VPWR VGND sky130_ef_sc_hd__decap_12
XPHY_EDGE_ROW_115_Left_254 VGND VGND VPWR VPWR sky130_fd_sc_hd__decap_3
XTAP_TAPCELL_ROW_111_1963 VGND VPWR sky130_fd_sc_hd__tapvpwrvgnd_1
X_5030_ rf.registers\[8\]\[7\] rf.registers\[9\]\[7\] rf.registers\[10\]\[7\] rf.registers\[11\]\[7\]
+ _1703_ _1704_ VGND VGND VPWR VPWR _1786_ sky130_fd_sc_hd__mux4_1
XTAP_TAPCELL_ROW_53_1092 VGND VPWR sky130_fd_sc_hd__tapvpwrvgnd_1
XFILLER_0_73_55 VGND VGND VPWR VPWR sky130_fd_sc_hd__fill_1
X_6981_ _3394_ VGND VGND VPWR VPWR _0951_ sky130_fd_sc_hd__clkbuf_1
XFILLER_0_73_88 VGND VGND VPWR VPWR sky130_fd_sc_hd__fill_1
XFILLER_0_73_66 VGND VGND VPWR VPWR sky130_fd_sc_hd__fill_2
X_5932_ _1856_ _2621_ _2612_ VGND VGND VPWR VPWR _2651_ sky130_fd_sc_hd__a21boi_1
X_8720_ clknet_leaf_66_CLK _0832_ VGND VGND VPWR VPWR rf.registers\[24\]\[31\] sky130_fd_sc_hd__dfxtp_1
XPHY_EDGE_ROW_124_Left_263 VGND VGND VPWR VPWR sky130_fd_sc_hd__decap_3
XFILLER_0_76_825 VPWR VGND VPWR VGND sky130_ef_sc_hd__decap_12
XFILLER_0_48_549 VGND VGND VPWR VPWR sky130_fd_sc_hd__fill_1
X_8651_ clknet_leaf_70_CLK _0763_ VGND VGND VPWR VPWR rf.registers\[17\]\[26\] sky130_fd_sc_hd__dfxtp_1
X_5863_ _2584_ _2585_ VGND VGND VPWR VPWR _2586_ sky130_fd_sc_hd__nor2_1
X_8582_ clknet_leaf_79_CLK _0694_ VGND VGND VPWR VPWR rf.registers\[12\]\[21\] sky130_fd_sc_hd__dfxtp_1
X_5794_ _2513_ _2514_ _2518_ _2421_ VGND VGND VPWR VPWR _2519_ sky130_fd_sc_hd__a22o_1
X_4814_ rf.registers\[0\]\[29\] rf.registers\[1\]\[29\] rf.registers\[2\]\[29\] rf.registers\[3\]\[29\]
+ _1382_ _1383_ VGND VGND VPWR VPWR _1580_ sky130_fd_sc_hd__mux4_1
X_7602_ _2963_ rf.registers\[27\]\[25\] _3719_ VGND VGND VPWR VPWR _3725_ sky130_fd_sc_hd__mux2_1
XFILLER_0_91_839 VGND VGND VPWR VPWR sky130_fd_sc_hd__fill_1
XFILLER_0_56_593 VGND VGND VPWR VPWR sky130_fd_sc_hd__fill_1
XFILLER_0_29_785 VPWR VGND VPWR VGND sky130_ef_sc_hd__decap_12
X_4745_ rf.registers\[12\]\[25\] rf.registers\[13\]\[25\] rf.registers\[14\]\[25\]
+ rf.registers\[15\]\[25\] _1183_ _1181_ VGND VGND VPWR VPWR _1515_ sky130_fd_sc_hd__mux4_1
X_7533_ _3688_ VGND VGND VPWR VPWR _0185_ sky130_fd_sc_hd__clkbuf_1
XFILLER_0_44_711 VGND VGND VPWR VPWR sky130_fd_sc_hd__fill_1
XFILLER_0_44_733 VGND VGND VPWR VPWR sky130_fd_sc_hd__fill_1
XFILLER_0_133_429 VPWR VGND VPWR VGND sky130_ef_sc_hd__decap_12
XFILLER_0_90_349 VPWR VGND VPWR VGND sky130_ef_sc_hd__decap_12
XFILLER_0_71_552 VGND VGND VPWR VPWR sky130_fd_sc_hd__fill_2
XFILLER_0_7_167 VGND VGND VPWR VPWR sky130_fd_sc_hd__fill_1
XFILLER_0_16_457 VPWR VGND VPWR VGND sky130_ef_sc_hd__decap_12
XFILLER_0_114_643 VGND VGND VPWR VPWR sky130_fd_sc_hd__fill_1
XFILLER_0_98_41 VPWR VGND VPWR VGND sky130_ef_sc_hd__decap_12
XFILLER_0_4_841 VGND VGND VPWR VPWR sky130_fd_sc_hd__fill_1
X_7464_ _3397_ rf.registers\[29\]\[24\] _3647_ VGND VGND VPWR VPWR _3652_ sky130_fd_sc_hd__mux2_1
X_4676_ rf.registers\[20\]\[21\] rf.registers\[21\]\[21\] rf.registers\[22\]\[21\]
+ rf.registers\[23\]\[21\] _1172_ _1173_ VGND VGND VPWR VPWR _1450_ sky130_fd_sc_hd__mux4_1
XPHY_EDGE_ROW_133_Left_272 VGND VGND VPWR VPWR sky130_fd_sc_hd__decap_3
X_9203_ clknet_leaf_46_CLK _0291_ VGND VGND VPWR VPWR rf.registers\[9\]\[2\] sky130_fd_sc_hd__dfxtp_1
XFILLER_0_102_805 VGND VGND VPWR VPWR sky130_fd_sc_hd__decap_6
X_6415_ rf.registers\[11\]\[9\] _3005_ _3056_ VGND VGND VPWR VPWR _3066_ sky130_fd_sc_hd__mux2_1
X_7395_ rf.registers\[8\]\[24\] _3328_ _3610_ VGND VGND VPWR VPWR _3615_ sky130_fd_sc_hd__mux2_1
X_6346_ _3021_ VGND VGND VPWR VPWR _0689_ sky130_fd_sc_hd__clkbuf_1
XTAP_TAPCELL_ROW_73_1402 VGND VPWR sky130_fd_sc_hd__tapvpwrvgnd_1
XFILLER_0_12_663 VGND VGND VPWR VPWR sky130_fd_sc_hd__decap_8
XFILLER_0_3_373 VPWR VGND VPWR VGND sky130_ef_sc_hd__decap_12
X_9134_ clknet_leaf_93_CLK _0222_ VGND VGND VPWR VPWR rf.registers\[27\]\[29\] sky130_fd_sc_hd__dfxtp_1
X_9065_ clknet_leaf_83_CLK _0153_ VGND VGND VPWR VPWR rf.registers\[29\]\[24\] sky130_fd_sc_hd__dfxtp_1
X_8016_ _2972_ rf.registers\[22\]\[27\] _3937_ VGND VGND VPWR VPWR _3945_ sky130_fd_sc_hd__mux2_1
X_6277_ _2973_ VGND VGND VPWR VPWR _0668_ sky130_fd_sc_hd__clkbuf_1
X_5228_ _1969_ _1972_ _1744_ VGND VGND VPWR VPWR _1973_ sky130_fd_sc_hd__mux2_1
X_5159_ rf.registers\[24\]\[15\] rf.registers\[25\]\[15\] rf.registers\[26\]\[15\]
+ rf.registers\[27\]\[15\] _1694_ _1695_ VGND VGND VPWR VPWR _1907_ sky130_fd_sc_hd__mux4_1
XFILLER_0_79_641 VGND VGND VPWR VPWR sky130_fd_sc_hd__decap_8
XTAP_TAPCELL_ROW_84_1553 VGND VPWR sky130_fd_sc_hd__tapvpwrvgnd_1
XFILLER_0_79_685 VPWR VGND VPWR VGND sky130_ef_sc_hd__decap_12
X_8918_ clknet_leaf_65_CLK _0006_ VGND VGND VPWR VPWR rf.registers\[4\]\[5\] sky130_fd_sc_hd__dfxtp_1
X_8849_ clknet_leaf_41_CLK _0961_ VGND VGND VPWR VPWR rf.registers\[6\]\[0\] sky130_fd_sc_hd__dfxtp_1
XTAP_TAPCELL_ROW_84_1564 VGND VPWR sky130_fd_sc_hd__tapvpwrvgnd_1
XFILLER_0_78_173 VGND VGND VPWR VPWR sky130_fd_sc_hd__fill_1
XFILLER_0_136_245 VGND VGND VPWR VPWR sky130_fd_sc_hd__decap_6
XFILLER_0_109_459 VGND VGND VPWR VPWR sky130_fd_sc_hd__decap_4
XFILLER_0_19_284 VGND VGND VPWR VPWR sky130_fd_sc_hd__fill_1
XFILLER_0_136_289 VPWR VGND VPWR VGND sky130_ef_sc_hd__decap_12
XTAP_TAPCELL_ROW_115_2030 VGND VPWR sky130_fd_sc_hd__tapvpwrvgnd_1
XFILLER_0_105_654 VPWR VGND VPWR VGND sky130_ef_sc_hd__decap_12
XFILLER_0_62_574 VGND VGND VPWR VPWR sky130_fd_sc_hd__fill_1
XFILLER_0_50_725 VPWR VGND VPWR VGND sky130_ef_sc_hd__decap_12
XFILLER_0_22_416 VGND VGND VPWR VPWR sky130_fd_sc_hd__decap_4
XFILLER_0_50_769 VPWR VGND VPWR VGND sky130_ef_sc_hd__decap_12
XFILLER_0_22_449 VGND VGND VPWR VPWR sky130_fd_sc_hd__fill_1
XFILLER_0_104_175 VGND VGND VPWR VPWR sky130_fd_sc_hd__fill_2
XFILLER_0_134_27 VGND VGND VPWR VPWR sky130_fd_sc_hd__fill_1
XTAP_TAPCELL_ROW_126_2192 VGND VPWR sky130_fd_sc_hd__tapvpwrvgnd_1
XFILLER_0_89_449 VGND VGND VPWR VPWR sky130_fd_sc_hd__decap_8
XFILLER_0_58_825 VGND VGND VPWR VPWR sky130_fd_sc_hd__decap_8
XFILLER_0_57_302 VGND VGND VPWR VPWR sky130_fd_sc_hd__fill_1
XFILLER_0_128_713 VPWR VGND VPWR VGND sky130_ef_sc_hd__decap_12
XFILLER_0_85_644 VGND VGND VPWR VPWR sky130_fd_sc_hd__decap_6
XTAP_TAPCELL_ROW_46_989 VGND VPWR sky130_fd_sc_hd__tapvpwrvgnd_1
XFILLER_0_127_223 VGND VGND VPWR VPWR sky130_fd_sc_hd__fill_1
XFILLER_0_57_379 VGND VGND VPWR VPWR sky130_fd_sc_hd__fill_1
XTAP_TAPCELL_ROW_26_691 VGND VPWR sky130_fd_sc_hd__tapvpwrvgnd_1
XFILLER_0_128_757 VPWR VGND VPWR VGND sky130_ef_sc_hd__decap_12
XFILLER_0_73_839 VGND VGND VPWR VPWR sky130_fd_sc_hd__fill_1
XFILLER_0_26_733 VPWR VGND VPWR VGND sky130_ef_sc_hd__decap_12
XFILLER_0_72_349 VGND VGND VPWR VPWR sky130_fd_sc_hd__fill_2
XFILLER_0_53_552 VGND VGND VPWR VPWR sky130_fd_sc_hd__decap_8
XFILLER_0_26_755 VGND VGND VPWR VPWR sky130_fd_sc_hd__fill_1
XFILLER_0_104_3 VPWR VGND VPWR VGND sky130_ef_sc_hd__decap_12
X_4530_ _1144_ VGND VGND VPWR VPWR _1312_ sky130_fd_sc_hd__buf_4
XFILLER_0_53_574 VGND VGND VPWR VPWR sky130_fd_sc_hd__fill_2
XFILLER_0_13_405 VPWR VGND VPWR VGND sky130_ef_sc_hd__decap_12
X_4461_ rf.registers\[4\]\[9\] rf.registers\[5\]\[9\] rf.registers\[6\]\[9\] rf.registers\[7\]\[9\]
+ _1118_ _1127_ VGND VGND VPWR VPWR _1247_ sky130_fd_sc_hd__mux4_1
XFILLER_0_80_393 VGND VGND VPWR VPWR sky130_fd_sc_hd__fill_1
XFILLER_0_53_596 VGND VGND VPWR VPWR sky130_fd_sc_hd__fill_2
XFILLER_0_13_449 VPWR VGND VPWR VGND sky130_ef_sc_hd__decap_12
XFILLER_0_123_473 VGND VGND VPWR VPWR sky130_fd_sc_hd__fill_1
X_7180_ rf.registers\[4\]\[19\] _3317_ _3491_ VGND VGND VPWR VPWR _3501_ sky130_fd_sc_hd__mux2_1
XFILLER_0_7_69 VPWR VGND VPWR VGND sky130_ef_sc_hd__decap_12
XFILLER_0_0_321 VGND VGND VPWR VPWR sky130_fd_sc_hd__decap_6
XFILLER_0_1_833 VGND VGND VPWR VPWR sky130_fd_sc_hd__decap_6
X_6200_ _2240_ _2839_ _2902_ _2560_ VGND VGND VPWR VPWR _2903_ sky130_fd_sc_hd__a211o_1
X_4392_ _1121_ VGND VGND VPWR VPWR _1181_ sky130_fd_sc_hd__buf_4
XTAP_TAPCELL_ROW_55_1132 VGND VPWR sky130_fd_sc_hd__tapvpwrvgnd_1
XTAP_TAPCELL_ROW_55_1121 VGND VPWR sky130_fd_sc_hd__tapvpwrvgnd_1
XFILLER_0_21_471 VGND VGND VPWR VPWR sky130_fd_sc_hd__decap_4
X_6131_ _2348_ _2837_ VGND VGND VPWR VPWR _2838_ sky130_fd_sc_hd__nand2_1
XFILLER_0_0_365 VPWR VGND VPWR VGND sky130_ef_sc_hd__decap_12
X_6062_ _2734_ _2744_ _2770_ _2771_ _2772_ VGND VGND VPWR VPWR _2773_ sky130_fd_sc_hd__o311a_1
X_5013_ _1744_ _1769_ VGND VGND VPWR VPWR _1770_ sky130_fd_sc_hd__nand2_1
XFILLER_0_84_76 VGND VGND VPWR VPWR sky130_fd_sc_hd__decap_8
XFILLER_0_108_83 VGND VGND VPWR VPWR sky130_fd_sc_hd__fill_1
XFILLER_0_17_81 VPWR VGND VPWR VGND sky130_ef_sc_hd__decap_12
X_6964_ _3382_ rf.registers\[15\]\[17\] _3368_ VGND VGND VPWR VPWR _3383_ sky130_fd_sc_hd__mux2_1
XPHY_EDGE_ROW_5_Right_5 VGND VGND VPWR VPWR sky130_fd_sc_hd__decap_3
X_8703_ clknet_leaf_27_CLK _0815_ VGND VGND VPWR VPWR rf.registers\[24\]\[14\] sky130_fd_sc_hd__dfxtp_1
XFILLER_0_75_110 VGND VGND VPWR VPWR sky130_fd_sc_hd__fill_2
X_6895_ _3335_ VGND VGND VPWR VPWR _0924_ sky130_fd_sc_hd__clkbuf_1
X_5915_ _2224_ _2230_ _1055_ VGND VGND VPWR VPWR _2634_ sky130_fd_sc_hd__mux2_1
X_8634_ clknet_leaf_34_CLK _0746_ VGND VGND VPWR VPWR rf.registers\[17\]\[9\] sky130_fd_sc_hd__dfxtp_1
XTAP_TAPCELL_ROW_66_1294 VGND VPWR sky130_fd_sc_hd__tapvpwrvgnd_1
XTAP_TAPCELL_ROW_66_1283 VGND VPWR sky130_fd_sc_hd__tapvpwrvgnd_1
X_5846_ _2314_ _2568_ _2326_ VGND VGND VPWR VPWR _2569_ sky130_fd_sc_hd__o21ai_1
XFILLER_0_8_421 VPWR VGND VPWR VGND sky130_ef_sc_hd__decap_12
XFILLER_0_118_245 VGND VGND VPWR VPWR sky130_fd_sc_hd__decap_6
XFILLER_0_76_699 VGND VGND VPWR VPWR sky130_fd_sc_hd__fill_1
XFILLER_0_63_327 VGND VGND VPWR VPWR sky130_fd_sc_hd__decap_3
X_8565_ clknet_leaf_49_CLK _0677_ VGND VGND VPWR VPWR rf.registers\[12\]\[4\] sky130_fd_sc_hd__dfxtp_1
XFILLER_0_16_221 VPWR VGND VPWR VGND sky130_ef_sc_hd__decap_12
X_5777_ _2502_ _2354_ _2236_ VGND VGND VPWR VPWR _2503_ sky130_fd_sc_hd__a21oi_1
XFILLER_0_44_530 VGND VGND VPWR VPWR sky130_fd_sc_hd__fill_2
XFILLER_0_134_749 VGND VGND VPWR VPWR sky130_fd_sc_hd__decap_6
XFILLER_0_133_237 VPWR VGND VPWR VGND sky130_ef_sc_hd__decap_12
XFILLER_0_90_168 VGND VGND VPWR VPWR sky130_fd_sc_hd__fill_1
X_7516_ _3679_ VGND VGND VPWR VPWR _0177_ sky130_fd_sc_hd__clkbuf_1
XFILLER_0_16_265 VPWR VGND VPWR VGND sky130_ef_sc_hd__decap_12
X_8496_ _3047_ rf.registers\[14\]\[29\] _4189_ VGND VGND VPWR VPWR _4199_ sky130_fd_sc_hd__mux2_1
XFILLER_0_32_725 VGND VGND VPWR VPWR sky130_fd_sc_hd__fill_1
X_4728_ _1495_ _1498_ _1135_ VGND VGND VPWR VPWR _1499_ sky130_fd_sc_hd__mux2_1
XFILLER_0_44_563 VPWR VGND VPWR VGND sky130_ef_sc_hd__decap_12
X_7447_ _3380_ rf.registers\[29\]\[16\] _3636_ VGND VGND VPWR VPWR _3643_ sky130_fd_sc_hd__mux2_1
XFILLER_0_71_393 VGND VGND VPWR VPWR sky130_fd_sc_hd__fill_1
X_4659_ rf.registers\[24\]\[20\] rf.registers\[25\]\[20\] rf.registers\[26\]\[20\]
+ rf.registers\[27\]\[20\] _1119_ _1122_ VGND VGND VPWR VPWR _1434_ sky130_fd_sc_hd__mux4_1
XFILLER_0_4_682 VPWR VGND VPWR VGND sky130_ef_sc_hd__decap_12
XFILLER_0_3_181 VPWR VGND VPWR VGND sky130_ef_sc_hd__decap_12
XFILLER_0_32_769 VGND VGND VPWR VPWR sky130_fd_sc_hd__decap_4
X_7378_ rf.registers\[8\]\[16\] _3311_ _3599_ VGND VGND VPWR VPWR _3606_ sky130_fd_sc_hd__mux2_1
X_9117_ clknet_leaf_23_CLK _0205_ VGND VGND VPWR VPWR rf.registers\[27\]\[12\] sky130_fd_sc_hd__dfxtp_1
XFILLER_0_101_178 VGND VGND VPWR VPWR sky130_fd_sc_hd__fill_1
X_6329_ net16 VGND VGND VPWR VPWR _3010_ sky130_fd_sc_hd__clkbuf_2
XFILLER_0_7_7 VPWR VGND VPWR VGND sky130_ef_sc_hd__decap_12
X_9048_ clknet_leaf_53_CLK _0136_ VGND VGND VPWR VPWR rf.registers\[29\]\[7\] sky130_fd_sc_hd__dfxtp_1
XTAP_TAPCELL_ROW_4_364 VGND VPWR sky130_fd_sc_hd__tapvpwrvgnd_1
XTAP_TAPCELL_ROW_4_353 VGND VPWR sky130_fd_sc_hd__tapvpwrvgnd_1
XFILLER_0_13_39 VPWR VGND VPWR VGND sky130_ef_sc_hd__decap_12
XTAP_TAPCELL_ROW_43_948 VGND VPWR sky130_fd_sc_hd__tapvpwrvgnd_1
XFILLER_0_81_113 VGND VGND VPWR VPWR sky130_fd_sc_hd__decap_8
XFILLER_0_55_839 VGND VGND VPWR VPWR sky130_fd_sc_hd__fill_1
XTAP_TAPCELL_ROW_23_650 VGND VPWR sky130_fd_sc_hd__tapvpwrvgnd_1
XFILLER_0_125_727 VGND VGND VPWR VPWR sky130_fd_sc_hd__fill_1
XFILLER_0_54_349 VGND VGND VPWR VPWR sky130_fd_sc_hd__decap_3
XFILLER_0_120_29 VPWR VGND VPWR VGND sky130_ef_sc_hd__decap_12
XFILLER_0_50_500 VGND VGND VPWR VPWR sky130_fd_sc_hd__fill_1
XTAP_TAPCELL_ROW_97_1755 VGND VPWR sky130_fd_sc_hd__tapvpwrvgnd_1
XFILLER_0_35_596 VPWR VGND VPWR VGND sky130_ef_sc_hd__decap_12
XFILLER_0_120_421 VGND VGND VPWR VPWR sky130_fd_sc_hd__fill_1
XFILLER_0_10_419 VGND VGND VPWR VPWR sky130_fd_sc_hd__fill_1
XFILLER_0_31_780 VGND VGND VPWR VPWR sky130_fd_sc_hd__decap_4
XFILLER_0_129_27 VPWR VGND VPWR VGND sky130_ef_sc_hd__decap_12
XFILLER_0_38_47 VGND VGND VPWR VPWR sky130_fd_sc_hd__fill_1
XTAP_TAPCELL_ROW_128_2221 VGND VPWR sky130_fd_sc_hd__tapvpwrvgnd_1
XTAP_TAPCELL_ROW_50_1051 VGND VPWR sky130_fd_sc_hd__tapvpwrvgnd_1
XFILLER_0_58_622 VGND VGND VPWR VPWR sky130_fd_sc_hd__decap_8
XTAP_TAPCELL_ROW_106_1895 VGND VPWR sky130_fd_sc_hd__tapvpwrvgnd_1
XTAP_TAPCELL_ROW_106_1884 VGND VPWR sky130_fd_sc_hd__tapvpwrvgnd_1
XFILLER_0_70_23 VGND VGND VPWR VPWR sky130_fd_sc_hd__fill_2
X_5700_ _2413_ _2423_ _2399_ _2428_ VGND VGND VPWR VPWR net135 sky130_fd_sc_hd__o2bb2a_1
X_6680_ rf.registers\[10\]\[3\] _2993_ _3205_ VGND VGND VPWR VPWR _3209_ sky130_fd_sc_hd__mux2_1
XFILLER_0_58_699 VGND VGND VPWR VPWR sky130_fd_sc_hd__fill_1
XTAP_TAPCELL_ROW_21_609 VGND VPWR sky130_fd_sc_hd__tapvpwrvgnd_1
XFILLER_0_61_809 VPWR VGND VPWR VGND sky130_ef_sc_hd__decap_12
XFILLER_0_26_541 VGND VGND VPWR VPWR sky130_fd_sc_hd__fill_2
X_5631_ _1982_ _2208_ _2209_ VGND VGND VPWR VPWR _2361_ sky130_fd_sc_hd__o21ai_1
XFILLER_0_116_749 VGND VGND VPWR VPWR sky130_fd_sc_hd__decap_6
X_5562_ _2287_ _2292_ _1075_ VGND VGND VPWR VPWR _2293_ sky130_fd_sc_hd__mux2_2
X_8350_ rf.registers\[20\]\[24\] net30 _4117_ VGND VGND VPWR VPWR _4122_ sky130_fd_sc_hd__mux2_1
X_4513_ rf.registers\[12\]\[12\] rf.registers\[13\]\[12\] rf.registers\[14\]\[12\]
+ rf.registers\[15\]\[12\] _1294_ _1295_ VGND VGND VPWR VPWR _1296_ sky130_fd_sc_hd__mux4_1
X_7301_ _3565_ VGND VGND VPWR VPWR _0076_ sky130_fd_sc_hd__clkbuf_1
XFILLER_0_53_393 VGND VGND VPWR VPWR sky130_fd_sc_hd__fill_2
X_8281_ _4085_ VGND VGND VPWR VPWR _0536_ sky130_fd_sc_hd__clkbuf_1
XFILLER_0_124_793 VPWR VGND VPWR VGND sky130_ef_sc_hd__decap_12
XFILLER_0_123_281 VPWR VGND VPWR VGND sky130_ef_sc_hd__decap_12
XFILLER_0_111_410 VGND VGND VPWR VPWR sky130_fd_sc_hd__fill_2
X_7232_ rf.registers\[19\]\[11\] _3301_ _3527_ VGND VGND VPWR VPWR _3529_ sky130_fd_sc_hd__mux2_1
XFILLER_0_14_769 VPWR VGND VPWR VGND sky130_ef_sc_hd__decap_12
X_5493_ _1842_ _2206_ VGND VGND VPWR VPWR _2224_ sky130_fd_sc_hd__nor2_1
X_4444_ rf.registers\[8\]\[8\] rf.registers\[9\]\[8\] rf.registers\[10\]\[8\] rf.registers\[11\]\[8\]
+ _1042_ _1044_ VGND VGND VPWR VPWR _1231_ sky130_fd_sc_hd__mux4_1
XFILLER_0_1_641 VPWR VGND VPWR VGND sky130_ef_sc_hd__decap_12
XFILLER_0_13_279 VGND VGND VPWR VPWR sky130_fd_sc_hd__fill_1
XFILLER_0_95_31 VPWR VGND VPWR VGND sky130_ef_sc_hd__decap_12
X_7163_ _3492_ VGND VGND VPWR VPWR _0011_ sky130_fd_sc_hd__clkbuf_1
X_4375_ rf.registers\[28\]\[5\] rf.registers\[29\]\[5\] rf.registers\[30\]\[5\] rf.registers\[31\]\[5\]
+ _1159_ _1160_ VGND VGND VPWR VPWR _1165_ sky130_fd_sc_hd__mux4_1
XFILLER_0_1_685 VGND VGND VPWR VPWR sky130_fd_sc_hd__decap_8
X_7094_ rf.registers\[5\]\[10\] _3298_ _3455_ VGND VGND VPWR VPWR _3456_ sky130_fd_sc_hd__mux2_1
X_6114_ net95 _2479_ VGND VGND VPWR VPWR _2822_ sky130_fd_sc_hd__and2_1
X_6045_ _2200_ _2646_ _2709_ VGND VGND VPWR VPWR _2757_ sky130_fd_sc_hd__a21oi_2
XFILLER_0_119_93 VPWR VGND VPWR VGND sky130_ef_sc_hd__decap_12
XTAP_TAPCELL_ROW_68_1323 VGND VPWR sky130_fd_sc_hd__tapvpwrvgnd_1
XTAP_TAPCELL_ROW_1_312 VGND VPWR sky130_fd_sc_hd__tapvpwrvgnd_1
XFILLER_0_68_408 VGND VGND VPWR VPWR sky130_fd_sc_hd__decap_3
XFILLER_0_135_81 VPWR VGND VPWR VGND sky130_ef_sc_hd__decap_12
X_7996_ _3934_ VGND VGND VPWR VPWR _0402_ sky130_fd_sc_hd__clkbuf_1
XFILLER_0_49_633 VGND VGND VPWR VPWR sky130_fd_sc_hd__fill_2
X_6947_ _3371_ VGND VGND VPWR VPWR _0940_ sky130_fd_sc_hd__clkbuf_1
XTAP_TAPCELL_ROW_81_1512 VGND VPWR sky130_fd_sc_hd__tapvpwrvgnd_1
XFILLER_0_76_474 VGND VGND VPWR VPWR sky130_fd_sc_hd__fill_2
XTAP_TAPCELL_ROW_40_907 VGND VPWR sky130_fd_sc_hd__tapvpwrvgnd_1
X_6878_ net28 VGND VGND VPWR VPWR _3324_ sky130_fd_sc_hd__buf_2
XFILLER_0_107_727 VGND VGND VPWR VPWR sky130_fd_sc_hd__fill_1
XFILLER_0_91_433 VPWR VGND VPWR VGND sky130_ef_sc_hd__decap_12
XFILLER_0_64_669 VPWR VGND VPWR VGND sky130_ef_sc_hd__decap_12
XFILLER_0_63_146 VGND VGND VPWR VPWR sky130_fd_sc_hd__fill_1
XFILLER_0_9_785 VPWR VGND VPWR VGND sky130_ef_sc_hd__decap_12
XFILLER_0_8_251 VGND VGND VPWR VPWR sky130_fd_sc_hd__fill_1
XFILLER_0_17_541 VGND VGND VPWR VPWR sky130_fd_sc_hd__decap_6
X_5829_ _2500_ _2552_ _2259_ VGND VGND VPWR VPWR _2553_ sky130_fd_sc_hd__mux2_1
X_8617_ clknet_leaf_73_CLK _0729_ VGND VGND VPWR VPWR rf.registers\[11\]\[24\] sky130_fd_sc_hd__dfxtp_1
X_8548_ _3033_ rf.registers\[13\]\[22\] _4216_ VGND VGND VPWR VPWR _4226_ sky130_fd_sc_hd__mux2_1
XFILLER_0_51_319 VGND VGND VPWR VPWR sky130_fd_sc_hd__fill_1
XFILLER_0_134_579 VGND VGND VPWR VPWR sky130_fd_sc_hd__fill_1
XFILLER_0_32_533 VGND VGND VPWR VPWR sky130_fd_sc_hd__decap_6
XTAP_TAPCELL_ROW_79_1485 VGND VPWR sky130_fd_sc_hd__tapvpwrvgnd_1
X_8479_ _4190_ VGND VGND VPWR VPWR _0629_ sky130_fd_sc_hd__clkbuf_1
XFILLER_0_102_443 VGND VGND VPWR VPWR sky130_fd_sc_hd__decap_4
XTAP_TAPCELL_ROW_9_434 VGND VPWR sky130_fd_sc_hd__tapvpwrvgnd_1
XFILLER_0_13_780 VGND VGND VPWR VPWR sky130_fd_sc_hd__decap_4
XTAP_TAPCELL_ROW_92_1685 VGND VPWR sky130_fd_sc_hd__tapvpwrvgnd_1
XTAP_TAPCELL_ROW_92_1674 VGND VPWR sky130_fd_sc_hd__tapvpwrvgnd_1
XFILLER_0_99_511 VGND VGND VPWR VPWR sky130_fd_sc_hd__fill_1
XTAP_TAPCELL_ROW_123_2140 VGND VPWR sky130_fd_sc_hd__tapvpwrvgnd_1
XTAP_TAPCELL_ROW_28_720 VGND VPWR sky130_fd_sc_hd__tapvpwrvgnd_1
XTAP_TAPCELL_ROW_123_2151 VGND VPWR sky130_fd_sc_hd__tapvpwrvgnd_1
XFILLER_0_24_27 VGND VGND VPWR VPWR sky130_fd_sc_hd__fill_1
XFILLER_0_129_329 VGND VGND VPWR VPWR sky130_fd_sc_hd__decap_6
XFILLER_0_138_841 VGND VGND VPWR VPWR sky130_fd_sc_hd__fill_1
XFILLER_0_95_783 VGND VGND VPWR VPWR sky130_fd_sc_hd__fill_1
XFILLER_0_55_625 VGND VGND VPWR VPWR sky130_fd_sc_hd__fill_1
XFILLER_0_137_373 VPWR VGND VPWR VGND sky130_ef_sc_hd__decap_12
XFILLER_0_40_15 VPWR VGND VPWR VGND sky130_ef_sc_hd__decap_12
XFILLER_0_43_809 VPWR VGND VPWR VGND sky130_ef_sc_hd__decap_12
XFILLER_0_82_499 VGND VGND VPWR VPWR sky130_fd_sc_hd__decap_4
XFILLER_0_106_793 VPWR VGND VPWR VGND sky130_ef_sc_hd__decap_12
XFILLER_0_121_741 VPWR VGND VPWR VGND sky130_ef_sc_hd__decap_12
XFILLER_0_50_385 VGND VGND VPWR VPWR sky130_fd_sc_hd__fill_2
XFILLER_0_121_785 VPWR VGND VPWR VGND sky130_ef_sc_hd__decap_12
XFILLER_0_120_251 VGND VGND VPWR VPWR sky130_fd_sc_hd__fill_1
XFILLER_0_120_284 VPWR VGND VPWR VGND sky130_ef_sc_hd__decap_12
XFILLER_0_4_15 VPWR VGND VPWR VGND sky130_ef_sc_hd__decap_12
XTAP_TAPCELL_ROW_108_1924 VGND VPWR sky130_fd_sc_hd__tapvpwrvgnd_1
XTAP_TAPCELL_ROW_108_1913 VGND VPWR sky130_fd_sc_hd__tapvpwrvgnd_1
X_7850_ _3374_ rf.registers\[28\]\[13\] _3853_ VGND VGND VPWR VPWR _3857_ sky130_fd_sc_hd__mux2_1
X_6801_ _3272_ VGND VGND VPWR VPWR _0893_ sky130_fd_sc_hd__clkbuf_1
XFILLER_0_105_51 VGND VGND VPWR VPWR sky130_fd_sc_hd__decap_4
X_7781_ _3820_ VGND VGND VPWR VPWR _0301_ sky130_fd_sc_hd__clkbuf_1
XFILLER_0_93_709 VPWR VGND VPWR VGND sky130_ef_sc_hd__decap_12
X_4993_ rf.registers\[4\]\[5\] rf.registers\[5\]\[5\] rf.registers\[6\]\[5\] rf.registers\[7\]\[5\]
+ _1749_ _1750_ VGND VGND VPWR VPWR _1751_ sky130_fd_sc_hd__mux4_1
XFILLER_0_129_841 VGND VGND VPWR VPWR sky130_fd_sc_hd__fill_1
XTAP_TAPCELL_ROW_63_1242 VGND VPWR sky130_fd_sc_hd__tapvpwrvgnd_1
XFILLER_0_58_474 VGND VGND VPWR VPWR sky130_fd_sc_hd__fill_2
X_9520_ clknet_leaf_62_CLK _0608_ VGND VGND VPWR VPWR rf.registers\[18\]\[31\] sky130_fd_sc_hd__dfxtp_1
XFILLER_0_19_839 VGND VGND VPWR VPWR sky130_fd_sc_hd__fill_1
X_6732_ rf.registers\[10\]\[28\] _3045_ _3227_ VGND VGND VPWR VPWR _3236_ sky130_fd_sc_hd__mux2_1
XFILLER_0_46_603 VPWR VGND VPWR VGND sky130_ef_sc_hd__decap_12
X_9451_ clknet_leaf_70_CLK _0539_ VGND VGND VPWR VPWR rf.registers\[25\]\[26\] sky130_fd_sc_hd__dfxtp_1
XFILLER_0_18_338 VGND VGND VPWR VPWR sky130_fd_sc_hd__fill_1
X_6663_ rf.registers\[24\]\[28\] _3045_ _3190_ VGND VGND VPWR VPWR _3199_ sky130_fd_sc_hd__mux2_1
XFILLER_0_45_113 VGND VGND VPWR VPWR sky130_fd_sc_hd__fill_2
X_8402_ _4149_ VGND VGND VPWR VPWR _0593_ sky130_fd_sc_hd__clkbuf_1
XFILLER_0_33_319 VGND VGND VPWR VPWR sky130_fd_sc_hd__fill_1
X_5614_ _2342_ _2343_ VGND VGND VPWR VPWR _2344_ sky130_fd_sc_hd__or2b_1
X_9382_ clknet_leaf_81_CLK _0470_ VGND VGND VPWR VPWR rf.registers\[26\]\[21\] sky130_fd_sc_hd__dfxtp_1
XFILLER_0_6_755 VGND VGND VPWR VPWR sky130_fd_sc_hd__fill_1
XFILLER_0_14_533 VPWR VGND VPWR VGND sky130_ef_sc_hd__decap_12
X_6594_ rf.registers\[1\]\[28\] _3045_ _3153_ VGND VGND VPWR VPWR _3162_ sky130_fd_sc_hd__mux2_1
X_8333_ rf.registers\[20\]\[16\] net21 _4106_ VGND VGND VPWR VPWR _4113_ sky130_fd_sc_hd__mux2_1
XFILLER_0_14_566 VGND VGND VPWR VPWR sky130_fd_sc_hd__decap_4
X_5545_ _2100_ _2218_ VGND VGND VPWR VPWR _2276_ sky130_fd_sc_hd__nor2_1
X_8264_ _4076_ VGND VGND VPWR VPWR _0528_ sky130_fd_sc_hd__clkbuf_1
XFILLER_0_76_3 VPWR VGND VPWR VGND sky130_ef_sc_hd__decap_12
XFILLER_0_14_599 VPWR VGND VPWR VGND sky130_ef_sc_hd__decap_12
X_5476_ _2206_ VGND VGND VPWR VPWR _2207_ sky130_fd_sc_hd__buf_2
X_7215_ rf.registers\[19\]\[3\] _3284_ _3516_ VGND VGND VPWR VPWR _3520_ sky130_fd_sc_hd__mux2_1
X_8195_ _3378_ rf.registers\[21\]\[15\] _4034_ VGND VGND VPWR VPWR _4040_ sky130_fd_sc_hd__mux2_1
X_4427_ _1213_ _1214_ _1137_ VGND VGND VPWR VPWR _1215_ sky130_fd_sc_hd__mux2_1
X_7146_ _3483_ VGND VGND VPWR VPWR _0003_ sky130_fd_sc_hd__clkbuf_1
X_4358_ _1148_ VGND VGND VPWR VPWR _1149_ sky130_fd_sc_hd__buf_4
X_4289_ _1061_ _1081_ VGND VGND VPWR VPWR _1082_ sky130_fd_sc_hd__nand2_1
X_7077_ rf.registers\[5\]\[2\] _3282_ _3444_ VGND VGND VPWR VPWR _3447_ sky130_fd_sc_hd__mux2_1
X_6028_ net90 _2740_ VGND VGND VPWR VPWR _2741_ sky130_fd_sc_hd__xnor2_4
X_7979_ _3925_ VGND VGND VPWR VPWR _0394_ sky130_fd_sc_hd__clkbuf_1
XFILLER_0_68_249 VGND VGND VPWR VPWR sky130_fd_sc_hd__decap_3
XFILLER_0_138_137 VGND VGND VPWR VPWR sky130_fd_sc_hd__decap_3
XFILLER_0_77_783 VGND VGND VPWR VPWR sky130_fd_sc_hd__fill_1
XFILLER_0_37_625 VPWR VGND VPWR VGND sky130_ef_sc_hd__decap_12
XFILLER_0_135_833 VGND VGND VPWR VPWR sky130_fd_sc_hd__decap_6
XFILLER_0_134_321 VPWR VGND VPWR VGND sky130_ef_sc_hd__decap_12
XFILLER_0_64_477 VGND VGND VPWR VPWR sky130_fd_sc_hd__decap_3
XFILLER_0_64_466 VGND VGND VPWR VPWR sky130_fd_sc_hd__decap_3
XFILLER_0_134_365 VPWR VGND VPWR VGND sky130_ef_sc_hd__decap_12
XFILLER_0_107_557 VGND VGND VPWR VPWR sky130_fd_sc_hd__decap_3
XFILLER_0_64_499 VGND VGND VPWR VPWR sky130_fd_sc_hd__fill_1
XFILLER_0_51_116 VGND VGND VPWR VPWR sky130_fd_sc_hd__fill_2
XFILLER_0_17_360 VPWR VGND VPWR VGND sky130_ef_sc_hd__decap_12
XFILLER_0_17_382 VGND VGND VPWR VPWR sky130_fd_sc_hd__decap_8
XFILLER_0_45_680 VGND VGND VPWR VPWR sky130_fd_sc_hd__decap_4
XTAP_TAPCELL_ROW_94_1714 VGND VPWR sky130_fd_sc_hd__tapvpwrvgnd_1
XTAP_TAPCELL_ROW_94_1703 VGND VPWR sky130_fd_sc_hd__tapvpwrvgnd_1
XFILLER_0_10_29 VPWR VGND VPWR VGND sky130_ef_sc_hd__decap_12
XFILLER_0_17_393 VPWR VGND VPWR VGND sky130_ef_sc_hd__decap_12
XFILLER_0_103_741 VPWR VGND VPWR VGND sky130_ef_sc_hd__decap_12
XFILLER_0_103_785 VPWR VGND VPWR VGND sky130_ef_sc_hd__decap_12
XFILLER_0_20_558 VPWR VGND VPWR VGND sky130_ef_sc_hd__decap_12
XFILLER_0_75_709 VPWR VGND VPWR VGND sky130_ef_sc_hd__decap_12
XFILLER_0_129_137 VPWR VGND VPWR VGND sky130_ef_sc_hd__decap_12
XTAP_TAPCELL_ROW_103_1843 VGND VPWR sky130_fd_sc_hd__tapvpwrvgnd_1
XFILLER_0_51_25 VPWR VGND VPWR VGND sky130_ef_sc_hd__decap_12
XFILLER_0_28_603 VGND VGND VPWR VPWR sky130_fd_sc_hd__fill_1
XFILLER_0_126_811 VGND VGND VPWR VPWR sky130_fd_sc_hd__fill_1
XFILLER_0_83_753 VPWR VGND VPWR VGND sky130_ef_sc_hd__decap_12
XFILLER_0_137_181 VPWR VGND VPWR VGND sky130_ef_sc_hd__decap_12
XFILLER_0_28_669 VGND VGND VPWR VPWR sky130_fd_sc_hd__decap_6
XTAP_TAPCELL_ROW_31_759 VGND VPWR sky130_fd_sc_hd__tapvpwrvgnd_1
XFILLER_0_43_617 VPWR VGND VPWR VGND sky130_ef_sc_hd__decap_12
XTAP_TAPCELL_ROW_136_2342 VGND VPWR sky130_fd_sc_hd__tapvpwrvgnd_1
XFILLER_0_113_505 VGND VGND VPWR VPWR sky130_fd_sc_hd__fill_2
XFILLER_0_83_797 VPWR VGND VPWR VGND sky130_ef_sc_hd__decap_12
XFILLER_0_42_116 VGND VGND VPWR VPWR sky130_fd_sc_hd__fill_2
Xclkload23 clknet_leaf_8_CLK VGND VGND VPWR VPWR clkload23/Y sky130_fd_sc_hd__clkinvlp_2
XTAP_TAPCELL_ROW_11_472 VGND VPWR sky130_fd_sc_hd__tapvpwrvgnd_1
XTAP_TAPCELL_ROW_11_461 VGND VPWR sky130_fd_sc_hd__tapvpwrvgnd_1
Xclkload34 clknet_leaf_69_CLK VGND VGND VPWR VPWR clkload34/Y sky130_fd_sc_hd__inv_6
Xclkload12 clknet_leaf_88_CLK VGND VGND VPWR VPWR clkload12/Y sky130_fd_sc_hd__inv_6
Xclkload67 clknet_leaf_36_CLK VGND VGND VPWR VPWR clkload67/Y sky130_fd_sc_hd__clkinv_4
Xclkload56 clknet_leaf_29_CLK VGND VGND VPWR VPWR clkload56/Y sky130_fd_sc_hd__clkinv_4
Xclkload78 clknet_leaf_57_CLK VGND VGND VPWR VPWR clkload78/Y sky130_fd_sc_hd__clkinv_4
Xclkload45 clknet_leaf_66_CLK VGND VGND VPWR VPWR clkload45/Y sky130_fd_sc_hd__inv_8
XFILLER_0_11_503 VGND VGND VPWR VPWR sky130_fd_sc_hd__fill_1
X_5330_ _2065_ _2068_ _1950_ VGND VGND VPWR VPWR _2069_ sky130_fd_sc_hd__mux2_1
Xclkload89 clknet_leaf_45_CLK VGND VGND VPWR VPWR clkload89/Y sky130_fd_sc_hd__clkinvlp_2
XFILLER_0_50_171 VGND VGND VPWR VPWR sky130_fd_sc_hd__decap_6
X_5261_ rf.registers\[20\]\[20\] rf.registers\[21\]\[20\] rf.registers\[22\]\[20\]
+ rf.registers\[23\]\[20\] _1999_ _2000_ VGND VGND VPWR VPWR _2004_ sky130_fd_sc_hd__mux4_1
X_7000_ _2980_ rf.registers\[15\]\[31\] _3346_ VGND VGND VPWR VPWR _3405_ sky130_fd_sc_hd__mux2_1
X_5192_ _1728_ _1928_ _1938_ VGND VGND VPWR VPWR _1939_ sky130_fd_sc_hd__o21ai_4
XFILLER_0_76_55 VGND VGND VPWR VPWR sky130_fd_sc_hd__decap_8
X_8951_ clknet_leaf_56_CLK _0039_ VGND VGND VPWR VPWR rf.registers\[19\]\[6\] sky130_fd_sc_hd__dfxtp_1
X_7902_ _3357_ rf.registers\[23\]\[5\] _3879_ VGND VGND VPWR VPWR _3885_ sky130_fd_sc_hd__mux2_1
X_8882_ clknet_leaf_45_CLK _0994_ VGND VGND VPWR VPWR rf.registers\[5\]\[1\] sky130_fd_sc_hd__dfxtp_1
XFILLER_0_116_83 VGND VGND VPWR VPWR sky130_fd_sc_hd__fill_1
X_7833_ _3357_ rf.registers\[28\]\[5\] _3842_ VGND VGND VPWR VPWR _3848_ sky130_fd_sc_hd__mux2_1
XTAP_TAPCELL_ROW_19_583 VGND VPWR sky130_fd_sc_hd__tapvpwrvgnd_1
X_7764_ _3811_ VGND VGND VPWR VPWR _0293_ sky130_fd_sc_hd__clkbuf_1
XFILLER_0_59_783 VGND VGND VPWR VPWR sky130_fd_sc_hd__fill_1
X_9503_ clknet_leaf_28_CLK _0591_ VGND VGND VPWR VPWR rf.registers\[18\]\[14\] sky130_fd_sc_hd__dfxtp_1
X_4976_ _1655_ VGND VGND VPWR VPWR _1734_ sky130_fd_sc_hd__buf_4
X_6715_ _3204_ VGND VGND VPWR VPWR _3227_ sky130_fd_sc_hd__clkbuf_8
XFILLER_0_117_833 VGND VGND VPWR VPWR sky130_fd_sc_hd__decap_6
X_7695_ _3355_ rf.registers\[30\]\[4\] _3770_ VGND VGND VPWR VPWR _3775_ sky130_fd_sc_hd__mux2_1
Xclkload6 clknet_3_7__leaf_CLK VGND VGND VPWR VPWR clkload6/Y sky130_fd_sc_hd__clkinv_8
X_9434_ clknet_leaf_55_CLK _0522_ VGND VGND VPWR VPWR rf.registers\[25\]\[9\] sky130_fd_sc_hd__dfxtp_1
XFILLER_0_73_296 VGND VGND VPWR VPWR sky130_fd_sc_hd__fill_2
XFILLER_0_18_179 VGND VGND VPWR VPWR sky130_fd_sc_hd__decap_8
XFILLER_0_34_628 VGND VGND VPWR VPWR sky130_fd_sc_hd__decap_6
X_6646_ _3167_ VGND VGND VPWR VPWR _3190_ sky130_fd_sc_hd__buf_4
XFILLER_0_132_825 VPWR VGND VPWR VGND sky130_ef_sc_hd__decap_12
XFILLER_0_116_365 VGND VGND VPWR VPWR sky130_fd_sc_hd__fill_2
X_9365_ clknet_leaf_56_CLK _0453_ VGND VGND VPWR VPWR rf.registers\[26\]\[4\] sky130_fd_sc_hd__dfxtp_1
XFILLER_0_61_447 VGND VGND VPWR VPWR sky130_fd_sc_hd__fill_1
X_6577_ _3130_ VGND VGND VPWR VPWR _3153_ sky130_fd_sc_hd__clkbuf_8
XFILLER_0_131_335 VGND VGND VPWR VPWR sky130_fd_sc_hd__fill_1
X_8316_ rf.registers\[20\]\[8\] net44 _4095_ VGND VGND VPWR VPWR _4104_ sky130_fd_sc_hd__mux2_1
XTAP_TAPCELL_ROW_76_1433 VGND VPWR sky130_fd_sc_hd__tapvpwrvgnd_1
XFILLER_0_14_363 VGND VGND VPWR VPWR sky130_fd_sc_hd__fill_1
X_5528_ _2233_ VGND VGND VPWR VPWR _2259_ sky130_fd_sc_hd__clkbuf_4
XFILLER_0_42_672 VPWR VGND VPWR VGND sky130_ef_sc_hd__decap_12
XTAP_TAPCELL_ROW_76_1444 VGND VPWR sky130_fd_sc_hd__tapvpwrvgnd_1
X_9296_ clknet_leaf_62_CLK _0384_ VGND VGND VPWR VPWR rf.registers\[23\]\[31\] sky130_fd_sc_hd__dfxtp_1
X_8247_ _4067_ VGND VGND VPWR VPWR _0520_ sky130_fd_sc_hd__clkbuf_1
X_5459_ _2189_ _2190_ _2074_ VGND VGND VPWR VPWR _2191_ sky130_fd_sc_hd__mux2_1
XFILLER_0_100_755 VGND VGND VPWR VPWR sky130_fd_sc_hd__fill_1
X_8178_ _3361_ rf.registers\[21\]\[7\] _4023_ VGND VGND VPWR VPWR _4031_ sky130_fd_sc_hd__mux2_1
X_7129_ rf.registers\[5\]\[27\] _3334_ _3466_ VGND VGND VPWR VPWR _3474_ sky130_fd_sc_hd__mux2_1
XFILLER_0_57_709 VPWR VGND VPWR VGND sky130_ef_sc_hd__decap_12
XTAP_TAPCELL_ROW_38_870 VGND VPWR sky130_fd_sc_hd__tapvpwrvgnd_1
XFILLER_0_108_811 VGND VGND VPWR VPWR sky130_fd_sc_hd__fill_1
XFILLER_0_119_181 VPWR VGND VPWR VGND sky130_ef_sc_hd__decap_12
XFILLER_0_80_701 VPWR VGND VPWR VGND sky130_ef_sc_hd__decap_12
XFILLER_0_65_753 VPWR VGND VPWR VGND sky130_ef_sc_hd__decap_12
XFILLER_0_25_617 VPWR VGND VPWR VGND sky130_ef_sc_hd__decap_12
XFILLER_0_37_444 VGND VGND VPWR VPWR sky130_fd_sc_hd__decap_4
XFILLER_0_135_641 VPWR VGND VPWR VGND sky130_ef_sc_hd__decap_12
XFILLER_0_65_797 VPWR VGND VPWR VGND sky130_ef_sc_hd__decap_12
XFILLER_0_18_680 VPWR VGND VPWR VGND sky130_ef_sc_hd__decap_12
XFILLER_0_21_39 VPWR VGND VPWR VGND sky130_ef_sc_hd__decap_12
XFILLER_0_135_685 VPWR VGND VPWR VGND sky130_ef_sc_hd__decap_12
XTAP_TAPCELL_ROW_118_2072 VGND VPWR sky130_fd_sc_hd__tapvpwrvgnd_1
XFILLER_0_52_458 VGND VGND VPWR VPWR sky130_fd_sc_hd__decap_8
XFILLER_0_134_195 VGND VGND VPWR VPWR sky130_fd_sc_hd__fill_1
XFILLER_0_107_398 VGND VGND VPWR VPWR sky130_fd_sc_hd__fill_1
XFILLER_0_122_357 VGND VGND VPWR VPWR sky130_fd_sc_hd__decap_6
Xclkbuf_leaf_70_CLK clknet_3_2__leaf_CLK VGND VGND VPWR VPWR clknet_leaf_70_CLK sky130_fd_sc_hd__clkbuf_8
XFILLER_0_32_193 VGND VGND VPWR VPWR sky130_fd_sc_hd__decap_3
XTAP_TAPCELL_ROW_131_2272 VGND VPWR sky130_fd_sc_hd__tapvpwrvgnd_1
XTAP_TAPCELL_ROW_131_2261 VGND VPWR sky130_fd_sc_hd__tapvpwrvgnd_1
XFILLER_0_137_27 VPWR VGND VPWR VGND sky130_ef_sc_hd__decap_12
XFILLER_0_1_27 VPWR VGND VPWR VGND sky130_ef_sc_hd__decap_12
XTAP_TAPCELL_ROW_47_1001 VGND VPWR sky130_fd_sc_hd__tapvpwrvgnd_1
XTAP_TAPCELL_ROW_47_1012 VGND VPWR sky130_fd_sc_hd__tapvpwrvgnd_1
X_4830_ rf.registers\[8\]\[30\] rf.registers\[9\]\[30\] rf.registers\[10\]\[30\] rf.registers\[11\]\[30\]
+ _1147_ _1149_ VGND VGND VPWR VPWR _1595_ sky130_fd_sc_hd__mux4_1
XTAP_TAPCELL_ROW_16_542 VGND VPWR sky130_fd_sc_hd__tapvpwrvgnd_1
XFILLER_0_134_3 VPWR VGND VPWR VGND sky130_ef_sc_hd__decap_12
XTAP_TAPCELL_ROW_60_1201 VGND VPWR sky130_fd_sc_hd__tapvpwrvgnd_1
XFILLER_0_7_305 VPWR VGND VPWR VGND sky130_ef_sc_hd__decap_12
X_4761_ rf.registers\[8\]\[26\] rf.registers\[9\]\[26\] rf.registers\[10\]\[26\] rf.registers\[11\]\[26\]
+ _1159_ _1160_ VGND VGND VPWR VPWR _1530_ sky130_fd_sc_hd__mux4_1
XFILLER_0_126_652 VPWR VGND VPWR VGND sky130_ef_sc_hd__decap_12
X_6500_ rf.registers\[17\]\[16\] _3020_ _3105_ VGND VGND VPWR VPWR _3112_ sky130_fd_sc_hd__mux2_1
X_7480_ _3345_ _3623_ VGND VGND VPWR VPWR _3660_ sky130_fd_sc_hd__nand2_4
XFILLER_0_7_349 VPWR VGND VPWR VGND sky130_ef_sc_hd__decap_12
XFILLER_0_15_105 VGND VGND VPWR VPWR sky130_fd_sc_hd__decap_6
XFILLER_0_28_477 VGND VGND VPWR VPWR sky130_fd_sc_hd__fill_1
X_4692_ rf.registers\[16\]\[22\] rf.registers\[17\]\[22\] rf.registers\[18\]\[22\]
+ rf.registers\[19\]\[22\] _1410_ _1411_ VGND VGND VPWR VPWR _1465_ sky130_fd_sc_hd__mux4_1
XFILLER_0_114_825 VPWR VGND VPWR VGND sky130_ef_sc_hd__decap_12
XFILLER_0_102_41 VPWR VGND VPWR VGND sky130_ef_sc_hd__decap_12
X_6431_ _3074_ VGND VGND VPWR VPWR _0721_ sky130_fd_sc_hd__clkbuf_1
XFILLER_0_15_149 VPWR VGND VPWR VGND sky130_ef_sc_hd__decap_12
XFILLER_0_43_447 VGND VGND VPWR VPWR sky130_fd_sc_hd__fill_1
XFILLER_0_102_85 VGND VGND VPWR VPWR sky130_fd_sc_hd__fill_2
X_9150_ clknet_leaf_29_CLK _0238_ VGND VGND VPWR VPWR rf.registers\[2\]\[13\] sky130_fd_sc_hd__dfxtp_1
X_6362_ _3032_ VGND VGND VPWR VPWR _0694_ sky130_fd_sc_hd__clkbuf_1
XFILLER_0_24_672 VPWR VGND VPWR VGND sky130_ef_sc_hd__decap_12
X_8101_ _3990_ VGND VGND VPWR VPWR _0451_ sky130_fd_sc_hd__clkbuf_1
Xclkbuf_leaf_61_CLK clknet_3_3__leaf_CLK VGND VGND VPWR VPWR clknet_leaf_61_CLK sky130_fd_sc_hd__clkbuf_8
X_5313_ _2049_ _2052_ _1744_ VGND VGND VPWR VPWR _2053_ sky130_fd_sc_hd__mux2_1
X_9081_ clknet_leaf_37_CLK _0169_ VGND VGND VPWR VPWR rf.registers\[31\]\[8\] sky130_fd_sc_hd__dfxtp_1
X_6293_ _2984_ VGND VGND VPWR VPWR _2985_ sky130_fd_sc_hd__buf_4
XTAP_TAPCELL_ROW_58_1174 VGND VPWR sky130_fd_sc_hd__tapvpwrvgnd_1
XTAP_TAPCELL_ROW_58_1163 VGND VPWR sky130_fd_sc_hd__tapvpwrvgnd_1
X_8032_ rf.registers\[7\]\[2\] _3282_ _3951_ VGND VGND VPWR VPWR _3954_ sky130_fd_sc_hd__mux2_1
X_5244_ _1986_ _1987_ _1747_ VGND VGND VPWR VPWR _1988_ sky130_fd_sc_hd__mux2_1
XTAP_TAPCELL_ROW_71_1363 VGND VPWR sky130_fd_sc_hd__tapvpwrvgnd_1
X_5175_ _1772_ VGND VGND VPWR VPWR _1922_ sky130_fd_sc_hd__buf_4
XFILLER_0_127_93 VPWR VGND VPWR VGND sky130_ef_sc_hd__decap_12
X_8934_ clknet_leaf_75_CLK _0022_ VGND VGND VPWR VPWR rf.registers\[4\]\[21\] sky130_fd_sc_hd__dfxtp_1
X_8865_ clknet_leaf_13_CLK _0977_ VGND VGND VPWR VPWR rf.registers\[6\]\[16\] sky130_fd_sc_hd__dfxtp_1
XFILLER_0_94_837 VGND VGND VPWR VPWR sky130_fd_sc_hd__fill_2
XFILLER_0_66_517 VPWR VGND VPWR VGND sky130_ef_sc_hd__decap_12
X_7816_ _3838_ VGND VGND VPWR VPWR _0318_ sky130_fd_sc_hd__clkbuf_1
X_8796_ clknet_leaf_30_CLK _0908_ VGND VGND VPWR VPWR rf.registers\[16\]\[11\] sky130_fd_sc_hd__dfxtp_1
X_4959_ _1714_ _1717_ _1628_ VGND VGND VPWR VPWR _1718_ sky130_fd_sc_hd__mux2_1
XFILLER_0_62_701 VPWR VGND VPWR VGND sky130_ef_sc_hd__decap_12
XFILLER_0_19_444 VGND VGND VPWR VPWR sky130_fd_sc_hd__decap_4
X_7747_ _2976_ rf.registers\[30\]\[29\] _3792_ VGND VGND VPWR VPWR _3802_ sky130_fd_sc_hd__mux2_1
XFILLER_0_46_230 VGND VGND VPWR VPWR sky130_fd_sc_hd__decap_6
XFILLER_0_47_753 VPWR VGND VPWR VGND sky130_ef_sc_hd__decap_12
XFILLER_0_117_652 VPWR VGND VPWR VGND sky130_ef_sc_hd__decap_12
XFILLER_0_117_641 VGND VGND VPWR VPWR sky130_fd_sc_hd__fill_2
X_7678_ rf.registers\[2\]\[29\] _3338_ _3755_ VGND VGND VPWR VPWR _3765_ sky130_fd_sc_hd__mux2_1
XFILLER_0_47_797 VPWR VGND VPWR VGND sky130_ef_sc_hd__decap_12
XFILLER_0_117_685 VPWR VGND VPWR VGND sky130_ef_sc_hd__decap_12
X_6629_ _3181_ VGND VGND VPWR VPWR _0812_ sky130_fd_sc_hd__clkbuf_1
XFILLER_0_62_745 VGND VGND VPWR VPWR sky130_fd_sc_hd__decap_8
XFILLER_0_61_222 VGND VGND VPWR VPWR sky130_fd_sc_hd__fill_2
X_9417_ clknet_leaf_84_CLK _0505_ VGND VGND VPWR VPWR rf.registers\[21\]\[24\] sky130_fd_sc_hd__dfxtp_1
XFILLER_0_116_195 VGND VGND VPWR VPWR sky130_fd_sc_hd__fill_1
XFILLER_0_15_650 VGND VGND VPWR VPWR sky130_fd_sc_hd__decap_4
Xclkbuf_leaf_52_CLK clknet_3_6__leaf_CLK VGND VGND VPWR VPWR clknet_leaf_52_CLK sky130_fd_sc_hd__clkbuf_8
X_9348_ clknet_leaf_19_CLK _0436_ VGND VGND VPWR VPWR rf.registers\[7\]\[19\] sky130_fd_sc_hd__dfxtp_1
XFILLER_0_61_299 VGND VGND VPWR VPWR sky130_fd_sc_hd__fill_1
XFILLER_0_132_699 VGND VGND VPWR VPWR sky130_fd_sc_hd__fill_1
X_9279_ clknet_leaf_25_CLK _0367_ VGND VGND VPWR VPWR rf.registers\[23\]\[14\] sky130_fd_sc_hd__dfxtp_1
XFILLER_0_107_19 VPWR VGND VPWR VGND sky130_ef_sc_hd__decap_12
XTAP_TAPCELL_ROW_89_1635 VGND VPWR sky130_fd_sc_hd__tapvpwrvgnd_1
XFILLER_0_97_631 VGND VGND VPWR VPWR sky130_fd_sc_hd__decap_4
XFILLER_0_96_130 VGND VGND VPWR VPWR sky130_fd_sc_hd__fill_1
XFILLER_0_97_697 VPWR VGND VPWR VGND sky130_ef_sc_hd__decap_12
XFILLER_0_96_141 VGND VGND VPWR VPWR sky130_fd_sc_hd__fill_1
XFILLER_0_84_303 VGND VGND VPWR VPWR sky130_fd_sc_hd__fill_2
XTAP_TAPCELL_ROW_100_1802 VGND VPWR sky130_fd_sc_hd__tapvpwrvgnd_1
XFILLER_0_32_27 VGND VGND VPWR VPWR sky130_fd_sc_hd__fill_1
XFILLER_0_65_550 VGND VGND VPWR VPWR sky130_fd_sc_hd__fill_1
XTAP_TAPCELL_ROW_13_501 VGND VPWR sky130_fd_sc_hd__tapvpwrvgnd_1
XFILLER_0_127_449 VGND VGND VPWR VPWR sky130_fd_sc_hd__fill_1
XFILLER_0_108_641 VGND VGND VPWR VPWR sky130_fd_sc_hd__decap_3
XFILLER_0_108_630 VGND VGND VPWR VPWR sky130_fd_sc_hd__fill_2
XFILLER_0_5_809 VPWR VGND VPWR VGND sky130_ef_sc_hd__decap_12
XTAP_TAPCELL_ROW_133_2301 VGND VPWR sky130_fd_sc_hd__tapvpwrvgnd_1
XFILLER_0_108_685 VPWR VGND VPWR VGND sky130_ef_sc_hd__decap_12
XFILLER_0_122_121 VPWR VGND VPWR VGND sky130_ef_sc_hd__decap_12
Xclkbuf_leaf_43_CLK clknet_3_7__leaf_CLK VGND VGND VPWR VPWR clknet_leaf_43_CLK sky130_fd_sc_hd__clkbuf_8
XFILLER_0_122_165 VPWR VGND VPWR VGND sky130_ef_sc_hd__decap_12
XFILLER_0_40_428 VGND VGND VPWR VPWR sky130_fd_sc_hd__fill_1
XFILLER_0_111_839 VGND VGND VPWR VPWR sky130_fd_sc_hd__fill_1
XFILLER_0_0_547 VPWR VGND VPWR VGND sky130_ef_sc_hd__decap_12
XFILLER_0_0_569 VGND VGND VPWR VPWR sky130_fd_sc_hd__fill_2
XFILLER_0_20_174 VGND VGND VPWR VPWR sky130_fd_sc_hd__decap_6
XTAP_TAPCELL_ROW_111_1964 VGND VPWR sky130_fd_sc_hd__tapvpwrvgnd_1
XFILLER_0_57_57 VPWR VGND VPWR VGND sky130_ef_sc_hd__decap_12
XTAP_TAPCELL_ROW_53_1093 VGND VPWR sky130_fd_sc_hd__tapvpwrvgnd_1
X_6980_ _3393_ rf.registers\[15\]\[22\] _3389_ VGND VGND VPWR VPWR _3394_ sky130_fd_sc_hd__mux2_1
X_5931_ _2579_ _2591_ _2614_ _2622_ VGND VGND VPWR VPWR _2650_ sky130_fd_sc_hd__or4bb_1
XFILLER_0_76_837 VGND VGND VPWR VPWR sky130_fd_sc_hd__fill_2
X_8650_ clknet_leaf_86_CLK _0762_ VGND VGND VPWR VPWR rf.registers\[17\]\[25\] sky130_fd_sc_hd__dfxtp_1
X_5862_ _2579_ _2583_ VGND VGND VPWR VPWR _2585_ sky130_fd_sc_hd__and2_1
X_8581_ clknet_leaf_9_CLK _0693_ VGND VGND VPWR VPWR rf.registers\[12\]\[20\] sky130_fd_sc_hd__dfxtp_1
XFILLER_0_8_614 VPWR VGND VPWR VGND sky130_ef_sc_hd__decap_12
XFILLER_0_7_113 VPWR VGND VPWR VGND sky130_ef_sc_hd__decap_12
X_5793_ _2237_ _2515_ _2517_ VGND VGND VPWR VPWR _2518_ sky130_fd_sc_hd__o21ai_1
X_4813_ rf.registers\[4\]\[29\] rf.registers\[5\]\[29\] rf.registers\[6\]\[29\] rf.registers\[7\]\[29\]
+ _1382_ _1383_ VGND VGND VPWR VPWR _1579_ sky130_fd_sc_hd__mux4_1
X_7601_ _3724_ VGND VGND VPWR VPWR _0217_ sky130_fd_sc_hd__clkbuf_1
XFILLER_0_113_51 VGND VGND VPWR VPWR sky130_fd_sc_hd__decap_4
XFILLER_0_29_797 VPWR VGND VPWR VGND sky130_ef_sc_hd__decap_12
X_4744_ rf.registers\[8\]\[25\] rf.registers\[9\]\[25\] rf.registers\[10\]\[25\] rf.registers\[11\]\[25\]
+ _1183_ _1181_ VGND VGND VPWR VPWR _1514_ sky130_fd_sc_hd__mux4_1
X_7532_ _3397_ rf.registers\[31\]\[24\] _3683_ VGND VGND VPWR VPWR _3688_ sky130_fd_sc_hd__mux2_1
XFILLER_0_71_531 VGND VGND VPWR VPWR sky130_fd_sc_hd__decap_6
XFILLER_0_22_71 VGND VGND VPWR VPWR sky130_fd_sc_hd__fill_1
X_9202_ clknet_leaf_45_CLK _0290_ VGND VGND VPWR VPWR rf.registers\[9\]\[1\] sky130_fd_sc_hd__dfxtp_1
XFILLER_0_98_53 VGND VGND VPWR VPWR sky130_fd_sc_hd__decap_8
X_4675_ _1291_ _1448_ VGND VGND VPWR VPWR _1449_ sky130_fd_sc_hd__nand2_1
X_7463_ _3651_ VGND VGND VPWR VPWR _0152_ sky130_fd_sc_hd__clkbuf_1
XFILLER_0_16_469 VGND VGND VPWR VPWR sky130_fd_sc_hd__decap_6
X_6414_ _3065_ VGND VGND VPWR VPWR _0713_ sky130_fd_sc_hd__clkbuf_1
Xclkbuf_leaf_34_CLK clknet_3_6__leaf_CLK VGND VGND VPWR VPWR clknet_leaf_34_CLK sky130_fd_sc_hd__clkbuf_8
X_7394_ _3614_ VGND VGND VPWR VPWR _0120_ sky130_fd_sc_hd__clkbuf_1
XFILLER_0_43_288 VGND VGND VPWR VPWR sky130_fd_sc_hd__decap_8
XPHY_EDGE_ROW_131_Right_131 VGND VGND VPWR VPWR sky130_fd_sc_hd__decap_3
XFILLER_0_114_699 VGND VGND VPWR VPWR sky130_fd_sc_hd__fill_1
XFILLER_0_113_187 VGND VGND VPWR VPWR sky130_fd_sc_hd__decap_8
X_6345_ rf.registers\[12\]\[16\] _3020_ _3008_ VGND VGND VPWR VPWR _3021_ sky130_fd_sc_hd__mux2_1
XFILLER_0_3_385 VGND VGND VPWR VPWR sky130_fd_sc_hd__decap_6
X_9133_ clknet_leaf_0_CLK _0221_ VGND VGND VPWR VPWR rf.registers\[27\]\[28\] sky130_fd_sc_hd__dfxtp_1
X_9064_ clknet_leaf_3_CLK _0152_ VGND VGND VPWR VPWR rf.registers\[29\]\[23\] sky130_fd_sc_hd__dfxtp_1
X_6276_ _2972_ rf.registers\[13\]\[27\] _2968_ VGND VGND VPWR VPWR _2973_ sky130_fd_sc_hd__mux2_1
X_5227_ _1970_ _1971_ _1768_ VGND VGND VPWR VPWR _1972_ sky130_fd_sc_hd__mux2_1
X_8015_ _3944_ VGND VGND VPWR VPWR _0411_ sky130_fd_sc_hd__clkbuf_1
XFILLER_0_138_81 VGND VGND VPWR VPWR sky130_fd_sc_hd__decap_3
X_5158_ rf.registers\[28\]\[15\] rf.registers\[29\]\[15\] rf.registers\[30\]\[15\]
+ rf.registers\[31\]\[15\] _1694_ _1695_ VGND VGND VPWR VPWR _1906_ sky130_fd_sc_hd__mux4_1
XFILLER_0_98_428 VGND VGND VPWR VPWR sky130_fd_sc_hd__decap_3
X_5089_ _1683_ _1833_ _1837_ _1841_ VGND VGND VPWR VPWR _1842_ sky130_fd_sc_hd__a2bb2o_4
X_8917_ clknet_leaf_49_CLK _0005_ VGND VGND VPWR VPWR rf.registers\[4\]\[4\] sky130_fd_sc_hd__dfxtp_1
XFILLER_0_94_612 VGND VGND VPWR VPWR sky130_fd_sc_hd__fill_2
XFILLER_0_78_141 VGND VGND VPWR VPWR sky130_fd_sc_hd__decap_6
XFILLER_0_94_645 VGND VGND VPWR VPWR sky130_fd_sc_hd__decap_4
XFILLER_0_93_111 VGND VGND VPWR VPWR sky130_fd_sc_hd__fill_1
XTAP_TAPCELL_ROW_84_1565 VGND VPWR sky130_fd_sc_hd__tapvpwrvgnd_1
XTAP_TAPCELL_ROW_84_1554 VGND VPWR sky130_fd_sc_hd__tapvpwrvgnd_1
XFILLER_0_79_697 VPWR VGND VPWR VGND sky130_ef_sc_hd__decap_12
X_8848_ clknet_leaf_77_CLK _0960_ VGND VGND VPWR VPWR rf.registers\[15\]\[31\] sky130_fd_sc_hd__dfxtp_1
X_8779_ clknet_leaf_68_CLK _0891_ VGND VGND VPWR VPWR rf.registers\[0\]\[26\] sky130_fd_sc_hd__dfxtp_1
XFILLER_0_47_561 VPWR VGND VPWR VGND sky130_ef_sc_hd__decap_12
XFILLER_0_62_531 VGND VGND VPWR VPWR sky130_fd_sc_hd__fill_1
XFILLER_0_35_745 VGND VGND VPWR VPWR sky130_fd_sc_hd__fill_2
XFILLER_0_47_594 VGND VGND VPWR VPWR sky130_fd_sc_hd__decap_8
XTAP_TAPCELL_ROW_115_2020 VGND VPWR sky130_fd_sc_hd__tapvpwrvgnd_1
XFILLER_0_62_586 VGND VGND VPWR VPWR sky130_fd_sc_hd__fill_2
XTAP_TAPCELL_ROW_115_2031 VGND VPWR sky130_fd_sc_hd__tapvpwrvgnd_1
Xclkbuf_leaf_25_CLK clknet_3_5__leaf_CLK VGND VGND VPWR VPWR clknet_leaf_25_CLK sky130_fd_sc_hd__clkbuf_8
XFILLER_0_105_666 VGND VGND VPWR VPWR sky130_fd_sc_hd__decap_6
XFILLER_0_62_597 VGND VGND VPWR VPWR sky130_fd_sc_hd__decap_3
XFILLER_0_50_737 VPWR VGND VPWR VGND sky130_ef_sc_hd__decap_12
XFILLER_0_120_636 VGND VGND VPWR VPWR sky130_fd_sc_hd__decap_8
XFILLER_0_118_29 VPWR VGND VPWR VGND sky130_ef_sc_hd__decap_12
XFILLER_0_89_439 VGND VGND VPWR VPWR sky130_fd_sc_hd__decap_8
XTAP_TAPCELL_ROW_126_2193 VGND VPWR sky130_fd_sc_hd__tapvpwrvgnd_1
XFILLER_0_58_837 VGND VGND VPWR VPWR sky130_fd_sc_hd__fill_2
XFILLER_0_128_725 VPWR VGND VPWR VGND sky130_ef_sc_hd__decap_12
XTAP_TAPCELL_ROW_26_692 VGND VPWR sky130_fd_sc_hd__tapvpwrvgnd_1
XFILLER_0_128_769 VPWR VGND VPWR VGND sky130_ef_sc_hd__decap_12
XFILLER_0_127_279 VGND VGND VPWR VPWR sky130_fd_sc_hd__fill_1
XFILLER_0_115_408 VGND VGND VPWR VPWR sky130_fd_sc_hd__decap_6
XFILLER_0_72_339 VGND VGND VPWR VPWR sky130_fd_sc_hd__decap_6
XFILLER_0_5_617 VPWR VGND VPWR VGND sky130_ef_sc_hd__decap_12
XFILLER_0_26_745 VGND VGND VPWR VPWR sky130_fd_sc_hd__fill_1
XFILLER_0_80_350 VPWR VGND VPWR VGND sky130_ef_sc_hd__decap_12
XFILLER_0_13_417 VPWR VGND VPWR VGND sky130_ef_sc_hd__decap_12
XFILLER_0_41_726 VGND VGND VPWR VPWR sky130_fd_sc_hd__fill_2
X_4460_ _1133_ _1243_ _1245_ _1034_ VGND VGND VPWR VPWR _1246_ sky130_fd_sc_hd__o211a_1
Xclkbuf_leaf_16_CLK clknet_3_4__leaf_CLK VGND VGND VPWR VPWR clknet_leaf_16_CLK sky130_fd_sc_hd__clkbuf_8
XFILLER_0_41_737 VPWR VGND VPWR VGND sky130_ef_sc_hd__decap_12
X_4391_ _1180_ VGND VGND VPWR VPWR net108 sky130_fd_sc_hd__inv_2
XFILLER_0_40_247 VGND VGND VPWR VPWR sky130_fd_sc_hd__decap_4
XFILLER_0_110_135 VGND VGND VPWR VPWR sky130_fd_sc_hd__fill_2
XTAP_TAPCELL_ROW_55_1122 VGND VPWR sky130_fd_sc_hd__tapvpwrvgnd_1
X_6130_ _2311_ _2279_ VGND VGND VPWR VPWR _2837_ sky130_fd_sc_hd__nor2_1
XFILLER_0_110_157 VGND VGND VPWR VPWR sky130_fd_sc_hd__fill_1
XFILLER_0_0_377 VGND VGND VPWR VPWR sky130_fd_sc_hd__fill_1
X_6061_ _1998_ _2758_ VGND VGND VPWR VPWR _2772_ sky130_fd_sc_hd__or2_1
XFILLER_0_84_33 VGND VGND VPWR VPWR sky130_fd_sc_hd__fill_1
X_5012_ _1766_ _1767_ _1768_ VGND VGND VPWR VPWR _1769_ sky130_fd_sc_hd__mux2_1
XFILLER_0_23_6 VPWR VGND VPWR VGND sky130_ef_sc_hd__decap_12
XFILLER_0_76_601 VPWR VGND VPWR VGND sky130_ef_sc_hd__decap_12
X_6963_ net22 VGND VGND VPWR VPWR _3382_ sky130_fd_sc_hd__clkbuf_2
XFILLER_0_17_93 VPWR VGND VPWR VGND sky130_ef_sc_hd__decap_12
X_8702_ clknet_leaf_27_CLK _0814_ VGND VGND VPWR VPWR rf.registers\[24\]\[13\] sky130_fd_sc_hd__dfxtp_1
XFILLER_0_76_645 VPWR VGND VPWR VGND sky130_ef_sc_hd__decap_12
X_5914_ _2467_ VGND VGND VPWR VPWR _2633_ sky130_fd_sc_hd__inv_2
X_6894_ rf.registers\[16\]\[27\] _3334_ _3320_ VGND VGND VPWR VPWR _3335_ sky130_fd_sc_hd__mux2_1
XFILLER_0_124_83 VGND VGND VPWR VPWR sky130_fd_sc_hd__fill_1
X_8633_ clknet_leaf_35_CLK _0745_ VGND VGND VPWR VPWR rf.registers\[17\]\[8\] sky130_fd_sc_hd__dfxtp_1
XTAP_TAPCELL_ROW_66_1295 VGND VPWR sky130_fd_sc_hd__tapvpwrvgnd_1
XTAP_TAPCELL_ROW_66_1284 VGND VPWR sky130_fd_sc_hd__tapvpwrvgnd_1
X_5845_ _2421_ _2266_ VGND VGND VPWR VPWR _2568_ sky130_fd_sc_hd__or2_4
XFILLER_0_8_433 VPWR VGND VPWR VGND sky130_ef_sc_hd__decap_12
XFILLER_0_133_205 VPWR VGND VPWR VGND sky130_ef_sc_hd__decap_12
X_8564_ clknet_leaf_36_CLK _0676_ VGND VGND VPWR VPWR rf.registers\[12\]\[3\] sky130_fd_sc_hd__dfxtp_1
XFILLER_0_56_380 VGND VGND VPWR VPWR sky130_fd_sc_hd__fill_1
XFILLER_0_8_477 VPWR VGND VPWR VGND sky130_ef_sc_hd__decap_12
XFILLER_0_16_233 VPWR VGND VPWR VGND sky130_ef_sc_hd__decap_12
X_5776_ _2241_ _2400_ VGND VGND VPWR VPWR _2502_ sky130_fd_sc_hd__or2_1
XFILLER_0_44_542 VGND VGND VPWR VPWR sky130_fd_sc_hd__fill_2
XFILLER_0_133_249 VPWR VGND VPWR VGND sky130_ef_sc_hd__decap_12
X_7515_ _3380_ rf.registers\[31\]\[16\] _3672_ VGND VGND VPWR VPWR _3679_ sky130_fd_sc_hd__mux2_1
X_8495_ _4198_ VGND VGND VPWR VPWR _0637_ sky130_fd_sc_hd__clkbuf_1
X_4727_ _1496_ _1497_ _1144_ VGND VGND VPWR VPWR _1498_ sky130_fd_sc_hd__mux2_1
XFILLER_0_44_575 VGND VGND VPWR VPWR sky130_fd_sc_hd__decap_8
X_7446_ _3642_ VGND VGND VPWR VPWR _0144_ sky130_fd_sc_hd__clkbuf_1
XFILLER_0_16_277 VPWR VGND VPWR VGND sky130_ef_sc_hd__decap_12
XFILLER_0_44_586 VGND VGND VPWR VPWR sky130_fd_sc_hd__fill_2
X_4658_ rf.registers\[28\]\[20\] rf.registers\[29\]\[20\] rf.registers\[30\]\[20\]
+ rf.registers\[31\]\[20\] _1119_ _1122_ VGND VGND VPWR VPWR _1433_ sky130_fd_sc_hd__mux4_1
XFILLER_0_4_694 VGND VGND VPWR VPWR sky130_fd_sc_hd__decap_6
X_9116_ clknet_leaf_27_CLK _0204_ VGND VGND VPWR VPWR rf.registers\[27\]\[11\] sky130_fd_sc_hd__dfxtp_1
X_7377_ _3605_ VGND VGND VPWR VPWR _0112_ sky130_fd_sc_hd__clkbuf_1
X_4589_ rf.registers\[0\]\[16\] rf.registers\[1\]\[16\] rf.registers\[2\]\[16\] rf.registers\[3\]\[16\]
+ _1126_ _1129_ VGND VGND VPWR VPWR _1368_ sky130_fd_sc_hd__mux4_1
XFILLER_0_3_193 VPWR VGND VPWR VGND sky130_ef_sc_hd__decap_12
XFILLER_0_40_781 VPWR VGND VPWR VGND sky130_ef_sc_hd__decap_12
X_6328_ _3009_ VGND VGND VPWR VPWR _0683_ sky130_fd_sc_hd__clkbuf_1
X_9047_ clknet_leaf_31_CLK _0135_ VGND VGND VPWR VPWR rf.registers\[29\]\[6\] sky130_fd_sc_hd__dfxtp_1
X_6259_ _2260_ _2921_ _2958_ _2254_ VGND VGND VPWR VPWR _2959_ sky130_fd_sc_hd__o211a_1
XTAP_TAPCELL_ROW_4_365 VGND VPWR sky130_fd_sc_hd__tapvpwrvgnd_1
XTAP_TAPCELL_ROW_4_354 VGND VPWR sky130_fd_sc_hd__tapvpwrvgnd_1
XFILLER_0_66_144 VGND VGND VPWR VPWR sky130_fd_sc_hd__fill_1
XPHY_EDGE_ROW_11_Right_11 VGND VGND VPWR VPWR sky130_fd_sc_hd__decap_3
XTAP_TAPCELL_ROW_43_938 VGND VPWR sky130_fd_sc_hd__tapvpwrvgnd_1
XTAP_TAPCELL_ROW_43_949 VGND VPWR sky130_fd_sc_hd__tapvpwrvgnd_1
XTAP_TAPCELL_ROW_23_640 VGND VPWR sky130_fd_sc_hd__tapvpwrvgnd_1
XFILLER_0_109_279 VGND VGND VPWR VPWR sky130_fd_sc_hd__fill_1
XFILLER_0_81_147 VGND VGND VPWR VPWR sky130_fd_sc_hd__fill_1
XTAP_TAPCELL_ROW_23_651 VGND VPWR sky130_fd_sc_hd__tapvpwrvgnd_1
XFILLER_0_81_169 VGND VGND VPWR VPWR sky130_fd_sc_hd__decap_6
XTAP_TAPCELL_ROW_97_1756 VGND VPWR sky130_fd_sc_hd__tapvpwrvgnd_1
XFILLER_0_133_783 VGND VGND VPWR VPWR sky130_fd_sc_hd__fill_1
XFILLER_0_50_567 VGND VGND VPWR VPWR sky130_fd_sc_hd__decap_8
XFILLER_0_129_39 VPWR VGND VPWR VGND sky130_ef_sc_hd__decap_12
XPHY_EDGE_ROW_20_Right_20 VGND VGND VPWR VPWR sky130_fd_sc_hd__decap_3
XFILLER_0_38_15 VPWR VGND VPWR VGND sky130_ef_sc_hd__decap_12
XFILLER_0_120_499 VGND VGND VPWR VPWR sky130_fd_sc_hd__fill_1
XTAP_TAPCELL_ROW_128_2222 VGND VPWR sky130_fd_sc_hd__tapvpwrvgnd_1
XTAP_TAPCELL_ROW_50_1052 VGND VPWR sky130_fd_sc_hd__tapvpwrvgnd_1
Xclkbuf_leaf_5_CLK clknet_3_1__leaf_CLK VGND VGND VPWR VPWR clknet_leaf_5_CLK sky130_fd_sc_hd__clkbuf_8
XFILLER_0_98_781 VPWR VGND VPWR VGND sky130_ef_sc_hd__decap_12
XTAP_TAPCELL_ROW_106_1896 VGND VPWR sky130_fd_sc_hd__tapvpwrvgnd_1
XTAP_TAPCELL_ROW_106_1885 VGND VPWR sky130_fd_sc_hd__tapvpwrvgnd_1
XFILLER_0_58_645 VPWR VGND VPWR VGND sky130_ef_sc_hd__decap_12
XFILLER_0_57_166 VGND VGND VPWR VPWR sky130_fd_sc_hd__fill_2
X_5630_ net106 _2341_ _2359_ VGND VGND VPWR VPWR _2360_ sky130_fd_sc_hd__a21oi_1
XFILLER_0_5_447 VGND VGND VPWR VPWR sky130_fd_sc_hd__fill_1
X_5561_ _2289_ _2291_ VGND VGND VPWR VPWR _2292_ sky130_fd_sc_hd__nand2_1
XFILLER_0_131_709 VPWR VGND VPWR VGND sky130_ef_sc_hd__decap_12
X_7300_ rf.registers\[3\]\[11\] _3301_ _3563_ VGND VGND VPWR VPWR _3565_ sky130_fd_sc_hd__mux2_1
X_8280_ _3035_ rf.registers\[25\]\[23\] _4081_ VGND VGND VPWR VPWR _4085_ sky130_fd_sc_hd__mux2_1
XFILLER_0_13_225 VPWR VGND VPWR VGND sky130_ef_sc_hd__decap_12
X_5492_ _2214_ _2222_ net92 VGND VGND VPWR VPWR _2223_ sky130_fd_sc_hd__mux2_1
X_4512_ _1140_ VGND VGND VPWR VPWR _1295_ sky130_fd_sc_hd__buf_4
XFILLER_0_110_41 VPWR VGND VPWR VGND sky130_ef_sc_hd__decap_12
X_7231_ _3528_ VGND VGND VPWR VPWR _0043_ sky130_fd_sc_hd__clkbuf_1
XFILLER_0_123_293 VPWR VGND VPWR VGND sky130_ef_sc_hd__decap_12
XFILLER_0_110_85 VPWR VGND VPWR VGND sky130_ef_sc_hd__decap_12
X_4443_ _1133_ _1229_ _1025_ VGND VGND VPWR VPWR _1230_ sky130_fd_sc_hd__o21a_1
XFILLER_0_1_653 VPWR VGND VPWR VGND sky130_ef_sc_hd__decap_12
X_7162_ rf.registers\[4\]\[10\] _3298_ _3491_ VGND VGND VPWR VPWR _3492_ sky130_fd_sc_hd__mux2_1
X_4374_ _1161_ _1162_ _1163_ VGND VGND VPWR VPWR _1164_ sky130_fd_sc_hd__mux2_1
XFILLER_0_95_43 VPWR VGND VPWR VGND sky130_ef_sc_hd__decap_12
X_7093_ _3443_ VGND VGND VPWR VPWR _3455_ sky130_fd_sc_hd__buf_4
X_6113_ net95 _2820_ _2479_ _1492_ VGND VGND VPWR VPWR _2821_ sky130_fd_sc_hd__o211ai_1
X_6044_ _1415_ _2198_ _2199_ _2646_ _1429_ VGND VGND VPWR VPWR _2756_ sky130_fd_sc_hd__a41o_1
XTAP_TAPCELL_ROW_68_1313 VGND VPWR sky130_fd_sc_hd__tapvpwrvgnd_1
XTAP_TAPCELL_ROW_1_313 VGND VPWR sky130_fd_sc_hd__tapvpwrvgnd_1
XFILLER_0_21_3 VPWR VGND VPWR VGND sky130_ef_sc_hd__decap_12
XTAP_TAPCELL_ROW_68_1324 VGND VPWR sky130_fd_sc_hd__tapvpwrvgnd_1
X_7995_ _3382_ rf.registers\[22\]\[17\] _3926_ VGND VGND VPWR VPWR _3934_ sky130_fd_sc_hd__mux2_1
XFILLER_0_135_93 VPWR VGND VPWR VGND sky130_ef_sc_hd__decap_12
X_6946_ _3370_ rf.registers\[15\]\[11\] _3368_ VGND VGND VPWR VPWR _3371_ sky130_fd_sc_hd__mux2_1
XTAP_TAPCELL_ROW_81_1513 VGND VPWR sky130_fd_sc_hd__tapvpwrvgnd_1
XFILLER_0_91_412 VGND VGND VPWR VPWR sky130_fd_sc_hd__fill_2
XFILLER_0_64_626 VGND VGND VPWR VPWR sky130_fd_sc_hd__decap_8
X_6877_ _3323_ VGND VGND VPWR VPWR _0918_ sky130_fd_sc_hd__clkbuf_1
XFILLER_0_134_514 VGND VGND VPWR VPWR sky130_fd_sc_hd__decap_8
X_8616_ clknet_leaf_8_CLK _0728_ VGND VGND VPWR VPWR rf.registers\[11\]\[23\] sky130_fd_sc_hd__dfxtp_1
XFILLER_0_9_764 VPWR VGND VPWR VGND sky130_ef_sc_hd__decap_12
X_5828_ _2343_ _2345_ VGND VGND VPWR VPWR _2552_ sky130_fd_sc_hd__nand2_1
X_8547_ _4225_ VGND VGND VPWR VPWR _0662_ sky130_fd_sc_hd__clkbuf_1
X_5759_ _1727_ _2475_ VGND VGND VPWR VPWR _2485_ sky130_fd_sc_hd__nor2_1
XFILLER_0_9_797 VPWR VGND VPWR VGND sky130_ef_sc_hd__decap_12
XFILLER_0_115_783 VGND VGND VPWR VPWR sky130_fd_sc_hd__fill_1
XTAP_TAPCELL_ROW_79_1486 VGND VPWR sky130_fd_sc_hd__tapvpwrvgnd_1
X_8478_ _3028_ rf.registers\[14\]\[20\] _4189_ VGND VGND VPWR VPWR _4190_ sky130_fd_sc_hd__mux2_1
XFILLER_0_32_556 VGND VGND VPWR VPWR sky130_fd_sc_hd__decap_8
XFILLER_0_32_567 VPWR VGND VPWR VGND sky130_ef_sc_hd__decap_12
X_7429_ _3633_ VGND VGND VPWR VPWR _0136_ sky130_fd_sc_hd__clkbuf_1
XFILLER_0_32_589 VGND VGND VPWR VPWR sky130_fd_sc_hd__fill_2
XFILLER_0_102_477 VGND VGND VPWR VPWR sky130_fd_sc_hd__fill_2
XTAP_TAPCELL_ROW_9_435 VGND VPWR sky130_fd_sc_hd__tapvpwrvgnd_1
XTAP_TAPCELL_ROW_92_1686 VGND VPWR sky130_fd_sc_hd__tapvpwrvgnd_1
XTAP_TAPCELL_ROW_92_1675 VGND VPWR sky130_fd_sc_hd__tapvpwrvgnd_1
XTAP_TAPCELL_ROW_123_2141 VGND VPWR sky130_fd_sc_hd__tapvpwrvgnd_1
XFILLER_0_99_567 VPWR VGND VPWR VGND sky130_ef_sc_hd__decap_12
XFILLER_0_87_729 VPWR VGND VPWR VGND sky130_ef_sc_hd__decap_12
XTAP_TAPCELL_ROW_28_721 VGND VPWR sky130_fd_sc_hd__tapvpwrvgnd_1
XTAP_TAPCELL_ROW_123_2152 VGND VPWR sky130_fd_sc_hd__tapvpwrvgnd_1
XFILLER_0_86_217 VGND VGND VPWR VPWR sky130_fd_sc_hd__decap_8
XFILLER_0_55_615 VGND VGND VPWR VPWR sky130_fd_sc_hd__fill_1
XFILLER_0_39_166 VGND VGND VPWR VPWR sky130_fd_sc_hd__fill_2
XFILLER_0_40_27 VGND VGND VPWR VPWR sky130_fd_sc_hd__fill_1
XFILLER_0_137_385 VGND VGND VPWR VPWR sky130_fd_sc_hd__decap_6
XFILLER_0_125_547 VGND VGND VPWR VPWR sky130_fd_sc_hd__fill_1
XFILLER_0_51_821 VPWR VGND VPWR VGND sky130_ef_sc_hd__decap_12
XFILLER_0_121_753 VPWR VGND VPWR VGND sky130_ef_sc_hd__decap_12
XFILLER_0_11_729 VPWR VGND VPWR VGND sky130_ef_sc_hd__decap_12
XFILLER_0_121_797 VPWR VGND VPWR VGND sky130_ef_sc_hd__decap_12
XFILLER_0_120_296 VGND VGND VPWR VPWR sky130_fd_sc_hd__fill_2
XFILLER_0_4_27 VGND VGND VPWR VPWR sky130_fd_sc_hd__fill_1
XTAP_TAPCELL_ROW_108_1914 VGND VPWR sky130_fd_sc_hd__tapvpwrvgnd_1
XTAP_TAPCELL_ROW_108_1925 VGND VPWR sky130_fd_sc_hd__tapvpwrvgnd_1
X_6800_ rf.registers\[0\]\[28\] _3045_ _3263_ VGND VGND VPWR VPWR _3272_ sky130_fd_sc_hd__mux2_1
X_7780_ rf.registers\[9\]\[12\] _3303_ _3817_ VGND VGND VPWR VPWR _3820_ sky130_fd_sc_hd__mux2_1
X_4992_ _1695_ VGND VGND VPWR VPWR _1750_ sky130_fd_sc_hd__buf_4
XTAP_TAPCELL_ROW_63_1243 VGND VPWR sky130_fd_sc_hd__tapvpwrvgnd_1
X_6731_ _3235_ VGND VGND VPWR VPWR _0860_ sky130_fd_sc_hd__clkbuf_1
XFILLER_0_46_615 VGND VGND VPWR VPWR sky130_fd_sc_hd__decap_6
XFILLER_0_128_363 VGND VGND VPWR VPWR sky130_fd_sc_hd__fill_1
XFILLER_0_58_497 VGND VGND VPWR VPWR sky130_fd_sc_hd__fill_2
XFILLER_0_6_701 VPWR VGND VPWR VGND sky130_ef_sc_hd__decap_12
XFILLER_0_14_83 VGND VGND VPWR VPWR sky130_fd_sc_hd__fill_1
X_6662_ _3198_ VGND VGND VPWR VPWR _0828_ sky130_fd_sc_hd__clkbuf_1
X_9450_ clknet_leaf_84_CLK _0538_ VGND VGND VPWR VPWR rf.registers\[25\]\[25\] sky130_fd_sc_hd__dfxtp_1
XFILLER_0_128_385 VGND VGND VPWR VPWR sky130_fd_sc_hd__fill_2
X_8401_ rf.registers\[18\]\[16\] net21 _4142_ VGND VGND VPWR VPWR _4149_ sky130_fd_sc_hd__mux2_1
XFILLER_0_6_723 VPWR VGND VPWR VGND sky130_ef_sc_hd__decap_12
X_5613_ _2229_ _2244_ VGND VGND VPWR VPWR _2343_ sky130_fd_sc_hd__nand2_1
X_9381_ clknet_leaf_82_CLK _0469_ VGND VGND VPWR VPWR rf.registers\[26\]\[20\] sky130_fd_sc_hd__dfxtp_1
XFILLER_0_121_51 VGND VGND VPWR VPWR sky130_fd_sc_hd__decap_4
X_8332_ _4112_ VGND VGND VPWR VPWR _0560_ sky130_fd_sc_hd__clkbuf_1
XFILLER_0_54_670 VPWR VGND VPWR VGND sky130_ef_sc_hd__decap_12
XFILLER_0_14_501 VPWR VGND VPWR VGND sky130_ef_sc_hd__decap_12
X_6593_ _3161_ VGND VGND VPWR VPWR _0796_ sky130_fd_sc_hd__clkbuf_1
XFILLER_0_14_545 VGND VGND VPWR VPWR sky130_fd_sc_hd__decap_8
X_5544_ _2272_ _2274_ VGND VGND VPWR VPWR _2275_ sky130_fd_sc_hd__or2_1
X_8263_ _3018_ rf.registers\[25\]\[15\] _4070_ VGND VGND VPWR VPWR _4076_ sky130_fd_sc_hd__mux2_1
XFILLER_0_14_589 VGND VGND VPWR VPWR sky130_fd_sc_hd__fill_1
X_5475_ _2205_ VGND VGND VPWR VPWR _2206_ sky130_fd_sc_hd__buf_2
X_7214_ _3519_ VGND VGND VPWR VPWR _0035_ sky130_fd_sc_hd__clkbuf_1
X_8194_ _4039_ VGND VGND VPWR VPWR _0495_ sky130_fd_sc_hd__clkbuf_1
X_4426_ rf.registers\[12\]\[7\] rf.registers\[13\]\[7\] rf.registers\[14\]\[7\] rf.registers\[15\]\[7\]
+ _1198_ _1199_ VGND VGND VPWR VPWR _1214_ sky130_fd_sc_hd__mux4_1
XFILLER_0_69_3 VPWR VGND VPWR VGND sky130_ef_sc_hd__decap_12
XFILLER_0_1_461 VPWR VGND VPWR VGND sky130_ef_sc_hd__decap_12
X_7145_ rf.registers\[4\]\[2\] _3282_ _3480_ VGND VGND VPWR VPWR _3483_ sky130_fd_sc_hd__mux2_1
X_4357_ _1127_ VGND VGND VPWR VPWR _1148_ sky130_fd_sc_hd__buf_4
X_4288_ _1079_ _1080_ net6 VGND VGND VPWR VPWR _1081_ sky130_fd_sc_hd__mux2_1
X_7076_ _3446_ VGND VGND VPWR VPWR _0994_ sky130_fd_sc_hd__clkbuf_1
X_6027_ _2198_ _2199_ _2646_ _2709_ VGND VGND VPWR VPWR _2740_ sky130_fd_sc_hd__a31o_1
XFILLER_0_69_729 VPWR VGND VPWR VGND sky130_ef_sc_hd__decap_12
X_7978_ _3365_ rf.registers\[22\]\[9\] _3915_ VGND VGND VPWR VPWR _3925_ sky130_fd_sc_hd__mux2_1
X_6929_ net42 VGND VGND VPWR VPWR _3359_ sky130_fd_sc_hd__clkbuf_2
XFILLER_0_107_503 VGND VGND VPWR VPWR sky130_fd_sc_hd__fill_1
XFILLER_0_37_648 VPWR VGND VPWR VGND sky130_ef_sc_hd__decap_12
XFILLER_0_9_583 VGND VGND VPWR VPWR sky130_fd_sc_hd__fill_2
XFILLER_0_24_309 VGND VGND VPWR VPWR sky130_fd_sc_hd__decap_6
XTAP_TAPCELL_ROW_33_790 VGND VPWR sky130_fd_sc_hd__tapvpwrvgnd_1
XFILLER_0_134_333 VPWR VGND VPWR VGND sky130_ef_sc_hd__decap_12
XFILLER_0_17_372 VGND VGND VPWR VPWR sky130_fd_sc_hd__fill_1
XFILLER_0_33_821 VPWR VGND VPWR VGND sky130_ef_sc_hd__decap_12
XFILLER_0_134_377 VPWR VGND VPWR VGND sky130_ef_sc_hd__decap_12
XTAP_TAPCELL_ROW_94_1715 VGND VPWR sky130_fd_sc_hd__tapvpwrvgnd_1
XTAP_TAPCELL_ROW_94_1704 VGND VPWR sky130_fd_sc_hd__tapvpwrvgnd_1
XFILLER_0_103_753 VPWR VGND VPWR VGND sky130_ef_sc_hd__decap_12
XFILLER_0_130_583 VGND VGND VPWR VPWR sky130_fd_sc_hd__fill_2
XFILLER_0_103_797 VPWR VGND VPWR VGND sky130_ef_sc_hd__decap_12
XFILLER_0_126_29 VPWR VGND VPWR VGND sky130_ef_sc_hd__decap_12
XFILLER_0_99_331 VGND VGND VPWR VPWR sky130_fd_sc_hd__fill_2
XFILLER_0_129_105 VGND VGND VPWR VPWR sky130_fd_sc_hd__decap_6
XFILLER_0_87_559 VGND VGND VPWR VPWR sky130_fd_sc_hd__fill_1
XFILLER_0_129_149 VPWR VGND VPWR VGND sky130_ef_sc_hd__decap_12
XTAP_TAPCELL_ROW_103_1844 VGND VPWR sky130_fd_sc_hd__tapvpwrvgnd_1
XFILLER_0_83_721 VGND VGND VPWR VPWR sky130_fd_sc_hd__decap_6
XFILLER_0_51_37 VPWR VGND VPWR VGND sky130_ef_sc_hd__decap_12
XFILLER_0_28_626 VGND VGND VPWR VPWR sky130_fd_sc_hd__fill_1
XFILLER_0_83_765 VPWR VGND VPWR VGND sky130_ef_sc_hd__decap_12
XFILLER_0_82_253 VGND VGND VPWR VPWR sky130_fd_sc_hd__decap_8
XFILLER_0_43_607 VGND VGND VPWR VPWR sky130_fd_sc_hd__decap_8
XFILLER_0_137_193 VPWR VGND VPWR VGND sky130_ef_sc_hd__decap_12
XTAP_TAPCELL_ROW_136_2343 VGND VPWR sky130_fd_sc_hd__tapvpwrvgnd_1
XFILLER_0_43_629 VGND VGND VPWR VPWR sky130_fd_sc_hd__decap_6
Xclkload24 clknet_leaf_9_CLK VGND VGND VPWR VPWR clkload24/Y sky130_fd_sc_hd__clkinv_1
XTAP_TAPCELL_ROW_11_462 VGND VPWR sky130_fd_sc_hd__tapvpwrvgnd_1
Xclkload35 clknet_leaf_70_CLK VGND VGND VPWR VPWR clkload35/X sky130_fd_sc_hd__clkbuf_4
Xclkload13 clknet_leaf_89_CLK VGND VGND VPWR VPWR clkload13/Y sky130_fd_sc_hd__inv_6
Xclkload68 clknet_leaf_37_CLK VGND VGND VPWR VPWR clkload68/Y sky130_fd_sc_hd__inv_6
Xclkload57 clknet_leaf_30_CLK VGND VGND VPWR VPWR clkload57/Y sky130_fd_sc_hd__inv_8
XFILLER_0_51_673 VGND VGND VPWR VPWR sky130_fd_sc_hd__fill_2
Xclkload46 clknet_leaf_74_CLK VGND VGND VPWR VPWR clkload46/Y sky130_fd_sc_hd__clkinvlp_2
XFILLER_0_23_375 VGND VGND VPWR VPWR sky130_fd_sc_hd__fill_2
XFILLER_0_121_561 VGND VGND VPWR VPWR sky130_fd_sc_hd__decap_3
Xclkload79 clknet_leaf_58_CLK VGND VGND VPWR VPWR clkload79/Y sky130_fd_sc_hd__clkinv_4
XFILLER_0_50_194 VGND VGND VPWR VPWR sky130_fd_sc_hd__fill_2
XFILLER_0_23_386 VGND VGND VPWR VPWR sky130_fd_sc_hd__decap_6
XFILLER_0_23_397 VGND VGND VPWR VPWR sky130_fd_sc_hd__fill_1
X_5260_ rf.registers\[16\]\[20\] rf.registers\[17\]\[20\] rf.registers\[18\]\[20\]
+ rf.registers\[19\]\[20\] _1999_ _2000_ VGND VGND VPWR VPWR _2003_ sky130_fd_sc_hd__mux4_1
X_5191_ _1932_ _1934_ _1937_ _1771_ _1755_ VGND VGND VPWR VPWR _1938_ sky130_fd_sc_hd__a221o_1
XFILLER_0_76_89 VPWR VGND VPWR VGND sky130_ef_sc_hd__decap_12
X_8950_ clknet_leaf_58_CLK _0038_ VGND VGND VPWR VPWR rf.registers\[19\]\[5\] sky130_fd_sc_hd__dfxtp_1
X_7901_ _3884_ VGND VGND VPWR VPWR _0357_ sky130_fd_sc_hd__clkbuf_1
X_8881_ clknet_leaf_41_CLK _0993_ VGND VGND VPWR VPWR rf.registers\[5\]\[0\] sky130_fd_sc_hd__dfxtp_1
X_7832_ _3847_ VGND VGND VPWR VPWR _0325_ sky130_fd_sc_hd__clkbuf_1
XTAP_TAPCELL_ROW_19_584 VGND VPWR sky130_fd_sc_hd__tapvpwrvgnd_1
X_7763_ rf.registers\[9\]\[4\] _3286_ _3806_ VGND VGND VPWR VPWR _3811_ sky130_fd_sc_hd__mux2_1
X_4975_ rf.registers\[24\]\[5\] rf.registers\[25\]\[5\] rf.registers\[26\]\[5\] rf.registers\[27\]\[5\]
+ _1730_ _1732_ VGND VGND VPWR VPWR _1733_ sky130_fd_sc_hd__mux4_1
X_9502_ clknet_leaf_28_CLK _0590_ VGND VGND VPWR VPWR rf.registers\[18\]\[13\] sky130_fd_sc_hd__dfxtp_1
X_6714_ _3226_ VGND VGND VPWR VPWR _0852_ sky130_fd_sc_hd__clkbuf_1
XFILLER_0_19_648 VGND VGND VPWR VPWR sky130_fd_sc_hd__decap_8
X_7694_ _3774_ VGND VGND VPWR VPWR _0260_ sky130_fd_sc_hd__clkbuf_1
X_9433_ clknet_leaf_36_CLK _0521_ VGND VGND VPWR VPWR rf.registers\[25\]\[8\] sky130_fd_sc_hd__dfxtp_1
XFILLER_0_132_83 VGND VGND VPWR VPWR sky130_fd_sc_hd__fill_1
XFILLER_0_116_333 VGND VGND VPWR VPWR sky130_fd_sc_hd__decap_8
X_6645_ _3189_ VGND VGND VPWR VPWR _0820_ sky130_fd_sc_hd__clkbuf_1
XFILLER_0_73_264 VPWR VGND VPWR VGND sky130_ef_sc_hd__decap_12
Xclkload7 clknet_leaf_1_CLK VGND VGND VPWR VPWR clkload7/Y sky130_fd_sc_hd__inv_8
XFILLER_0_6_531 VGND VGND VPWR VPWR sky130_fd_sc_hd__fill_1
XFILLER_0_15_821 VPWR VGND VPWR VGND sky130_ef_sc_hd__decap_12
XFILLER_0_132_837 VGND VGND VPWR VPWR sky130_fd_sc_hd__fill_2
X_9364_ clknet_leaf_38_CLK _0452_ VGND VGND VPWR VPWR rf.registers\[26\]\[3\] sky130_fd_sc_hd__dfxtp_1
X_6576_ _3152_ VGND VGND VPWR VPWR _0788_ sky130_fd_sc_hd__clkbuf_1
X_8315_ _4103_ VGND VGND VPWR VPWR _0552_ sky130_fd_sc_hd__clkbuf_1
XTAP_TAPCELL_ROW_76_1434 VGND VPWR sky130_fd_sc_hd__tapvpwrvgnd_1
XFILLER_0_6_597 VGND VGND VPWR VPWR sky130_fd_sc_hd__decap_3
XFILLER_0_30_802 VGND VGND VPWR VPWR sky130_fd_sc_hd__decap_8
XFILLER_0_30_813 VPWR VGND VPWR VGND sky130_ef_sc_hd__decap_12
X_9295_ clknet_leaf_67_CLK _0383_ VGND VGND VPWR VPWR rf.registers\[23\]\[30\] sky130_fd_sc_hd__dfxtp_1
X_5527_ _2211_ _1666_ _2218_ VGND VGND VPWR VPWR _2258_ sky130_fd_sc_hd__or3_1
XFILLER_0_100_701 VPWR VGND VPWR VGND sky130_ef_sc_hd__decap_12
X_8246_ _3001_ rf.registers\[25\]\[7\] _4059_ VGND VGND VPWR VPWR _4067_ sky130_fd_sc_hd__mux2_1
XTAP_TAPCELL_ROW_76_1445 VGND VPWR sky130_fd_sc_hd__tapvpwrvgnd_1
X_5458_ rf.registers\[12\]\[31\] rf.registers\[13\]\[31\] rf.registers\[14\]\[31\]
+ rf.registers\[15\]\[31\] _1951_ _1952_ VGND VGND VPWR VPWR _2190_ sky130_fd_sc_hd__mux4_1
XFILLER_0_2_781 VPWR VGND VPWR VGND sky130_ef_sc_hd__decap_12
X_8177_ _4030_ VGND VGND VPWR VPWR _0487_ sky130_fd_sc_hd__clkbuf_1
X_4409_ _1146_ VGND VGND VPWR VPWR _1198_ sky130_fd_sc_hd__clkbuf_8
XFILLER_0_10_581 VGND VGND VPWR VPWR sky130_fd_sc_hd__fill_1
X_5389_ rf.registers\[8\]\[27\] rf.registers\[9\]\[27\] rf.registers\[10\]\[27\] rf.registers\[11\]\[27\]
+ _2008_ _2009_ VGND VGND VPWR VPWR _2125_ sky130_fd_sc_hd__mux4_1
XFILLER_0_5_81 VPWR VGND VPWR VGND sky130_ef_sc_hd__decap_12
X_7128_ _3473_ VGND VGND VPWR VPWR _1019_ sky130_fd_sc_hd__clkbuf_1
X_7059_ rf.registers\[6\]\[26\] _3332_ _3430_ VGND VGND VPWR VPWR _3437_ sky130_fd_sc_hd__mux2_1
XTAP_TAPCELL_ROW_120_2100 VGND VPWR sky130_fd_sc_hd__tapvpwrvgnd_1
XFILLER_0_69_559 VGND VGND VPWR VPWR sky130_fd_sc_hd__fill_1
XTAP_TAPCELL_ROW_38_871 VGND VPWR sky130_fd_sc_hd__tapvpwrvgnd_1
XFILLER_0_65_765 VPWR VGND VPWR VGND sky130_ef_sc_hd__decap_12
XFILLER_0_64_253 VGND VGND VPWR VPWR sky130_fd_sc_hd__decap_6
XFILLER_0_135_653 VPWR VGND VPWR VGND sky130_ef_sc_hd__decap_12
XFILLER_0_119_193 VPWR VGND VPWR VGND sky130_ef_sc_hd__decap_12
XFILLER_0_80_713 VPWR VGND VPWR VGND sky130_ef_sc_hd__decap_12
XFILLER_0_9_391 VGND VGND VPWR VPWR sky130_fd_sc_hd__fill_1
XFILLER_0_24_106 VGND VGND VPWR VPWR sky130_fd_sc_hd__fill_1
XFILLER_0_25_629 VGND VGND VPWR VPWR sky130_fd_sc_hd__decap_6
XFILLER_0_135_697 VPWR VGND VPWR VGND sky130_ef_sc_hd__decap_12
XFILLER_0_134_141 VPWR VGND VPWR VGND sky130_ef_sc_hd__decap_12
XTAP_TAPCELL_ROW_118_2073 VGND VPWR sky130_fd_sc_hd__tapvpwrvgnd_1
XFILLER_0_80_757 VPWR VGND VPWR VGND sky130_ef_sc_hd__decap_12
XFILLER_0_18_692 VGND VGND VPWR VPWR sky130_fd_sc_hd__decap_8
XFILLER_0_32_150 VGND VGND VPWR VPWR sky130_fd_sc_hd__fill_1
XFILLER_0_33_673 VPWR VGND VPWR VGND sky130_ef_sc_hd__decap_12
XFILLER_0_0_729 VGND VGND VPWR VPWR sky130_fd_sc_hd__decap_4
XFILLER_0_33_695 VGND VGND VPWR VPWR sky130_fd_sc_hd__decap_8
XTAP_TAPCELL_ROW_131_2262 VGND VPWR sky130_fd_sc_hd__tapvpwrvgnd_1
XFILLER_0_46_15 VPWR VGND VPWR VGND sky130_ef_sc_hd__decap_12
XFILLER_0_137_39 VPWR VGND VPWR VGND sky130_ef_sc_hd__decap_12
XFILLER_0_88_813 VPWR VGND VPWR VGND sky130_ef_sc_hd__decap_12
XFILLER_0_1_39 VPWR VGND VPWR VGND sky130_ef_sc_hd__decap_12
XTAP_TAPCELL_ROW_47_1002 VGND VPWR sky130_fd_sc_hd__tapvpwrvgnd_1
XFILLER_0_75_529 VGND VGND VPWR VPWR sky130_fd_sc_hd__decap_4
XTAP_TAPCELL_ROW_16_543 VGND VPWR sky130_fd_sc_hd__tapvpwrvgnd_1
XFILLER_0_83_551 VGND VGND VPWR VPWR sky130_fd_sc_hd__decap_8
XTAP_TAPCELL_ROW_60_1202 VGND VPWR sky130_fd_sc_hd__tapvpwrvgnd_1
XFILLER_0_7_317 VPWR VGND VPWR VGND sky130_ef_sc_hd__decap_12
X_4760_ _1525_ _1528_ _1168_ VGND VGND VPWR VPWR _1529_ sky130_fd_sc_hd__mux2_1
XPHY_EDGE_ROW_112_Right_112 VGND VGND VPWR VPWR sky130_fd_sc_hd__decap_3
X_4691_ rf.registers\[28\]\[22\] rf.registers\[29\]\[22\] rf.registers\[30\]\[22\]
+ rf.registers\[31\]\[22\] _1410_ _1411_ VGND VGND VPWR VPWR _1464_ sky130_fd_sc_hd__mux4_1
XFILLER_0_126_664 VPWR VGND VPWR VGND sky130_ef_sc_hd__decap_12
XFILLER_0_114_837 VGND VGND VPWR VPWR sky130_fd_sc_hd__fill_2
XFILLER_0_102_53 VPWR VGND VPWR VGND sky130_ef_sc_hd__decap_12
X_6430_ rf.registers\[11\]\[16\] _3020_ _3067_ VGND VGND VPWR VPWR _3074_ sky130_fd_sc_hd__mux2_1
X_6361_ rf.registers\[12\]\[21\] _3031_ _3029_ VGND VGND VPWR VPWR _3032_ sky130_fd_sc_hd__mux2_1
XFILLER_0_12_813 VPWR VGND VPWR VGND sky130_ef_sc_hd__decap_12
XFILLER_0_24_651 VGND VGND VPWR VPWR sky130_fd_sc_hd__decap_8
X_8100_ _3351_ rf.registers\[26\]\[2\] _3987_ VGND VGND VPWR VPWR _3990_ sky130_fd_sc_hd__mux2_1
X_5312_ _2050_ _2051_ _1747_ VGND VGND VPWR VPWR _2052_ sky130_fd_sc_hd__mux2_1
XPHY_EDGE_ROW_49_Right_49 VGND VGND VPWR VPWR sky130_fd_sc_hd__decap_3
XFILLER_0_24_684 VPWR VGND VPWR VGND sky130_ef_sc_hd__decap_12
X_9080_ clknet_leaf_53_CLK _0168_ VGND VGND VPWR VPWR rf.registers\[31\]\[7\] sky130_fd_sc_hd__dfxtp_1
X_6292_ net10 net9 net46 VGND VGND VPWR VPWR _2984_ sky130_fd_sc_hd__or3b_1
XTAP_TAPCELL_ROW_58_1175 VGND VPWR sky130_fd_sc_hd__tapvpwrvgnd_1
XTAP_TAPCELL_ROW_58_1164 VGND VPWR sky130_fd_sc_hd__tapvpwrvgnd_1
XFILLER_0_121_391 VGND VGND VPWR VPWR sky130_fd_sc_hd__fill_1
X_8031_ _3953_ VGND VGND VPWR VPWR _0418_ sky130_fd_sc_hd__clkbuf_1
X_5243_ rf.registers\[24\]\[19\] rf.registers\[25\]\[19\] rf.registers\[26\]\[19\]
+ rf.registers\[27\]\[19\] _1749_ _1750_ VGND VGND VPWR VPWR _1987_ sky130_fd_sc_hd__mux4_1
X_5174_ rf.registers\[24\]\[16\] rf.registers\[25\]\[16\] rf.registers\[26\]\[16\]
+ rf.registers\[27\]\[16\] _1919_ _1920_ VGND VGND VPWR VPWR _1921_ sky130_fd_sc_hd__mux4_1
XTAP_TAPCELL_ROW_71_1364 VGND VPWR sky130_fd_sc_hd__tapvpwrvgnd_1
XPHY_EDGE_ROW_58_Right_58 VGND VGND VPWR VPWR sky130_fd_sc_hd__decap_3
X_8933_ clknet_leaf_74_CLK _0021_ VGND VGND VPWR VPWR rf.registers\[4\]\[20\] sky130_fd_sc_hd__dfxtp_1
X_8864_ clknet_leaf_16_CLK _0976_ VGND VGND VPWR VPWR rf.registers\[6\]\[15\] sky130_fd_sc_hd__dfxtp_1
XFILLER_0_94_805 VGND VGND VPWR VPWR sky130_fd_sc_hd__decap_6
XFILLER_0_66_529 VGND VGND VPWR VPWR sky130_fd_sc_hd__decap_3
XFILLER_0_66_507 VGND VGND VPWR VPWR sky130_fd_sc_hd__fill_1
X_7815_ rf.registers\[9\]\[29\] _3338_ _3828_ VGND VGND VPWR VPWR _3838_ sky130_fd_sc_hd__mux2_1
XTAP_TAPCELL_ROW_35_830 VGND VPWR sky130_fd_sc_hd__tapvpwrvgnd_1
X_8795_ clknet_leaf_33_CLK _0907_ VGND VGND VPWR VPWR rf.registers\[16\]\[10\] sky130_fd_sc_hd__dfxtp_1
XFILLER_0_93_337 VGND VGND VPWR VPWR sky130_fd_sc_hd__decap_8
X_4958_ _1715_ _1716_ _1635_ VGND VGND VPWR VPWR _1717_ sky130_fd_sc_hd__mux2_1
X_7746_ _3801_ VGND VGND VPWR VPWR _0285_ sky130_fd_sc_hd__clkbuf_1
XFILLER_0_47_765 VPWR VGND VPWR VGND sky130_ef_sc_hd__decap_12
X_4889_ _1628_ VGND VGND VPWR VPWR _1651_ sky130_fd_sc_hd__buf_4
XFILLER_0_62_713 VPWR VGND VPWR VGND sky130_ef_sc_hd__decap_12
X_7677_ _3764_ VGND VGND VPWR VPWR _0253_ sky130_fd_sc_hd__clkbuf_1
XFILLER_0_46_253 VGND VGND VPWR VPWR sky130_fd_sc_hd__fill_1
XFILLER_0_46_275 VGND VGND VPWR VPWR sky130_fd_sc_hd__decap_3
XFILLER_0_117_664 VGND VGND VPWR VPWR sky130_fd_sc_hd__fill_1
XFILLER_0_116_141 VPWR VGND VPWR VGND sky130_ef_sc_hd__decap_12
X_6628_ rf.registers\[24\]\[11\] _3010_ _3179_ VGND VGND VPWR VPWR _3181_ sky130_fd_sc_hd__mux2_1
XFILLER_0_62_757 VPWR VGND VPWR VGND sky130_ef_sc_hd__decap_12
XFILLER_0_61_234 VGND VGND VPWR VPWR sky130_fd_sc_hd__fill_1
XFILLER_0_34_437 VGND VGND VPWR VPWR sky130_fd_sc_hd__decap_3
X_9416_ clknet_leaf_2_CLK _0504_ VGND VGND VPWR VPWR rf.registers\[21\]\[23\] sky130_fd_sc_hd__dfxtp_1
XFILLER_0_132_645 VPWR VGND VPWR VGND sky130_ef_sc_hd__decap_12
XFILLER_0_132_623 VPWR VGND VPWR VGND sky130_ef_sc_hd__decap_12
XFILLER_0_131_111 VGND VGND VPWR VPWR sky130_fd_sc_hd__fill_1
XFILLER_0_117_697 VPWR VGND VPWR VGND sky130_ef_sc_hd__decap_12
X_9347_ clknet_leaf_6_CLK _0435_ VGND VGND VPWR VPWR rf.registers\[7\]\[18\] sky130_fd_sc_hd__dfxtp_1
XPHY_EDGE_ROW_67_Right_67 VGND VGND VPWR VPWR sky130_fd_sc_hd__decap_3
XFILLER_0_15_673 VPWR VGND VPWR VGND sky130_ef_sc_hd__decap_12
XFILLER_0_104_347 VGND VGND VPWR VPWR sky130_fd_sc_hd__fill_1
X_6559_ rf.registers\[1\]\[11\] _3010_ _3142_ VGND VGND VPWR VPWR _3144_ sky130_fd_sc_hd__mux2_1
X_9278_ clknet_leaf_27_CLK _0366_ VGND VGND VPWR VPWR rf.registers\[23\]\[13\] sky130_fd_sc_hd__dfxtp_1
XFILLER_0_100_542 VGND VGND VPWR VPWR sky130_fd_sc_hd__decap_3
X_8229_ _4057_ VGND VGND VPWR VPWR _0512_ sky130_fd_sc_hd__clkbuf_1
XTAP_TAPCELL_ROW_89_1636 VGND VPWR sky130_fd_sc_hd__tapvpwrvgnd_1
XPHY_EDGE_ROW_76_Right_76 VGND VGND VPWR VPWR sky130_fd_sc_hd__decap_3
XFILLER_0_16_29 VPWR VGND VPWR VGND sky130_ef_sc_hd__decap_12
XFILLER_0_96_197 VGND VGND VPWR VPWR sky130_fd_sc_hd__fill_1
XFILLER_0_69_389 VGND VGND VPWR VPWR sky130_fd_sc_hd__decap_3
XTAP_TAPCELL_ROW_100_1803 VGND VPWR sky130_fd_sc_hd__tapvpwrvgnd_1
XTAP_TAPCELL_ROW_13_502 VGND VPWR sky130_fd_sc_hd__tapvpwrvgnd_1
XFILLER_0_53_702 VGND VGND VPWR VPWR sky130_fd_sc_hd__decap_8
XTAP_TAPCELL_ROW_133_2302 VGND VPWR sky130_fd_sc_hd__tapvpwrvgnd_1
XPHY_EDGE_ROW_85_Right_85 VGND VGND VPWR VPWR sky130_fd_sc_hd__decap_3
XFILLER_0_52_223 VGND VGND VPWR VPWR sky130_fd_sc_hd__fill_1
XFILLER_0_4_309 VPWR VGND VPWR VGND sky130_ef_sc_hd__decap_12
XFILLER_0_108_697 VGND VGND VPWR VPWR sky130_fd_sc_hd__decap_3
XFILLER_0_80_587 VGND VGND VPWR VPWR sky130_fd_sc_hd__fill_1
XFILLER_0_52_278 VGND VGND VPWR VPWR sky130_fd_sc_hd__fill_1
XFILLER_0_52_245 VGND VGND VPWR VPWR sky130_fd_sc_hd__decap_6
XFILLER_0_12_109 VPWR VGND VPWR VGND sky130_ef_sc_hd__decap_12
XFILLER_0_122_133 VGND VGND VPWR VPWR sky130_fd_sc_hd__decap_6
XFILLER_0_80_598 VGND VGND VPWR VPWR sky130_fd_sc_hd__decap_4
XFILLER_0_122_177 VPWR VGND VPWR VGND sky130_ef_sc_hd__decap_12
XFILLER_0_110_339 VGND VGND VPWR VPWR sky130_fd_sc_hd__decap_8
XFILLER_0_0_559 VGND VGND VPWR VPWR sky130_fd_sc_hd__fill_1
XFILLER_0_21_698 VGND VGND VPWR VPWR sky130_fd_sc_hd__fill_1
XTAP_TAPCELL_ROW_111_1965 VGND VPWR sky130_fd_sc_hd__tapvpwrvgnd_1
XPHY_EDGE_ROW_94_Right_94 VGND VGND VPWR VPWR sky130_fd_sc_hd__decap_3
XFILLER_0_57_69 VGND VGND VPWR VPWR sky130_fd_sc_hd__decap_8
XPHY_EDGE_ROW_29_Left_168 VGND VGND VPWR VPWR sky130_fd_sc_hd__decap_3
XTAP_TAPCELL_ROW_53_1094 VGND VPWR sky130_fd_sc_hd__tapvpwrvgnd_1
XFILLER_0_73_57 VGND VGND VPWR VPWR sky130_fd_sc_hd__decap_6
X_5930_ net52 _2648_ VGND VGND VPWR VPWR _2649_ sky130_fd_sc_hd__xnor2_1
XFILLER_0_87_164 VGND VGND VPWR VPWR sky130_fd_sc_hd__fill_1
XFILLER_0_76_805 VGND VGND VPWR VPWR sky130_fd_sc_hd__decap_6
XFILLER_0_75_337 VGND VGND VPWR VPWR sky130_fd_sc_hd__decap_6
X_5861_ _2579_ _2583_ VGND VGND VPWR VPWR _2584_ sky130_fd_sc_hd__nor2_1
XFILLER_0_8_604 VGND VGND VPWR VPWR sky130_fd_sc_hd__fill_1
X_7600_ _3397_ rf.registers\[27\]\[24\] _3719_ VGND VGND VPWR VPWR _3724_ sky130_fd_sc_hd__mux2_1
X_8580_ clknet_leaf_19_CLK _0692_ VGND VGND VPWR VPWR rf.registers\[12\]\[19\] sky130_fd_sc_hd__dfxtp_1
XFILLER_0_8_626 VPWR VGND VPWR VGND sky130_ef_sc_hd__decap_12
XPHY_EDGE_ROW_1_Left_140 VGND VGND VPWR VPWR sky130_fd_sc_hd__decap_3
X_5792_ _1096_ _2516_ VGND VGND VPWR VPWR _2517_ sky130_fd_sc_hd__or2_1
X_4812_ _1301_ _1577_ VGND VGND VPWR VPWR _1578_ sky130_fd_sc_hd__or2_1
XPHY_EDGE_ROW_38_Left_177 VGND VGND VPWR VPWR sky130_fd_sc_hd__decap_3
XFILLER_0_90_307 VGND VGND VPWR VPWR sky130_fd_sc_hd__fill_1
X_7531_ _3687_ VGND VGND VPWR VPWR _0184_ sky130_fd_sc_hd__clkbuf_1
XFILLER_0_7_125 VPWR VGND VPWR VGND sky130_ef_sc_hd__decap_12
XFILLER_0_28_253 VGND VGND VPWR VPWR sky130_fd_sc_hd__fill_1
X_4743_ _1509_ _1510_ _1511_ _1512_ _1137_ _1135_ VGND VGND VPWR VPWR _1513_ sky130_fd_sc_hd__mux4_1
XFILLER_0_83_381 VGND VGND VPWR VPWR sky130_fd_sc_hd__decap_8
X_7462_ _3395_ rf.registers\[29\]\[23\] _3647_ VGND VGND VPWR VPWR _3651_ sky130_fd_sc_hd__mux2_1
XFILLER_0_7_169 VPWR VGND VPWR VGND sky130_ef_sc_hd__decap_12
XFILLER_0_22_94 VGND VGND VPWR VPWR sky130_fd_sc_hd__fill_2
XFILLER_0_28_286 VGND VGND VPWR VPWR sky130_fd_sc_hd__decap_3
XFILLER_0_44_757 VGND VGND VPWR VPWR sky130_fd_sc_hd__fill_2
X_9201_ clknet_leaf_40_CLK _0289_ VGND VGND VPWR VPWR rf.registers\[9\]\[0\] sky130_fd_sc_hd__dfxtp_1
XFILLER_0_113_111 VGND VGND VPWR VPWR sky130_fd_sc_hd__fill_1
X_6413_ rf.registers\[11\]\[8\] _3003_ _3056_ VGND VGND VPWR VPWR _3065_ sky130_fd_sc_hd__mux2_1
X_4674_ _1446_ _1447_ _1137_ VGND VGND VPWR VPWR _1448_ sky130_fd_sc_hd__mux2_1
XFILLER_0_43_278 VGND VGND VPWR VPWR sky130_fd_sc_hd__fill_2
X_7393_ rf.registers\[8\]\[23\] _3326_ _3610_ VGND VGND VPWR VPWR _3614_ sky130_fd_sc_hd__mux2_1
XFILLER_0_113_177 VGND VGND VPWR VPWR sky130_fd_sc_hd__fill_1
X_6344_ net21 VGND VGND VPWR VPWR _3020_ sky130_fd_sc_hd__buf_2
X_9132_ clknet_leaf_87_CLK _0220_ VGND VGND VPWR VPWR rf.registers\[27\]\[27\] sky130_fd_sc_hd__dfxtp_1
XFILLER_0_12_698 VGND VGND VPWR VPWR sky130_fd_sc_hd__fill_2
X_6275_ net33 VGND VGND VPWR VPWR _2972_ sky130_fd_sc_hd__clkbuf_2
X_9063_ clknet_leaf_94_CLK _0151_ VGND VGND VPWR VPWR rf.registers\[29\]\[22\] sky130_fd_sc_hd__dfxtp_1
X_5226_ rf.registers\[24\]\[18\] rf.registers\[25\]\[18\] rf.registers\[26\]\[18\]
+ rf.registers\[27\]\[18\] _1929_ _1930_ VGND VGND VPWR VPWR _1971_ sky130_fd_sc_hd__mux4_1
X_8014_ _2970_ rf.registers\[22\]\[26\] _3937_ VGND VGND VPWR VPWR _3944_ sky130_fd_sc_hd__mux2_1
XPHY_EDGE_ROW_47_Left_186 VGND VGND VPWR VPWR sky130_fd_sc_hd__decap_3
X_5157_ _1903_ _1904_ _1707_ VGND VGND VPWR VPWR _1905_ sky130_fd_sc_hd__mux2_1
X_5088_ _1742_ _1840_ _1709_ VGND VGND VPWR VPWR _1841_ sky130_fd_sc_hd__a21oi_1
X_8916_ clknet_leaf_47_CLK _0004_ VGND VGND VPWR VPWR rf.registers\[4\]\[3\] sky130_fd_sc_hd__dfxtp_1
XFILLER_0_79_654 VPWR VGND VPWR VGND sky130_ef_sc_hd__decap_12
XTAP_TAPCELL_ROW_84_1566 VGND VPWR sky130_fd_sc_hd__tapvpwrvgnd_1
XTAP_TAPCELL_ROW_84_1555 VGND VPWR sky130_fd_sc_hd__tapvpwrvgnd_1
XFILLER_0_78_197 VGND VGND VPWR VPWR sky130_fd_sc_hd__decap_6
X_8847_ clknet_leaf_61_CLK _0959_ VGND VGND VPWR VPWR rf.registers\[15\]\[30\] sky130_fd_sc_hd__dfxtp_1
XPHY_EDGE_ROW_56_Left_195 VGND VGND VPWR VPWR sky130_fd_sc_hd__decap_3
XFILLER_0_66_359 VGND VGND VPWR VPWR sky130_fd_sc_hd__decap_4
X_8778_ clknet_leaf_70_CLK _0890_ VGND VGND VPWR VPWR rf.registers\[0\]\[25\] sky130_fd_sc_hd__dfxtp_1
X_7729_ _3388_ rf.registers\[30\]\[20\] _3792_ VGND VGND VPWR VPWR _3793_ sky130_fd_sc_hd__mux2_1
XFILLER_0_47_573 VPWR VGND VPWR VGND sky130_ef_sc_hd__decap_12
XFILLER_0_7_670 VGND VGND VPWR VPWR sky130_fd_sc_hd__fill_2
XTAP_TAPCELL_ROW_115_2021 VGND VPWR sky130_fd_sc_hd__tapvpwrvgnd_1
XTAP_TAPCELL_ROW_115_2032 VGND VPWR sky130_fd_sc_hd__tapvpwrvgnd_1
XFILLER_0_50_749 VGND VGND VPWR VPWR sky130_fd_sc_hd__decap_6
XFILLER_0_132_475 VGND VGND VPWR VPWR sky130_fd_sc_hd__fill_1
XFILLER_0_30_451 VGND VGND VPWR VPWR sky130_fd_sc_hd__decap_4
XTAP_TAPCELL_ROW_126_2183 VGND VPWR sky130_fd_sc_hd__tapvpwrvgnd_1
XFILLER_0_134_29 VPWR VGND VPWR VGND sky130_ef_sc_hd__decap_12
XTAP_TAPCELL_ROW_126_2194 VGND VPWR sky130_fd_sc_hd__tapvpwrvgnd_1
XFILLER_0_58_805 VGND VGND VPWR VPWR sky130_fd_sc_hd__decap_6
XFILLER_0_128_737 VPWR VGND VPWR VGND sky130_ef_sc_hd__decap_12
XFILLER_0_127_225 VPWR VGND VPWR VGND sky130_ef_sc_hd__decap_12
XTAP_TAPCELL_ROW_26_693 VGND VPWR sky130_fd_sc_hd__tapvpwrvgnd_1
XFILLER_0_38_562 VGND VGND VPWR VPWR sky130_fd_sc_hd__decap_3
XFILLER_0_81_841 VGND VGND VPWR VPWR sky130_fd_sc_hd__fill_1
XFILLER_0_53_521 VGND VGND VPWR VPWR sky130_fd_sc_hd__fill_1
XFILLER_0_5_629 VPWR VGND VPWR VGND sky130_ef_sc_hd__decap_12
XFILLER_0_26_757 VPWR VGND VPWR VGND sky130_ef_sc_hd__decap_12
XFILLER_0_136_781 VPWR VGND VPWR VGND sky130_ef_sc_hd__decap_12
XFILLER_0_80_362 VGND VGND VPWR VPWR sky130_fd_sc_hd__fill_2
XFILLER_0_4_139 VGND VGND VPWR VPWR sky130_fd_sc_hd__fill_1
XFILLER_0_13_429 VPWR VGND VPWR VGND sky130_ef_sc_hd__decap_12
XFILLER_0_40_215 VGND VGND VPWR VPWR sky130_fd_sc_hd__fill_2
XFILLER_0_41_749 VGND VGND VPWR VPWR sky130_fd_sc_hd__decap_3
XFILLER_0_111_615 VGND VGND VPWR VPWR sky130_fd_sc_hd__fill_1
X_4390_ _1117_ _1169_ _1179_ VGND VGND VPWR VPWR _1180_ sky130_fd_sc_hd__o21ai_4
XFILLER_0_111_648 VGND VGND VPWR VPWR sky130_fd_sc_hd__fill_1
XTAP_TAPCELL_ROW_55_1123 VGND VPWR sky130_fd_sc_hd__tapvpwrvgnd_1
XFILLER_0_21_484 VPWR VGND VPWR VGND sky130_ef_sc_hd__decap_12
X_6060_ _1998_ _2758_ _2741_ _1982_ VGND VGND VPWR VPWR _2771_ sky130_fd_sc_hd__a211o_1
X_5011_ _1698_ VGND VGND VPWR VPWR _1768_ sky130_fd_sc_hd__buf_4
XFILLER_0_108_41 VPWR VGND VPWR VGND sky130_ef_sc_hd__decap_12
XFILLER_0_108_85 VPWR VGND VPWR VGND sky130_ef_sc_hd__decap_12
X_6962_ _3381_ VGND VGND VPWR VPWR _0945_ sky130_fd_sc_hd__clkbuf_1
X_8701_ clknet_leaf_28_CLK _0813_ VGND VGND VPWR VPWR rf.registers\[24\]\[12\] sky130_fd_sc_hd__dfxtp_1
XFILLER_0_88_473 VGND VGND VPWR VPWR sky130_fd_sc_hd__decap_3
XFILLER_0_76_613 VPWR VGND VPWR VGND sky130_ef_sc_hd__decap_12
X_6893_ net33 VGND VGND VPWR VPWR _3334_ sky130_fd_sc_hd__clkbuf_2
X_5913_ _2541_ _2624_ _2625_ _2632_ VGND VGND VPWR VPWR net115 sky130_fd_sc_hd__o31a_1
X_8632_ clknet_leaf_52_CLK _0744_ VGND VGND VPWR VPWR rf.registers\[17\]\[7\] sky130_fd_sc_hd__dfxtp_1
XFILLER_0_76_657 VPWR VGND VPWR VGND sky130_ef_sc_hd__decap_12
XTAP_TAPCELL_ROW_66_1296 VGND VPWR sky130_fd_sc_hd__tapvpwrvgnd_1
XTAP_TAPCELL_ROW_66_1285 VGND VPWR sky130_fd_sc_hd__tapvpwrvgnd_1
XFILLER_0_8_401 VPWR VGND VPWR VGND sky130_ef_sc_hd__decap_12
X_5844_ _2560_ _2566_ VGND VGND VPWR VPWR _2567_ sky130_fd_sc_hd__nor2_1
XTAP_TAPCELL_ROW_45_980 VGND VPWR sky130_fd_sc_hd__tapvpwrvgnd_1
X_8563_ clknet_leaf_44_CLK _0675_ VGND VGND VPWR VPWR rf.registers\[12\]\[2\] sky130_fd_sc_hd__dfxtp_1
XFILLER_0_63_307 VGND VGND VPWR VPWR sky130_fd_sc_hd__fill_1
XFILLER_0_8_445 VPWR VGND VPWR VGND sky130_ef_sc_hd__decap_12
X_7514_ _3678_ VGND VGND VPWR VPWR _0176_ sky130_fd_sc_hd__clkbuf_1
XFILLER_0_8_489 VPWR VGND VPWR VGND sky130_ef_sc_hd__decap_12
X_5775_ _2452_ _2500_ _2233_ VGND VGND VPWR VPWR _2501_ sky130_fd_sc_hd__mux2_1
XFILLER_0_133_217 VGND VGND VPWR VPWR sky130_fd_sc_hd__decap_6
X_8494_ _3045_ rf.registers\[14\]\[28\] _4189_ VGND VGND VPWR VPWR _4198_ sky130_fd_sc_hd__mux2_1
X_4726_ rf.registers\[16\]\[24\] rf.registers\[17\]\[24\] rf.registers\[18\]\[24\]
+ rf.registers\[19\]\[24\] _1146_ _1148_ VGND VGND VPWR VPWR _1497_ sky130_fd_sc_hd__mux4_1
X_7445_ _3378_ rf.registers\[29\]\[15\] _3636_ VGND VGND VPWR VPWR _3642_ sky130_fd_sc_hd__mux2_1
XFILLER_0_16_289 VPWR VGND VPWR VGND sky130_ef_sc_hd__decap_12
X_4657_ _1430_ _1431_ _1163_ VGND VGND VPWR VPWR _1432_ sky130_fd_sc_hd__mux2_1
XFILLER_0_114_475 VGND VGND VPWR VPWR sky130_fd_sc_hd__fill_1
X_7376_ rf.registers\[8\]\[15\] _3309_ _3599_ VGND VGND VPWR VPWR _3605_ sky130_fd_sc_hd__mux2_1
XFILLER_0_3_161 VGND VGND VPWR VPWR sky130_fd_sc_hd__decap_6
X_9115_ clknet_leaf_26_CLK _0203_ VGND VGND VPWR VPWR rf.registers\[27\]\[10\] sky130_fd_sc_hd__dfxtp_1
X_6327_ rf.registers\[12\]\[10\] _3007_ _3008_ VGND VGND VPWR VPWR _3009_ sky130_fd_sc_hd__mux2_1
X_4588_ rf.registers\[4\]\[16\] rf.registers\[5\]\[16\] rf.registers\[6\]\[16\] rf.registers\[7\]\[16\]
+ _1126_ _1129_ VGND VGND VPWR VPWR _1367_ sky130_fd_sc_hd__mux4_1
XFILLER_0_40_793 VPWR VGND VPWR VGND sky130_ef_sc_hd__decap_12
X_9046_ clknet_leaf_78_CLK _0134_ VGND VGND VPWR VPWR rf.registers\[29\]\[5\] sky130_fd_sc_hd__dfxtp_1
X_6258_ _2957_ _2380_ _2260_ VGND VGND VPWR VPWR _2958_ sky130_fd_sc_hd__o21ai_1
X_5209_ _1768_ VGND VGND VPWR VPWR _1955_ sky130_fd_sc_hd__buf_4
X_6189_ _2374_ _2376_ VGND VGND VPWR VPWR _2893_ sky130_fd_sc_hd__nand2_1
XFILLER_0_99_727 VGND VGND VPWR VPWR sky130_fd_sc_hd__fill_1
XTAP_TAPCELL_ROW_4_366 VGND VPWR sky130_fd_sc_hd__tapvpwrvgnd_1
XTAP_TAPCELL_ROW_4_355 VGND VPWR sky130_fd_sc_hd__tapvpwrvgnd_1
XPHY_EDGE_ROW_64_Left_203 VGND VGND VPWR VPWR sky130_fd_sc_hd__decap_3
XFILLER_0_94_421 VGND VGND VPWR VPWR sky130_fd_sc_hd__fill_2
XFILLER_0_94_410 VGND VGND VPWR VPWR sky130_fd_sc_hd__decap_8
XFILLER_0_94_432 VGND VGND VPWR VPWR sky130_fd_sc_hd__fill_1
XFILLER_0_39_337 VGND VGND VPWR VPWR sky130_fd_sc_hd__fill_1
XFILLER_0_39_359 VGND VGND VPWR VPWR sky130_fd_sc_hd__fill_2
XTAP_TAPCELL_ROW_43_939 VGND VPWR sky130_fd_sc_hd__tapvpwrvgnd_1
XFILLER_0_109_247 VGND VGND VPWR VPWR sky130_fd_sc_hd__fill_2
XFILLER_0_109_225 VGND VGND VPWR VPWR sky130_fd_sc_hd__fill_1
XTAP_TAPCELL_ROW_23_641 VGND VPWR sky130_fd_sc_hd__tapvpwrvgnd_1
XFILLER_0_125_729 VPWR VGND VPWR VGND sky130_ef_sc_hd__decap_12
XFILLER_0_63_841 VGND VGND VPWR VPWR sky130_fd_sc_hd__fill_1
XFILLER_0_54_329 VGND VGND VPWR VPWR sky130_fd_sc_hd__fill_1
XTAP_TAPCELL_ROW_23_652 VGND VPWR sky130_fd_sc_hd__tapvpwrvgnd_1
XFILLER_0_118_781 VPWR VGND VPWR VGND sky130_ef_sc_hd__decap_12
XFILLER_0_35_554 VGND VGND VPWR VPWR sky130_fd_sc_hd__decap_6
XTAP_TAPCELL_ROW_97_1757 VGND VPWR sky130_fd_sc_hd__tapvpwrvgnd_1
XPHY_EDGE_ROW_73_Left_212 VGND VGND VPWR VPWR sky130_fd_sc_hd__decap_3
XFILLER_0_23_727 VGND VGND VPWR VPWR sky130_fd_sc_hd__fill_1
XFILLER_0_23_738 VGND VGND VPWR VPWR sky130_fd_sc_hd__decap_8
XFILLER_0_120_412 VGND VGND VPWR VPWR sky130_fd_sc_hd__fill_1
XFILLER_0_38_27 VGND VGND VPWR VPWR sky130_fd_sc_hd__fill_1
XTAP_TAPCELL_ROW_128_2223 VGND VPWR sky130_fd_sc_hd__tapvpwrvgnd_1
XTAP_TAPCELL_ROW_50_1053 VGND VPWR sky130_fd_sc_hd__tapvpwrvgnd_1
XPHY_EDGE_ROW_82_Left_221 VGND VGND VPWR VPWR sky130_fd_sc_hd__decap_3
XFILLER_0_54_15 VPWR VGND VPWR VGND sky130_ef_sc_hd__decap_12
XFILLER_0_98_793 VPWR VGND VPWR VGND sky130_ef_sc_hd__decap_12
XTAP_TAPCELL_ROW_106_1897 VGND VPWR sky130_fd_sc_hd__tapvpwrvgnd_1
XTAP_TAPCELL_ROW_106_1886 VGND VPWR sky130_fd_sc_hd__tapvpwrvgnd_1
XFILLER_0_58_657 VPWR VGND VPWR VGND sky130_ef_sc_hd__decap_12
XFILLER_0_72_104 VPWR VGND VPWR VGND sky130_ef_sc_hd__decap_12
XFILLER_0_26_521 VGND VGND VPWR VPWR sky130_fd_sc_hd__decap_8
XPHY_EDGE_ROW_91_Left_230 VGND VGND VPWR VPWR sky130_fd_sc_hd__decap_3
X_5560_ _2212_ _2290_ VGND VGND VPWR VPWR _2291_ sky130_fd_sc_hd__nand2_1
XFILLER_0_26_598 VPWR VGND VPWR VGND sky130_ef_sc_hd__decap_12
X_4511_ _1139_ VGND VGND VPWR VPWR _1294_ sky130_fd_sc_hd__clkbuf_8
X_5491_ _2217_ _2221_ VGND VGND VPWR VPWR _2222_ sky130_fd_sc_hd__nand2_1
XFILLER_0_130_209 VPWR VGND VPWR VGND sky130_ef_sc_hd__decap_12
XFILLER_0_123_261 VPWR VGND VPWR VGND sky130_ef_sc_hd__decap_12
XFILLER_0_110_53 VPWR VGND VPWR VGND sky130_ef_sc_hd__decap_12
X_4442_ rf.registers\[0\]\[8\] rf.registers\[1\]\[8\] rf.registers\[2\]\[8\] rf.registers\[3\]\[8\]
+ _1042_ _1044_ VGND VGND VPWR VPWR _1229_ sky130_fd_sc_hd__mux4_1
X_7230_ rf.registers\[19\]\[10\] _3298_ _3527_ VGND VGND VPWR VPWR _3528_ sky130_fd_sc_hd__mux2_1
XFILLER_0_13_237 VPWR VGND VPWR VGND sky130_ef_sc_hd__decap_12
XFILLER_0_110_97 VPWR VGND VPWR VGND sky130_ef_sc_hd__decap_12
X_4373_ _1143_ VGND VGND VPWR VPWR _1163_ sky130_fd_sc_hd__buf_4
X_7161_ _3479_ VGND VGND VPWR VPWR _3491_ sky130_fd_sc_hd__buf_4
XFILLER_0_1_665 VGND VGND VPWR VPWR sky130_fd_sc_hd__decap_6
XFILLER_0_21_281 VGND VGND VPWR VPWR sky130_fd_sc_hd__decap_4
X_7092_ _3454_ VGND VGND VPWR VPWR _1002_ sky130_fd_sc_hd__clkbuf_1
XFILLER_0_95_55 VGND VGND VPWR VPWR sky130_fd_sc_hd__fill_1
X_6112_ _1445_ _1462_ _2200_ _2646_ VGND VGND VPWR VPWR _2820_ sky130_fd_sc_hd__nand4_2
XFILLER_0_0_197 VPWR VGND VPWR VGND sky130_ef_sc_hd__decap_12
X_6043_ _2742_ _2745_ VGND VGND VPWR VPWR _2755_ sky130_fd_sc_hd__nor2_1
XTAP_TAPCELL_ROW_68_1314 VGND VPWR sky130_fd_sc_hd__tapvpwrvgnd_1
XTAP_TAPCELL_ROW_1_314 VGND VPWR sky130_fd_sc_hd__tapvpwrvgnd_1
X_7994_ _3933_ VGND VGND VPWR VPWR _0401_ sky130_fd_sc_hd__clkbuf_1
XTAP_TAPCELL_ROW_68_1325 VGND VPWR sky130_fd_sc_hd__tapvpwrvgnd_1
XFILLER_0_14_3 VPWR VGND VPWR VGND sky130_ef_sc_hd__decap_12
X_6945_ net16 VGND VGND VPWR VPWR _3370_ sky130_fd_sc_hd__clkbuf_2
XTAP_TAPCELL_ROW_81_1514 VGND VPWR sky130_fd_sc_hd__tapvpwrvgnd_1
XFILLER_0_76_421 VGND VGND VPWR VPWR sky130_fd_sc_hd__decap_6
XFILLER_0_76_487 VGND VGND VPWR VPWR sky130_fd_sc_hd__decap_3
XFILLER_0_9_743 VGND VGND VPWR VPWR sky130_fd_sc_hd__decap_3
X_6876_ rf.registers\[16\]\[21\] _3322_ _3320_ VGND VGND VPWR VPWR _3323_ sky130_fd_sc_hd__mux2_1
XFILLER_0_48_178 VGND VGND VPWR VPWR sky130_fd_sc_hd__fill_1
XFILLER_0_134_504 VGND VGND VPWR VPWR sky130_fd_sc_hd__fill_1
XFILLER_0_107_729 VPWR VGND VPWR VGND sky130_ef_sc_hd__decap_12
XFILLER_0_64_638 VGND VGND VPWR VPWR sky130_fd_sc_hd__decap_6
X_8615_ clknet_leaf_7_CLK _0727_ VGND VGND VPWR VPWR rf.registers\[11\]\[22\] sky130_fd_sc_hd__dfxtp_1
XFILLER_0_9_776 VGND VGND VPWR VPWR sky130_fd_sc_hd__decap_8
XFILLER_0_8_253 VPWR VGND VPWR VGND sky130_ef_sc_hd__decap_12
X_5827_ _2440_ _2459_ _2550_ _2296_ VGND VGND VPWR VPWR _2551_ sky130_fd_sc_hd__o22a_1
XFILLER_0_45_841 VGND VGND VPWR VPWR sky130_fd_sc_hd__fill_1
X_8546_ _3031_ rf.registers\[13\]\[21\] _4216_ VGND VGND VPWR VPWR _4225_ sky130_fd_sc_hd__mux2_1
X_5758_ _2483_ VGND VGND VPWR VPWR _2484_ sky130_fd_sc_hd__inv_2
XFILLER_0_17_554 VGND VGND VPWR VPWR sky130_fd_sc_hd__decap_6
XTAP_TAPCELL_ROW_20_600 VGND VPWR sky130_fd_sc_hd__tapvpwrvgnd_1
XFILLER_0_60_811 VGND VGND VPWR VPWR sky130_fd_sc_hd__fill_1
X_8477_ _4166_ VGND VGND VPWR VPWR _4189_ sky130_fd_sc_hd__clkbuf_8
X_4709_ rf.registers\[24\]\[23\] rf.registers\[25\]\[23\] rf.registers\[26\]\[23\]
+ rf.registers\[27\]\[23\] _1329_ _1330_ VGND VGND VPWR VPWR _1481_ sky130_fd_sc_hd__mux4_1
X_7428_ _3361_ rf.registers\[29\]\[7\] _3625_ VGND VGND VPWR VPWR _3633_ sky130_fd_sc_hd__mux2_1
XFILLER_0_20_708 VPWR VGND VPWR VGND sky130_ef_sc_hd__decap_12
X_5689_ _2312_ _2280_ _2332_ VGND VGND VPWR VPWR _2418_ sky130_fd_sc_hd__mux2_1
XTAP_TAPCELL_ROW_79_1487 VGND VPWR sky130_fd_sc_hd__tapvpwrvgnd_1
XFILLER_0_32_579 VGND VGND VPWR VPWR sky130_fd_sc_hd__decap_8
X_7359_ rf.registers\[8\]\[7\] _3292_ _3588_ VGND VGND VPWR VPWR _3596_ sky130_fd_sc_hd__mux2_1
XTAP_TAPCELL_ROW_9_436 VGND VPWR sky130_fd_sc_hd__tapvpwrvgnd_1
XTAP_TAPCELL_ROW_92_1687 VGND VPWR sky130_fd_sc_hd__tapvpwrvgnd_1
XTAP_TAPCELL_ROW_92_1676 VGND VPWR sky130_fd_sc_hd__tapvpwrvgnd_1
X_9029_ clknet_leaf_81_CLK _0117_ VGND VGND VPWR VPWR rf.registers\[8\]\[20\] sky130_fd_sc_hd__dfxtp_1
XFILLER_0_99_535 VGND VGND VPWR VPWR sky130_fd_sc_hd__decap_4
XFILLER_0_99_579 VGND VGND VPWR VPWR sky130_fd_sc_hd__decap_8
XTAP_TAPCELL_ROW_28_722 VGND VPWR sky130_fd_sc_hd__tapvpwrvgnd_1
XTAP_TAPCELL_ROW_123_2142 VGND VPWR sky130_fd_sc_hd__tapvpwrvgnd_1
XFILLER_0_24_29 VPWR VGND VPWR VGND sky130_ef_sc_hd__decap_12
XFILLER_0_138_821 VGND VGND VPWR VPWR sky130_fd_sc_hd__fill_1
XFILLER_0_95_741 VPWR VGND VPWR VGND sky130_ef_sc_hd__decap_12
XFILLER_0_79_281 VGND VGND VPWR VPWR sky130_fd_sc_hd__decap_4
XFILLER_0_95_785 VPWR VGND VPWR VGND sky130_ef_sc_hd__decap_12
XFILLER_0_94_251 VGND VGND VPWR VPWR sky130_fd_sc_hd__fill_1
XFILLER_0_27_318 VGND VGND VPWR VPWR sky130_fd_sc_hd__fill_2
XFILLER_0_131_19 VPWR VGND VPWR VGND sky130_ef_sc_hd__decap_12
XFILLER_0_70_619 VGND VGND VPWR VPWR sky130_fd_sc_hd__fill_1
XFILLER_0_63_660 VPWR VGND VPWR VGND sky130_ef_sc_hd__decap_12
XFILLER_0_51_833 VGND VGND VPWR VPWR sky130_fd_sc_hd__decap_6
XFILLER_0_121_721 VGND VGND VPWR VPWR sky130_fd_sc_hd__decap_6
XFILLER_0_50_365 VGND VGND VPWR VPWR sky130_fd_sc_hd__fill_2
XFILLER_0_49_15 VPWR VGND VPWR VGND sky130_ef_sc_hd__decap_12
XFILLER_0_121_765 VPWR VGND VPWR VGND sky130_ef_sc_hd__decap_12
XFILLER_0_120_253 VPWR VGND VPWR VGND sky130_ef_sc_hd__decap_12
XTAP_TAPCELL_ROW_108_1915 VGND VPWR sky130_fd_sc_hd__tapvpwrvgnd_1
XTAP_TAPCELL_ROW_108_1926 VGND VPWR sky130_fd_sc_hd__tapvpwrvgnd_1
XFILLER_0_81_35 VGND VGND VPWR VPWR sky130_fd_sc_hd__decap_3
XFILLER_0_77_207 VGND VGND VPWR VPWR sky130_fd_sc_hd__fill_1
XFILLER_0_58_410 VGND VGND VPWR VPWR sky130_fd_sc_hd__fill_1
X_4991_ _1703_ VGND VGND VPWR VPWR _1749_ sky130_fd_sc_hd__clkbuf_8
XFILLER_0_81_57 VGND VGND VPWR VPWR sky130_fd_sc_hd__decap_3
X_6730_ rf.registers\[10\]\[27\] _3043_ _3227_ VGND VGND VPWR VPWR _3235_ sky130_fd_sc_hd__mux2_1
XFILLER_0_129_821 VPWR VGND VPWR VGND sky130_ef_sc_hd__decap_12
XFILLER_0_85_240 VGND VGND VPWR VPWR sky130_fd_sc_hd__fill_1
XTAP_TAPCELL_ROW_63_1244 VGND VPWR sky130_fd_sc_hd__tapvpwrvgnd_1
XFILLER_0_18_307 VGND VGND VPWR VPWR sky130_fd_sc_hd__fill_1
X_6661_ rf.registers\[24\]\[27\] _3043_ _3190_ VGND VGND VPWR VPWR _3198_ sky130_fd_sc_hd__mux2_1
XFILLER_0_27_830 VGND VGND VPWR VPWR sky130_fd_sc_hd__decap_4
X_8400_ _4148_ VGND VGND VPWR VPWR _0592_ sky130_fd_sc_hd__clkbuf_1
X_9380_ clknet_leaf_21_CLK _0468_ VGND VGND VPWR VPWR rf.registers\[26\]\[19\] sky130_fd_sc_hd__dfxtp_1
XFILLER_0_6_735 VPWR VGND VPWR VGND sky130_ef_sc_hd__decap_12
XFILLER_0_6_713 VGND VGND VPWR VPWR sky130_fd_sc_hd__decap_4
X_6592_ rf.registers\[1\]\[27\] _3043_ _3153_ VGND VGND VPWR VPWR _3161_ sky130_fd_sc_hd__mux2_1
XFILLER_0_27_841 VGND VGND VPWR VPWR sky130_fd_sc_hd__fill_1
X_5612_ _2212_ _2228_ VGND VGND VPWR VPWR _2342_ sky130_fd_sc_hd__nor2_1
X_8331_ rf.registers\[20\]\[15\] net20 _4106_ VGND VGND VPWR VPWR _4112_ sky130_fd_sc_hd__mux2_1
XFILLER_0_54_682 VPWR VGND VPWR VGND sky130_ef_sc_hd__decap_12
XFILLER_0_6_757 VPWR VGND VPWR VGND sky130_ef_sc_hd__decap_12
XFILLER_0_5_223 VGND VGND VPWR VPWR sky130_fd_sc_hd__fill_1
XFILLER_0_14_513 VPWR VGND VPWR VGND sky130_ef_sc_hd__decap_12
X_5543_ _1056_ _2273_ VGND VGND VPWR VPWR _2274_ sky130_fd_sc_hd__nor2_1
XFILLER_0_42_811 VGND VGND VPWR VPWR sky130_fd_sc_hd__fill_1
XFILLER_0_131_529 VGND VGND VPWR VPWR sky130_fd_sc_hd__fill_1
X_8262_ _4075_ VGND VGND VPWR VPWR _0527_ sky130_fd_sc_hd__clkbuf_1
X_5474_ _2197_ _2200_ _2204_ VGND VGND VPWR VPWR _2205_ sky130_fd_sc_hd__nand3b_2
X_7213_ rf.registers\[19\]\[2\] _3282_ _3516_ VGND VGND VPWR VPWR _3519_ sky130_fd_sc_hd__mux2_1
X_8193_ _3376_ rf.registers\[21\]\[14\] _4034_ VGND VGND VPWR VPWR _4039_ sky130_fd_sc_hd__mux2_1
X_4425_ rf.registers\[8\]\[7\] rf.registers\[9\]\[7\] rf.registers\[10\]\[7\] rf.registers\[11\]\[7\]
+ _1198_ _1199_ VGND VGND VPWR VPWR _1213_ sky130_fd_sc_hd__mux4_1
X_7144_ _3482_ VGND VGND VPWR VPWR _0002_ sky130_fd_sc_hd__clkbuf_1
X_4356_ _1146_ VGND VGND VPWR VPWR _1147_ sky130_fd_sc_hd__clkbuf_8
XFILLER_0_1_473 VPWR VGND VPWR VGND sky130_ef_sc_hd__decap_12
X_4287_ rf.registers\[28\]\[2\] rf.registers\[29\]\[2\] rf.registers\[30\]\[2\] rf.registers\[31\]\[2\]
+ _1077_ _1078_ VGND VGND VPWR VPWR _1080_ sky130_fd_sc_hd__mux4_1
X_7075_ rf.registers\[5\]\[1\] _3280_ _3444_ VGND VGND VPWR VPWR _3446_ sky130_fd_sc_hd__mux2_1
X_6026_ _2724_ _2730_ _2739_ _2399_ VGND VGND VPWR VPWR net121 sky130_fd_sc_hd__o22a_1
XPHY_EDGE_ROW_126_Right_126 VGND VGND VPWR VPWR sky130_fd_sc_hd__decap_3
X_7977_ _3924_ VGND VGND VPWR VPWR _0393_ sky130_fd_sc_hd__clkbuf_1
XFILLER_0_77_741 VPWR VGND VPWR VGND sky130_ef_sc_hd__decap_12
XFILLER_0_77_785 VPWR VGND VPWR VGND sky130_ef_sc_hd__decap_12
X_6928_ _3358_ VGND VGND VPWR VPWR _0934_ sky130_fd_sc_hd__clkbuf_1
X_6859_ net21 VGND VGND VPWR VPWR _3311_ sky130_fd_sc_hd__buf_2
XFILLER_0_134_301 VGND VGND VPWR VPWR sky130_fd_sc_hd__decap_6
XFILLER_0_119_375 VGND VGND VPWR VPWR sky130_fd_sc_hd__fill_2
XFILLER_0_92_755 VGND VGND VPWR VPWR sky130_fd_sc_hd__fill_1
XFILLER_0_9_595 VGND VGND VPWR VPWR sky130_fd_sc_hd__fill_1
XTAP_TAPCELL_ROW_33_791 VGND VPWR sky130_fd_sc_hd__tapvpwrvgnd_1
XFILLER_0_134_345 VPWR VGND VPWR VGND sky130_ef_sc_hd__decap_12
XFILLER_0_91_265 VGND VGND VPWR VPWR sky130_fd_sc_hd__fill_2
XFILLER_0_45_671 VGND VGND VPWR VPWR sky130_fd_sc_hd__fill_1
XFILLER_0_134_389 VPWR VGND VPWR VGND sky130_ef_sc_hd__decap_12
XTAP_TAPCELL_ROW_94_1705 VGND VPWR sky130_fd_sc_hd__tapvpwrvgnd_1
X_8529_ _2967_ VGND VGND VPWR VPWR _4216_ sky130_fd_sc_hd__buf_4
XFILLER_0_33_833 VGND VGND VPWR VPWR sky130_fd_sc_hd__decap_6
XFILLER_0_45_693 VGND VGND VPWR VPWR sky130_fd_sc_hd__decap_3
XFILLER_0_103_721 VGND VGND VPWR VPWR sky130_fd_sc_hd__decap_6
XTAP_TAPCELL_ROW_94_1716 VGND VPWR sky130_fd_sc_hd__tapvpwrvgnd_1
XFILLER_0_20_505 VPWR VGND VPWR VGND sky130_ef_sc_hd__decap_12
XFILLER_0_103_765 VPWR VGND VPWR VGND sky130_ef_sc_hd__decap_12
XFILLER_0_102_253 VGND VGND VPWR VPWR sky130_fd_sc_hd__decap_4
XTAP_TAPCELL_ROW_103_1845 VGND VPWR sky130_fd_sc_hd__tapvpwrvgnd_1
XFILLER_0_67_273 VGND VGND VPWR VPWR sky130_fd_sc_hd__fill_2
XFILLER_0_51_49 VGND VGND VPWR VPWR sky130_fd_sc_hd__decap_6
XFILLER_0_138_673 VPWR VGND VPWR VGND sky130_ef_sc_hd__decap_12
XFILLER_0_137_161 VGND VGND VPWR VPWR sky130_fd_sc_hd__decap_6
XFILLER_0_126_813 VPWR VGND VPWR VGND sky130_ef_sc_hd__decap_12
XFILLER_0_83_777 VGND VGND VPWR VPWR sky130_fd_sc_hd__decap_6
XFILLER_0_82_232 VGND VGND VPWR VPWR sky130_fd_sc_hd__fill_1
XTAP_TAPCELL_ROW_136_2344 VGND VPWR sky130_fd_sc_hd__tapvpwrvgnd_1
XTAP_TAPCELL_ROW_136_2333 VGND VPWR sky130_fd_sc_hd__tapvpwrvgnd_1
Xclkload25 clknet_leaf_10_CLK VGND VGND VPWR VPWR clkload25/Y sky130_fd_sc_hd__clkinv_1
XTAP_TAPCELL_ROW_11_463 VGND VPWR sky130_fd_sc_hd__tapvpwrvgnd_1
XFILLER_0_3_727 VGND VGND VPWR VPWR sky130_fd_sc_hd__fill_1
Xclkload14 clknet_leaf_90_CLK VGND VGND VPWR VPWR clkload14/Y sky130_fd_sc_hd__clkinvlp_4
Xclkload69 clknet_leaf_38_CLK VGND VGND VPWR VPWR clkload69/Y sky130_fd_sc_hd__clkinv_1
Xclkload58 clknet_leaf_31_CLK VGND VGND VPWR VPWR clkload58/Y sky130_fd_sc_hd__clkinv_4
Xclkload47 clknet_leaf_75_CLK VGND VGND VPWR VPWR clkload47/Y sky130_fd_sc_hd__clkinv_4
XFILLER_0_11_505 VPWR VGND VPWR VGND sky130_ef_sc_hd__decap_12
Xclkload36 clknet_leaf_71_CLK VGND VGND VPWR VPWR clkload36/Y sky130_fd_sc_hd__clkinvlp_4
XFILLER_0_121_540 VGND VGND VPWR VPWR sky130_fd_sc_hd__decap_4
XFILLER_0_11_549 VGND VGND VPWR VPWR sky130_fd_sc_hd__fill_2
X_5190_ _1935_ _1936_ _1768_ VGND VGND VPWR VPWR _1937_ sky130_fd_sc_hd__mux2_1
XPHY_EDGE_ROW_10_Left_149 VGND VGND VPWR VPWR sky130_fd_sc_hd__decap_3
XFILLER_0_76_79 VGND VGND VPWR VPWR sky130_fd_sc_hd__decap_4
XFILLER_0_76_68 VGND VGND VPWR VPWR sky130_fd_sc_hd__decap_8
X_7900_ _3355_ rf.registers\[23\]\[4\] _3879_ VGND VGND VPWR VPWR _3884_ sky130_fd_sc_hd__mux2_1
XFILLER_0_116_41 VPWR VGND VPWR VGND sky130_ef_sc_hd__decap_12
X_8880_ clknet_leaf_75_CLK _0992_ VGND VGND VPWR VPWR rf.registers\[6\]\[31\] sky130_fd_sc_hd__dfxtp_1
XFILLER_0_116_85 VPWR VGND VPWR VGND sky130_ef_sc_hd__decap_12
X_7831_ _3355_ rf.registers\[28\]\[4\] _3842_ VGND VGND VPWR VPWR _3847_ sky130_fd_sc_hd__mux2_1
XFILLER_0_59_741 VPWR VGND VPWR VGND sky130_ef_sc_hd__decap_12
X_7762_ _3810_ VGND VGND VPWR VPWR _0292_ sky130_fd_sc_hd__clkbuf_1
X_4974_ _1731_ VGND VGND VPWR VPWR _1732_ sky130_fd_sc_hd__buf_4
XTAP_TAPCELL_ROW_19_585 VGND VPWR sky130_fd_sc_hd__tapvpwrvgnd_1
X_7693_ _3353_ rf.registers\[30\]\[3\] _3770_ VGND VGND VPWR VPWR _3774_ sky130_fd_sc_hd__mux2_1
X_9501_ clknet_leaf_23_CLK _0589_ VGND VGND VPWR VPWR rf.registers\[18\]\[12\] sky130_fd_sc_hd__dfxtp_1
X_6713_ rf.registers\[10\]\[19\] _3026_ _3216_ VGND VGND VPWR VPWR _3226_ sky130_fd_sc_hd__mux2_1
XFILLER_0_73_210 VGND VGND VPWR VPWR sky130_fd_sc_hd__decap_6
XFILLER_0_59_785 VPWR VGND VPWR VGND sky130_ef_sc_hd__decap_12
XFILLER_0_129_673 VPWR VGND VPWR VGND sky130_ef_sc_hd__decap_12
X_6644_ rf.registers\[24\]\[19\] _3026_ _3179_ VGND VGND VPWR VPWR _3189_ sky130_fd_sc_hd__mux2_1
X_9432_ clknet_leaf_54_CLK _0520_ VGND VGND VPWR VPWR rf.registers\[25\]\[7\] sky130_fd_sc_hd__dfxtp_1
XFILLER_0_74_755 VGND VGND VPWR VPWR sky130_fd_sc_hd__fill_1
XFILLER_0_73_276 VGND VGND VPWR VPWR sky130_fd_sc_hd__decap_4
Xclkload8 clknet_leaf_2_CLK VGND VGND VPWR VPWR clkload8/Y sky130_fd_sc_hd__bufinv_16
XFILLER_0_132_805 VGND VGND VPWR VPWR sky130_fd_sc_hd__decap_6
X_9363_ clknet_leaf_42_CLK _0451_ VGND VGND VPWR VPWR rf.registers\[26\]\[2\] sky130_fd_sc_hd__dfxtp_1
X_6575_ rf.registers\[1\]\[19\] _3026_ _3142_ VGND VGND VPWR VPWR _3152_ sky130_fd_sc_hd__mux2_1
XFILLER_0_81_3 VPWR VGND VPWR VGND sky130_ef_sc_hd__decap_12
XFILLER_0_14_321 VPWR VGND VPWR VGND sky130_ef_sc_hd__decap_12
XFILLER_0_15_833 VGND VGND VPWR VPWR sky130_fd_sc_hd__decap_6
XTAP_TAPCELL_ROW_30_750 VGND VPWR sky130_fd_sc_hd__tapvpwrvgnd_1
XFILLER_0_131_337 VPWR VGND VPWR VGND sky130_ef_sc_hd__decap_12
X_8314_ rf.registers\[20\]\[7\] net43 _4095_ VGND VGND VPWR VPWR _4103_ sky130_fd_sc_hd__mux2_1
XFILLER_0_14_365 VPWR VGND VPWR VGND sky130_ef_sc_hd__decap_12
X_9294_ clknet_leaf_93_CLK _0382_ VGND VGND VPWR VPWR rf.registers\[23\]\[29\] sky130_fd_sc_hd__dfxtp_1
X_5526_ _2255_ _2256_ VGND VGND VPWR VPWR _2257_ sky130_fd_sc_hd__and2_1
X_8245_ _4066_ VGND VGND VPWR VPWR _0519_ sky130_fd_sc_hd__clkbuf_1
XTAP_TAPCELL_ROW_76_1446 VGND VPWR sky130_fd_sc_hd__tapvpwrvgnd_1
XTAP_TAPCELL_ROW_76_1435 VGND VPWR sky130_fd_sc_hd__tapvpwrvgnd_1
X_5457_ rf.registers\[8\]\[31\] rf.registers\[9\]\[31\] rf.registers\[10\]\[31\] rf.registers\[11\]\[31\]
+ _1951_ _1952_ VGND VGND VPWR VPWR _2189_ sky130_fd_sc_hd__mux4_1
XFILLER_0_30_825 VGND VGND VPWR VPWR sky130_fd_sc_hd__decap_8
XFILLER_0_41_162 VGND VGND VPWR VPWR sky130_fd_sc_hd__decap_6
XFILLER_0_100_713 VPWR VGND VPWR VGND sky130_ef_sc_hd__decap_12
X_4408_ _1135_ VGND VGND VPWR VPWR _1197_ sky130_fd_sc_hd__buf_4
XFILLER_0_2_793 VPWR VGND VPWR VGND sky130_ef_sc_hd__decap_12
XFILLER_0_100_757 VPWR VGND VPWR VGND sky130_ef_sc_hd__decap_12
X_8176_ _3359_ rf.registers\[21\]\[6\] _4023_ VGND VGND VPWR VPWR _4030_ sky130_fd_sc_hd__mux2_1
XFILLER_0_1_281 VPWR VGND VPWR VGND sky130_ef_sc_hd__decap_12
X_5388_ _2120_ _2121_ _2122_ _2123_ _2074_ _1771_ VGND VGND VPWR VPWR _2124_ sky130_fd_sc_hd__mux4_1
X_4339_ rf.registers\[28\]\[4\] rf.registers\[29\]\[4\] rf.registers\[30\]\[4\] rf.registers\[31\]\[4\]
+ _1126_ _1129_ VGND VGND VPWR VPWR _1130_ sky130_fd_sc_hd__mux4_1
X_7127_ rf.registers\[5\]\[26\] _3332_ _3466_ VGND VGND VPWR VPWR _3473_ sky130_fd_sc_hd__mux2_1
XFILLER_0_5_93 VPWR VGND VPWR VGND sky130_ef_sc_hd__decap_12
X_7058_ _3436_ VGND VGND VPWR VPWR _0986_ sky130_fd_sc_hd__clkbuf_1
X_6009_ _2391_ _2715_ _2723_ VGND VGND VPWR VPWR net120 sky130_fd_sc_hd__a21oi_2
XFILLER_0_69_505 VGND VGND VPWR VPWR sky130_fd_sc_hd__decap_4
XTAP_TAPCELL_ROW_120_2101 VGND VPWR sky130_fd_sc_hd__tapvpwrvgnd_1
XTAP_TAPCELL_ROW_38_872 VGND VPWR sky130_fd_sc_hd__tapvpwrvgnd_1
XFILLER_0_96_357 VGND VGND VPWR VPWR sky130_fd_sc_hd__fill_2
XFILLER_0_37_424 VGND VGND VPWR VPWR sky130_fd_sc_hd__fill_1
XFILLER_0_126_109 VPWR VGND VPWR VGND sky130_ef_sc_hd__decap_12
XFILLER_0_119_161 VGND VGND VPWR VPWR sky130_fd_sc_hd__decap_6
XFILLER_0_108_813 VPWR VGND VPWR VGND sky130_ef_sc_hd__decap_12
XFILLER_0_107_312 VGND VGND VPWR VPWR sky130_fd_sc_hd__fill_1
XFILLER_0_92_530 VGND VGND VPWR VPWR sky130_fd_sc_hd__fill_2
XFILLER_0_65_777 VGND VGND VPWR VPWR sky130_fd_sc_hd__decap_6
XFILLER_0_64_232 VPWR VGND VPWR VGND sky130_ef_sc_hd__decap_12
XFILLER_0_80_725 VPWR VGND VPWR VGND sky130_ef_sc_hd__decap_12
XFILLER_0_135_665 VGND VGND VPWR VPWR sky130_fd_sc_hd__decap_6
XFILLER_0_134_153 VPWR VGND VPWR VGND sky130_ef_sc_hd__decap_12
XTAP_TAPCELL_ROW_118_2074 VGND VPWR sky130_fd_sc_hd__tapvpwrvgnd_1
XTAP_TAPCELL_ROW_118_2063 VGND VPWR sky130_fd_sc_hd__tapvpwrvgnd_1
XFILLER_0_80_769 VPWR VGND VPWR VGND sky130_ef_sc_hd__decap_12
XFILLER_0_17_181 VPWR VGND VPWR VGND sky130_ef_sc_hd__decap_12
XFILLER_0_134_197 VPWR VGND VPWR VGND sky130_ef_sc_hd__decap_12
XFILLER_0_33_663 VGND VGND VPWR VPWR sky130_fd_sc_hd__fill_1
XFILLER_0_103_540 VGND VGND VPWR VPWR sky130_fd_sc_hd__fill_2
XTAP_TAPCELL_ROW_131_2263 VGND VPWR sky130_fd_sc_hd__tapvpwrvgnd_1
XFILLER_0_46_27 VGND VGND VPWR VPWR sky130_fd_sc_hd__fill_1
XFILLER_0_99_151 VGND VGND VPWR VPWR sky130_fd_sc_hd__fill_1
XFILLER_0_88_825 VPWR VGND VPWR VGND sky130_ef_sc_hd__decap_12
XFILLER_0_99_173 VGND VGND VPWR VPWR sky130_fd_sc_hd__fill_1
XFILLER_0_87_335 VGND VGND VPWR VPWR sky130_fd_sc_hd__fill_1
XFILLER_0_62_15 VPWR VGND VPWR VGND sky130_ef_sc_hd__decap_12
XTAP_TAPCELL_ROW_47_1003 VGND VPWR sky130_fd_sc_hd__tapvpwrvgnd_1
XTAP_TAPCELL_ROW_16_533 VGND VPWR sky130_fd_sc_hd__tapvpwrvgnd_1
XFILLER_0_68_593 VPWR VGND VPWR VGND sky130_ef_sc_hd__decap_12
XTAP_TAPCELL_ROW_16_544 VGND VPWR sky130_fd_sc_hd__tapvpwrvgnd_1
XTAP_TAPCELL_ROW_60_1203 VGND VPWR sky130_fd_sc_hd__tapvpwrvgnd_1
XFILLER_0_56_755 VGND VGND VPWR VPWR sky130_fd_sc_hd__fill_1
XFILLER_0_7_329 VGND VGND VPWR VPWR sky130_fd_sc_hd__decap_6
XFILLER_0_83_574 VGND VGND VPWR VPWR sky130_fd_sc_hd__fill_1
X_4690_ rf.registers\[24\]\[22\] rf.registers\[25\]\[22\] rf.registers\[26\]\[22\]
+ rf.registers\[27\]\[22\] _1410_ _1411_ VGND VGND VPWR VPWR _1463_ sky130_fd_sc_hd__mux4_1
XFILLER_0_126_676 VPWR VGND VPWR VGND sky130_ef_sc_hd__decap_12
XFILLER_0_114_805 VGND VGND VPWR VPWR sky130_fd_sc_hd__decap_6
XFILLER_0_83_596 VGND VGND VPWR VPWR sky130_fd_sc_hd__fill_2
XFILLER_0_36_490 VGND VGND VPWR VPWR sky130_fd_sc_hd__decap_3
XFILLER_0_43_449 VGND VGND VPWR VPWR sky130_fd_sc_hd__decap_4
XFILLER_0_113_337 VGND VGND VPWR VPWR sky130_fd_sc_hd__fill_2
XFILLER_0_102_65 VGND VGND VPWR VPWR sky130_fd_sc_hd__decap_3
XFILLER_0_70_257 VGND VGND VPWR VPWR sky130_fd_sc_hd__decap_4
X_6360_ net27 VGND VGND VPWR VPWR _3031_ sky130_fd_sc_hd__clkbuf_2
X_5311_ rf.registers\[24\]\[23\] rf.registers\[25\]\[23\] rf.registers\[26\]\[23\]
+ rf.registers\[27\]\[23\] _1772_ _1773_ VGND VGND VPWR VPWR _2051_ sky130_fd_sc_hd__mux4_1
XFILLER_0_12_825 VPWR VGND VPWR VGND sky130_ef_sc_hd__decap_12
XFILLER_0_24_696 VGND VGND VPWR VPWR sky130_fd_sc_hd__decap_4
X_8030_ rf.registers\[7\]\[1\] _3280_ _3951_ VGND VGND VPWR VPWR _3953_ sky130_fd_sc_hd__mux2_1
X_6291_ _2964_ VGND VGND VPWR VPWR _2983_ sky130_fd_sc_hd__inv_2
XTAP_TAPCELL_ROW_58_1176 VGND VPWR sky130_fd_sc_hd__tapvpwrvgnd_1
XTAP_TAPCELL_ROW_58_1165 VGND VPWR sky130_fd_sc_hd__tapvpwrvgnd_1
XFILLER_0_11_335 VGND VGND VPWR VPWR sky130_fd_sc_hd__fill_1
X_5242_ rf.registers\[28\]\[19\] rf.registers\[29\]\[19\] rf.registers\[30\]\[19\]
+ rf.registers\[31\]\[19\] _1749_ _1750_ VGND VGND VPWR VPWR _1986_ sky130_fd_sc_hd__mux4_1
XFILLER_0_87_78 VGND VGND VPWR VPWR sky130_fd_sc_hd__decap_6
X_5173_ _1737_ VGND VGND VPWR VPWR _1920_ sky130_fd_sc_hd__clkbuf_4
XTAP_TAPCELL_ROW_71_1365 VGND VPWR sky130_fd_sc_hd__tapvpwrvgnd_1
Xinput1 A1[0] VGND VGND VPWR VPWR net1 sky130_fd_sc_hd__clkbuf_2
X_8932_ clknet_leaf_15_CLK _0020_ VGND VGND VPWR VPWR rf.registers\[4\]\[19\] sky130_fd_sc_hd__dfxtp_1
X_8863_ clknet_leaf_16_CLK _0975_ VGND VGND VPWR VPWR rf.registers\[6\]\[14\] sky130_fd_sc_hd__dfxtp_1
XFILLER_0_78_324 VGND VGND VPWR VPWR sky130_fd_sc_hd__decap_8
X_7814_ _3837_ VGND VGND VPWR VPWR _0317_ sky130_fd_sc_hd__clkbuf_1
XTAP_TAPCELL_ROW_35_820 VGND VPWR sky130_fd_sc_hd__tapvpwrvgnd_1
XTAP_TAPCELL_ROW_35_831 VGND VPWR sky130_fd_sc_hd__tapvpwrvgnd_1
X_8794_ clknet_leaf_56_CLK _0906_ VGND VGND VPWR VPWR rf.registers\[16\]\[9\] sky130_fd_sc_hd__dfxtp_1
X_4957_ rf.registers\[24\]\[4\] rf.registers\[25\]\[4\] rf.registers\[26\]\[4\] rf.registers\[27\]\[4\]
+ _1631_ _1632_ VGND VGND VPWR VPWR _1716_ sky130_fd_sc_hd__mux4_1
XFILLER_0_74_552 VGND VGND VPWR VPWR sky130_fd_sc_hd__decap_4
XFILLER_0_74_530 VGND VGND VPWR VPWR sky130_fd_sc_hd__fill_2
X_7745_ _2974_ rf.registers\[30\]\[28\] _3792_ VGND VGND VPWR VPWR _3801_ sky130_fd_sc_hd__mux2_1
X_4888_ _1646_ _1649_ _1628_ VGND VGND VPWR VPWR _1650_ sky130_fd_sc_hd__mux2_1
XFILLER_0_62_725 VPWR VGND VPWR VGND sky130_ef_sc_hd__decap_12
XFILLER_0_7_841 VGND VGND VPWR VPWR sky130_fd_sc_hd__fill_1
XFILLER_0_19_468 VGND VGND VPWR VPWR sky130_fd_sc_hd__decap_4
X_7676_ rf.registers\[2\]\[28\] _3336_ _3755_ VGND VGND VPWR VPWR _3764_ sky130_fd_sc_hd__mux2_1
XFILLER_0_47_777 VGND VGND VPWR VPWR sky130_fd_sc_hd__decap_6
XFILLER_0_116_153 VPWR VGND VPWR VGND sky130_ef_sc_hd__decap_12
X_6627_ _3180_ VGND VGND VPWR VPWR _0811_ sky130_fd_sc_hd__clkbuf_1
XFILLER_0_62_769 VPWR VGND VPWR VGND sky130_ef_sc_hd__decap_12
X_9415_ clknet_leaf_2_CLK _0503_ VGND VGND VPWR VPWR rf.registers\[21\]\[22\] sky130_fd_sc_hd__dfxtp_1
XFILLER_0_132_635 VGND VGND VPWR VPWR sky130_fd_sc_hd__decap_8
XFILLER_0_116_197 VPWR VGND VPWR VGND sky130_ef_sc_hd__decap_12
X_6558_ _3143_ VGND VGND VPWR VPWR _0779_ sky130_fd_sc_hd__clkbuf_1
X_9346_ clknet_leaf_12_CLK _0434_ VGND VGND VPWR VPWR rf.registers\[7\]\[17\] sky130_fd_sc_hd__dfxtp_1
XFILLER_0_132_657 VPWR VGND VPWR VGND sky130_ef_sc_hd__decap_12
XFILLER_0_15_685 VPWR VGND VPWR VGND sky130_ef_sc_hd__decap_12
XFILLER_0_131_167 VGND VGND VPWR VPWR sky130_fd_sc_hd__fill_1
X_9277_ clknet_leaf_23_CLK _0365_ VGND VGND VPWR VPWR rf.registers\[23\]\[12\] sky130_fd_sc_hd__dfxtp_1
X_6489_ _3106_ VGND VGND VPWR VPWR _0747_ sky130_fd_sc_hd__clkbuf_1
XFILLER_0_14_195 VGND VGND VPWR VPWR sky130_fd_sc_hd__fill_1
X_5509_ _2239_ VGND VGND VPWR VPWR _2240_ sky130_fd_sc_hd__buf_2
X_8228_ _3051_ rf.registers\[21\]\[31\] _4022_ VGND VGND VPWR VPWR _4057_ sky130_fd_sc_hd__mux2_1
X_8159_ _4020_ VGND VGND VPWR VPWR _0479_ sky130_fd_sc_hd__clkbuf_1
XFILLER_0_100_587 VGND VGND VPWR VPWR sky130_fd_sc_hd__fill_1
XTAP_TAPCELL_ROW_89_1637 VGND VPWR sky130_fd_sc_hd__tapvpwrvgnd_1
XFILLER_0_97_644 VGND VGND VPWR VPWR sky130_fd_sc_hd__decap_4
XFILLER_0_69_335 VGND VGND VPWR VPWR sky130_fd_sc_hd__fill_1
XFILLER_0_85_839 VGND VGND VPWR VPWR sky130_fd_sc_hd__fill_1
XFILLER_0_32_29 VPWR VGND VPWR VGND sky130_ef_sc_hd__decap_12
XFILLER_0_38_733 VGND VGND VPWR VPWR sky130_fd_sc_hd__fill_1
XTAP_TAPCELL_ROW_100_1804 VGND VPWR sky130_fd_sc_hd__tapvpwrvgnd_1
XFILLER_0_37_232 VGND VGND VPWR VPWR sky130_fd_sc_hd__decap_4
XFILLER_0_38_755 VGND VGND VPWR VPWR sky130_fd_sc_hd__fill_1
XFILLER_0_92_360 VGND VGND VPWR VPWR sky130_fd_sc_hd__fill_1
XFILLER_0_53_714 VPWR VGND VPWR VGND sky130_ef_sc_hd__decap_12
XFILLER_0_65_596 VGND VGND VPWR VPWR sky130_fd_sc_hd__decap_6
XFILLER_0_52_268 VGND VGND VPWR VPWR sky130_fd_sc_hd__fill_1
XFILLER_0_122_189 VGND VGND VPWR VPWR sky130_fd_sc_hd__decap_6
XFILLER_0_0_505 VPWR VGND VPWR VGND sky130_ef_sc_hd__decap_12
XFILLER_0_57_15 VPWR VGND VPWR VGND sky130_ef_sc_hd__decap_12
XTAP_TAPCELL_ROW_111_1966 VGND VPWR sky130_fd_sc_hd__tapvpwrvgnd_1
XTAP_TAPCELL_ROW_53_1095 VGND VPWR sky130_fd_sc_hd__tapvpwrvgnd_1
XFILLER_0_88_666 VGND VGND VPWR VPWR sky130_fd_sc_hd__fill_1
XFILLER_0_87_154 VGND VGND VPWR VPWR sky130_fd_sc_hd__fill_1
X_5860_ _2581_ _2582_ VGND VGND VPWR VPWR _2583_ sky130_fd_sc_hd__or2_1
XFILLER_0_48_508 VGND VGND VPWR VPWR sky130_fd_sc_hd__fill_1
XFILLER_0_88_699 VGND VGND VPWR VPWR sky130_fd_sc_hd__fill_1
X_4811_ _1575_ _1576_ _1381_ VGND VGND VPWR VPWR _1577_ sky130_fd_sc_hd__mux2_1
XFILLER_0_91_809 VPWR VGND VPWR VGND sky130_ef_sc_hd__decap_12
XFILLER_0_8_638 VGND VGND VPWR VPWR sky130_fd_sc_hd__decap_6
X_5791_ _2312_ _2280_ _1076_ VGND VGND VPWR VPWR _2516_ sky130_fd_sc_hd__mux2_1
XFILLER_0_29_744 VGND VGND VPWR VPWR sky130_fd_sc_hd__fill_1
X_7530_ _3395_ rf.registers\[31\]\[23\] _3683_ VGND VGND VPWR VPWR _3687_ sky130_fd_sc_hd__mux2_1
XFILLER_0_8_649 VGND VGND VPWR VPWR sky130_fd_sc_hd__fill_1
XFILLER_0_7_137 VPWR VGND VPWR VGND sky130_ef_sc_hd__decap_12
XFILLER_0_28_276 VGND VGND VPWR VPWR sky130_fd_sc_hd__fill_1
X_4742_ rf.registers\[20\]\[25\] rf.registers\[21\]\[25\] rf.registers\[22\]\[25\]
+ rf.registers\[23\]\[25\] _1191_ _1192_ VGND VGND VPWR VPWR _1512_ sky130_fd_sc_hd__mux4_1
XFILLER_0_83_393 VGND VGND VPWR VPWR sky130_fd_sc_hd__decap_4
XFILLER_0_71_544 VGND VGND VPWR VPWR sky130_fd_sc_hd__decap_8
XFILLER_0_71_522 VGND VGND VPWR VPWR sky130_fd_sc_hd__decap_3
X_4673_ rf.registers\[28\]\[21\] rf.registers\[29\]\[21\] rf.registers\[30\]\[21\]
+ rf.registers\[31\]\[21\] _1147_ _1149_ VGND VGND VPWR VPWR _1447_ sky130_fd_sc_hd__mux4_1
XFILLER_0_4_811 VGND VGND VPWR VPWR sky130_fd_sc_hd__fill_1
X_7461_ _3650_ VGND VGND VPWR VPWR _0151_ sky130_fd_sc_hd__clkbuf_1
X_6412_ _3064_ VGND VGND VPWR VPWR _0712_ sky130_fd_sc_hd__clkbuf_1
X_9200_ clknet_leaf_62_CLK _0288_ VGND VGND VPWR VPWR rf.registers\[30\]\[31\] sky130_fd_sc_hd__dfxtp_1
XFILLER_0_114_679 VPWR VGND VPWR VGND sky130_ef_sc_hd__decap_12
X_7392_ _3613_ VGND VGND VPWR VPWR _0119_ sky130_fd_sc_hd__clkbuf_1
XFILLER_0_113_167 VGND VGND VPWR VPWR sky130_fd_sc_hd__fill_1
X_6343_ _3019_ VGND VGND VPWR VPWR _0688_ sky130_fd_sc_hd__clkbuf_1
XFILLER_0_51_290 VGND VGND VPWR VPWR sky130_fd_sc_hd__decap_6
X_9131_ clknet_leaf_86_CLK _0219_ VGND VGND VPWR VPWR rf.registers\[27\]\[26\] sky130_fd_sc_hd__dfxtp_1
X_9062_ clknet_leaf_81_CLK _0150_ VGND VGND VPWR VPWR rf.registers\[29\]\[21\] sky130_fd_sc_hd__dfxtp_1
XFILLER_0_12_677 VPWR VGND VPWR VGND sky130_ef_sc_hd__decap_12
X_6274_ _2971_ VGND VGND VPWR VPWR _0667_ sky130_fd_sc_hd__clkbuf_1
XPHY_EDGE_ROW_102_Left_241 VGND VGND VPWR VPWR sky130_fd_sc_hd__decap_3
X_5225_ rf.registers\[28\]\[18\] rf.registers\[29\]\[18\] rf.registers\[30\]\[18\]
+ rf.registers\[31\]\[18\] _1929_ _1930_ VGND VGND VPWR VPWR _1970_ sky130_fd_sc_hd__mux4_1
X_8013_ _3943_ VGND VGND VPWR VPWR _0410_ sky130_fd_sc_hd__clkbuf_1
XFILLER_0_44_3 VPWR VGND VPWR VGND sky130_ef_sc_hd__decap_12
X_5156_ rf.registers\[16\]\[15\] rf.registers\[17\]\[15\] rf.registers\[18\]\[15\]
+ rf.registers\[19\]\[15\] _1694_ _1695_ VGND VGND VPWR VPWR _1904_ sky130_fd_sc_hd__mux4_1
X_5087_ _1838_ _1839_ _1707_ VGND VGND VPWR VPWR _1840_ sky130_fd_sc_hd__mux2_1
X_8915_ clknet_leaf_46_CLK _0003_ VGND VGND VPWR VPWR rf.registers\[4\]\[2\] sky130_fd_sc_hd__dfxtp_1
XFILLER_0_79_666 VGND VGND VPWR VPWR sky130_fd_sc_hd__decap_6
XFILLER_0_2_83 VGND VGND VPWR VPWR sky130_fd_sc_hd__fill_1
XTAP_TAPCELL_ROW_84_1567 VGND VPWR sky130_fd_sc_hd__tapvpwrvgnd_1
XTAP_TAPCELL_ROW_84_1556 VGND VPWR sky130_fd_sc_hd__tapvpwrvgnd_1
XFILLER_0_67_839 VGND VGND VPWR VPWR sky130_fd_sc_hd__fill_1
X_8846_ clknet_leaf_90_CLK _0958_ VGND VGND VPWR VPWR rf.registers\[15\]\[29\] sky130_fd_sc_hd__dfxtp_1
XFILLER_0_137_727 VGND VGND VPWR VPWR sky130_fd_sc_hd__fill_1
XPHY_EDGE_ROW_111_Left_250 VGND VGND VPWR VPWR sky130_fd_sc_hd__decap_3
X_8777_ clknet_leaf_68_CLK _0889_ VGND VGND VPWR VPWR rf.registers\[0\]\[24\] sky130_fd_sc_hd__dfxtp_1
X_5989_ _2676_ _2691_ VGND VGND VPWR VPWR _2704_ sky130_fd_sc_hd__nand2_1
X_7728_ _3769_ VGND VGND VPWR VPWR _3792_ sky130_fd_sc_hd__buf_4
XFILLER_0_19_243 VGND VGND VPWR VPWR sky130_fd_sc_hd__fill_1
XFILLER_0_19_265 VGND VGND VPWR VPWR sky130_fd_sc_hd__fill_2
XFILLER_0_35_758 VPWR VGND VPWR VGND sky130_ef_sc_hd__decap_12
XFILLER_0_47_585 VGND VGND VPWR VPWR sky130_fd_sc_hd__decap_4
XFILLER_0_132_421 VPWR VGND VPWR VGND sky130_ef_sc_hd__decap_12
XFILLER_0_105_635 VPWR VGND VPWR VGND sky130_ef_sc_hd__decap_12
X_7659_ _3732_ VGND VGND VPWR VPWR _3755_ sky130_fd_sc_hd__buf_4
XTAP_TAPCELL_ROW_115_2022 VGND VPWR sky130_fd_sc_hd__tapvpwrvgnd_1
X_9329_ clknet_leaf_41_CLK _0417_ VGND VGND VPWR VPWR rf.registers\[7\]\[0\] sky130_fd_sc_hd__dfxtp_1
XFILLER_0_30_430 VGND VGND VPWR VPWR sky130_fd_sc_hd__fill_1
XFILLER_0_120_649 VGND VGND VPWR VPWR sky130_fd_sc_hd__fill_1
XFILLER_0_101_841 VGND VGND VPWR VPWR sky130_fd_sc_hd__fill_1
XFILLER_0_27_18 VPWR VGND VPWR VGND sky130_ef_sc_hd__decap_12
XTAP_TAPCELL_ROW_126_2184 VGND VPWR sky130_fd_sc_hd__tapvpwrvgnd_1
XTAP_TAPCELL_ROW_126_2195 VGND VPWR sky130_fd_sc_hd__tapvpwrvgnd_1
XFILLER_0_69_121 VGND VGND VPWR VPWR sky130_fd_sc_hd__fill_1
XFILLER_0_73_809 VPWR VGND VPWR VGND sky130_ef_sc_hd__decap_12
XFILLER_0_57_349 VGND VGND VPWR VPWR sky130_fd_sc_hd__fill_2
XTAP_TAPCELL_ROW_26_683 VGND VPWR sky130_fd_sc_hd__tapvpwrvgnd_1
XFILLER_0_128_749 VGND VGND VPWR VPWR sky130_fd_sc_hd__decap_6
XFILLER_0_127_237 VPWR VGND VPWR VGND sky130_ef_sc_hd__decap_12
XTAP_TAPCELL_ROW_26_694 VGND VPWR sky130_fd_sc_hd__tapvpwrvgnd_1
XFILLER_0_108_440 VGND VGND VPWR VPWR sky130_fd_sc_hd__decap_4
XFILLER_0_65_393 VGND VGND VPWR VPWR sky130_fd_sc_hd__fill_2
XFILLER_0_65_371 VGND VGND VPWR VPWR sky130_fd_sc_hd__decap_4
XFILLER_0_38_585 VGND VGND VPWR VPWR sky130_fd_sc_hd__decap_3
XFILLER_0_136_793 VPWR VGND VPWR VGND sky130_ef_sc_hd__decap_12
XFILLER_0_26_769 VPWR VGND VPWR VGND sky130_ef_sc_hd__decap_12
XFILLER_0_135_281 VPWR VGND VPWR VGND sky130_ef_sc_hd__decap_12
XTAP_TAPCELL_ROW_55_1124 VGND VPWR sky130_fd_sc_hd__tapvpwrvgnd_1
XFILLER_0_0_335 VGND VGND VPWR VPWR sky130_fd_sc_hd__fill_1
XFILLER_0_21_496 VGND VGND VPWR VPWR sky130_fd_sc_hd__decap_8
X_5010_ rf.registers\[8\]\[6\] rf.registers\[9\]\[6\] rf.registers\[10\]\[6\] rf.registers\[11\]\[6\]
+ _1735_ _1737_ VGND VGND VPWR VPWR _1767_ sky130_fd_sc_hd__mux4_1
XFILLER_0_108_53 VPWR VGND VPWR VGND sky130_ef_sc_hd__decap_12
XFILLER_0_17_51 VGND VGND VPWR VPWR sky130_fd_sc_hd__decap_4
XFILLER_0_108_97 VGND VGND VPWR VPWR sky130_fd_sc_hd__decap_4
X_8700_ clknet_leaf_26_CLK _0812_ VGND VGND VPWR VPWR rf.registers\[24\]\[11\] sky130_fd_sc_hd__dfxtp_1
X_6961_ _3380_ rf.registers\[15\]\[16\] _3368_ VGND VGND VPWR VPWR _3381_ sky130_fd_sc_hd__mux2_1
XFILLER_0_124_41 VPWR VGND VPWR VGND sky130_ef_sc_hd__decap_12
XFILLER_0_76_625 VGND VGND VPWR VPWR sky130_fd_sc_hd__decap_4
XFILLER_0_49_839 VGND VGND VPWR VPWR sky130_fd_sc_hd__fill_1
X_5912_ _2560_ _2629_ _2631_ VGND VGND VPWR VPWR _2632_ sky130_fd_sc_hd__o21ai_1
X_6892_ _3333_ VGND VGND VPWR VPWR _0923_ sky130_fd_sc_hd__clkbuf_1
XFILLER_0_119_727 VGND VGND VPWR VPWR sky130_fd_sc_hd__fill_1
X_8631_ clknet_leaf_56_CLK _0743_ VGND VGND VPWR VPWR rf.registers\[17\]\[6\] sky130_fd_sc_hd__dfxtp_1
XFILLER_0_76_669 VPWR VGND VPWR VGND sky130_ef_sc_hd__decap_12
XFILLER_0_75_113 VPWR VGND VPWR VGND sky130_ef_sc_hd__decap_12
XTAP_TAPCELL_ROW_66_1297 VGND VPWR sky130_fd_sc_hd__tapvpwrvgnd_1
XTAP_TAPCELL_ROW_66_1286 VGND VPWR sky130_fd_sc_hd__tapvpwrvgnd_1
XFILLER_0_8_413 VGND VGND VPWR VPWR sky130_fd_sc_hd__decap_6
X_5843_ _2252_ _2459_ _2565_ _2296_ VGND VGND VPWR VPWR _2566_ sky130_fd_sc_hd__o22a_1
XFILLER_0_29_530 VGND VGND VPWR VPWR sky130_fd_sc_hd__decap_3
XTAP_TAPCELL_ROW_45_970 VGND VPWR sky130_fd_sc_hd__tapvpwrvgnd_1
XTAP_TAPCELL_ROW_45_981 VGND VPWR sky130_fd_sc_hd__tapvpwrvgnd_1
XFILLER_0_124_85 VPWR VGND VPWR VGND sky130_ef_sc_hd__decap_12
X_8562_ clknet_leaf_46_CLK _0674_ VGND VGND VPWR VPWR rf.registers\[12\]\[1\] sky130_fd_sc_hd__dfxtp_1
XFILLER_0_118_259 VPWR VGND VPWR VGND sky130_ef_sc_hd__decap_12
X_7513_ _3378_ rf.registers\[31\]\[15\] _3672_ VGND VGND VPWR VPWR _3678_ sky130_fd_sc_hd__mux2_1
XFILLER_0_8_457 VPWR VGND VPWR VGND sky130_ef_sc_hd__decap_12
X_5774_ _2350_ _2346_ VGND VGND VPWR VPWR _2500_ sky130_fd_sc_hd__nand2_1
X_8493_ _4197_ VGND VGND VPWR VPWR _0636_ sky130_fd_sc_hd__clkbuf_1
X_4725_ rf.registers\[20\]\[24\] rf.registers\[21\]\[24\] rf.registers\[22\]\[24\]
+ rf.registers\[23\]\[24\] _1146_ _1148_ VGND VGND VPWR VPWR _1496_ sky130_fd_sc_hd__mux4_1
XFILLER_0_114_421 VPWR VGND VPWR VGND sky130_ef_sc_hd__decap_12
X_7444_ _3641_ VGND VGND VPWR VPWR _0143_ sky130_fd_sc_hd__clkbuf_1
XFILLER_0_32_739 VPWR VGND VPWR VGND sky130_ef_sc_hd__decap_12
X_4656_ rf.registers\[16\]\[20\] rf.registers\[17\]\[20\] rf.registers\[18\]\[20\]
+ rf.registers\[19\]\[20\] _1119_ _1122_ VGND VGND VPWR VPWR _1431_ sky130_fd_sc_hd__mux4_1
X_7375_ _3604_ VGND VGND VPWR VPWR _0111_ sky130_fd_sc_hd__clkbuf_1
X_4587_ _1190_ _1365_ VGND VGND VPWR VPWR _1366_ sky130_fd_sc_hd__nand2_1
XFILLER_0_4_663 VGND VGND VPWR VPWR sky130_fd_sc_hd__fill_1
XFILLER_0_31_249 VGND VGND VPWR VPWR sky130_fd_sc_hd__fill_2
XFILLER_0_102_638 VGND VGND VPWR VPWR sky130_fd_sc_hd__decap_6
X_9114_ clknet_leaf_56_CLK _0202_ VGND VGND VPWR VPWR rf.registers\[27\]\[9\] sky130_fd_sc_hd__dfxtp_1
X_6326_ _2986_ VGND VGND VPWR VPWR _3008_ sky130_fd_sc_hd__clkbuf_8
XFILLER_0_40_772 VGND VGND VPWR VPWR sky130_fd_sc_hd__fill_1
X_9045_ clknet_leaf_48_CLK _0133_ VGND VGND VPWR VPWR rf.registers\[29\]\[4\] sky130_fd_sc_hd__dfxtp_1
X_6257_ _2379_ VGND VGND VPWR VPWR _2957_ sky130_fd_sc_hd__inv_2
X_5208_ rf.registers\[8\]\[17\] rf.registers\[9\]\[17\] rf.registers\[10\]\[17\] rf.registers\[11\]\[17\]
+ _1951_ _1952_ VGND VGND VPWR VPWR _1954_ sky130_fd_sc_hd__mux4_1
X_6188_ _2883_ _2880_ _2890_ _2391_ VGND VGND VPWR VPWR _2892_ sky130_fd_sc_hd__o31a_1
XTAP_TAPCELL_ROW_4_367 VGND VPWR sky130_fd_sc_hd__tapvpwrvgnd_1
XTAP_TAPCELL_ROW_4_356 VGND VPWR sky130_fd_sc_hd__tapvpwrvgnd_1
X_5139_ _1888_ VGND VGND VPWR VPWR net53 sky130_fd_sc_hd__inv_2
XFILLER_0_67_603 VPWR VGND VPWR VGND sky130_ef_sc_hd__decap_12
X_8829_ clknet_leaf_23_CLK _0941_ VGND VGND VPWR VPWR rf.registers\[15\]\[12\] sky130_fd_sc_hd__dfxtp_1
XFILLER_0_55_809 VPWR VGND VPWR VGND sky130_ef_sc_hd__decap_12
XTAP_TAPCELL_ROW_23_642 VGND VPWR sky130_fd_sc_hd__tapvpwrvgnd_1
XFILLER_0_118_793 VPWR VGND VPWR VGND sky130_ef_sc_hd__decap_12
XFILLER_0_90_661 VGND VGND VPWR VPWR sky130_fd_sc_hd__fill_1
XFILLER_0_133_741 VPWR VGND VPWR VGND sky130_ef_sc_hd__decap_12
XTAP_TAPCELL_ROW_97_1758 VGND VPWR sky130_fd_sc_hd__tapvpwrvgnd_1
XFILLER_0_62_363 VGND VGND VPWR VPWR sky130_fd_sc_hd__fill_1
XFILLER_0_16_780 VPWR VGND VPWR VGND sky130_ef_sc_hd__decap_12
XFILLER_0_35_577 VGND VGND VPWR VPWR sky130_fd_sc_hd__fill_1
XFILLER_0_133_785 VPWR VGND VPWR VGND sky130_ef_sc_hd__decap_12
XFILLER_0_132_251 VGND VGND VPWR VPWR sky130_fd_sc_hd__fill_1
XTAP_TAPCELL_ROW_128_2224 VGND VPWR sky130_fd_sc_hd__tapvpwrvgnd_1
XTAP_TAPCELL_ROW_128_2213 VGND VPWR sky130_fd_sc_hd__tapvpwrvgnd_1
XTAP_TAPCELL_ROW_50_1054 VGND VPWR sky130_fd_sc_hd__tapvpwrvgnd_1
XTAP_TAPCELL_ROW_50_1043 VGND VPWR sky130_fd_sc_hd__tapvpwrvgnd_1
XFILLER_0_54_27 VGND VGND VPWR VPWR sky130_fd_sc_hd__fill_1
XTAP_TAPCELL_ROW_106_1887 VGND VPWR sky130_fd_sc_hd__tapvpwrvgnd_1
XFILLER_0_70_15 VGND VGND VPWR VPWR sky130_fd_sc_hd__decap_8
XFILLER_0_58_669 VPWR VGND VPWR VGND sky130_ef_sc_hd__decap_12
XFILLER_0_73_617 VGND VGND VPWR VPWR sky130_fd_sc_hd__fill_2
XFILLER_0_72_116 VGND VGND VPWR VPWR sky130_fd_sc_hd__decap_6
XFILLER_0_5_405 VPWR VGND VPWR VGND sky130_ef_sc_hd__decap_12
XFILLER_0_26_533 VGND VGND VPWR VPWR sky130_fd_sc_hd__decap_8
XFILLER_0_53_374 VGND VGND VPWR VPWR sky130_fd_sc_hd__fill_1
XFILLER_0_5_449 VPWR VGND VPWR VGND sky130_ef_sc_hd__decap_12
XFILLER_0_13_205 VPWR VGND VPWR VGND sky130_ef_sc_hd__decap_12
X_4510_ _1291_ VGND VGND VPWR VPWR _1293_ sky130_fd_sc_hd__clkbuf_4
X_5490_ _1902_ _2219_ _2220_ VGND VGND VPWR VPWR _2221_ sky130_fd_sc_hd__o21ai_1
X_4441_ _1143_ _1227_ VGND VGND VPWR VPWR _1228_ sky130_fd_sc_hd__or2_1
XFILLER_0_102_3 VPWR VGND VPWR VGND sky130_ef_sc_hd__decap_12
XFILLER_0_13_249 VPWR VGND VPWR VGND sky130_ef_sc_hd__decap_12
XFILLER_0_123_273 VGND VGND VPWR VPWR sky130_fd_sc_hd__decap_6
XFILLER_0_110_65 VPWR VGND VPWR VGND sky130_ef_sc_hd__decap_12
X_7160_ _3490_ VGND VGND VPWR VPWR _0010_ sky130_fd_sc_hd__clkbuf_1
XPHY_EDGE_ROW_9_Right_9 VGND VGND VPWR VPWR sky130_fd_sc_hd__decap_3
XFILLER_0_41_569 VPWR VGND VPWR VGND sky130_ef_sc_hd__decap_12
X_4372_ rf.registers\[16\]\[5\] rf.registers\[17\]\[5\] rf.registers\[18\]\[5\] rf.registers\[19\]\[5\]
+ _1159_ _1160_ VGND VGND VPWR VPWR _1162_ sky130_fd_sc_hd__mux4_1
X_6111_ _2813_ _2815_ _2811_ VGND VGND VPWR VPWR _2819_ sky130_fd_sc_hd__o21a_1
X_7091_ rf.registers\[5\]\[9\] _3296_ _3444_ VGND VGND VPWR VPWR _3454_ sky130_fd_sc_hd__mux2_1
XFILLER_0_0_176 VPWR VGND VPWR VGND sky130_ef_sc_hd__decap_12
XFILLER_0_1_699 VPWR VGND VPWR VGND sky130_ef_sc_hd__decap_12
XPHY_EDGE_ROW_107_Right_107 VGND VGND VPWR VPWR sky130_fd_sc_hd__decap_3
X_6042_ _1982_ _2741_ VGND VGND VPWR VPWR _2754_ sky130_fd_sc_hd__nor2_1
XTAP_TAPCELL_ROW_1_315 VGND VPWR sky130_fd_sc_hd__tapvpwrvgnd_1
X_7993_ _3380_ rf.registers\[22\]\[16\] _3926_ VGND VGND VPWR VPWR _3933_ sky130_fd_sc_hd__mux2_1
XTAP_TAPCELL_ROW_68_1326 VGND VPWR sky130_fd_sc_hd__tapvpwrvgnd_1
XTAP_TAPCELL_ROW_68_1315 VGND VPWR sky130_fd_sc_hd__tapvpwrvgnd_1
X_6944_ _3369_ VGND VGND VPWR VPWR _0939_ sky130_fd_sc_hd__clkbuf_1
XFILLER_0_89_783 VGND VGND VPWR VPWR sky130_fd_sc_hd__fill_1
XTAP_TAPCELL_ROW_81_1515 VGND VPWR sky130_fd_sc_hd__tapvpwrvgnd_1
X_8614_ clknet_leaf_78_CLK _0726_ VGND VGND VPWR VPWR rf.registers\[11\]\[21\] sky130_fd_sc_hd__dfxtp_1
X_6875_ net27 VGND VGND VPWR VPWR _3322_ sky130_fd_sc_hd__buf_2
XFILLER_0_8_221 VPWR VGND VPWR VGND sky130_ef_sc_hd__decap_12
XFILLER_0_63_105 VGND VGND VPWR VPWR sky130_fd_sc_hd__fill_1
X_5826_ _2438_ _2441_ net103 VGND VGND VPWR VPWR _2550_ sky130_fd_sc_hd__mux2_1
X_8545_ _4224_ VGND VGND VPWR VPWR _0661_ sky130_fd_sc_hd__clkbuf_1
X_5757_ _1757_ _2481_ VGND VGND VPWR VPWR _2483_ sky130_fd_sc_hd__nor2_1
XFILLER_0_8_265 VPWR VGND VPWR VGND sky130_ef_sc_hd__decap_12
XTAP_TAPCELL_ROW_20_601 VGND VPWR sky130_fd_sc_hd__tapvpwrvgnd_1
XFILLER_0_115_741 VPWR VGND VPWR VGND sky130_ef_sc_hd__decap_12
X_8476_ _4188_ VGND VGND VPWR VPWR _0628_ sky130_fd_sc_hd__clkbuf_1
X_4708_ rf.registers\[28\]\[23\] rf.registers\[29\]\[23\] rf.registers\[30\]\[23\]
+ rf.registers\[31\]\[23\] _1329_ _1330_ VGND VGND VPWR VPWR _1480_ sky130_fd_sc_hd__mux4_1
XFILLER_0_44_363 VGND VGND VPWR VPWR sky130_fd_sc_hd__fill_1
XFILLER_0_115_785 VPWR VGND VPWR VGND sky130_ef_sc_hd__decap_12
X_7427_ _3632_ VGND VGND VPWR VPWR _0135_ sky130_fd_sc_hd__clkbuf_1
X_5688_ _2414_ _2415_ _2416_ VGND VGND VPWR VPWR _2417_ sky130_fd_sc_hd__mux2_1
XTAP_TAPCELL_ROW_79_1488 VGND VPWR sky130_fd_sc_hd__tapvpwrvgnd_1
X_4639_ _1415_ VGND VGND VPWR VPWR net90 sky130_fd_sc_hd__inv_2
XFILLER_0_130_755 VGND VGND VPWR VPWR sky130_fd_sc_hd__fill_1
X_7358_ _3595_ VGND VGND VPWR VPWR _0103_ sky130_fd_sc_hd__clkbuf_1
XTAP_TAPCELL_ROW_9_437 VGND VPWR sky130_fd_sc_hd__tapvpwrvgnd_1
X_6309_ _2996_ VGND VGND VPWR VPWR _0677_ sky130_fd_sc_hd__clkbuf_1
XTAP_TAPCELL_ROW_92_1677 VGND VPWR sky130_fd_sc_hd__tapvpwrvgnd_1
X_7289_ rf.registers\[3\]\[6\] _3290_ _3552_ VGND VGND VPWR VPWR _3559_ sky130_fd_sc_hd__mux2_1
X_9028_ clknet_leaf_18_CLK _0116_ VGND VGND VPWR VPWR rf.registers\[8\]\[19\] sky130_fd_sc_hd__dfxtp_1
XFILLER_0_99_503 VGND VGND VPWR VPWR sky130_fd_sc_hd__fill_1
XTAP_TAPCELL_ROW_28_723 VGND VPWR sky130_fd_sc_hd__tapvpwrvgnd_1
XTAP_TAPCELL_ROW_123_2143 VGND VPWR sky130_fd_sc_hd__tapvpwrvgnd_1
XFILLER_0_95_753 VPWR VGND VPWR VGND sky130_ef_sc_hd__decap_12
XFILLER_0_67_433 VGND VGND VPWR VPWR sky130_fd_sc_hd__decap_4
XFILLER_0_67_422 VGND VGND VPWR VPWR sky130_fd_sc_hd__fill_2
XFILLER_0_39_113 VGND VGND VPWR VPWR sky130_fd_sc_hd__fill_1
XFILLER_0_55_617 VGND VGND VPWR VPWR sky130_fd_sc_hd__fill_1
XFILLER_0_55_606 VGND VGND VPWR VPWR sky130_fd_sc_hd__decap_4
XFILLER_0_95_797 VPWR VGND VPWR VGND sky130_ef_sc_hd__decap_12
XFILLER_0_39_179 VGND VGND VPWR VPWR sky130_fd_sc_hd__fill_1
XFILLER_0_40_29 VPWR VGND VPWR VGND sky130_ef_sc_hd__decap_12
XFILLER_0_23_503 VGND VGND VPWR VPWR sky130_fd_sc_hd__fill_1
XFILLER_0_2_419 VGND VGND VPWR VPWR sky130_fd_sc_hd__fill_1
XFILLER_0_120_221 VPWR VGND VPWR VGND sky130_ef_sc_hd__decap_12
XFILLER_0_49_27 VPWR VGND VPWR VGND sky130_ef_sc_hd__decap_12
XFILLER_0_121_777 VGND VGND VPWR VPWR sky130_fd_sc_hd__decap_6
XFILLER_0_120_265 VGND VGND VPWR VPWR sky130_fd_sc_hd__decap_4
XFILLER_0_65_15 VPWR VGND VPWR VGND sky130_ef_sc_hd__decap_12
XFILLER_0_4_29 VPWR VGND VPWR VGND sky130_ef_sc_hd__decap_12
XTAP_TAPCELL_ROW_108_1927 VGND VPWR sky130_fd_sc_hd__tapvpwrvgnd_1
XTAP_TAPCELL_ROW_108_1916 VGND VPWR sky130_fd_sc_hd__tapvpwrvgnd_1
X_4990_ _1745_ _1746_ _1747_ VGND VGND VPWR VPWR _1748_ sky130_fd_sc_hd__mux2_1
XFILLER_0_129_833 VGND VGND VPWR VPWR sky130_fd_sc_hd__decap_6
XFILLER_0_128_321 VPWR VGND VPWR VGND sky130_ef_sc_hd__decap_12
XFILLER_0_14_41 VPWR VGND VPWR VGND sky130_ef_sc_hd__decap_12
XFILLER_0_19_809 VPWR VGND VPWR VGND sky130_ef_sc_hd__decap_12
XTAP_TAPCELL_ROW_63_1245 VGND VPWR sky130_fd_sc_hd__tapvpwrvgnd_1
XFILLER_0_14_85 VPWR VGND VPWR VGND sky130_ef_sc_hd__decap_12
X_6660_ _3197_ VGND VGND VPWR VPWR _0827_ sky130_fd_sc_hd__clkbuf_1
XFILLER_0_128_365 VPWR VGND VPWR VGND sky130_ef_sc_hd__decap_12
X_6591_ _3160_ VGND VGND VPWR VPWR _0795_ sky130_fd_sc_hd__clkbuf_1
X_5611_ _2333_ _2339_ _2340_ VGND VGND VPWR VPWR _2341_ sky130_fd_sc_hd__mux2_1
XFILLER_0_26_341 VPWR VGND VPWR VGND sky130_ef_sc_hd__decap_12
X_8330_ _4111_ VGND VGND VPWR VPWR _0559_ sky130_fd_sc_hd__clkbuf_1
XFILLER_0_6_769 VPWR VGND VPWR VGND sky130_ef_sc_hd__decap_12
XFILLER_0_6_747 VGND VGND VPWR VPWR sky130_fd_sc_hd__decap_8
X_5542_ _2119_ _2218_ VGND VGND VPWR VPWR _2273_ sky130_fd_sc_hd__nor2_1
XFILLER_0_83_7 VGND VGND VPWR VPWR sky130_fd_sc_hd__decap_8
XFILLER_0_54_694 VGND VGND VPWR VPWR sky130_fd_sc_hd__decap_6
XFILLER_0_5_279 VGND VGND VPWR VPWR sky130_fd_sc_hd__fill_1
XFILLER_0_14_525 VGND VGND VPWR VPWR sky130_fd_sc_hd__decap_6
Xclkbuf_leaf_91_CLK clknet_3_0__leaf_CLK VGND VGND VPWR VPWR clknet_leaf_91_CLK sky130_fd_sc_hd__clkbuf_8
XFILLER_0_30_73 VGND VGND VPWR VPWR sky130_fd_sc_hd__fill_2
X_8261_ _3016_ rf.registers\[25\]\[14\] _4070_ VGND VGND VPWR VPWR _4075_ sky130_fd_sc_hd__mux2_1
X_5473_ _2201_ _2202_ _2203_ VGND VGND VPWR VPWR _2204_ sky130_fd_sc_hd__nor3_1
X_7212_ _3518_ VGND VGND VPWR VPWR _0034_ sky130_fd_sc_hd__clkbuf_1
X_8192_ _4038_ VGND VGND VPWR VPWR _0494_ sky130_fd_sc_hd__clkbuf_1
XFILLER_0_112_755 VGND VGND VPWR VPWR sky130_fd_sc_hd__fill_1
X_4424_ _1208_ _1211_ _1168_ VGND VGND VPWR VPWR _1212_ sky130_fd_sc_hd__mux2_1
XFILLER_0_1_441 VGND VGND VPWR VPWR sky130_fd_sc_hd__decap_6
X_7143_ rf.registers\[4\]\[1\] _3280_ _3480_ VGND VGND VPWR VPWR _3482_ sky130_fd_sc_hd__mux2_1
X_4355_ _1118_ VGND VGND VPWR VPWR _1146_ sky130_fd_sc_hd__clkbuf_8
XFILLER_0_1_485 VPWR VGND VPWR VGND sky130_ef_sc_hd__decap_12
X_7074_ _3445_ VGND VGND VPWR VPWR _0993_ sky130_fd_sc_hd__clkbuf_1
X_4286_ rf.registers\[24\]\[2\] rf.registers\[25\]\[2\] rf.registers\[26\]\[2\] rf.registers\[27\]\[2\]
+ _1077_ _1078_ VGND VGND VPWR VPWR _1079_ sky130_fd_sc_hd__mux4_1
Xclkbuf_3_0__f_CLK clknet_0_CLK VGND VGND VPWR VPWR clknet_3_0__leaf_CLK sky130_fd_sc_hd__clkbuf_16
X_6025_ _2736_ _2738_ VGND VGND VPWR VPWR _2739_ sky130_fd_sc_hd__xnor2_1
XFILLER_0_69_709 VPWR VGND VPWR VGND sky130_ef_sc_hd__decap_12
X_7976_ _3363_ rf.registers\[22\]\[8\] _3915_ VGND VGND VPWR VPWR _3924_ sky130_fd_sc_hd__mux2_1
XFILLER_0_96_539 VGND VGND VPWR VPWR sky130_fd_sc_hd__fill_1
XFILLER_0_92_701 VPWR VGND VPWR VGND sky130_ef_sc_hd__decap_12
XFILLER_0_77_753 VPWR VGND VPWR VGND sky130_ef_sc_hd__decap_12
X_6927_ _3357_ rf.registers\[15\]\[5\] _3347_ VGND VGND VPWR VPWR _3358_ sky130_fd_sc_hd__mux2_1
X_6858_ _3310_ VGND VGND VPWR VPWR _0912_ sky130_fd_sc_hd__clkbuf_1
XFILLER_0_77_797 VPWR VGND VPWR VGND sky130_ef_sc_hd__decap_12
XFILLER_0_9_541 VGND VGND VPWR VPWR sky130_fd_sc_hd__decap_8
X_5809_ _1778_ _2533_ VGND VGND VPWR VPWR _2534_ sky130_fd_sc_hd__nand2_1
XFILLER_0_29_190 VGND VGND VPWR VPWR sky130_fd_sc_hd__fill_1
X_9577_ clknet_leaf_73_CLK _0665_ VGND VGND VPWR VPWR rf.registers\[13\]\[24\] sky130_fd_sc_hd__dfxtp_1
X_8528_ _4215_ VGND VGND VPWR VPWR _0653_ sky130_fd_sc_hd__clkbuf_1
XTAP_TAPCELL_ROW_33_792 VGND VPWR sky130_fd_sc_hd__tapvpwrvgnd_1
X_6789_ _3266_ VGND VGND VPWR VPWR _0887_ sky130_fd_sc_hd__clkbuf_1
XFILLER_0_134_357 VGND VGND VPWR VPWR sky130_fd_sc_hd__decap_6
XTAP_TAPCELL_ROW_94_1706 VGND VPWR sky130_fd_sc_hd__tapvpwrvgnd_1
Xclkbuf_leaf_82_CLK clknet_3_0__leaf_CLK VGND VGND VPWR VPWR clknet_leaf_82_CLK sky130_fd_sc_hd__clkbuf_8
X_8459_ _3010_ rf.registers\[14\]\[11\] _4178_ VGND VGND VPWR VPWR _4180_ sky130_fd_sc_hd__mux2_1
XTAP_TAPCELL_ROW_94_1717 VGND VPWR sky130_fd_sc_hd__tapvpwrvgnd_1
XFILLER_0_130_530 VGND VGND VPWR VPWR sky130_fd_sc_hd__fill_2
XFILLER_0_103_777 VGND VGND VPWR VPWR sky130_fd_sc_hd__decap_6
XFILLER_0_13_580 VGND VGND VPWR VPWR sky130_fd_sc_hd__fill_2
XFILLER_0_20_517 VPWR VGND VPWR VGND sky130_ef_sc_hd__decap_12
XFILLER_0_99_366 VGND VGND VPWR VPWR sky130_fd_sc_hd__fill_2
XFILLER_0_87_539 VGND VGND VPWR VPWR sky130_fd_sc_hd__decap_4
XFILLER_0_95_561 VGND VGND VPWR VPWR sky130_fd_sc_hd__fill_2
XFILLER_0_138_641 VGND VGND VPWR VPWR sky130_fd_sc_hd__decap_3
XTAP_TAPCELL_ROW_103_1846 VGND VPWR sky130_fd_sc_hd__tapvpwrvgnd_1
XFILLER_0_138_685 VPWR VGND VPWR VGND sky130_ef_sc_hd__decap_12
XFILLER_0_126_825 VPWR VGND VPWR VGND sky130_ef_sc_hd__decap_12
XFILLER_0_67_296 VGND VGND VPWR VPWR sky130_fd_sc_hd__fill_1
XTAP_TAPCELL_ROW_136_2345 VGND VPWR sky130_fd_sc_hd__tapvpwrvgnd_1
XTAP_TAPCELL_ROW_136_2334 VGND VPWR sky130_fd_sc_hd__tapvpwrvgnd_1
XFILLER_0_125_335 VGND VGND VPWR VPWR sky130_fd_sc_hd__fill_1
XFILLER_0_82_299 VGND VGND VPWR VPWR sky130_fd_sc_hd__decap_3
Xclkload26 clknet_leaf_11_CLK VGND VGND VPWR VPWR clkload26/Y sky130_fd_sc_hd__clkinv_1
XFILLER_0_51_642 VGND VGND VPWR VPWR sky130_fd_sc_hd__decap_3
XTAP_TAPCELL_ROW_11_464 VGND VPWR sky130_fd_sc_hd__tapvpwrvgnd_1
Xclkload15 clknet_leaf_91_CLK VGND VGND VPWR VPWR clkload15/Y sky130_fd_sc_hd__inv_6
Xclkbuf_leaf_73_CLK clknet_3_2__leaf_CLK VGND VGND VPWR VPWR clknet_leaf_73_CLK sky130_fd_sc_hd__clkbuf_8
Xclkload59 clknet_leaf_32_CLK VGND VGND VPWR VPWR clkload59/Y sky130_fd_sc_hd__clkinv_8
Xclkload48 clknet_leaf_76_CLK VGND VGND VPWR VPWR clkload48/Y sky130_fd_sc_hd__clkinvlp_4
XFILLER_0_51_664 VGND VGND VPWR VPWR sky130_fd_sc_hd__fill_1
XFILLER_0_50_141 VGND VGND VPWR VPWR sky130_fd_sc_hd__decap_4
Xclkload37 clknet_leaf_72_CLK VGND VGND VPWR VPWR clkload37/Y sky130_fd_sc_hd__inv_8
XFILLER_0_11_517 VPWR VGND VPWR VGND sky130_ef_sc_hd__decap_12
XFILLER_0_121_585 VGND VGND VPWR VPWR sky130_fd_sc_hd__fill_2
X_7830_ _3846_ VGND VGND VPWR VPWR _0324_ sky130_fd_sc_hd__clkbuf_1
XFILLER_0_92_68 VGND VGND VPWR VPWR sky130_fd_sc_hd__fill_1
XFILLER_0_116_53 VPWR VGND VPWR VGND sky130_ef_sc_hd__decap_12
XFILLER_0_116_97 VPWR VGND VPWR VGND sky130_ef_sc_hd__decap_12
X_7761_ rf.registers\[9\]\[3\] _3284_ _3806_ VGND VGND VPWR VPWR _3810_ sky130_fd_sc_hd__mux2_1
X_4973_ _1653_ VGND VGND VPWR VPWR _1731_ sky130_fd_sc_hd__clkbuf_4
XFILLER_0_74_701 VPWR VGND VPWR VGND sky130_ef_sc_hd__decap_12
XFILLER_0_59_753 VPWR VGND VPWR VGND sky130_ef_sc_hd__decap_12
XTAP_TAPCELL_ROW_19_586 VGND VPWR sky130_fd_sc_hd__tapvpwrvgnd_1
X_7692_ _3773_ VGND VGND VPWR VPWR _0259_ sky130_fd_sc_hd__clkbuf_1
X_9500_ clknet_leaf_27_CLK _0588_ VGND VGND VPWR VPWR rf.registers\[18\]\[11\] sky130_fd_sc_hd__dfxtp_1
X_6712_ _3225_ VGND VGND VPWR VPWR _0851_ sky130_fd_sc_hd__clkbuf_1
XFILLER_0_59_797 VPWR VGND VPWR VGND sky130_ef_sc_hd__decap_12
XFILLER_0_19_617 VGND VGND VPWR VPWR sky130_fd_sc_hd__decap_4
XFILLER_0_132_41 VPWR VGND VPWR VGND sky130_ef_sc_hd__decap_12
XFILLER_0_129_685 VPWR VGND VPWR VGND sky130_ef_sc_hd__decap_12
X_9431_ clknet_leaf_58_CLK _0519_ VGND VGND VPWR VPWR rf.registers\[25\]\[6\] sky130_fd_sc_hd__dfxtp_1
X_6643_ _3188_ VGND VGND VPWR VPWR _0819_ sky130_fd_sc_hd__clkbuf_1
XFILLER_0_132_85 VPWR VGND VPWR VGND sky130_ef_sc_hd__decap_12
XFILLER_0_128_195 VGND VGND VPWR VPWR sky130_fd_sc_hd__fill_1
XFILLER_0_73_255 VGND VGND VPWR VPWR sky130_fd_sc_hd__decap_6
Xclkload9 clknet_leaf_81_CLK VGND VGND VPWR VPWR clkload9/Y sky130_fd_sc_hd__clkinv_4
XFILLER_0_6_533 VPWR VGND VPWR VGND sky130_ef_sc_hd__decap_12
XFILLER_0_131_305 VPWR VGND VPWR VGND sky130_ef_sc_hd__decap_12
X_9362_ clknet_leaf_42_CLK _0450_ VGND VGND VPWR VPWR rf.registers\[26\]\[1\] sky130_fd_sc_hd__dfxtp_1
Xclkbuf_leaf_64_CLK clknet_3_6__leaf_CLK VGND VGND VPWR VPWR clknet_leaf_64_CLK sky130_fd_sc_hd__clkbuf_8
X_6574_ _3151_ VGND VGND VPWR VPWR _0787_ sky130_fd_sc_hd__clkbuf_1
XTAP_TAPCELL_ROW_30_751 VGND VPWR sky130_fd_sc_hd__tapvpwrvgnd_1
XFILLER_0_41_94 VGND VGND VPWR VPWR sky130_fd_sc_hd__fill_2
X_8313_ _4102_ VGND VGND VPWR VPWR _0551_ sky130_fd_sc_hd__clkbuf_1
XFILLER_0_14_333 VPWR VGND VPWR VGND sky130_ef_sc_hd__decap_12
X_9293_ clknet_leaf_94_CLK _0381_ VGND VGND VPWR VPWR rf.registers\[23\]\[28\] sky130_fd_sc_hd__dfxtp_1
XFILLER_0_42_642 VGND VGND VPWR VPWR sky130_fd_sc_hd__fill_2
X_5525_ _1055_ _1682_ _2218_ VGND VGND VPWR VPWR _2256_ sky130_fd_sc_hd__or3_1
XFILLER_0_131_349 VPWR VGND VPWR VGND sky130_ef_sc_hd__decap_12
X_8244_ _2999_ rf.registers\[25\]\[6\] _4059_ VGND VGND VPWR VPWR _4066_ sky130_fd_sc_hd__mux2_1
XTAP_TAPCELL_ROW_76_1447 VGND VPWR sky130_fd_sc_hd__tapvpwrvgnd_1
XTAP_TAPCELL_ROW_76_1436 VGND VPWR sky130_fd_sc_hd__tapvpwrvgnd_1
XFILLER_0_74_3 VPWR VGND VPWR VGND sky130_ef_sc_hd__decap_12
X_5456_ _2081_ _2187_ _1948_ VGND VGND VPWR VPWR _2188_ sky130_fd_sc_hd__a21o_1
XFILLER_0_14_377 VPWR VGND VPWR VGND sky130_ef_sc_hd__decap_12
XFILLER_0_30_837 VGND VGND VPWR VPWR sky130_fd_sc_hd__fill_2
XFILLER_0_100_725 VPWR VGND VPWR VGND sky130_ef_sc_hd__decap_12
X_4407_ _1190_ _1195_ VGND VGND VPWR VPWR _1196_ sky130_fd_sc_hd__nand2_1
XFILLER_0_100_769 VPWR VGND VPWR VGND sky130_ef_sc_hd__decap_12
X_8175_ _4029_ VGND VGND VPWR VPWR _0486_ sky130_fd_sc_hd__clkbuf_1
XFILLER_0_1_293 VPWR VGND VPWR VGND sky130_ef_sc_hd__decap_12
X_5387_ rf.registers\[20\]\[27\] rf.registers\[21\]\[27\] rf.registers\[22\]\[27\]
+ rf.registers\[23\]\[27\] _2086_ _2087_ VGND VGND VPWR VPWR _2123_ sky130_fd_sc_hd__mux4_1
X_4338_ _1128_ VGND VGND VPWR VPWR _1129_ sky130_fd_sc_hd__buf_4
X_7126_ _3472_ VGND VGND VPWR VPWR _1018_ sky130_fd_sc_hd__clkbuf_1
X_4269_ rf.registers\[24\]\[1\] rf.registers\[25\]\[1\] rf.registers\[26\]\[1\] rf.registers\[27\]\[1\]
+ _1041_ _1043_ VGND VGND VPWR VPWR _1063_ sky130_fd_sc_hd__mux4_1
XFILLER_0_66_80 VGND VGND VPWR VPWR sky130_fd_sc_hd__fill_1
X_7057_ rf.registers\[6\]\[25\] _3330_ _3430_ VGND VGND VPWR VPWR _3436_ sky130_fd_sc_hd__mux2_1
X_6008_ _2316_ _2358_ _2722_ VGND VGND VPWR VPWR _2723_ sky130_fd_sc_hd__o21a_1
XTAP_TAPCELL_ROW_120_2102 VGND VPWR sky130_fd_sc_hd__tapvpwrvgnd_1
XTAP_TAPCELL_ROW_38_873 VGND VPWR sky130_fd_sc_hd__tapvpwrvgnd_1
XTAP_TAPCELL_ROW_87_1598 VGND VPWR sky130_fd_sc_hd__tapvpwrvgnd_1
X_7959_ _3914_ VGND VGND VPWR VPWR _3915_ sky130_fd_sc_hd__clkbuf_8
XFILLER_0_77_594 VGND VGND VPWR VPWR sky130_fd_sc_hd__decap_6
XFILLER_0_77_561 VGND VGND VPWR VPWR sky130_fd_sc_hd__decap_6
XFILLER_0_108_825 VPWR VGND VPWR VGND sky130_ef_sc_hd__decap_12
XFILLER_0_107_302 VGND VGND VPWR VPWR sky130_fd_sc_hd__fill_1
XFILLER_0_64_244 VGND VGND VPWR VPWR sky130_fd_sc_hd__decap_8
XFILLER_0_134_121 VPWR VGND VPWR VGND sky130_ef_sc_hd__decap_12
XFILLER_0_107_335 VGND VGND VPWR VPWR sky130_fd_sc_hd__fill_1
XFILLER_0_9_393 VPWR VGND VPWR VGND sky130_ef_sc_hd__decap_12
XFILLER_0_25_609 VGND VGND VPWR VPWR sky130_fd_sc_hd__decap_6
XFILLER_0_134_165 VPWR VGND VPWR VGND sky130_ef_sc_hd__decap_12
XTAP_TAPCELL_ROW_118_2064 VGND VPWR sky130_fd_sc_hd__tapvpwrvgnd_1
Xclkbuf_leaf_55_CLK clknet_3_6__leaf_CLK VGND VGND VPWR VPWR clknet_leaf_55_CLK sky130_fd_sc_hd__clkbuf_8
XFILLER_0_80_737 VPWR VGND VPWR VGND sky130_ef_sc_hd__decap_12
XFILLER_0_64_299 VGND VGND VPWR VPWR sky130_fd_sc_hd__decap_3
XFILLER_0_123_839 VGND VGND VPWR VPWR sky130_fd_sc_hd__fill_1
XTAP_TAPCELL_ROW_118_2075 VGND VPWR sky130_fd_sc_hd__tapvpwrvgnd_1
XFILLER_0_17_193 VGND VGND VPWR VPWR sky130_fd_sc_hd__fill_1
XFILLER_0_0_709 VPWR VGND VPWR VGND sky130_ef_sc_hd__decap_12
XTAP_TAPCELL_ROW_131_2264 VGND VPWR sky130_fd_sc_hd__tapvpwrvgnd_1
XFILLER_0_88_837 VGND VGND VPWR VPWR sky130_fd_sc_hd__fill_2
XFILLER_0_62_27 VGND VGND VPWR VPWR sky130_fd_sc_hd__fill_1
XTAP_TAPCELL_ROW_47_1004 VGND VPWR sky130_fd_sc_hd__tapvpwrvgnd_1
XFILLER_0_87_358 VGND VGND VPWR VPWR sky130_fd_sc_hd__decap_6
XFILLER_0_56_701 VPWR VGND VPWR VGND sky130_ef_sc_hd__decap_12
XTAP_TAPCELL_ROW_16_534 VGND VPWR sky130_fd_sc_hd__tapvpwrvgnd_1
XTAP_TAPCELL_ROW_16_545 VGND VPWR sky130_fd_sc_hd__tapvpwrvgnd_1
XFILLER_0_28_425 VGND VGND VPWR VPWR sky130_fd_sc_hd__fill_1
XTAP_TAPCELL_ROW_60_1204 VGND VPWR sky130_fd_sc_hd__tapvpwrvgnd_1
XFILLER_0_55_222 VGND VGND VPWR VPWR sky130_fd_sc_hd__fill_2
XFILLER_0_71_726 VGND VGND VPWR VPWR sky130_fd_sc_hd__fill_2
XFILLER_0_55_255 VGND VGND VPWR VPWR sky130_fd_sc_hd__decap_4
XFILLER_0_126_688 VPWR VGND VPWR VGND sky130_ef_sc_hd__decap_12
Xclkbuf_leaf_46_CLK clknet_3_7__leaf_CLK VGND VGND VPWR VPWR clknet_leaf_46_CLK sky130_fd_sc_hd__clkbuf_8
XFILLER_0_3_503 VGND VGND VPWR VPWR sky130_fd_sc_hd__fill_1
XFILLER_0_11_53 VGND VGND VPWR VPWR sky130_fd_sc_hd__decap_3
XFILLER_0_24_642 VGND VGND VPWR VPWR sky130_fd_sc_hd__fill_2
X_6290_ net14 VGND VGND VPWR VPWR _2982_ sky130_fd_sc_hd__clkbuf_2
X_5310_ rf.registers\[28\]\[23\] rf.registers\[29\]\[23\] rf.registers\[30\]\[23\]
+ rf.registers\[31\]\[23\] _1772_ _1773_ VGND VGND VPWR VPWR _2050_ sky130_fd_sc_hd__mux4_1
XFILLER_0_12_837 VGND VGND VPWR VPWR sky130_fd_sc_hd__fill_2
XTAP_TAPCELL_ROW_58_1177 VGND VPWR sky130_fd_sc_hd__tapvpwrvgnd_1
XTAP_TAPCELL_ROW_58_1166 VGND VPWR sky130_fd_sc_hd__tapvpwrvgnd_1
X_5241_ _1983_ _1984_ _1747_ VGND VGND VPWR VPWR _1985_ sky130_fd_sc_hd__mux2_1
X_5172_ _1772_ VGND VGND VPWR VPWR _1919_ sky130_fd_sc_hd__buf_4
XTAP_TAPCELL_ROW_71_1366 VGND VPWR sky130_fd_sc_hd__tapvpwrvgnd_1
Xinput2 A1[1] VGND VGND VPWR VPWR net2 sky130_fd_sc_hd__buf_2
X_8931_ clknet_leaf_11_CLK _0019_ VGND VGND VPWR VPWR rf.registers\[4\]\[18\] sky130_fd_sc_hd__dfxtp_1
X_8862_ clknet_leaf_14_CLK _0974_ VGND VGND VPWR VPWR rf.registers\[6\]\[13\] sky130_fd_sc_hd__dfxtp_1
XFILLER_0_78_336 VGND VGND VPWR VPWR sky130_fd_sc_hd__decap_4
X_8793_ clknet_leaf_35_CLK _0905_ VGND VGND VPWR VPWR rf.registers\[16\]\[8\] sky130_fd_sc_hd__dfxtp_1
XFILLER_0_78_347 VPWR VGND VPWR VGND sky130_ef_sc_hd__decap_12
X_7813_ rf.registers\[9\]\[28\] _3336_ _3828_ VGND VGND VPWR VPWR _3837_ sky130_fd_sc_hd__mux2_1
XTAP_TAPCELL_ROW_35_821 VGND VPWR sky130_fd_sc_hd__tapvpwrvgnd_1
XTAP_TAPCELL_ROW_35_832 VGND VPWR sky130_fd_sc_hd__tapvpwrvgnd_1
XFILLER_0_59_561 VGND VGND VPWR VPWR sky130_fd_sc_hd__decap_4
X_7744_ _3800_ VGND VGND VPWR VPWR _0284_ sky130_fd_sc_hd__clkbuf_1
XFILLER_0_136_419 VGND VGND VPWR VPWR sky130_fd_sc_hd__fill_1
X_4956_ rf.registers\[28\]\[4\] rf.registers\[29\]\[4\] rf.registers\[30\]\[4\] rf.registers\[31\]\[4\]
+ _1631_ _1632_ VGND VGND VPWR VPWR _1715_ sky130_fd_sc_hd__mux4_1
XFILLER_0_74_542 VGND VGND VPWR VPWR sky130_fd_sc_hd__fill_1
XFILLER_0_46_211 VGND VGND VPWR VPWR sky130_fd_sc_hd__decap_8
X_4887_ _1647_ _1648_ _1635_ VGND VGND VPWR VPWR _1649_ sky130_fd_sc_hd__mux2_1
XFILLER_0_117_633 VGND VGND VPWR VPWR sky130_fd_sc_hd__decap_8
XFILLER_0_116_121 VPWR VGND VPWR VGND sky130_ef_sc_hd__decap_12
X_7675_ _3763_ VGND VGND VPWR VPWR _0252_ sky130_fd_sc_hd__clkbuf_1
Xclkbuf_leaf_37_CLK clknet_3_5__leaf_CLK VGND VGND VPWR VPWR clknet_leaf_37_CLK sky130_fd_sc_hd__clkbuf_8
X_6626_ rf.registers\[24\]\[10\] _3007_ _3179_ VGND VGND VPWR VPWR _3180_ sky130_fd_sc_hd__mux2_1
XFILLER_0_62_737 VGND VGND VPWR VPWR sky130_fd_sc_hd__decap_4
X_9414_ clknet_leaf_80_CLK _0502_ VGND VGND VPWR VPWR rf.registers\[21\]\[21\] sky130_fd_sc_hd__dfxtp_1
XFILLER_0_131_113 VPWR VGND VPWR VGND sky130_ef_sc_hd__decap_12
XFILLER_0_116_165 VPWR VGND VPWR VGND sky130_ef_sc_hd__decap_12
XFILLER_0_105_839 VGND VGND VPWR VPWR sky130_fd_sc_hd__fill_1
X_6557_ rf.registers\[1\]\[10\] _3007_ _3142_ VGND VGND VPWR VPWR _3143_ sky130_fd_sc_hd__mux2_1
X_9345_ clknet_leaf_13_CLK _0433_ VGND VGND VPWR VPWR rf.registers\[7\]\[16\] sky130_fd_sc_hd__dfxtp_1
XFILLER_0_61_258 VGND VGND VPWR VPWR sky130_fd_sc_hd__fill_1
XFILLER_0_6_363 VGND VGND VPWR VPWR sky130_fd_sc_hd__fill_1
XFILLER_0_14_141 VPWR VGND VPWR VGND sky130_ef_sc_hd__decap_12
XFILLER_0_132_669 VPWR VGND VPWR VGND sky130_ef_sc_hd__decap_12
XFILLER_0_70_781 VPWR VGND VPWR VGND sky130_ef_sc_hd__decap_12
XFILLER_0_15_697 VGND VGND VPWR VPWR sky130_fd_sc_hd__decap_8
X_5508_ _2236_ _1114_ VGND VGND VPWR VPWR _2239_ sky130_fd_sc_hd__nor2_1
XFILLER_0_42_472 VGND VGND VPWR VPWR sky130_fd_sc_hd__decap_4
X_9276_ clknet_leaf_27_CLK _0364_ VGND VGND VPWR VPWR rf.registers\[23\]\[11\] sky130_fd_sc_hd__dfxtp_1
XFILLER_0_112_360 VGND VGND VPWR VPWR sky130_fd_sc_hd__decap_4
X_6488_ rf.registers\[17\]\[10\] _3007_ _3105_ VGND VGND VPWR VPWR _3106_ sky130_fd_sc_hd__mux2_1
X_5439_ _2074_ _2171_ VGND VGND VPWR VPWR _2172_ sky130_fd_sc_hd__and2_1
X_8227_ _4056_ VGND VGND VPWR VPWR _0511_ sky130_fd_sc_hd__clkbuf_1
X_8158_ _2978_ rf.registers\[26\]\[30\] _3986_ VGND VGND VPWR VPWR _4020_ sky130_fd_sc_hd__mux2_1
X_7109_ _3463_ VGND VGND VPWR VPWR _1010_ sky130_fd_sc_hd__clkbuf_1
XTAP_TAPCELL_ROW_89_1638 VGND VPWR sky130_fd_sc_hd__tapvpwrvgnd_1
X_8089_ _3983_ VGND VGND VPWR VPWR _0446_ sky130_fd_sc_hd__clkbuf_1
XFILLER_0_38_701 VGND VGND VPWR VPWR sky130_fd_sc_hd__decap_6
XTAP_TAPCELL_ROW_100_1805 VGND VPWR sky130_fd_sc_hd__tapvpwrvgnd_1
XFILLER_0_108_622 VGND VGND VPWR VPWR sky130_fd_sc_hd__decap_8
XFILLER_0_38_778 VPWR VGND VPWR VGND sky130_ef_sc_hd__decap_12
XFILLER_0_135_441 VGND VGND VPWR VPWR sky130_fd_sc_hd__decap_6
Xclkbuf_leaf_28_CLK clknet_3_5__leaf_CLK VGND VGND VPWR VPWR clknet_leaf_28_CLK sky130_fd_sc_hd__clkbuf_8
XFILLER_0_53_726 VGND VGND VPWR VPWR sky130_fd_sc_hd__fill_2
XFILLER_0_25_428 VGND VGND VPWR VPWR sky130_fd_sc_hd__fill_1
XFILLER_0_135_496 VGND VGND VPWR VPWR sky130_fd_sc_hd__fill_1
XFILLER_0_111_809 VPWR VGND VPWR VGND sky130_ef_sc_hd__decap_12
XFILLER_0_21_645 VGND VGND VPWR VPWR sky130_fd_sc_hd__fill_2
XFILLER_0_57_27 VPWR VGND VPWR VGND sky130_ef_sc_hd__decap_12
XTAP_TAPCELL_ROW_111_1967 VGND VPWR sky130_fd_sc_hd__tapvpwrvgnd_1
XTAP_TAPCELL_ROW_53_1096 VGND VPWR sky130_fd_sc_hd__tapvpwrvgnd_1
XFILLER_0_73_15 VPWR VGND VPWR VGND sky130_ef_sc_hd__decap_12
XFILLER_0_87_122 VGND VGND VPWR VPWR sky130_fd_sc_hd__decap_4
X_4810_ rf.registers\[12\]\[29\] rf.registers\[13\]\[29\] rf.registers\[14\]\[29\]
+ rf.registers\[15\]\[29\] _1329_ _1330_ VGND VGND VPWR VPWR _1576_ sky130_fd_sc_hd__mux4_1
XFILLER_0_132_3 VPWR VGND VPWR VGND sky130_ef_sc_hd__decap_12
XFILLER_0_56_542 VGND VGND VPWR VPWR sky130_fd_sc_hd__decap_6
XFILLER_0_7_105 VGND VGND VPWR VPWR sky130_fd_sc_hd__decap_6
X_5790_ _2275_ _2287_ net92 VGND VGND VPWR VPWR _2515_ sky130_fd_sc_hd__mux2_1
XFILLER_0_28_200 VPWR VGND VPWR VGND sky130_ef_sc_hd__decap_12
XFILLER_0_71_501 VGND VGND VPWR VPWR sky130_fd_sc_hd__decap_3
XFILLER_0_22_41 VPWR VGND VPWR VGND sky130_ef_sc_hd__decap_12
X_4741_ rf.registers\[16\]\[25\] rf.registers\[17\]\[25\] rf.registers\[18\]\[25\]
+ rf.registers\[19\]\[25\] _1191_ _1192_ VGND VGND VPWR VPWR _1511_ sky130_fd_sc_hd__mux4_1
Xclkbuf_leaf_19_CLK clknet_3_1__leaf_CLK VGND VGND VPWR VPWR clknet_leaf_19_CLK sky130_fd_sc_hd__clkbuf_8
X_4672_ rf.registers\[24\]\[21\] rf.registers\[25\]\[21\] rf.registers\[26\]\[21\]
+ rf.registers\[27\]\[21\] _1147_ _1149_ VGND VGND VPWR VPWR _1446_ sky130_fd_sc_hd__mux4_1
XFILLER_0_7_149 VPWR VGND VPWR VGND sky130_ef_sc_hd__decap_12
X_7460_ _3393_ rf.registers\[29\]\[22\] _3647_ VGND VGND VPWR VPWR _3650_ sky130_fd_sc_hd__mux2_1
XFILLER_0_43_214 VGND VGND VPWR VPWR sky130_fd_sc_hd__decap_3
XFILLER_0_44_748 VGND VGND VPWR VPWR sky130_fd_sc_hd__decap_4
XFILLER_0_113_113 VPWR VGND VPWR VGND sky130_ef_sc_hd__decap_12
X_6411_ rf.registers\[11\]\[7\] _3001_ _3056_ VGND VGND VPWR VPWR _3064_ sky130_fd_sc_hd__mux2_1
X_7391_ rf.registers\[8\]\[22\] _3324_ _3610_ VGND VGND VPWR VPWR _3613_ sky130_fd_sc_hd__mux2_1
XFILLER_0_52_781 VPWR VGND VPWR VGND sky130_ef_sc_hd__decap_12
X_9130_ clknet_leaf_84_CLK _0218_ VGND VGND VPWR VPWR rf.registers\[27\]\[25\] sky130_fd_sc_hd__dfxtp_1
X_6342_ rf.registers\[12\]\[15\] _3018_ _3008_ VGND VGND VPWR VPWR _3019_ sky130_fd_sc_hd__mux2_1
XFILLER_0_12_645 VGND VGND VPWR VPWR sky130_fd_sc_hd__fill_1
XFILLER_0_11_111 VGND VGND VPWR VPWR sky130_fd_sc_hd__fill_1
X_9061_ clknet_leaf_81_CLK _0149_ VGND VGND VPWR VPWR rf.registers\[29\]\[20\] sky130_fd_sc_hd__dfxtp_1
XFILLER_0_12_689 VGND VGND VPWR VPWR sky130_fd_sc_hd__decap_4
X_6273_ _2970_ rf.registers\[13\]\[26\] _2968_ VGND VGND VPWR VPWR _2971_ sky130_fd_sc_hd__mux2_1
X_5224_ _1967_ _1968_ _1768_ VGND VGND VPWR VPWR _1969_ sky130_fd_sc_hd__mux2_1
X_8012_ _2963_ rf.registers\[22\]\[25\] _3937_ VGND VGND VPWR VPWR _3943_ sky130_fd_sc_hd__mux2_1
X_5155_ rf.registers\[20\]\[15\] rf.registers\[21\]\[15\] rf.registers\[22\]\[15\]
+ rf.registers\[23\]\[15\] _1699_ _1700_ VGND VGND VPWR VPWR _1903_ sky130_fd_sc_hd__mux4_1
XFILLER_0_37_3 VPWR VGND VPWR VGND sky130_ef_sc_hd__decap_12
XFILLER_0_47_60 VGND VGND VPWR VPWR sky130_fd_sc_hd__fill_1
X_5086_ rf.registers\[0\]\[10\] rf.registers\[1\]\[10\] rf.registers\[2\]\[10\] rf.registers\[3\]\[10\]
+ _1699_ _1700_ VGND VGND VPWR VPWR _1839_ sky130_fd_sc_hd__mux4_1
X_8914_ clknet_leaf_45_CLK _0002_ VGND VGND VPWR VPWR rf.registers\[4\]\[1\] sky130_fd_sc_hd__dfxtp_1
X_8845_ clknet_leaf_92_CLK _0957_ VGND VGND VPWR VPWR rf.registers\[15\]\[28\] sky130_fd_sc_hd__dfxtp_1
XTAP_TAPCELL_ROW_84_1557 VGND VPWR sky130_fd_sc_hd__tapvpwrvgnd_1
X_8776_ clknet_leaf_9_CLK _0888_ VGND VGND VPWR VPWR rf.registers\[0\]\[23\] sky130_fd_sc_hd__dfxtp_1
X_5988_ _2653_ _2701_ VGND VGND VPWR VPWR _2703_ sky130_fd_sc_hd__nand2_1
X_4939_ _1631_ VGND VGND VPWR VPWR _1699_ sky130_fd_sc_hd__buf_4
XFILLER_0_93_169 VGND VGND VPWR VPWR sky130_fd_sc_hd__fill_2
X_7727_ _3791_ VGND VGND VPWR VPWR _0276_ sky130_fd_sc_hd__clkbuf_1
XFILLER_0_35_704 VGND VGND VPWR VPWR sky130_fd_sc_hd__fill_1
XFILLER_0_117_452 VGND VGND VPWR VPWR sky130_fd_sc_hd__fill_1
X_7658_ _3754_ VGND VGND VPWR VPWR _0244_ sky130_fd_sc_hd__clkbuf_1
XFILLER_0_35_737 VGND VGND VPWR VPWR sky130_fd_sc_hd__fill_2
X_6609_ rf.registers\[24\]\[2\] _2991_ _3168_ VGND VGND VPWR VPWR _3171_ sky130_fd_sc_hd__mux2_1
XFILLER_0_132_433 VGND VGND VPWR VPWR sky130_fd_sc_hd__decap_4
XTAP_TAPCELL_ROW_115_2023 VGND VPWR sky130_fd_sc_hd__tapvpwrvgnd_1
XFILLER_0_105_647 VGND VGND VPWR VPWR sky130_fd_sc_hd__decap_4
X_7589_ _3386_ rf.registers\[27\]\[19\] _3708_ VGND VGND VPWR VPWR _3718_ sky130_fd_sc_hd__mux2_1
XFILLER_0_62_589 VGND VGND VPWR VPWR sky130_fd_sc_hd__decap_8
XFILLER_0_15_461 VPWR VGND VPWR VGND sky130_ef_sc_hd__decap_12
XFILLER_0_132_477 VGND VGND VPWR VPWR sky130_fd_sc_hd__fill_2
X_9328_ clknet_leaf_62_CLK _0416_ VGND VGND VPWR VPWR rf.registers\[22\]\[31\] sky130_fd_sc_hd__dfxtp_1
X_9259_ clknet_leaf_86_CLK _0347_ VGND VGND VPWR VPWR rf.registers\[28\]\[26\] sky130_fd_sc_hd__dfxtp_1
XTAP_TAPCELL_ROW_7_398 VGND VPWR sky130_fd_sc_hd__tapvpwrvgnd_1
XTAP_TAPCELL_ROW_126_2196 VGND VPWR sky130_fd_sc_hd__tapvpwrvgnd_1
XTAP_TAPCELL_ROW_126_2185 VGND VPWR sky130_fd_sc_hd__tapvpwrvgnd_1
XFILLER_0_127_205 VPWR VGND VPWR VGND sky130_ef_sc_hd__decap_12
XFILLER_0_69_188 VGND VGND VPWR VPWR sky130_fd_sc_hd__fill_1
XFILLER_0_38_520 VGND VGND VPWR VPWR sky130_fd_sc_hd__fill_1
XFILLER_0_84_169 VGND VGND VPWR VPWR sky130_fd_sc_hd__fill_2
XFILLER_0_72_309 VGND VGND VPWR VPWR sky130_fd_sc_hd__fill_2
XTAP_TAPCELL_ROW_26_684 VGND VPWR sky130_fd_sc_hd__tapvpwrvgnd_1
XTAP_TAPCELL_ROW_26_695 VGND VPWR sky130_fd_sc_hd__tapvpwrvgnd_1
XFILLER_0_38_553 VGND VGND VPWR VPWR sky130_fd_sc_hd__decap_3
XFILLER_0_127_249 VPWR VGND VPWR VGND sky130_ef_sc_hd__decap_12
XFILLER_0_81_821 VPWR VGND VPWR VGND sky130_ef_sc_hd__decap_12
XFILLER_0_5_609 VGND VGND VPWR VPWR sky130_fd_sc_hd__decap_6
XFILLER_0_38_597 VGND VGND VPWR VPWR sky130_fd_sc_hd__fill_2
XFILLER_0_135_293 VPWR VGND VPWR VGND sky130_ef_sc_hd__decap_12
XFILLER_0_41_729 VGND VGND VPWR VPWR sky130_fd_sc_hd__decap_4
XFILLER_0_68_15 VPWR VGND VPWR VGND sky130_ef_sc_hd__decap_12
XTAP_TAPCELL_ROW_55_1125 VGND VPWR sky130_fd_sc_hd__tapvpwrvgnd_1
XFILLER_0_0_358 VGND VGND VPWR VPWR sky130_fd_sc_hd__decap_6
Xclkbuf_leaf_8_CLK clknet_3_1__leaf_CLK VGND VGND VPWR VPWR clknet_leaf_8_CLK sky130_fd_sc_hd__clkbuf_8
XFILLER_0_108_65 VPWR VGND VPWR VGND sky130_ef_sc_hd__decap_12
X_6960_ net21 VGND VGND VPWR VPWR _3380_ sky130_fd_sc_hd__clkbuf_2
X_5911_ _2446_ _2571_ _2572_ _2442_ _2630_ VGND VGND VPWR VPWR _2631_ sky130_fd_sc_hd__o221a_1
X_6891_ rf.registers\[16\]\[26\] _3332_ _3320_ VGND VGND VPWR VPWR _3333_ sky130_fd_sc_hd__mux2_1
XFILLER_0_124_53 VPWR VGND VPWR VGND sky130_ef_sc_hd__decap_12
X_8630_ clknet_leaf_57_CLK _0742_ VGND VGND VPWR VPWR rf.registers\[17\]\[5\] sky130_fd_sc_hd__dfxtp_1
XFILLER_0_75_125 VGND VGND VPWR VPWR sky130_fd_sc_hd__decap_6
XTAP_TAPCELL_ROW_66_1287 VGND VPWR sky130_fd_sc_hd__tapvpwrvgnd_1
X_5842_ _2237_ _2563_ _2564_ VGND VGND VPWR VPWR _2565_ sky130_fd_sc_hd__a21oi_1
XTAP_TAPCELL_ROW_45_971 VGND VPWR sky130_fd_sc_hd__tapvpwrvgnd_1
XTAP_TAPCELL_ROW_45_982 VGND VPWR sky130_fd_sc_hd__tapvpwrvgnd_1
XFILLER_0_124_97 VPWR VGND VPWR VGND sky130_ef_sc_hd__decap_12
X_8561_ clknet_leaf_42_CLK _0673_ VGND VGND VPWR VPWR rf.registers\[12\]\[0\] sky130_fd_sc_hd__dfxtp_1
X_5773_ _2421_ _2498_ _2459_ _2384_ VGND VGND VPWR VPWR _2499_ sky130_fd_sc_hd__o2bb2a_1
XFILLER_0_29_553 VGND VGND VPWR VPWR sky130_fd_sc_hd__decap_6
X_7512_ _3677_ VGND VGND VPWR VPWR _0175_ sky130_fd_sc_hd__clkbuf_1
XFILLER_0_90_106 VGND VGND VPWR VPWR sky130_fd_sc_hd__fill_2
XFILLER_0_8_469 VGND VGND VPWR VPWR sky130_fd_sc_hd__decap_6
X_4724_ _1493_ _1494_ _1133_ VGND VGND VPWR VPWR _1495_ sky130_fd_sc_hd__mux2_1
XFILLER_0_127_783 VGND VGND VPWR VPWR sky130_fd_sc_hd__fill_1
X_8492_ _3043_ rf.registers\[14\]\[27\] _4189_ VGND VGND VPWR VPWR _4197_ sky130_fd_sc_hd__mux2_1
XFILLER_0_114_433 VGND VGND VPWR VPWR sky130_fd_sc_hd__decap_3
X_7443_ _3376_ rf.registers\[29\]\[14\] _3636_ VGND VGND VPWR VPWR _3641_ sky130_fd_sc_hd__mux2_1
X_4655_ rf.registers\[20\]\[20\] rf.registers\[21\]\[20\] rf.registers\[22\]\[20\]
+ rf.registers\[23\]\[20\] _1119_ _1122_ VGND VGND VPWR VPWR _1430_ sky130_fd_sc_hd__mux4_1
X_7374_ rf.registers\[8\]\[14\] _3307_ _3599_ VGND VGND VPWR VPWR _3604_ sky130_fd_sc_hd__mux2_1
X_4586_ _1363_ _1364_ _1312_ VGND VGND VPWR VPWR _1365_ sky130_fd_sc_hd__mux2_1
XFILLER_0_114_499 VGND VGND VPWR VPWR sky130_fd_sc_hd__fill_1
X_9113_ clknet_leaf_36_CLK _0201_ VGND VGND VPWR VPWR rf.registers\[27\]\[8\] sky130_fd_sc_hd__dfxtp_1
X_6325_ net15 VGND VGND VPWR VPWR _3007_ sky130_fd_sc_hd__clkbuf_2
X_9044_ clknet_leaf_38_CLK _0132_ VGND VGND VPWR VPWR rf.registers\[29\]\[3\] sky130_fd_sc_hd__dfxtp_1
XFILLER_0_12_475 VGND VGND VPWR VPWR sky130_fd_sc_hd__fill_1
X_6256_ _2952_ _2955_ VGND VGND VPWR VPWR _2956_ sky130_fd_sc_hd__xnor2_1
X_5207_ rf.registers\[12\]\[17\] rf.registers\[13\]\[17\] rf.registers\[14\]\[17\]
+ rf.registers\[15\]\[17\] _1951_ _1952_ VGND VGND VPWR VPWR _1953_ sky130_fd_sc_hd__mux4_1
X_6187_ _2883_ _2880_ _2890_ VGND VGND VPWR VPWR _2891_ sky130_fd_sc_hd__o21ai_1
XFILLER_0_99_729 VPWR VGND VPWR VGND sky130_ef_sc_hd__decap_12
X_5138_ _1683_ _1879_ _1883_ _1887_ VGND VGND VPWR VPWR _1888_ sky130_fd_sc_hd__a2bb2o_4
XTAP_TAPCELL_ROW_4_357 VGND VPWR sky130_fd_sc_hd__tapvpwrvgnd_1
XFILLER_0_98_206 VGND VGND VPWR VPWR sky130_fd_sc_hd__fill_1
X_5069_ rf.registers\[12\]\[9\] rf.registers\[13\]\[9\] rf.registers\[14\]\[9\] rf.registers\[15\]\[9\]
+ _1816_ _1817_ VGND VGND VPWR VPWR _1823_ sky130_fd_sc_hd__mux4_1
XFILLER_0_67_615 VGND VGND VPWR VPWR sky130_fd_sc_hd__fill_1
XFILLER_0_137_503 VGND VGND VPWR VPWR sky130_fd_sc_hd__fill_1
X_8828_ clknet_leaf_29_CLK _0940_ VGND VGND VPWR VPWR rf.registers\[15\]\[11\] sky130_fd_sc_hd__dfxtp_1
X_8759_ clknet_leaf_57_CLK _0871_ VGND VGND VPWR VPWR rf.registers\[0\]\[6\] sky130_fd_sc_hd__dfxtp_1
XFILLER_0_125_709 VPWR VGND VPWR VGND sky130_ef_sc_hd__decap_12
XFILLER_0_63_821 VPWR VGND VPWR VGND sky130_ef_sc_hd__decap_12
XTAP_TAPCELL_ROW_23_643 VGND VPWR sky130_fd_sc_hd__tapvpwrvgnd_1
XFILLER_0_81_139 VGND VGND VPWR VPWR sky130_fd_sc_hd__decap_8
XFILLER_0_133_753 VPWR VGND VPWR VGND sky130_ef_sc_hd__decap_12
XTAP_TAPCELL_ROW_97_1748 VGND VPWR sky130_fd_sc_hd__tapvpwrvgnd_1
XFILLER_0_22_206 VGND VGND VPWR VPWR sky130_fd_sc_hd__fill_2
XTAP_TAPCELL_ROW_97_1759 VGND VPWR sky130_fd_sc_hd__tapvpwrvgnd_1
XFILLER_0_16_792 VPWR VGND VPWR VGND sky130_ef_sc_hd__decap_12
XFILLER_0_133_797 VPWR VGND VPWR VGND sky130_ef_sc_hd__decap_12
XFILLER_0_31_762 VPWR VGND VPWR VGND sky130_ef_sc_hd__decap_12
XFILLER_0_38_29 VPWR VGND VPWR VGND sky130_ef_sc_hd__decap_12
XTAP_TAPCELL_ROW_128_2225 VGND VPWR sky130_fd_sc_hd__tapvpwrvgnd_1
XTAP_TAPCELL_ROW_128_2214 VGND VPWR sky130_fd_sc_hd__tapvpwrvgnd_1
XTAP_TAPCELL_ROW_50_1055 VGND VPWR sky130_fd_sc_hd__tapvpwrvgnd_1
XTAP_TAPCELL_ROW_50_1044 VGND VPWR sky130_fd_sc_hd__tapvpwrvgnd_1
XTAP_TAPCELL_ROW_106_1888 VGND VPWR sky130_fd_sc_hd__tapvpwrvgnd_1
XFILLER_0_128_536 VGND VGND VPWR VPWR sky130_fd_sc_hd__fill_2
XTAP_TAPCELL_ROW_42_930 VGND VPWR sky130_fd_sc_hd__tapvpwrvgnd_1
XFILLER_0_72_128 VPWR VGND VPWR VGND sky130_ef_sc_hd__decap_12
XFILLER_0_66_681 VPWR VGND VPWR VGND sky130_ef_sc_hd__decap_12
XFILLER_0_115_208 VGND VGND VPWR VPWR sky130_fd_sc_hd__decap_3
XFILLER_0_109_783 VGND VGND VPWR VPWR sky130_fd_sc_hd__fill_1
XFILLER_0_53_320 VGND VGND VPWR VPWR sky130_fd_sc_hd__decap_3
XFILLER_0_5_417 VPWR VGND VPWR VGND sky130_ef_sc_hd__decap_12
XPHY_EDGE_ROW_130_Left_269 VGND VGND VPWR VPWR sky130_fd_sc_hd__decap_3
XFILLER_0_108_282 VGND VGND VPWR VPWR sky130_fd_sc_hd__fill_2
XFILLER_0_81_673 VPWR VGND VPWR VGND sky130_ef_sc_hd__decap_12
XFILLER_0_14_718 VGND VGND VPWR VPWR sky130_fd_sc_hd__fill_1
XFILLER_0_26_589 VGND VGND VPWR VPWR sky130_fd_sc_hd__decap_3
X_4440_ rf.registers\[4\]\[8\] rf.registers\[5\]\[8\] rf.registers\[6\]\[8\] rf.registers\[7\]\[8\]
+ _1042_ _1044_ VGND VGND VPWR VPWR _1227_ sky130_fd_sc_hd__mux4_1
XFILLER_0_13_217 VGND VGND VPWR VPWR sky130_fd_sc_hd__decap_6
XFILLER_0_41_548 VGND VGND VPWR VPWR sky130_fd_sc_hd__fill_1
XFILLER_0_110_77 VGND VGND VPWR VPWR sky130_fd_sc_hd__decap_6
XFILLER_0_0_100 VPWR VGND VPWR VGND sky130_ef_sc_hd__decap_12
X_4371_ rf.registers\[20\]\[5\] rf.registers\[21\]\[5\] rf.registers\[22\]\[5\] rf.registers\[23\]\[5\]
+ _1159_ _1160_ VGND VGND VPWR VPWR _1161_ sky130_fd_sc_hd__mux4_1
XFILLER_0_0_144 VPWR VGND VPWR VGND sky130_ef_sc_hd__decap_12
X_6110_ _2046_ _2810_ VGND VGND VPWR VPWR _2818_ sky130_fd_sc_hd__nor2_1
X_7090_ _3453_ VGND VGND VPWR VPWR _1001_ sky130_fd_sc_hd__clkbuf_1
XFILLER_0_95_57 VGND VGND VPWR VPWR sky130_fd_sc_hd__fill_1
XFILLER_0_0_188 VGND VGND VPWR VPWR sky130_fd_sc_hd__decap_4
XFILLER_0_119_31 VPWR VGND VPWR VGND sky130_ef_sc_hd__decap_12
X_6041_ _2358_ _2422_ _2746_ _2541_ _2753_ VGND VGND VPWR VPWR net122 sky130_fd_sc_hd__o221ai_4
XTAP_TAPCELL_ROW_1_316 VGND VPWR sky130_fd_sc_hd__tapvpwrvgnd_1
X_7992_ _3932_ VGND VGND VPWR VPWR _0400_ sky130_fd_sc_hd__clkbuf_1
XTAP_TAPCELL_ROW_68_1327 VGND VPWR sky130_fd_sc_hd__tapvpwrvgnd_1
XTAP_TAPCELL_ROW_68_1316 VGND VPWR sky130_fd_sc_hd__tapvpwrvgnd_1
X_6943_ _3367_ rf.registers\[15\]\[10\] _3368_ VGND VGND VPWR VPWR _3369_ sky130_fd_sc_hd__mux2_1
XTAP_TAPCELL_ROW_81_1516 VGND VPWR sky130_fd_sc_hd__tapvpwrvgnd_1
XFILLER_0_49_626 VGND VGND VPWR VPWR sky130_fd_sc_hd__fill_2
X_6874_ _3321_ VGND VGND VPWR VPWR _0917_ sky130_fd_sc_hd__clkbuf_1
XFILLER_0_119_514 VGND VGND VPWR VPWR sky130_fd_sc_hd__fill_1
XFILLER_0_91_404 VGND VGND VPWR VPWR sky130_fd_sc_hd__decap_8
XFILLER_0_64_618 VGND VGND VPWR VPWR sky130_fd_sc_hd__decap_4
X_8613_ clknet_leaf_9_CLK _0725_ VGND VGND VPWR VPWR rf.registers\[11\]\[20\] sky130_fd_sc_hd__dfxtp_1
X_5825_ _2547_ _2548_ VGND VGND VPWR VPWR _2549_ sky130_fd_sc_hd__xnor2_2
XFILLER_0_36_309 VGND VGND VPWR VPWR sky130_fd_sc_hd__fill_1
XFILLER_0_107_709 VPWR VGND VPWR VGND sky130_ef_sc_hd__decap_12
XFILLER_0_8_233 VPWR VGND VPWR VGND sky130_ef_sc_hd__decap_12
XFILLER_0_45_821 VPWR VGND VPWR VGND sky130_ef_sc_hd__decap_12
X_8544_ _3028_ rf.registers\[13\]\[20\] _4216_ VGND VGND VPWR VPWR _4224_ sky130_fd_sc_hd__mux2_1
X_5756_ _1757_ _2481_ VGND VGND VPWR VPWR _2482_ sky130_fd_sc_hd__nand2_1
XFILLER_0_8_277 VPWR VGND VPWR VGND sky130_ef_sc_hd__decap_12
XTAP_TAPCELL_ROW_20_602 VGND VPWR sky130_fd_sc_hd__tapvpwrvgnd_1
X_8475_ _3026_ rf.registers\[14\]\[19\] _4178_ VGND VGND VPWR VPWR _4188_ sky130_fd_sc_hd__mux2_1
XFILLER_0_60_813 VPWR VGND VPWR VGND sky130_ef_sc_hd__decap_12
X_4707_ _1477_ _1478_ _1298_ VGND VGND VPWR VPWR _1479_ sky130_fd_sc_hd__mux2_1
X_5687_ _2236_ VGND VGND VPWR VPWR _2416_ sky130_fd_sc_hd__clkbuf_4
XFILLER_0_17_567 VGND VGND VPWR VPWR sky130_fd_sc_hd__decap_3
XFILLER_0_130_701 VPWR VGND VPWR VGND sky130_ef_sc_hd__decap_12
XFILLER_0_115_753 VPWR VGND VPWR VGND sky130_ef_sc_hd__decap_12
X_7426_ _3359_ rf.registers\[29\]\[6\] _3625_ VGND VGND VPWR VPWR _3632_ sky130_fd_sc_hd__mux2_1
X_4638_ _1282_ _1402_ _1408_ _1414_ VGND VGND VPWR VPWR _1415_ sky130_fd_sc_hd__a2bb2o_2
XFILLER_0_115_797 VPWR VGND VPWR VGND sky130_ef_sc_hd__decap_12
XTAP_TAPCELL_ROW_79_1489 VGND VPWR sky130_fd_sc_hd__tapvpwrvgnd_1
XTAP_TAPCELL_ROW_79_1478 VGND VPWR sky130_fd_sc_hd__tapvpwrvgnd_1
XFILLER_0_8_83 VGND VGND VPWR VPWR sky130_fd_sc_hd__fill_1
X_4569_ _1345_ _1346_ _1347_ _1348_ _1134_ _1156_ VGND VGND VPWR VPWR _1349_ sky130_fd_sc_hd__mux4_1
X_7357_ rf.registers\[8\]\[6\] _3290_ _3588_ VGND VGND VPWR VPWR _3595_ sky130_fd_sc_hd__mux2_1
XTAP_TAPCELL_ROW_9_438 VGND VPWR sky130_fd_sc_hd__tapvpwrvgnd_1
XTAP_TAPCELL_ROW_92_1678 VGND VPWR sky130_fd_sc_hd__tapvpwrvgnd_1
X_6308_ rf.registers\[12\]\[4\] _2995_ _2987_ VGND VGND VPWR VPWR _2996_ sky130_fd_sc_hd__mux2_1
X_7288_ _3558_ VGND VGND VPWR VPWR _0070_ sky130_fd_sc_hd__clkbuf_1
X_9027_ clknet_leaf_7_CLK _0115_ VGND VGND VPWR VPWR rf.registers\[8\]\[18\] sky130_fd_sc_hd__dfxtp_1
X_6239_ _2684_ _2780_ VGND VGND VPWR VPWR _2940_ sky130_fd_sc_hd__or2_1
XFILLER_0_99_548 VPWR VGND VPWR VGND sky130_ef_sc_hd__decap_12
XTAP_TAPCELL_ROW_28_713 VGND VPWR sky130_fd_sc_hd__tapvpwrvgnd_1
XTAP_TAPCELL_ROW_28_724 VGND VPWR sky130_fd_sc_hd__tapvpwrvgnd_1
XTAP_TAPCELL_ROW_123_2144 VGND VPWR sky130_fd_sc_hd__tapvpwrvgnd_1
XFILLER_0_95_765 VPWR VGND VPWR VGND sky130_ef_sc_hd__decap_12
XFILLER_0_94_253 VGND VGND VPWR VPWR sky130_fd_sc_hd__decap_3
XFILLER_0_39_158 VGND VGND VPWR VPWR sky130_fd_sc_hd__decap_8
XFILLER_0_82_437 VGND VGND VPWR VPWR sky130_fd_sc_hd__decap_6
XFILLER_0_67_489 VGND VGND VPWR VPWR sky130_fd_sc_hd__fill_1
XFILLER_0_39_169 VGND VGND VPWR VPWR sky130_fd_sc_hd__fill_1
XFILLER_0_63_673 VPWR VGND VPWR VGND sky130_ef_sc_hd__decap_12
XFILLER_0_133_561 VGND VGND VPWR VPWR sky130_fd_sc_hd__fill_2
XFILLER_0_62_183 VGND VGND VPWR VPWR sky130_fd_sc_hd__fill_1
XFILLER_0_120_233 VPWR VGND VPWR VGND sky130_ef_sc_hd__decap_12
XFILLER_0_49_39 VGND VGND VPWR VPWR sky130_fd_sc_hd__decap_4
XFILLER_0_10_209 VPWR VGND VPWR VGND sky130_ef_sc_hd__decap_12
XFILLER_0_65_27 VGND VGND VPWR VPWR sky130_fd_sc_hd__fill_2
XTAP_TAPCELL_ROW_108_1917 VGND VPWR sky130_fd_sc_hd__tapvpwrvgnd_1
XFILLER_0_81_15 VPWR VGND VPWR VGND sky130_ef_sc_hd__decap_12
XFILLER_0_128_300 VGND VGND VPWR VPWR sky130_fd_sc_hd__decap_8
XFILLER_0_105_55 VGND VGND VPWR VPWR sky130_fd_sc_hd__fill_1
XFILLER_0_14_53 VPWR VGND VPWR VGND sky130_ef_sc_hd__decap_12
XFILLER_0_128_333 VPWR VGND VPWR VGND sky130_ef_sc_hd__decap_12
XFILLER_0_105_77 VGND VGND VPWR VPWR sky130_fd_sc_hd__decap_3
XTAP_TAPCELL_ROW_63_1246 VGND VPWR sky130_fd_sc_hd__tapvpwrvgnd_1
XFILLER_0_39_681 VGND VGND VPWR VPWR sky130_fd_sc_hd__fill_2
XFILLER_0_128_377 VGND VGND VPWR VPWR sky130_fd_sc_hd__decap_8
XFILLER_0_14_97 VPWR VGND VPWR VGND sky130_ef_sc_hd__decap_12
X_5610_ _2236_ VGND VGND VPWR VPWR _2340_ sky130_fd_sc_hd__clkbuf_4
X_6590_ rf.registers\[1\]\[26\] _3041_ _3153_ VGND VGND VPWR VPWR _3160_ sky130_fd_sc_hd__mux2_1
XFILLER_0_116_539 VGND VGND VPWR VPWR sky130_fd_sc_hd__fill_2
XFILLER_0_5_225 VPWR VGND VPWR VGND sky130_ef_sc_hd__decap_12
XFILLER_0_26_353 VGND VGND VPWR VPWR sky130_fd_sc_hd__fill_2
XFILLER_0_30_41 VPWR VGND VPWR VGND sky130_ef_sc_hd__decap_12
X_5541_ _2229_ _2271_ VGND VGND VPWR VPWR _2272_ sky130_fd_sc_hd__nor2_1
XFILLER_0_42_813 VPWR VGND VPWR VGND sky130_ef_sc_hd__decap_12
XFILLER_0_112_701 VPWR VGND VPWR VGND sky130_ef_sc_hd__decap_12
X_8260_ _4074_ VGND VGND VPWR VPWR _0526_ sky130_fd_sc_hd__clkbuf_1
X_7211_ rf.registers\[19\]\[1\] _3280_ _3516_ VGND VGND VPWR VPWR _3518_ sky130_fd_sc_hd__mux2_1
X_5472_ net95 net96 VGND VGND VPWR VPWR _2203_ sky130_fd_sc_hd__or2_2
X_8191_ _3374_ rf.registers\[21\]\[13\] _4034_ VGND VGND VPWR VPWR _4038_ sky130_fd_sc_hd__mux2_1
X_4423_ _1209_ _1210_ _1163_ VGND VGND VPWR VPWR _1211_ sky130_fd_sc_hd__mux2_1
XFILLER_0_111_266 VGND VGND VPWR VPWR sky130_fd_sc_hd__fill_1
X_7142_ _3481_ VGND VGND VPWR VPWR _0001_ sky130_fd_sc_hd__clkbuf_1
X_4354_ _1144_ VGND VGND VPWR VPWR _1145_ sky130_fd_sc_hd__clkbuf_8
X_7073_ rf.registers\[5\]\[0\] _3276_ _3444_ VGND VGND VPWR VPWR _3445_ sky130_fd_sc_hd__mux2_1
XFILLER_0_1_497 VGND VGND VPWR VPWR sky130_fd_sc_hd__decap_6
X_4285_ A2[1] VGND VGND VPWR VPWR _1078_ sky130_fd_sc_hd__clkbuf_4
X_6024_ _2737_ _2713_ VGND VGND VPWR VPWR _2738_ sky130_fd_sc_hd__nor2_1
X_7975_ _3923_ VGND VGND VPWR VPWR _0392_ sky130_fd_sc_hd__clkbuf_1
X_6926_ net41 VGND VGND VPWR VPWR _3357_ sky130_fd_sc_hd__buf_2
XFILLER_0_77_721 VGND VGND VPWR VPWR sky130_fd_sc_hd__decap_6
XFILLER_0_49_423 VPWR VGND VPWR VGND sky130_ef_sc_hd__decap_12
XFILLER_0_77_765 VPWR VGND VPWR VGND sky130_ef_sc_hd__decap_12
XFILLER_0_76_253 VGND VGND VPWR VPWR sky130_fd_sc_hd__fill_1
XFILLER_0_92_713 VPWR VGND VPWR VGND sky130_ef_sc_hd__decap_12
X_6857_ rf.registers\[16\]\[15\] _3309_ _3299_ VGND VGND VPWR VPWR _3310_ sky130_fd_sc_hd__mux2_1
XFILLER_0_36_106 VGND VGND VPWR VPWR sky130_fd_sc_hd__fill_2
XFILLER_0_92_757 VPWR VGND VPWR VGND sky130_ef_sc_hd__decap_12
XFILLER_0_91_223 VGND VGND VPWR VPWR sky130_fd_sc_hd__fill_1
X_9576_ clknet_leaf_8_CLK _0664_ VGND VGND VPWR VPWR rf.registers\[13\]\[23\] sky130_fd_sc_hd__dfxtp_1
X_5808_ _1205_ _2532_ VGND VGND VPWR VPWR _2533_ sky130_fd_sc_hd__xnor2_1
XFILLER_0_9_564 VPWR VGND VPWR VGND sky130_ef_sc_hd__decap_12
X_6788_ rf.registers\[0\]\[22\] _3033_ _3263_ VGND VGND VPWR VPWR _3266_ sky130_fd_sc_hd__mux2_1
X_8527_ _3012_ rf.registers\[13\]\[12\] _4205_ VGND VGND VPWR VPWR _4215_ sky130_fd_sc_hd__mux2_1
X_5739_ _1076_ _2402_ _2465_ VGND VGND VPWR VPWR _2466_ sky130_fd_sc_hd__a21oi_1
XTAP_TAPCELL_ROW_33_793 VGND VPWR sky130_fd_sc_hd__tapvpwrvgnd_1
XFILLER_0_45_673 VGND VGND VPWR VPWR sky130_fd_sc_hd__decap_3
X_8458_ _4179_ VGND VGND VPWR VPWR _0619_ sky130_fd_sc_hd__clkbuf_1
XTAP_TAPCELL_ROW_94_1707 VGND VPWR sky130_fd_sc_hd__tapvpwrvgnd_1
XFILLER_0_130_542 VGND VGND VPWR VPWR sky130_fd_sc_hd__fill_2
X_8389_ rf.registers\[18\]\[10\] net15 _4142_ VGND VGND VPWR VPWR _4143_ sky130_fd_sc_hd__mux2_1
X_7409_ rf.registers\[8\]\[31\] _3342_ _3587_ VGND VGND VPWR VPWR _3622_ sky130_fd_sc_hd__mux2_1
XFILLER_0_20_529 VGND VGND VPWR VPWR sky130_fd_sc_hd__decap_3
XFILLER_0_35_19 VPWR VGND VPWR VGND sky130_ef_sc_hd__decap_12
XFILLER_0_95_551 VGND VGND VPWR VPWR sky130_fd_sc_hd__decap_8
XFILLER_0_68_754 VGND VGND VPWR VPWR sky130_fd_sc_hd__fill_2
XTAP_TAPCELL_ROW_103_1847 VGND VPWR sky130_fd_sc_hd__tapvpwrvgnd_1
XFILLER_0_55_404 VGND VGND VPWR VPWR sky130_fd_sc_hd__decap_3
XFILLER_0_28_618 VGND VGND VPWR VPWR sky130_fd_sc_hd__decap_8
XFILLER_0_126_837 VGND VGND VPWR VPWR sky130_fd_sc_hd__fill_2
XFILLER_0_138_697 VGND VGND VPWR VPWR sky130_fd_sc_hd__decap_3
XTAP_TAPCELL_ROW_136_2346 VGND VPWR sky130_fd_sc_hd__tapvpwrvgnd_1
XTAP_TAPCELL_ROW_136_2335 VGND VPWR sky130_fd_sc_hd__tapvpwrvgnd_1
XFILLER_0_24_813 VPWR VGND VPWR VGND sky130_ef_sc_hd__decap_12
XFILLER_0_82_289 VGND VGND VPWR VPWR sky130_fd_sc_hd__fill_1
XTAP_TAPCELL_ROW_11_465 VGND VPWR sky130_fd_sc_hd__tapvpwrvgnd_1
Xclkload16 clknet_leaf_92_CLK VGND VGND VPWR VPWR clkload16/Y sky130_fd_sc_hd__inv_6
Xclkload27 clknet_leaf_14_CLK VGND VGND VPWR VPWR clkload27/Y sky130_fd_sc_hd__clkinvlp_4
Xclkload49 clknet_leaf_77_CLK VGND VGND VPWR VPWR clkload49/Y sky130_fd_sc_hd__inv_6
XFILLER_0_3_729 VPWR VGND VPWR VGND sky130_ef_sc_hd__decap_12
Xclkload38 clknet_leaf_73_CLK VGND VGND VPWR VPWR clkload38/X sky130_fd_sc_hd__clkbuf_4
XFILLER_0_133_391 VGND VGND VPWR VPWR sky130_fd_sc_hd__fill_1
XFILLER_0_11_529 VPWR VGND VPWR VGND sky130_ef_sc_hd__decap_12
XFILLER_0_23_367 VGND VGND VPWR VPWR sky130_fd_sc_hd__fill_2
XFILLER_0_76_15 VPWR VGND VPWR VGND sky130_ef_sc_hd__decap_12
XFILLER_0_116_65 VPWR VGND VPWR VGND sky130_ef_sc_hd__decap_12
XFILLER_0_59_721 VGND VGND VPWR VPWR sky130_fd_sc_hd__decap_6
X_7760_ _3809_ VGND VGND VPWR VPWR _0291_ sky130_fd_sc_hd__clkbuf_1
X_4972_ _1729_ VGND VGND VPWR VPWR _1730_ sky130_fd_sc_hd__buf_4
XFILLER_0_59_765 VPWR VGND VPWR VGND sky130_ef_sc_hd__decap_12
XTAP_TAPCELL_ROW_19_587 VGND VPWR sky130_fd_sc_hd__tapvpwrvgnd_1
X_7691_ _3351_ rf.registers\[30\]\[2\] _3770_ VGND VGND VPWR VPWR _3773_ sky130_fd_sc_hd__mux2_1
XFILLER_0_74_713 VPWR VGND VPWR VGND sky130_ef_sc_hd__decap_12
X_6711_ rf.registers\[10\]\[18\] _3024_ _3216_ VGND VGND VPWR VPWR _3225_ sky130_fd_sc_hd__mux2_1
XFILLER_0_132_53 VPWR VGND VPWR VGND sky130_ef_sc_hd__decap_12
XFILLER_0_128_141 VPWR VGND VPWR VGND sky130_ef_sc_hd__decap_12
XFILLER_0_74_757 VPWR VGND VPWR VGND sky130_ef_sc_hd__decap_12
XFILLER_0_73_245 VGND VGND VPWR VPWR sky130_fd_sc_hd__fill_1
XFILLER_0_73_223 VGND VGND VPWR VPWR sky130_fd_sc_hd__fill_1
X_9430_ clknet_leaf_59_CLK _0518_ VGND VGND VPWR VPWR rf.registers\[25\]\[5\] sky130_fd_sc_hd__dfxtp_1
X_6642_ rf.registers\[24\]\[18\] _3024_ _3179_ VGND VGND VPWR VPWR _3188_ sky130_fd_sc_hd__mux2_1
XFILLER_0_6_501 VPWR VGND VPWR VGND sky130_ef_sc_hd__decap_12
XFILLER_0_18_139 VGND VGND VPWR VPWR sky130_fd_sc_hd__fill_1
XFILLER_0_46_437 VPWR VGND VPWR VGND sky130_ef_sc_hd__decap_12
XFILLER_0_132_97 VPWR VGND VPWR VGND sky130_ef_sc_hd__decap_12
XFILLER_0_129_697 VPWR VGND VPWR VGND sky130_ef_sc_hd__decap_12
X_9361_ clknet_leaf_39_CLK _0449_ VGND VGND VPWR VPWR rf.registers\[26\]\[0\] sky130_fd_sc_hd__dfxtp_1
XFILLER_0_6_545 VPWR VGND VPWR VGND sky130_ef_sc_hd__decap_12
X_8312_ rf.registers\[20\]\[6\] net42 _4095_ VGND VGND VPWR VPWR _4102_ sky130_fd_sc_hd__mux2_1
X_6573_ rf.registers\[1\]\[18\] _3024_ _3142_ VGND VGND VPWR VPWR _3151_ sky130_fd_sc_hd__mux2_1
XFILLER_0_61_429 VGND VGND VPWR VPWR sky130_fd_sc_hd__fill_2
XFILLER_0_54_492 VGND VGND VPWR VPWR sky130_fd_sc_hd__fill_1
XFILLER_0_14_301 VGND VGND VPWR VPWR sky130_fd_sc_hd__decap_6
XTAP_TAPCELL_ROW_30_752 VGND VPWR sky130_fd_sc_hd__tapvpwrvgnd_1
XFILLER_0_42_610 VPWR VGND VPWR VGND sky130_ef_sc_hd__decap_12
XFILLER_0_131_317 VPWR VGND VPWR VGND sky130_ef_sc_hd__decap_12
XFILLER_0_6_589 VGND VGND VPWR VPWR sky130_fd_sc_hd__decap_8
XFILLER_0_14_345 VPWR VGND VPWR VGND sky130_ef_sc_hd__decap_12
X_9292_ clknet_leaf_88_CLK _0380_ VGND VGND VPWR VPWR rf.registers\[23\]\[27\] sky130_fd_sc_hd__dfxtp_1
X_5524_ _2211_ _1711_ _2206_ VGND VGND VPWR VPWR _2255_ sky130_fd_sc_hd__or3_1
XFILLER_0_112_531 VGND VGND VPWR VPWR sky130_fd_sc_hd__fill_1
XTAP_TAPCELL_ROW_76_1437 VGND VPWR sky130_fd_sc_hd__tapvpwrvgnd_1
X_8243_ _4065_ VGND VGND VPWR VPWR _0518_ sky130_fd_sc_hd__clkbuf_1
X_5455_ rf.registers\[0\]\[31\] rf.registers\[1\]\[31\] rf.registers\[2\]\[31\] rf.registers\[3\]\[31\]
+ _2086_ _2087_ VGND VGND VPWR VPWR _2187_ sky130_fd_sc_hd__mux4_1
XFILLER_0_14_389 VPWR VGND VPWR VGND sky130_ef_sc_hd__decap_12
XFILLER_0_112_586 VGND VGND VPWR VPWR sky130_fd_sc_hd__fill_2
X_8174_ _3357_ rf.registers\[21\]\[5\] _4023_ VGND VGND VPWR VPWR _4029_ sky130_fd_sc_hd__mux2_1
X_4406_ _1193_ _1194_ _1145_ VGND VGND VPWR VPWR _1195_ sky130_fd_sc_hd__mux2_1
XFILLER_0_1_261 VPWR VGND VPWR VGND sky130_ef_sc_hd__decap_12
XFILLER_0_100_737 VPWR VGND VPWR VGND sky130_ef_sc_hd__decap_12
XFILLER_0_10_562 VPWR VGND VPWR VGND sky130_ef_sc_hd__decap_12
X_5386_ rf.registers\[16\]\[27\] rf.registers\[17\]\[27\] rf.registers\[18\]\[27\]
+ rf.registers\[19\]\[27\] _2086_ _2087_ VGND VGND VPWR VPWR _2122_ sky130_fd_sc_hd__mux4_1
X_7125_ rf.registers\[5\]\[25\] _3330_ _3466_ VGND VGND VPWR VPWR _3472_ sky130_fd_sc_hd__mux2_1
X_4337_ _1127_ VGND VGND VPWR VPWR _1128_ sky130_fd_sc_hd__buf_4
XFILLER_0_10_595 VGND VGND VPWR VPWR sky130_fd_sc_hd__decap_4
XFILLER_0_5_51 VGND VGND VPWR VPWR sky130_fd_sc_hd__decap_4
X_4268_ rf.registers\[28\]\[1\] rf.registers\[29\]\[1\] rf.registers\[30\]\[1\] rf.registers\[31\]\[1\]
+ _1041_ _1043_ VGND VGND VPWR VPWR _1062_ sky130_fd_sc_hd__mux4_1
X_7056_ _3435_ VGND VGND VPWR VPWR _0985_ sky130_fd_sc_hd__clkbuf_1
X_6007_ _2565_ _2716_ _2719_ _2463_ _2721_ VGND VGND VPWR VPWR _2722_ sky130_fd_sc_hd__o221a_1
XTAP_TAPCELL_ROW_120_2103 VGND VPWR sky130_fd_sc_hd__tapvpwrvgnd_1
XTAP_TAPCELL_ROW_38_863 VGND VPWR sky130_fd_sc_hd__tapvpwrvgnd_1
XTAP_TAPCELL_ROW_38_874 VGND VPWR sky130_fd_sc_hd__tapvpwrvgnd_1
XTAP_TAPCELL_ROW_87_1599 VGND VPWR sky130_fd_sc_hd__tapvpwrvgnd_1
X_7958_ _3768_ _3877_ VGND VGND VPWR VPWR _3914_ sky130_fd_sc_hd__nand2_4
X_6909_ net10 net9 net46 VGND VGND VPWR VPWR _3345_ sky130_fd_sc_hd__and3_2
X_7889_ net12 net11 net13 VGND VGND VPWR VPWR _3877_ sky130_fd_sc_hd__and3b_4
XFILLER_0_9_361 VPWR VGND VPWR VGND sky130_ef_sc_hd__decap_12
XFILLER_0_108_837 VGND VGND VPWR VPWR sky130_fd_sc_hd__fill_2
XFILLER_0_92_587 VGND VGND VPWR VPWR sky130_fd_sc_hd__fill_1
XFILLER_0_134_133 VGND VGND VPWR VPWR sky130_fd_sc_hd__decap_6
XFILLER_0_80_749 VGND VGND VPWR VPWR sky130_fd_sc_hd__decap_6
X_9559_ clknet_leaf_59_CLK _0647_ VGND VGND VPWR VPWR rf.registers\[13\]\[6\] sky130_fd_sc_hd__dfxtp_1
XFILLER_0_17_161 VGND VGND VPWR VPWR sky130_fd_sc_hd__decap_6
XFILLER_0_45_470 VGND VGND VPWR VPWR sky130_fd_sc_hd__decap_6
XFILLER_0_134_177 VPWR VGND VPWR VGND sky130_ef_sc_hd__decap_12
XTAP_TAPCELL_ROW_118_2076 VGND VPWR sky130_fd_sc_hd__tapvpwrvgnd_1
XTAP_TAPCELL_ROW_118_2065 VGND VPWR sky130_fd_sc_hd__tapvpwrvgnd_1
XTAP_TAPCELL_ROW_131_2265 VGND VPWR sky130_fd_sc_hd__tapvpwrvgnd_1
XFILLER_0_32_197 VGND VGND VPWR VPWR sky130_fd_sc_hd__decap_4
XFILLER_0_46_29 VPWR VGND VPWR VGND sky130_ef_sc_hd__decap_12
XFILLER_0_88_805 VGND VGND VPWR VPWR sky130_fd_sc_hd__decap_6
XTAP_TAPCELL_ROW_47_1005 VGND VPWR sky130_fd_sc_hd__tapvpwrvgnd_1
XFILLER_0_68_573 VGND VGND VPWR VPWR sky130_fd_sc_hd__decap_3
XFILLER_0_56_713 VPWR VGND VPWR VGND sky130_ef_sc_hd__decap_12
XTAP_TAPCELL_ROW_16_535 VGND VPWR sky130_fd_sc_hd__tapvpwrvgnd_1
XTAP_TAPCELL_ROW_16_546 VGND VPWR sky130_fd_sc_hd__tapvpwrvgnd_1
XFILLER_0_138_461 VPWR VGND VPWR VGND sky130_ef_sc_hd__decap_12
XTAP_TAPCELL_ROW_60_1205 VGND VPWR sky130_fd_sc_hd__tapvpwrvgnd_1
XFILLER_0_56_757 VPWR VGND VPWR VGND sky130_ef_sc_hd__decap_12
XFILLER_0_125_111 VGND VGND VPWR VPWR sky130_fd_sc_hd__fill_1
XFILLER_0_55_289 VGND VGND VPWR VPWR sky130_fd_sc_hd__fill_1
XFILLER_0_11_21 VPWR VGND VPWR VGND sky130_ef_sc_hd__decap_12
XFILLER_0_24_610 VPWR VGND VPWR VGND sky130_ef_sc_hd__decap_12
XFILLER_0_51_440 VGND VGND VPWR VPWR sky130_fd_sc_hd__decap_3
XFILLER_0_3_559 VGND VGND VPWR VPWR sky130_fd_sc_hd__fill_1
XFILLER_0_121_361 VPWR VGND VPWR VGND sky130_ef_sc_hd__decap_12
X_5240_ rf.registers\[16\]\[19\] rf.registers\[17\]\[19\] rf.registers\[18\]\[19\]
+ rf.registers\[19\]\[19\] _1749_ _1750_ VGND VGND VPWR VPWR _1984_ sky130_fd_sc_hd__mux4_1
XTAP_TAPCELL_ROW_58_1167 VGND VPWR sky130_fd_sc_hd__tapvpwrvgnd_1
XFILLER_0_11_337 VPWR VGND VPWR VGND sky130_ef_sc_hd__decap_12
X_5171_ _1918_ VGND VGND VPWR VPWR net55 sky130_fd_sc_hd__clkbuf_2
XPHY_EDGE_ROW_18_Right_18 VGND VGND VPWR VPWR sky130_fd_sc_hd__decap_3
XTAP_TAPCELL_ROW_71_1367 VGND VPWR sky130_fd_sc_hd__tapvpwrvgnd_1
XFILLER_0_127_31 VPWR VGND VPWR VGND sky130_ef_sc_hd__decap_12
X_8930_ clknet_leaf_78_CLK _0018_ VGND VGND VPWR VPWR rf.registers\[4\]\[17\] sky130_fd_sc_hd__dfxtp_1
XFILLER_0_39_7 VPWR VGND VPWR VGND sky130_ef_sc_hd__decap_12
Xinput3 A1[2] VGND VGND VPWR VPWR net3 sky130_fd_sc_hd__dlymetal6s2s_1
X_8861_ clknet_leaf_18_CLK _0973_ VGND VGND VPWR VPWR rf.registers\[6\]\[12\] sky130_fd_sc_hd__dfxtp_1
X_8792_ clknet_leaf_52_CLK _0904_ VGND VGND VPWR VPWR rf.registers\[16\]\[7\] sky130_fd_sc_hd__dfxtp_1
XFILLER_0_78_359 VGND VGND VPWR VPWR sky130_fd_sc_hd__decap_4
X_7812_ _3836_ VGND VGND VPWR VPWR _0316_ sky130_fd_sc_hd__clkbuf_1
XTAP_TAPCELL_ROW_35_822 VGND VPWR sky130_fd_sc_hd__tapvpwrvgnd_1
X_4955_ _1712_ _1713_ _1635_ VGND VGND VPWR VPWR _1714_ sky130_fd_sc_hd__mux2_1
XFILLER_0_19_415 VGND VGND VPWR VPWR sky130_fd_sc_hd__fill_1
X_7743_ _2972_ rf.registers\[30\]\[27\] _3792_ VGND VGND VPWR VPWR _3800_ sky130_fd_sc_hd__mux2_1
XPHY_EDGE_ROW_27_Right_27 VGND VGND VPWR VPWR sky130_fd_sc_hd__decap_3
XFILLER_0_47_713 VPWR VGND VPWR VGND sky130_ef_sc_hd__decap_12
X_4886_ rf.registers\[24\]\[1\] rf.registers\[25\]\[1\] rf.registers\[26\]\[1\] rf.registers\[27\]\[1\]
+ _1617_ _1618_ VGND VGND VPWR VPWR _1648_ sky130_fd_sc_hd__mux4_1
XFILLER_0_74_565 VGND VGND VPWR VPWR sky130_fd_sc_hd__decap_4
XFILLER_0_7_821 VPWR VGND VPWR VGND sky130_ef_sc_hd__decap_12
X_7674_ rf.registers\[2\]\[27\] _3334_ _3755_ VGND VGND VPWR VPWR _3763_ sky130_fd_sc_hd__mux2_1
XFILLER_0_116_133 VGND VGND VPWR VPWR sky130_fd_sc_hd__decap_6
X_6625_ _3167_ VGND VGND VPWR VPWR _3179_ sky130_fd_sc_hd__clkbuf_8
X_9413_ clknet_leaf_82_CLK _0501_ VGND VGND VPWR VPWR rf.registers\[21\]\[20\] sky130_fd_sc_hd__dfxtp_1
XFILLER_0_116_177 VPWR VGND VPWR VGND sky130_ef_sc_hd__decap_12
X_9344_ clknet_leaf_16_CLK _0432_ VGND VGND VPWR VPWR rf.registers\[7\]\[15\] sky130_fd_sc_hd__dfxtp_1
X_6556_ _3130_ VGND VGND VPWR VPWR _3142_ sky130_fd_sc_hd__buf_4
XFILLER_0_42_440 VGND VGND VPWR VPWR sky130_fd_sc_hd__fill_2
XFILLER_0_131_125 VPWR VGND VPWR VGND sky130_ef_sc_hd__decap_12
X_9275_ clknet_leaf_37_CLK _0363_ VGND VGND VPWR VPWR rf.registers\[23\]\[10\] sky130_fd_sc_hd__dfxtp_1
X_5507_ _2223_ _2235_ _2237_ VGND VGND VPWR VPWR _2238_ sky130_fd_sc_hd__mux2_1
XFILLER_0_14_153 VPWR VGND VPWR VGND sky130_ef_sc_hd__decap_12
XFILLER_0_131_169 VPWR VGND VPWR VGND sky130_ef_sc_hd__decap_12
XFILLER_0_70_793 VPWR VGND VPWR VGND sky130_ef_sc_hd__decap_12
X_6487_ _3093_ VGND VGND VPWR VPWR _3105_ sky130_fd_sc_hd__clkbuf_8
XFILLER_0_14_197 VPWR VGND VPWR VGND sky130_ef_sc_hd__decap_12
X_8226_ _3049_ rf.registers\[21\]\[30\] _4022_ VGND VGND VPWR VPWR _4056_ sky130_fd_sc_hd__mux2_1
X_5438_ rf.registers\[4\]\[30\] rf.registers\[5\]\[30\] rf.registers\[6\]\[30\] rf.registers\[7\]\[30\]
+ _2086_ _2087_ VGND VGND VPWR VPWR _2171_ sky130_fd_sc_hd__mux4_1
XFILLER_0_2_581 VGND VGND VPWR VPWR sky130_fd_sc_hd__decap_6
XPHY_EDGE_ROW_36_Right_36 VGND VGND VPWR VPWR sky130_fd_sc_hd__decap_3
X_5369_ rf.registers\[24\]\[26\] rf.registers\[25\]\[26\] rf.registers\[26\]\[26\]
+ rf.registers\[27\]\[26\] _2070_ _2071_ VGND VGND VPWR VPWR _2106_ sky130_fd_sc_hd__mux4_1
X_8157_ _4019_ VGND VGND VPWR VPWR _0478_ sky130_fd_sc_hd__clkbuf_1
X_7108_ rf.registers\[5\]\[17\] _3313_ _3455_ VGND VGND VPWR VPWR _3463_ sky130_fd_sc_hd__mux2_1
X_8088_ rf.registers\[7\]\[29\] _3338_ _3973_ VGND VGND VPWR VPWR _3983_ sky130_fd_sc_hd__mux2_1
XTAP_TAPCELL_ROW_89_1639 VGND VPWR sky130_fd_sc_hd__tapvpwrvgnd_1
XTAP_TAPCELL_ROW_89_1628 VGND VPWR sky130_fd_sc_hd__tapvpwrvgnd_1
X_7039_ _3426_ VGND VGND VPWR VPWR _0977_ sky130_fd_sc_hd__clkbuf_1
XFILLER_0_69_359 VGND VGND VPWR VPWR sky130_fd_sc_hd__fill_1
XFILLER_0_69_348 VGND VGND VPWR VPWR sky130_fd_sc_hd__fill_2
XPHY_EDGE_ROW_45_Right_45 VGND VGND VPWR VPWR sky130_fd_sc_hd__decap_3
XTAP_TAPCELL_ROW_100_1806 VGND VPWR sky130_fd_sc_hd__tapvpwrvgnd_1
XFILLER_0_93_841 VGND VGND VPWR VPWR sky130_fd_sc_hd__fill_1
XFILLER_0_37_223 VGND VGND VPWR VPWR sky130_fd_sc_hd__fill_1
XFILLER_0_38_757 VGND VGND VPWR VPWR sky130_fd_sc_hd__fill_1
XFILLER_0_135_453 VGND VGND VPWR VPWR sky130_fd_sc_hd__fill_1
XFILLER_0_123_615 VGND VGND VPWR VPWR sky130_fd_sc_hd__fill_1
XFILLER_0_33_462 VGND VGND VPWR VPWR sky130_fd_sc_hd__decap_3
XPHY_EDGE_ROW_54_Right_54 VGND VGND VPWR VPWR sky130_fd_sc_hd__decap_3
XFILLER_0_20_112 VPWR VGND VPWR VGND sky130_ef_sc_hd__decap_12
XFILLER_0_21_668 VGND VGND VPWR VPWR sky130_fd_sc_hd__decap_4
XFILLER_0_57_39 VPWR VGND VPWR VGND sky130_ef_sc_hd__decap_12
XTAP_TAPCELL_ROW_111_1968 VGND VPWR sky130_fd_sc_hd__tapvpwrvgnd_1
XTAP_TAPCELL_ROW_53_1097 VGND VPWR sky130_fd_sc_hd__tapvpwrvgnd_1
XFILLER_0_73_27 VPWR VGND VPWR VGND sky130_ef_sc_hd__decap_12
XPHY_EDGE_ROW_63_Right_63 VGND VGND VPWR VPWR sky130_fd_sc_hd__decap_3
XFILLER_0_88_679 VPWR VGND VPWR VGND sky130_ef_sc_hd__decap_12
XFILLER_0_28_212 VGND VGND VPWR VPWR sky130_fd_sc_hd__decap_3
XFILLER_0_113_55 VGND VGND VPWR VPWR sky130_fd_sc_hd__fill_1
X_4740_ rf.registers\[28\]\[25\] rf.registers\[29\]\[25\] rf.registers\[30\]\[25\]
+ rf.registers\[31\]\[25\] _1283_ _1284_ VGND VGND VPWR VPWR _1510_ sky130_fd_sc_hd__mux4_1
XFILLER_0_125_3 VPWR VGND VPWR VGND sky130_ef_sc_hd__decap_12
X_4671_ _1445_ VGND VGND VPWR VPWR net93 sky130_fd_sc_hd__inv_2
XFILLER_0_56_587 VGND VGND VPWR VPWR sky130_fd_sc_hd__fill_1
XFILLER_0_22_53 VPWR VGND VPWR VGND sky130_ef_sc_hd__decap_12
XFILLER_0_22_75 VGND VGND VPWR VPWR sky130_fd_sc_hd__decap_6
XFILLER_0_126_475 VGND VGND VPWR VPWR sky130_fd_sc_hd__fill_1
X_6410_ _3063_ VGND VGND VPWR VPWR _0711_ sky130_fd_sc_hd__clkbuf_1
X_7390_ _3612_ VGND VGND VPWR VPWR _0118_ sky130_fd_sc_hd__clkbuf_1
XFILLER_0_4_813 VPWR VGND VPWR VGND sky130_ef_sc_hd__decap_12
XFILLER_0_43_248 VGND VGND VPWR VPWR sky130_fd_sc_hd__fill_1
XFILLER_0_114_648 VGND VGND VPWR VPWR sky130_fd_sc_hd__fill_1
XFILLER_0_113_125 VPWR VGND VPWR VGND sky130_ef_sc_hd__decap_12
X_6341_ net20 VGND VGND VPWR VPWR _3018_ sky130_fd_sc_hd__buf_2
XPHY_EDGE_ROW_72_Right_72 VGND VGND VPWR VPWR sky130_fd_sc_hd__decap_3
XFILLER_0_113_169 VGND VGND VPWR VPWR sky130_fd_sc_hd__decap_8
XFILLER_0_101_309 VGND VGND VPWR VPWR sky130_fd_sc_hd__fill_1
XFILLER_0_52_793 VPWR VGND VPWR VGND sky130_ef_sc_hd__decap_12
X_9060_ clknet_leaf_22_CLK _0148_ VGND VGND VPWR VPWR rf.registers\[29\]\[19\] sky130_fd_sc_hd__dfxtp_1
X_6272_ net32 VGND VGND VPWR VPWR _2970_ sky130_fd_sc_hd__clkbuf_2
X_5223_ rf.registers\[16\]\[18\] rf.registers\[17\]\[18\] rf.registers\[18\]\[18\]
+ rf.registers\[19\]\[18\] _1929_ _1930_ VGND VGND VPWR VPWR _1968_ sky130_fd_sc_hd__mux4_1
XFILLER_0_11_167 VGND VGND VPWR VPWR sky130_fd_sc_hd__fill_1
X_8011_ _3942_ VGND VGND VPWR VPWR _0409_ sky130_fd_sc_hd__clkbuf_1
X_5154_ _1902_ VGND VGND VPWR VPWR net54 sky130_fd_sc_hd__inv_2
X_5085_ rf.registers\[4\]\[10\] rf.registers\[5\]\[10\] rf.registers\[6\]\[10\] rf.registers\[7\]\[10\]
+ _1816_ _1817_ VGND VGND VPWR VPWR _1838_ sky130_fd_sc_hd__mux4_1
XPHY_EDGE_ROW_81_Right_81 VGND VGND VPWR VPWR sky130_fd_sc_hd__decap_3
XPHY_EDGE_ROW_16_Left_155 VGND VGND VPWR VPWR sky130_fd_sc_hd__decap_3
X_8913_ clknet_leaf_41_CLK _0001_ VGND VGND VPWR VPWR rf.registers\[4\]\[0\] sky130_fd_sc_hd__dfxtp_1
XFILLER_0_79_613 VGND VGND VPWR VPWR sky130_fd_sc_hd__decap_3
XFILLER_0_78_101 VGND VGND VPWR VPWR sky130_fd_sc_hd__fill_2
XFILLER_0_2_41 VPWR VGND VPWR VGND sky130_ef_sc_hd__decap_12
XFILLER_0_2_85 VPWR VGND VPWR VGND sky130_ef_sc_hd__decap_12
X_8844_ clknet_leaf_86_CLK _0956_ VGND VGND VPWR VPWR rf.registers\[15\]\[27\] sky130_fd_sc_hd__dfxtp_1
XTAP_TAPCELL_ROW_84_1558 VGND VPWR sky130_fd_sc_hd__tapvpwrvgnd_1
XFILLER_0_78_167 VGND VGND VPWR VPWR sky130_fd_sc_hd__decap_6
XFILLER_0_137_729 VPWR VGND VPWR VGND sky130_ef_sc_hd__decap_12
XFILLER_0_75_841 VGND VGND VPWR VPWR sky130_fd_sc_hd__fill_1
XFILLER_0_59_381 VGND VGND VPWR VPWR sky130_fd_sc_hd__decap_4
X_8775_ clknet_leaf_1_CLK _0887_ VGND VGND VPWR VPWR rf.registers\[0\]\[22\] sky130_fd_sc_hd__dfxtp_1
X_5987_ _2581_ _2582_ _2650_ _2701_ VGND VGND VPWR VPWR _2702_ sky130_fd_sc_hd__or4b_1
X_7726_ _3386_ rf.registers\[30\]\[19\] _3781_ VGND VGND VPWR VPWR _3791_ sky130_fd_sc_hd__mux2_1
X_4938_ _1635_ VGND VGND VPWR VPWR _1698_ sky130_fd_sc_hd__buf_4
X_4869_ net2 VGND VGND VPWR VPWR _1632_ sky130_fd_sc_hd__clkbuf_4
XFILLER_0_90_811 VGND VGND VPWR VPWR sky130_fd_sc_hd__fill_1
X_7657_ rf.registers\[2\]\[19\] _3317_ _3744_ VGND VGND VPWR VPWR _3754_ sky130_fd_sc_hd__mux2_1
XPHY_EDGE_ROW_25_Left_164 VGND VGND VPWR VPWR sky130_fd_sc_hd__decap_3
XFILLER_0_35_727 VGND VGND VPWR VPWR sky130_fd_sc_hd__fill_1
XFILLER_0_132_401 VPWR VGND VPWR VGND sky130_ef_sc_hd__decap_12
X_6608_ _3170_ VGND VGND VPWR VPWR _0802_ sky130_fd_sc_hd__clkbuf_1
XPHY_EDGE_ROW_90_Right_90 VGND VGND VPWR VPWR sky130_fd_sc_hd__decap_3
XFILLER_0_62_546 VGND VGND VPWR VPWR sky130_fd_sc_hd__decap_3
XFILLER_0_7_673 VPWR VGND VPWR VGND sky130_ef_sc_hd__decap_12
XTAP_TAPCELL_ROW_115_2024 VGND VPWR sky130_fd_sc_hd__tapvpwrvgnd_1
XTAP_TAPCELL_ROW_99_1790 VGND VPWR sky130_fd_sc_hd__tapvpwrvgnd_1
X_7588_ _3717_ VGND VGND VPWR VPWR _0211_ sky130_fd_sc_hd__clkbuf_1
XFILLER_0_15_473 VPWR VGND VPWR VGND sky130_ef_sc_hd__decap_12
XFILLER_0_43_782 VGND VGND VPWR VPWR sky130_fd_sc_hd__fill_2
X_6539_ _3133_ VGND VGND VPWR VPWR _0770_ sky130_fd_sc_hd__clkbuf_1
X_9327_ clknet_leaf_67_CLK _0415_ VGND VGND VPWR VPWR rf.registers\[22\]\[30\] sky130_fd_sc_hd__dfxtp_1
XFILLER_0_101_821 VPWR VGND VPWR VGND sky130_ef_sc_hd__decap_12
X_9258_ clknet_leaf_84_CLK _0346_ VGND VGND VPWR VPWR rf.registers\[28\]\[25\] sky130_fd_sc_hd__dfxtp_1
X_8209_ _4047_ VGND VGND VPWR VPWR _0502_ sky130_fd_sc_hd__clkbuf_1
X_9189_ clknet_leaf_81_CLK _0277_ VGND VGND VPWR VPWR rf.registers\[30\]\[20\] sky130_fd_sc_hd__dfxtp_1
XTAP_TAPCELL_ROW_7_399 VGND VPWR sky130_fd_sc_hd__tapvpwrvgnd_1
XPHY_EDGE_ROW_34_Left_173 VGND VGND VPWR VPWR sky130_fd_sc_hd__decap_3
XFILLER_0_97_410 VGND VGND VPWR VPWR sky130_fd_sc_hd__fill_1
XTAP_TAPCELL_ROW_126_2197 VGND VPWR sky130_fd_sc_hd__tapvpwrvgnd_1
XTAP_TAPCELL_ROW_126_2186 VGND VPWR sky130_fd_sc_hd__tapvpwrvgnd_1
XFILLER_0_43_19 VPWR VGND VPWR VGND sky130_ef_sc_hd__decap_12
XFILLER_0_84_104 VGND VGND VPWR VPWR sky130_fd_sc_hd__fill_1
XFILLER_0_69_167 VGND VGND VPWR VPWR sky130_fd_sc_hd__fill_1
XFILLER_0_127_217 VGND VGND VPWR VPWR sky130_fd_sc_hd__decap_6
XTAP_TAPCELL_ROW_26_685 VGND VPWR sky130_fd_sc_hd__tapvpwrvgnd_1
XTAP_TAPCELL_ROW_26_696 VGND VPWR sky130_fd_sc_hd__tapvpwrvgnd_1
XPHY_EDGE_ROW_43_Left_182 VGND VGND VPWR VPWR sky130_fd_sc_hd__decap_3
XFILLER_0_93_671 VGND VGND VPWR VPWR sky130_fd_sc_hd__fill_1
XFILLER_0_81_833 VGND VGND VPWR VPWR sky130_fd_sc_hd__decap_6
XFILLER_0_135_261 VPWR VGND VPWR VGND sky130_ef_sc_hd__decap_12
XFILLER_0_111_9 VPWR VGND VPWR VGND sky130_ef_sc_hd__decap_12
XFILLER_0_4_109 VPWR VGND VPWR VGND sky130_ef_sc_hd__decap_12
XFILLER_0_80_365 VPWR VGND VPWR VGND sky130_ef_sc_hd__decap_12
XFILLER_0_61_590 VGND VGND VPWR VPWR sky130_fd_sc_hd__fill_2
XFILLER_0_7_19 VPWR VGND VPWR VGND sky130_ef_sc_hd__decap_12
XFILLER_0_110_117 VGND VGND VPWR VPWR sky130_fd_sc_hd__fill_2
XFILLER_0_68_27 VGND VGND VPWR VPWR sky130_fd_sc_hd__fill_1
XFILLER_0_0_304 VGND VGND VPWR VPWR sky130_fd_sc_hd__decap_4
XFILLER_0_0_337 VPWR VGND VPWR VGND sky130_ef_sc_hd__decap_12
XTAP_TAPCELL_ROW_55_1126 VGND VPWR sky130_fd_sc_hd__tapvpwrvgnd_1
XPHY_EDGE_ROW_52_Left_191 VGND VGND VPWR VPWR sky130_fd_sc_hd__decap_3
XFILLER_0_84_15 VPWR VGND VPWR VGND sky130_ef_sc_hd__decap_12
XFILLER_0_108_77 VGND VGND VPWR VPWR sky130_fd_sc_hd__decap_6
XFILLER_0_88_421 VPWR VGND VPWR VGND sky130_ef_sc_hd__decap_12
X_5910_ _2439_ _2568_ _2263_ VGND VGND VPWR VPWR _2630_ sky130_fd_sc_hd__o21a_1
XFILLER_0_88_465 VGND VGND VPWR VPWR sky130_fd_sc_hd__decap_8
XFILLER_0_48_318 VGND VGND VPWR VPWR sky130_fd_sc_hd__decap_6
X_6890_ net32 VGND VGND VPWR VPWR _3332_ sky130_fd_sc_hd__buf_2
XFILLER_0_124_65 VPWR VGND VPWR VGND sky130_ef_sc_hd__decap_12
XFILLER_0_76_638 VGND VGND VPWR VPWR sky130_fd_sc_hd__decap_6
XTAP_TAPCELL_ROW_66_1288 VGND VPWR sky130_fd_sc_hd__tapvpwrvgnd_1
X_5841_ _2340_ _2466_ VGND VGND VPWR VPWR _2564_ sky130_fd_sc_hd__nor2_1
XTAP_TAPCELL_ROW_45_972 VGND VPWR sky130_fd_sc_hd__tapvpwrvgnd_1
XFILLER_0_119_729 VPWR VGND VPWR VGND sky130_ef_sc_hd__decap_12
X_8560_ clknet_leaf_75_CLK _0672_ VGND VGND VPWR VPWR rf.registers\[13\]\[31\] sky130_fd_sc_hd__dfxtp_1
XFILLER_0_57_841 VGND VGND VPWR VPWR sky130_fd_sc_hd__fill_1
X_5772_ _2493_ _2497_ _2236_ VGND VGND VPWR VPWR _2498_ sky130_fd_sc_hd__mux2_1
X_7511_ _3376_ rf.registers\[31\]\[14\] _3672_ VGND VGND VPWR VPWR _3677_ sky130_fd_sc_hd__mux2_1
XFILLER_0_72_811 VGND VGND VPWR VPWR sky130_fd_sc_hd__fill_1
XFILLER_0_17_716 VPWR VGND VPWR VGND sky130_ef_sc_hd__decap_12
X_8491_ _4196_ VGND VGND VPWR VPWR _0635_ sky130_fd_sc_hd__clkbuf_1
XFILLER_0_29_576 VGND VGND VPWR VPWR sky130_fd_sc_hd__fill_2
X_4723_ rf.registers\[28\]\[24\] rf.registers\[29\]\[24\] rf.registers\[30\]\[24\]
+ rf.registers\[31\]\[24\] _1146_ _1148_ VGND VGND VPWR VPWR _1494_ sky130_fd_sc_hd__mux4_1
XFILLER_0_44_513 VGND VGND VPWR VPWR sky130_fd_sc_hd__decap_6
X_7442_ _3640_ VGND VGND VPWR VPWR _0142_ sky130_fd_sc_hd__clkbuf_1
XFILLER_0_16_248 VGND VGND VPWR VPWR sky130_fd_sc_hd__decap_4
X_4654_ _1429_ VGND VGND VPWR VPWR net91 sky130_fd_sc_hd__inv_2
XFILLER_0_4_643 VGND VGND VPWR VPWR sky130_fd_sc_hd__fill_1
XFILLER_0_32_719 VGND VGND VPWR VPWR sky130_fd_sc_hd__decap_6
X_7373_ _3603_ VGND VGND VPWR VPWR _0110_ sky130_fd_sc_hd__clkbuf_1
X_4585_ rf.registers\[24\]\[16\] rf.registers\[25\]\[16\] rf.registers\[26\]\[16\]
+ rf.registers\[27\]\[16\] _1191_ _1192_ VGND VGND VPWR VPWR _1364_ sky130_fd_sc_hd__mux4_1
XFILLER_0_12_421 VPWR VGND VPWR VGND sky130_ef_sc_hd__decap_12
X_6324_ _3006_ VGND VGND VPWR VPWR _0682_ sky130_fd_sc_hd__clkbuf_1
X_9112_ clknet_leaf_54_CLK _0200_ VGND VGND VPWR VPWR rf.registers\[27\]\[7\] sky130_fd_sc_hd__dfxtp_1
XFILLER_0_24_292 VGND VGND VPWR VPWR sky130_fd_sc_hd__decap_4
X_9043_ clknet_leaf_43_CLK _0131_ VGND VGND VPWR VPWR rf.registers\[29\]\[2\] sky130_fd_sc_hd__dfxtp_1
X_6255_ _2953_ _2954_ VGND VGND VPWR VPWR _2955_ sky130_fd_sc_hd__xnor2_1
X_5206_ _1930_ VGND VGND VPWR VPWR _1952_ sky130_fd_sc_hd__buf_4
X_6186_ _2888_ _2889_ VGND VGND VPWR VPWR _2890_ sky130_fd_sc_hd__nor2_1
X_5137_ _1742_ _1886_ _1755_ VGND VGND VPWR VPWR _1887_ sky130_fd_sc_hd__a21oi_1
XTAP_TAPCELL_ROW_4_358 VGND VPWR sky130_fd_sc_hd__tapvpwrvgnd_1
X_5068_ rf.registers\[8\]\[9\] rf.registers\[9\]\[9\] rf.registers\[10\]\[9\] rf.registers\[11\]\[9\]
+ _1816_ _1817_ VGND VGND VPWR VPWR _1822_ sky130_fd_sc_hd__mux4_1
X_8827_ clknet_leaf_33_CLK _0939_ VGND VGND VPWR VPWR rf.registers\[15\]\[10\] sky130_fd_sc_hd__dfxtp_1
XPHY_EDGE_ROW_0_Right_0 VGND VGND VPWR VPWR sky130_fd_sc_hd__decap_3
X_8758_ clknet_leaf_65_CLK _0870_ VGND VGND VPWR VPWR rf.registers\[0\]\[5\] sky130_fd_sc_hd__dfxtp_1
XFILLER_0_137_559 VGND VGND VPWR VPWR sky130_fd_sc_hd__fill_1
X_7709_ _3782_ VGND VGND VPWR VPWR _0267_ sky130_fd_sc_hd__clkbuf_1
XFILLER_0_75_671 VGND VGND VPWR VPWR sky130_fd_sc_hd__fill_1
XFILLER_0_63_833 VGND VGND VPWR VPWR sky130_fd_sc_hd__decap_6
XTAP_TAPCELL_ROW_23_644 VGND VPWR sky130_fd_sc_hd__tapvpwrvgnd_1
XFILLER_0_35_502 VGND VGND VPWR VPWR sky130_fd_sc_hd__fill_2
XFILLER_0_35_513 VGND VGND VPWR VPWR sky130_fd_sc_hd__decap_4
X_8689_ clknet_leaf_39_CLK _0801_ VGND VGND VPWR VPWR rf.registers\[24\]\[0\] sky130_fd_sc_hd__dfxtp_1
XFILLER_0_124_209 VPWR VGND VPWR VGND sky130_ef_sc_hd__decap_12
XFILLER_0_62_343 VPWR VGND VPWR VGND sky130_ef_sc_hd__decap_12
XFILLER_0_133_721 VGND VGND VPWR VPWR sky130_fd_sc_hd__decap_6
XTAP_TAPCELL_ROW_97_1749 VGND VPWR sky130_fd_sc_hd__tapvpwrvgnd_1
XFILLER_0_62_376 VGND VGND VPWR VPWR sky130_fd_sc_hd__fill_1
XFILLER_0_133_765 VPWR VGND VPWR VGND sky130_ef_sc_hd__decap_12
XFILLER_0_132_253 VPWR VGND VPWR VGND sky130_ef_sc_hd__decap_12
XFILLER_0_15_281 VPWR VGND VPWR VGND sky130_ef_sc_hd__decap_12
XFILLER_0_31_752 VGND VGND VPWR VPWR sky130_fd_sc_hd__fill_1
XFILLER_0_31_785 VPWR VGND VPWR VGND sky130_ef_sc_hd__decap_12
XFILLER_0_101_673 VPWR VGND VPWR VGND sky130_ef_sc_hd__decap_12
XFILLER_0_100_161 VGND VGND VPWR VPWR sky130_fd_sc_hd__decap_4
XTAP_TAPCELL_ROW_128_2226 VGND VPWR sky130_fd_sc_hd__tapvpwrvgnd_1
XTAP_TAPCELL_ROW_128_2215 VGND VPWR sky130_fd_sc_hd__tapvpwrvgnd_1
XTAP_TAPCELL_ROW_50_1045 VGND VPWR sky130_fd_sc_hd__tapvpwrvgnd_1
XFILLER_0_54_29 VPWR VGND VPWR VGND sky130_ef_sc_hd__decap_12
XTAP_TAPCELL_ROW_50_1056 VGND VPWR sky130_fd_sc_hd__tapvpwrvgnd_1
XPHY_EDGE_ROW_121_Right_121 VGND VGND VPWR VPWR sky130_fd_sc_hd__decap_3
XFILLER_0_97_262 VGND VGND VPWR VPWR sky130_fd_sc_hd__fill_2
XTAP_TAPCELL_ROW_106_1889 VGND VPWR sky130_fd_sc_hd__tapvpwrvgnd_1
XFILLER_0_97_284 VGND VGND VPWR VPWR sky130_fd_sc_hd__fill_2
XFILLER_0_58_638 VGND VGND VPWR VPWR sky130_fd_sc_hd__decap_6
XFILLER_0_85_468 VGND VGND VPWR VPWR sky130_fd_sc_hd__fill_2
XFILLER_0_73_608 VGND VGND VPWR VPWR sky130_fd_sc_hd__decap_8
XFILLER_0_39_841 VGND VGND VPWR VPWR sky130_fd_sc_hd__fill_1
XTAP_TAPCELL_ROW_42_931 VGND VPWR sky130_fd_sc_hd__tapvpwrvgnd_1
XFILLER_0_54_811 VGND VGND VPWR VPWR sky130_fd_sc_hd__fill_1
XFILLER_0_66_693 VGND VGND VPWR VPWR sky130_fd_sc_hd__decap_6
XFILLER_0_5_429 VPWR VGND VPWR VGND sky130_ef_sc_hd__decap_12
XFILLER_0_136_581 VGND VGND VPWR VPWR sky130_fd_sc_hd__decap_6
XFILLER_0_81_685 VPWR VGND VPWR VGND sky130_ef_sc_hd__decap_12
XFILLER_0_79_37 VPWR VGND VPWR VGND sky130_ef_sc_hd__decap_12
X_4370_ _1121_ VGND VGND VPWR VPWR _1160_ sky130_fd_sc_hd__buf_4
XFILLER_0_0_156 VPWR VGND VPWR VGND sky130_ef_sc_hd__decap_12
XFILLER_0_119_43 VPWR VGND VPWR VGND sky130_ef_sc_hd__decap_12
X_6040_ _2747_ _2751_ _2752_ VGND VGND VPWR VPWR _2753_ sky130_fd_sc_hd__a21o_1
XFILLER_0_28_41 VGND VGND VPWR VPWR sky130_fd_sc_hd__fill_2
XFILLER_0_28_96 VGND VGND VPWR VPWR sky130_fd_sc_hd__fill_2
XFILLER_0_135_31 VPWR VGND VPWR VGND sky130_ef_sc_hd__decap_12
X_7991_ _3378_ rf.registers\[22\]\[15\] _3926_ VGND VGND VPWR VPWR _3932_ sky130_fd_sc_hd__mux2_1
XFILLER_0_89_741 VPWR VGND VPWR VGND sky130_ef_sc_hd__decap_12
XTAP_TAPCELL_ROW_68_1317 VGND VPWR sky130_fd_sc_hd__tapvpwrvgnd_1
XTAP_TAPCELL_ROW_1_317 VGND VPWR sky130_fd_sc_hd__tapvpwrvgnd_1
XFILLER_0_89_785 VPWR VGND VPWR VGND sky130_ef_sc_hd__decap_12
X_6942_ _3346_ VGND VGND VPWR VPWR _3368_ sky130_fd_sc_hd__clkbuf_8
XFILLER_0_49_605 VGND VGND VPWR VPWR sky130_fd_sc_hd__fill_1
XFILLER_0_44_62 VGND VGND VPWR VPWR sky130_fd_sc_hd__decap_3
XTAP_TAPCELL_ROW_81_1517 VGND VPWR sky130_fd_sc_hd__tapvpwrvgnd_1
X_6873_ rf.registers\[16\]\[20\] _3319_ _3320_ VGND VGND VPWR VPWR _3321_ sky130_fd_sc_hd__mux2_1
X_8612_ clknet_leaf_18_CLK _0724_ VGND VGND VPWR VPWR rf.registers\[11\]\[19\] sky130_fd_sc_hd__dfxtp_1
X_5824_ _2535_ _2539_ _2536_ VGND VGND VPWR VPWR _2548_ sky130_fd_sc_hd__o21ba_1
XFILLER_0_8_245 VGND VGND VPWR VPWR sky130_fd_sc_hd__decap_6
XFILLER_0_29_362 VGND VGND VPWR VPWR sky130_fd_sc_hd__fill_1
XFILLER_0_91_449 VGND VGND VPWR VPWR sky130_fd_sc_hd__fill_2
X_8543_ _4223_ VGND VGND VPWR VPWR _0660_ sky130_fd_sc_hd__clkbuf_1
XFILLER_0_56_181 VGND VGND VPWR VPWR sky130_fd_sc_hd__decap_8
X_5755_ _1180_ _2480_ VGND VGND VPWR VPWR _2481_ sky130_fd_sc_hd__xnor2_1
XTAP_TAPCELL_ROW_20_603 VGND VPWR sky130_fd_sc_hd__tapvpwrvgnd_1
XFILLER_0_44_332 VGND VGND VPWR VPWR sky130_fd_sc_hd__fill_2
XFILLER_0_45_833 VGND VGND VPWR VPWR sky130_fd_sc_hd__decap_6
XFILLER_0_97_3 VPWR VGND VPWR VGND sky130_ef_sc_hd__decap_12
XFILLER_0_72_663 VPWR VGND VPWR VGND sky130_ef_sc_hd__decap_12
X_8474_ _4187_ VGND VGND VPWR VPWR _0627_ sky130_fd_sc_hd__clkbuf_1
XFILLER_0_60_825 VPWR VGND VPWR VGND sky130_ef_sc_hd__decap_12
X_4706_ rf.registers\[16\]\[23\] rf.registers\[17\]\[23\] rf.registers\[18\]\[23\]
+ rf.registers\[19\]\[23\] _1329_ _1330_ VGND VGND VPWR VPWR _1478_ sky130_fd_sc_hd__mux4_1
XFILLER_0_8_289 VPWR VGND VPWR VGND sky130_ef_sc_hd__decap_12
XFILLER_0_17_579 VGND VGND VPWR VPWR sky130_fd_sc_hd__decap_4
X_5686_ _2275_ _2287_ _2332_ VGND VGND VPWR VPWR _2415_ sky130_fd_sc_hd__mux2_1
XFILLER_0_44_343 VGND VGND VPWR VPWR sky130_fd_sc_hd__fill_2
XFILLER_0_44_365 VGND VGND VPWR VPWR sky130_fd_sc_hd__decap_8
XFILLER_0_115_765 VPWR VGND VPWR VGND sky130_ef_sc_hd__decap_12
XFILLER_0_114_253 VGND VGND VPWR VPWR sky130_fd_sc_hd__decap_4
X_7425_ _3631_ VGND VGND VPWR VPWR _0134_ sky130_fd_sc_hd__clkbuf_1
X_4637_ _1301_ _1413_ _1307_ VGND VGND VPWR VPWR _1414_ sky130_fd_sc_hd__a21oi_1
XFILLER_0_44_398 VGND VGND VPWR VPWR sky130_fd_sc_hd__decap_4
XFILLER_0_130_713 VPWR VGND VPWR VGND sky130_ef_sc_hd__decap_12
XFILLER_0_102_426 VGND VGND VPWR VPWR sky130_fd_sc_hd__fill_1
XTAP_TAPCELL_ROW_79_1479 VGND VPWR sky130_fd_sc_hd__tapvpwrvgnd_1
XFILLER_0_13_741 VGND VGND VPWR VPWR sky130_fd_sc_hd__decap_8
XFILLER_0_130_757 VPWR VGND VPWR VGND sky130_ef_sc_hd__decap_12
X_4568_ rf.registers\[20\]\[15\] rf.registers\[21\]\[15\] rf.registers\[22\]\[15\]
+ rf.registers\[23\]\[15\] _1329_ _1330_ VGND VGND VPWR VPWR _1348_ sky130_fd_sc_hd__mux4_1
X_7356_ _3594_ VGND VGND VPWR VPWR _0102_ sky130_fd_sc_hd__clkbuf_1
XFILLER_0_12_251 VGND VGND VPWR VPWR sky130_fd_sc_hd__fill_1
XTAP_TAPCELL_ROW_9_439 VGND VPWR sky130_fd_sc_hd__tapvpwrvgnd_1
XTAP_TAPCELL_ROW_9_428 VGND VPWR sky130_fd_sc_hd__tapvpwrvgnd_1
XFILLER_0_13_785 VPWR VGND VPWR VGND sky130_ef_sc_hd__decap_12
X_6307_ net40 VGND VGND VPWR VPWR _2995_ sky130_fd_sc_hd__clkbuf_2
XTAP_TAPCELL_ROW_92_1679 VGND VPWR sky130_fd_sc_hd__tapvpwrvgnd_1
X_4499_ _1117_ VGND VGND VPWR VPWR _1282_ sky130_fd_sc_hd__buf_4
X_7287_ rf.registers\[3\]\[5\] _3288_ _3552_ VGND VGND VPWR VPWR _3558_ sky130_fd_sc_hd__mux2_1
X_9026_ clknet_leaf_12_CLK _0114_ VGND VGND VPWR VPWR rf.registers\[8\]\[17\] sky130_fd_sc_hd__dfxtp_1
X_6238_ _2414_ _2898_ _2938_ _2326_ VGND VGND VPWR VPWR _2939_ sky130_fd_sc_hd__o211a_1
X_6169_ net98 _2873_ _2479_ VGND VGND VPWR VPWR _2874_ sky130_fd_sc_hd__o21ai_1
XTAP_TAPCELL_ROW_28_714 VGND VPWR sky130_fd_sc_hd__tapvpwrvgnd_1
XTAP_TAPCELL_ROW_123_2145 VGND VPWR sky130_fd_sc_hd__tapvpwrvgnd_1
XTAP_TAPCELL_ROW_28_725 VGND VPWR sky130_fd_sc_hd__tapvpwrvgnd_1
XFILLER_0_138_813 VGND VGND VPWR VPWR sky130_fd_sc_hd__decap_8
XFILLER_0_95_777 VGND VGND VPWR VPWR sky130_fd_sc_hd__decap_6
XFILLER_0_82_427 VGND VGND VPWR VPWR sky130_fd_sc_hd__fill_1
XFILLER_0_48_693 VGND VGND VPWR VPWR sky130_fd_sc_hd__decap_6
XFILLER_0_23_505 VPWR VGND VPWR VGND sky130_ef_sc_hd__decap_12
XFILLER_0_63_685 VPWR VGND VPWR VGND sky130_ef_sc_hd__decap_12
XFILLER_0_133_595 VGND VGND VPWR VPWR sky130_fd_sc_hd__decap_4
XFILLER_0_120_245 VGND VGND VPWR VPWR sky130_fd_sc_hd__decap_6
XFILLER_0_50_379 VGND VGND VPWR VPWR sky130_fd_sc_hd__decap_3
XFILLER_0_31_593 VGND VGND VPWR VPWR sky130_fd_sc_hd__decap_6
XFILLER_0_101_492 VGND VGND VPWR VPWR sky130_fd_sc_hd__decap_3
XTAP_TAPCELL_ROW_108_1918 VGND VPWR sky130_fd_sc_hd__tapvpwrvgnd_1
XFILLER_0_81_27 VGND VGND VPWR VPWR sky130_fd_sc_hd__decap_8
XFILLER_0_86_755 VGND VGND VPWR VPWR sky130_fd_sc_hd__fill_1
XFILLER_0_85_232 VGND VGND VPWR VPWR sky130_fd_sc_hd__fill_1
XFILLER_0_85_221 VGND VGND VPWR VPWR sky130_fd_sc_hd__decap_3
XFILLER_0_128_345 VPWR VGND VPWR VGND sky130_ef_sc_hd__decap_12
XTAP_TAPCELL_ROW_63_1247 VGND VPWR sky130_fd_sc_hd__tapvpwrvgnd_1
XFILLER_0_14_65 VPWR VGND VPWR VGND sky130_ef_sc_hd__decap_12
XFILLER_0_5_237 VPWR VGND VPWR VGND sky130_ef_sc_hd__decap_12
X_5540_ net68 _2270_ VGND VGND VPWR VPWR _2271_ sky130_fd_sc_hd__and2_1
XFILLER_0_121_55 VGND VGND VPWR VPWR sky130_fd_sc_hd__fill_1
XFILLER_0_81_482 VGND VGND VPWR VPWR sky130_fd_sc_hd__fill_2
X_5471_ net101 net102 VGND VGND VPWR VPWR _2202_ sky130_fd_sc_hd__or2_1
XFILLER_0_30_53 VGND VGND VPWR VPWR sky130_fd_sc_hd__fill_2
XFILLER_0_42_825 VPWR VGND VPWR VGND sky130_ef_sc_hd__decap_12
X_7210_ _3517_ VGND VGND VPWR VPWR _0033_ sky130_fd_sc_hd__clkbuf_1
XFILLER_0_112_713 VPWR VGND VPWR VGND sky130_ef_sc_hd__decap_12
X_4422_ rf.registers\[24\]\[7\] rf.registers\[25\]\[7\] rf.registers\[26\]\[7\] rf.registers\[27\]\[7\]
+ _1119_ _1122_ VGND VGND VPWR VPWR _1210_ sky130_fd_sc_hd__mux4_1
XFILLER_0_112_757 VPWR VGND VPWR VGND sky130_ef_sc_hd__decap_12
X_8190_ _4037_ VGND VGND VPWR VPWR _0493_ sky130_fd_sc_hd__clkbuf_1
X_7141_ rf.registers\[4\]\[0\] _3276_ _3480_ VGND VGND VPWR VPWR _3481_ sky130_fd_sc_hd__mux2_1
X_4353_ _1143_ VGND VGND VPWR VPWR _1144_ sky130_fd_sc_hd__buf_4
XFILLER_0_10_755 VGND VGND VPWR VPWR sky130_fd_sc_hd__fill_1
X_4284_ A2[0] VGND VGND VPWR VPWR _1077_ sky130_fd_sc_hd__buf_4
X_7072_ _3443_ VGND VGND VPWR VPWR _3444_ sky130_fd_sc_hd__buf_4
X_6023_ _1939_ _2711_ VGND VGND VPWR VPWR _2737_ sky130_fd_sc_hd__nor2_1
X_7974_ _3361_ rf.registers\[22\]\[7\] _3915_ VGND VGND VPWR VPWR _3923_ sky130_fd_sc_hd__mux2_1
X_6925_ _3356_ VGND VGND VPWR VPWR _0933_ sky130_fd_sc_hd__clkbuf_1
XFILLER_0_49_402 VPWR VGND VPWR VGND sky130_ef_sc_hd__decap_12
XFILLER_0_12_3 VPWR VGND VPWR VGND sky130_ef_sc_hd__decap_12
XFILLER_0_138_109 VGND VGND VPWR VPWR sky130_fd_sc_hd__decap_3
XFILLER_0_49_435 VPWR VGND VPWR VGND sky130_ef_sc_hd__decap_12
XFILLER_0_119_323 VPWR VGND VPWR VGND sky130_ef_sc_hd__decap_12
XFILLER_0_92_725 VPWR VGND VPWR VGND sky130_ef_sc_hd__decap_12
X_6856_ net20 VGND VGND VPWR VPWR _3309_ sky130_fd_sc_hd__clkbuf_2
XFILLER_0_77_777 VGND VGND VPWR VPWR sky130_fd_sc_hd__decap_6
XFILLER_0_18_811 VGND VGND VPWR VPWR sky130_fd_sc_hd__fill_1
XFILLER_0_92_769 VPWR VGND VPWR VGND sky130_ef_sc_hd__decap_12
XFILLER_0_64_449 VGND VGND VPWR VPWR sky130_fd_sc_hd__decap_8
X_9575_ clknet_leaf_7_CLK _0663_ VGND VGND VPWR VPWR rf.registers\[13\]\[22\] sky130_fd_sc_hd__dfxtp_1
X_5807_ _2473_ _2531_ _2479_ VGND VGND VPWR VPWR _2532_ sky130_fd_sc_hd__o21a_1
X_6787_ _3265_ VGND VGND VPWR VPWR _0886_ sky130_fd_sc_hd__clkbuf_1
XFILLER_0_9_576 VGND VGND VPWR VPWR sky130_fd_sc_hd__decap_3
XFILLER_0_18_833 VGND VGND VPWR VPWR sky130_fd_sc_hd__fill_2
XFILLER_0_36_129 VGND VGND VPWR VPWR sky130_fd_sc_hd__fill_2
X_8526_ _4214_ VGND VGND VPWR VPWR _0652_ sky130_fd_sc_hd__clkbuf_1
XFILLER_0_17_343 VGND VGND VPWR VPWR sky130_fd_sc_hd__fill_1
X_5738_ _1076_ _2464_ VGND VGND VPWR VPWR _2465_ sky130_fd_sc_hd__nor2_1
XTAP_TAPCELL_ROW_33_794 VGND VPWR sky130_fd_sc_hd__tapvpwrvgnd_1
XFILLER_0_72_493 VGND VGND VPWR VPWR sky130_fd_sc_hd__decap_3
X_8457_ _3007_ rf.registers\[14\]\[10\] _4178_ VGND VGND VPWR VPWR _4179_ sky130_fd_sc_hd__mux2_1
XTAP_TAPCELL_ROW_94_1708 VGND VPWR sky130_fd_sc_hd__tapvpwrvgnd_1
X_5669_ _2398_ VGND VGND VPWR VPWR _2399_ sky130_fd_sc_hd__buf_2
X_8388_ _4130_ VGND VGND VPWR VPWR _4142_ sky130_fd_sc_hd__clkbuf_8
XFILLER_0_60_699 VGND VGND VPWR VPWR sky130_fd_sc_hd__fill_1
X_7408_ _3621_ VGND VGND VPWR VPWR _0127_ sky130_fd_sc_hd__clkbuf_1
XFILLER_0_130_565 VGND VGND VPWR VPWR sky130_fd_sc_hd__fill_1
X_7339_ rf.registers\[3\]\[30\] _3340_ _3551_ VGND VGND VPWR VPWR _3585_ sky130_fd_sc_hd__mux2_1
XFILLER_0_13_593 VGND VGND VPWR VPWR sky130_fd_sc_hd__decap_3
XPHY_EDGE_ROW_8_Left_147 VGND VGND VPWR VPWR sky130_fd_sc_hd__decap_3
X_9009_ clknet_leaf_40_CLK _0097_ VGND VGND VPWR VPWR rf.registers\[8\]\[0\] sky130_fd_sc_hd__dfxtp_1
XFILLER_0_68_722 VPWR VGND VPWR VGND sky130_ef_sc_hd__decap_12
XFILLER_0_138_610 VGND VGND VPWR VPWR sky130_fd_sc_hd__decap_6
XTAP_TAPCELL_ROW_103_1848 VGND VPWR sky130_fd_sc_hd__tapvpwrvgnd_1
XFILLER_0_126_805 VGND VGND VPWR VPWR sky130_fd_sc_hd__decap_6
XFILLER_0_82_224 VGND VGND VPWR VPWR sky130_fd_sc_hd__decap_8
XFILLER_0_55_449 VGND VGND VPWR VPWR sky130_fd_sc_hd__fill_2
XTAP_TAPCELL_ROW_136_2336 VGND VPWR sky130_fd_sc_hd__tapvpwrvgnd_1
XFILLER_0_125_337 VPWR VGND VPWR VGND sky130_ef_sc_hd__decap_12
XFILLER_0_36_663 VGND VGND VPWR VPWR sky130_fd_sc_hd__fill_1
XTAP_TAPCELL_ROW_136_2347 VGND VPWR sky130_fd_sc_hd__tapvpwrvgnd_1
XFILLER_0_63_482 VGND VGND VPWR VPWR sky130_fd_sc_hd__decap_4
XFILLER_0_63_460 VGND VGND VPWR VPWR sky130_fd_sc_hd__decap_6
XFILLER_0_24_825 VPWR VGND VPWR VGND sky130_ef_sc_hd__decap_12
Xclkload17 clknet_leaf_93_CLK VGND VGND VPWR VPWR clkload17/X sky130_fd_sc_hd__clkbuf_4
XFILLER_0_106_584 VGND VGND VPWR VPWR sky130_fd_sc_hd__fill_1
Xclkload28 clknet_leaf_15_CLK VGND VGND VPWR VPWR clkload28/Y sky130_fd_sc_hd__bufinv_16
XTAP_TAPCELL_ROW_11_466 VGND VPWR sky130_fd_sc_hd__tapvpwrvgnd_1
Xclkload39 clknet_leaf_83_CLK VGND VGND VPWR VPWR clkload39/Y sky130_fd_sc_hd__clkinv_4
XFILLER_0_76_49 VGND VGND VPWR VPWR sky130_fd_sc_hd__fill_2
XFILLER_0_76_27 VGND VGND VPWR VPWR sky130_fd_sc_hd__fill_1
XFILLER_0_92_15 VPWR VGND VPWR VGND sky130_ef_sc_hd__decap_12
XFILLER_0_116_77 VGND VGND VPWR VPWR sky130_fd_sc_hd__decap_6
X_4971_ _1652_ VGND VGND VPWR VPWR _1729_ sky130_fd_sc_hd__buf_4
XTAP_TAPCELL_ROW_19_588 VGND VPWR sky130_fd_sc_hd__tapvpwrvgnd_1
X_7690_ _3772_ VGND VGND VPWR VPWR _0258_ sky130_fd_sc_hd__clkbuf_1
XFILLER_0_74_725 VPWR VGND VPWR VGND sky130_ef_sc_hd__decap_12
X_6710_ _3224_ VGND VGND VPWR VPWR _0850_ sky130_fd_sc_hd__clkbuf_1
XFILLER_0_59_777 VGND VGND VPWR VPWR sky130_fd_sc_hd__decap_6
XFILLER_0_46_416 VGND VGND VPWR VPWR sky130_fd_sc_hd__fill_1
XFILLER_0_129_654 VPWR VGND VPWR VGND sky130_ef_sc_hd__decap_12
XFILLER_0_128_153 VPWR VGND VPWR VGND sky130_ef_sc_hd__decap_12
X_6641_ _3187_ VGND VGND VPWR VPWR _0818_ sky130_fd_sc_hd__clkbuf_1
XFILLER_0_46_449 VPWR VGND VPWR VGND sky130_ef_sc_hd__decap_12
XFILLER_0_132_65 VPWR VGND VPWR VGND sky130_ef_sc_hd__decap_12
XFILLER_0_128_197 VPWR VGND VPWR VGND sky130_ef_sc_hd__decap_12
XFILLER_0_74_769 VPWR VGND VPWR VGND sky130_ef_sc_hd__decap_12
X_9360_ clknet_leaf_76_CLK _0448_ VGND VGND VPWR VPWR rf.registers\[7\]\[31\] sky130_fd_sc_hd__dfxtp_1
XFILLER_0_6_513 VPWR VGND VPWR VGND sky130_ef_sc_hd__decap_12
XFILLER_0_116_359 VGND VGND VPWR VPWR sky130_fd_sc_hd__fill_2
X_8311_ _4101_ VGND VGND VPWR VPWR _0550_ sky130_fd_sc_hd__clkbuf_1
X_6572_ _3150_ VGND VGND VPWR VPWR _0786_ sky130_fd_sc_hd__clkbuf_1
XFILLER_0_6_557 VPWR VGND VPWR VGND sky130_ef_sc_hd__decap_12
XTAP_TAPCELL_ROW_30_753 VGND VPWR sky130_fd_sc_hd__tapvpwrvgnd_1
XFILLER_0_42_622 VGND VGND VPWR VPWR sky130_fd_sc_hd__decap_6
XFILLER_0_131_329 VGND VGND VPWR VPWR sky130_fd_sc_hd__decap_6
XFILLER_0_14_357 VGND VGND VPWR VPWR sky130_fd_sc_hd__decap_6
X_9291_ clknet_leaf_70_CLK _0379_ VGND VGND VPWR VPWR rf.registers\[23\]\[26\] sky130_fd_sc_hd__dfxtp_1
X_5523_ _2253_ VGND VGND VPWR VPWR _2254_ sky130_fd_sc_hd__clkbuf_4
XTAP_TAPCELL_ROW_76_1438 VGND VPWR sky130_fd_sc_hd__tapvpwrvgnd_1
X_8242_ _2997_ rf.registers\[25\]\[5\] _4059_ VGND VGND VPWR VPWR _4065_ sky130_fd_sc_hd__mux2_1
X_5454_ _2074_ _2185_ VGND VGND VPWR VPWR _2186_ sky130_fd_sc_hd__and2_1
X_8173_ _4028_ VGND VGND VPWR VPWR _0485_ sky130_fd_sc_hd__clkbuf_1
X_4405_ rf.registers\[8\]\[6\] rf.registers\[9\]\[6\] rf.registers\[10\]\[6\] rf.registers\[11\]\[6\]
+ _1191_ _1192_ VGND VGND VPWR VPWR _1194_ sky130_fd_sc_hd__mux4_1
X_5385_ rf.registers\[28\]\[27\] rf.registers\[29\]\[27\] rf.registers\[30\]\[27\]
+ rf.registers\[31\]\[27\] _2086_ _2087_ VGND VGND VPWR VPWR _2121_ sky130_fd_sc_hd__mux4_1
X_4336_ _1043_ VGND VGND VPWR VPWR _1127_ sky130_fd_sc_hd__buf_4
XFILLER_0_112_598 VGND VGND VPWR VPWR sky130_fd_sc_hd__fill_2
XFILLER_0_100_749 VGND VGND VPWR VPWR sky130_fd_sc_hd__decap_6
XFILLER_0_1_273 VGND VGND VPWR VPWR sky130_fd_sc_hd__decap_6
X_7124_ _3471_ VGND VGND VPWR VPWR _1017_ sky130_fd_sc_hd__clkbuf_1
X_4267_ net7 VGND VGND VPWR VPWR _1061_ sky130_fd_sc_hd__clkbuf_4
X_7055_ rf.registers\[6\]\[24\] _3328_ _3430_ VGND VGND VPWR VPWR _3435_ sky130_fd_sc_hd__mux2_1
X_6006_ _2252_ _2720_ _2263_ VGND VGND VPWR VPWR _2721_ sky130_fd_sc_hd__o21a_1
XTAP_TAPCELL_ROW_120_2104 VGND VPWR sky130_fd_sc_hd__tapvpwrvgnd_1
XFILLER_0_97_839 VGND VGND VPWR VPWR sky130_fd_sc_hd__fill_1
XTAP_TAPCELL_ROW_38_864 VGND VPWR sky130_fd_sc_hd__tapvpwrvgnd_1
XFILLER_0_96_349 VGND VGND VPWR VPWR sky130_fd_sc_hd__decap_8
X_7957_ _3913_ VGND VGND VPWR VPWR _0384_ sky130_fd_sc_hd__clkbuf_1
XFILLER_0_49_221 VGND VGND VPWR VPWR sky130_fd_sc_hd__decap_3
XTAP_TAPCELL_ROW_38_875 VGND VPWR sky130_fd_sc_hd__tapvpwrvgnd_1
X_6908_ net14 VGND VGND VPWR VPWR _3344_ sky130_fd_sc_hd__clkbuf_2
XFILLER_0_65_714 VPWR VGND VPWR VGND sky130_ef_sc_hd__decap_12
X_7888_ _3876_ VGND VGND VPWR VPWR _0352_ sky130_fd_sc_hd__clkbuf_1
XFILLER_0_49_265 VGND VGND VPWR VPWR sky130_fd_sc_hd__decap_3
XFILLER_0_108_805 VGND VGND VPWR VPWR sky130_fd_sc_hd__decap_6
X_6839_ _3297_ VGND VGND VPWR VPWR _0906_ sky130_fd_sc_hd__clkbuf_1
XFILLER_0_64_268 VGND VGND VPWR VPWR sky130_fd_sc_hd__decap_4
XFILLER_0_9_373 VPWR VGND VPWR VGND sky130_ef_sc_hd__decap_12
X_9558_ clknet_leaf_53_CLK _0646_ VGND VGND VPWR VPWR rf.registers\[13\]\[5\] sky130_fd_sc_hd__dfxtp_1
XFILLER_0_52_419 VGND VGND VPWR VPWR sky130_fd_sc_hd__fill_1
XFILLER_0_134_189 VGND VGND VPWR VPWR sky130_fd_sc_hd__decap_6
X_9489_ clknet_leaf_39_CLK _0577_ VGND VGND VPWR VPWR rf.registers\[18\]\[0\] sky130_fd_sc_hd__dfxtp_1
XFILLER_0_122_307 VGND VGND VPWR VPWR sky130_fd_sc_hd__fill_1
XTAP_TAPCELL_ROW_118_2077 VGND VPWR sky130_fd_sc_hd__tapvpwrvgnd_1
XTAP_TAPCELL_ROW_118_2066 VGND VPWR sky130_fd_sc_hd__tapvpwrvgnd_1
X_8509_ _2993_ rf.registers\[13\]\[3\] _4205_ VGND VGND VPWR VPWR _4206_ sky130_fd_sc_hd__mux2_1
XFILLER_0_131_841 VGND VGND VPWR VPWR sky130_fd_sc_hd__fill_1
XFILLER_0_60_474 VGND VGND VPWR VPWR sky130_fd_sc_hd__fill_2
XFILLER_0_21_839 VGND VGND VPWR VPWR sky130_fd_sc_hd__fill_1
XTAP_TAPCELL_ROW_131_2266 VGND VPWR sky130_fd_sc_hd__tapvpwrvgnd_1
XFILLER_0_1_3 VPWR VGND VPWR VGND sky130_ef_sc_hd__decap_12
XFILLER_0_99_110 VGND VGND VPWR VPWR sky130_fd_sc_hd__fill_2
XTAP_TAPCELL_ROW_47_1006 VGND VPWR sky130_fd_sc_hd__tapvpwrvgnd_1
XFILLER_0_62_29 VPWR VGND VPWR VGND sky130_ef_sc_hd__decap_12
XFILLER_0_56_725 VPWR VGND VPWR VGND sky130_ef_sc_hd__decap_12
XTAP_TAPCELL_ROW_16_536 VGND VPWR sky130_fd_sc_hd__tapvpwrvgnd_1
XTAP_TAPCELL_ROW_16_547 VGND VPWR sky130_fd_sc_hd__tapvpwrvgnd_1
XFILLER_0_68_585 VGND VGND VPWR VPWR sky130_fd_sc_hd__decap_3
XTAP_TAPCELL_ROW_60_1206 VGND VPWR sky130_fd_sc_hd__tapvpwrvgnd_1
XFILLER_0_138_473 VGND VGND VPWR VPWR sky130_fd_sc_hd__decap_3
XFILLER_0_127_7 VPWR VGND VPWR VGND sky130_ef_sc_hd__decap_12
XFILLER_0_71_706 VPWR VGND VPWR VGND sky130_ef_sc_hd__decap_12
XFILLER_0_56_769 VPWR VGND VPWR VGND sky130_ef_sc_hd__decap_12
XFILLER_0_11_33 VPWR VGND VPWR VGND sky130_ef_sc_hd__decap_12
XFILLER_0_24_600 VGND VGND VPWR VPWR sky130_fd_sc_hd__fill_1
XFILLER_0_24_622 VPWR VGND VPWR VGND sky130_ef_sc_hd__decap_12
XFILLER_0_36_482 VGND VGND VPWR VPWR sky130_fd_sc_hd__decap_8
XFILLER_0_125_167 VGND VGND VPWR VPWR sky130_fd_sc_hd__fill_1
XFILLER_0_3_505 VPWR VGND VPWR VGND sky130_ef_sc_hd__decap_12
XFILLER_0_51_452 VGND VGND VPWR VPWR sky130_fd_sc_hd__decap_4
XFILLER_0_11_305 VPWR VGND VPWR VGND sky130_ef_sc_hd__decap_12
XFILLER_0_12_806 VGND VGND VPWR VPWR sky130_fd_sc_hd__decap_6
XTAP_TAPCELL_ROW_58_1168 VGND VPWR sky130_fd_sc_hd__tapvpwrvgnd_1
XFILLER_0_51_485 VGND VGND VPWR VPWR sky130_fd_sc_hd__decap_4
XFILLER_0_11_349 VPWR VGND VPWR VGND sky130_ef_sc_hd__decap_12
XFILLER_0_121_373 VPWR VGND VPWR VGND sky130_ef_sc_hd__decap_12
X_5170_ _1683_ _1909_ _1917_ VGND VGND VPWR VPWR _1918_ sky130_fd_sc_hd__o21a_2
XTAP_TAPCELL_ROW_71_1368 VGND VPWR sky130_fd_sc_hd__tapvpwrvgnd_1
XFILLER_0_127_43 VPWR VGND VPWR VGND sky130_ef_sc_hd__decap_12
Xinput4 A1[3] VGND VGND VPWR VPWR net4 sky130_fd_sc_hd__buf_2
XFILLER_0_36_41 VPWR VGND VPWR VGND sky130_ef_sc_hd__decap_12
X_8860_ clknet_leaf_13_CLK _0972_ VGND VGND VPWR VPWR rf.registers\[6\]\[11\] sky130_fd_sc_hd__dfxtp_1
XFILLER_0_79_839 VGND VGND VPWR VPWR sky130_fd_sc_hd__fill_1
XFILLER_0_78_305 VGND VGND VPWR VPWR sky130_fd_sc_hd__decap_3
X_8791_ clknet_leaf_56_CLK _0903_ VGND VGND VPWR VPWR rf.registers\[16\]\[6\] sky130_fd_sc_hd__dfxtp_1
X_7811_ rf.registers\[9\]\[27\] _3334_ _3828_ VGND VGND VPWR VPWR _3836_ sky130_fd_sc_hd__mux2_1
XTAP_TAPCELL_ROW_35_823 VGND VPWR sky130_fd_sc_hd__tapvpwrvgnd_1
X_4954_ rf.registers\[16\]\[4\] rf.registers\[17\]\[4\] rf.registers\[18\]\[4\] rf.registers\[19\]\[4\]
+ _1631_ _1632_ VGND VGND VPWR VPWR _1713_ sky130_fd_sc_hd__mux4_1
XFILLER_0_59_574 VPWR VGND VPWR VGND sky130_ef_sc_hd__decap_12
X_7742_ _3799_ VGND VGND VPWR VPWR _0283_ sky130_fd_sc_hd__clkbuf_1
X_4885_ rf.registers\[28\]\[1\] rf.registers\[29\]\[1\] rf.registers\[30\]\[1\] rf.registers\[31\]\[1\]
+ _1617_ _1618_ VGND VGND VPWR VPWR _1647_ sky130_fd_sc_hd__mux4_1
X_9412_ clknet_leaf_21_CLK _0500_ VGND VGND VPWR VPWR rf.registers\[21\]\[19\] sky130_fd_sc_hd__dfxtp_1
XFILLER_0_7_833 VGND VGND VPWR VPWR sky130_fd_sc_hd__fill_1
X_7673_ _3762_ VGND VGND VPWR VPWR _0251_ sky130_fd_sc_hd__clkbuf_1
XFILLER_0_117_668 VGND VGND VPWR VPWR sky130_fd_sc_hd__decap_4
X_6624_ _3178_ VGND VGND VPWR VPWR _0810_ sky130_fd_sc_hd__clkbuf_1
XFILLER_0_6_321 VPWR VGND VPWR VGND sky130_ef_sc_hd__decap_12
XFILLER_0_15_600 VGND VGND VPWR VPWR sky130_fd_sc_hd__decap_6
X_6555_ _3141_ VGND VGND VPWR VPWR _0778_ sky130_fd_sc_hd__clkbuf_1
X_9343_ clknet_leaf_16_CLK _0431_ VGND VGND VPWR VPWR rf.registers\[7\]\[14\] sky130_fd_sc_hd__dfxtp_1
XFILLER_0_54_290 VGND VGND VPWR VPWR sky130_fd_sc_hd__fill_1
XFILLER_0_6_365 VPWR VGND VPWR VGND sky130_ef_sc_hd__decap_12
XFILLER_0_14_121 VPWR VGND VPWR VGND sky130_ef_sc_hd__decap_12
XFILLER_0_15_633 VGND VGND VPWR VPWR sky130_fd_sc_hd__fill_1
XFILLER_0_131_137 VPWR VGND VPWR VGND sky130_ef_sc_hd__decap_12
XFILLER_0_116_189 VGND VGND VPWR VPWR sky130_fd_sc_hd__decap_6
XFILLER_0_113_841 VGND VGND VPWR VPWR sky130_fd_sc_hd__fill_1
X_9274_ clknet_leaf_32_CLK _0362_ VGND VGND VPWR VPWR rf.registers\[23\]\[9\] sky130_fd_sc_hd__dfxtp_1
XPHY_EDGE_ROW_89_Left_228 VGND VGND VPWR VPWR sky130_fd_sc_hd__decap_3
X_5506_ _2236_ VGND VGND VPWR VPWR _2237_ sky130_fd_sc_hd__clkbuf_4
XFILLER_0_14_165 VPWR VGND VPWR VGND sky130_ef_sc_hd__decap_12
XFILLER_0_30_614 VGND VGND VPWR VPWR sky130_fd_sc_hd__decap_6
X_6486_ _3104_ VGND VGND VPWR VPWR _0746_ sky130_fd_sc_hd__clkbuf_1
X_8225_ _4055_ VGND VGND VPWR VPWR _0510_ sky130_fd_sc_hd__clkbuf_1
XFILLER_0_112_395 VGND VGND VPWR VPWR sky130_fd_sc_hd__fill_1
XFILLER_0_100_524 VGND VGND VPWR VPWR sky130_fd_sc_hd__fill_2
XFILLER_0_100_502 VGND VGND VPWR VPWR sky130_fd_sc_hd__fill_1
X_5437_ _2166_ _2167_ _2168_ _2169_ _2081_ _1950_ VGND VGND VPWR VPWR _2170_ sky130_fd_sc_hd__mux4_2
X_8156_ _2976_ rf.registers\[26\]\[29\] _4009_ VGND VGND VPWR VPWR _4019_ sky130_fd_sc_hd__mux2_1
X_5368_ rf.registers\[28\]\[26\] rf.registers\[29\]\[26\] rf.registers\[30\]\[26\]
+ rf.registers\[31\]\[26\] _2070_ _2071_ VGND VGND VPWR VPWR _2105_ sky130_fd_sc_hd__mux4_1
X_4319_ _1109_ _1110_ _1030_ VGND VGND VPWR VPWR _1111_ sky130_fd_sc_hd__mux2_1
X_7107_ _3462_ VGND VGND VPWR VPWR _1009_ sky130_fd_sc_hd__clkbuf_1
X_5299_ _2038_ _2039_ _1741_ VGND VGND VPWR VPWR _2040_ sky130_fd_sc_hd__mux2_1
X_8087_ _3982_ VGND VGND VPWR VPWR _0445_ sky130_fd_sc_hd__clkbuf_1
XTAP_TAPCELL_ROW_89_1629 VGND VPWR sky130_fd_sc_hd__tapvpwrvgnd_1
X_7038_ rf.registers\[6\]\[16\] _3311_ _3419_ VGND VGND VPWR VPWR _3426_ sky130_fd_sc_hd__mux2_1
XPHY_EDGE_ROW_98_Left_237 VGND VGND VPWR VPWR sky130_fd_sc_hd__decap_3
X_8989_ clknet_leaf_17_CLK _0077_ VGND VGND VPWR VPWR rf.registers\[3\]\[12\] sky130_fd_sc_hd__dfxtp_1
XFILLER_0_85_809 VPWR VGND VPWR VGND sky130_ef_sc_hd__decap_12
XFILLER_0_96_179 VGND VGND VPWR VPWR sky130_fd_sc_hd__fill_1
XFILLER_0_77_360 VPWR VGND VPWR VGND sky130_ef_sc_hd__decap_12
XTAP_TAPCELL_ROW_100_1807 VGND VPWR sky130_fd_sc_hd__tapvpwrvgnd_1
XFILLER_0_65_522 VGND VGND VPWR VPWR sky130_fd_sc_hd__fill_1
XFILLER_0_108_602 VGND VGND VPWR VPWR sky130_fd_sc_hd__decap_4
XFILLER_0_65_544 VGND VGND VPWR VPWR sky130_fd_sc_hd__decap_6
XFILLER_0_38_769 VGND VGND VPWR VPWR sky130_fd_sc_hd__decap_3
XFILLER_0_52_205 VGND VGND VPWR VPWR sky130_fd_sc_hd__fill_2
XFILLER_0_9_181 VPWR VGND VPWR VGND sky130_ef_sc_hd__decap_12
XFILLER_0_37_279 VGND VGND VPWR VPWR sky130_fd_sc_hd__fill_1
XFILLER_0_107_178 VGND VGND VPWR VPWR sky130_fd_sc_hd__decap_6
XFILLER_0_45_290 VGND VGND VPWR VPWR sky130_fd_sc_hd__decap_6
XFILLER_0_61_783 VGND VGND VPWR VPWR sky130_fd_sc_hd__fill_1
XFILLER_0_21_603 VPWR VGND VPWR VGND sky130_ef_sc_hd__decap_12
XFILLER_0_20_124 VPWR VGND VPWR VGND sky130_ef_sc_hd__decap_12
XFILLER_0_21_625 VPWR VGND VPWR VGND sky130_ef_sc_hd__decap_12
XFILLER_0_20_157 VGND VGND VPWR VPWR sky130_fd_sc_hd__fill_1
XFILLER_0_21_658 VGND VGND VPWR VPWR sky130_fd_sc_hd__decap_3
XTAP_TAPCELL_ROW_111_1969 VGND VPWR sky130_fd_sc_hd__tapvpwrvgnd_1
XTAP_TAPCELL_ROW_111_1958 VGND VPWR sky130_fd_sc_hd__tapvpwrvgnd_1
XTAP_TAPCELL_ROW_53_1098 VGND VPWR sky130_fd_sc_hd__tapvpwrvgnd_1
XFILLER_0_73_39 VGND VGND VPWR VPWR sky130_fd_sc_hd__fill_1
XFILLER_0_29_714 VGND VGND VPWR VPWR sky130_fd_sc_hd__decap_4
XFILLER_0_96_691 VGND VGND VPWR VPWR sky130_fd_sc_hd__decap_8
XFILLER_0_68_382 VGND VGND VPWR VPWR sky130_fd_sc_hd__fill_1
XFILLER_0_138_281 VPWR VGND VPWR VGND sky130_ef_sc_hd__decap_12
XFILLER_0_71_514 VGND VGND VPWR VPWR sky130_fd_sc_hd__decap_8
X_4670_ _1117_ _1436_ _1440_ _1444_ VGND VGND VPWR VPWR _1445_ sky130_fd_sc_hd__a2bb2o_4
XFILLER_0_16_419 VGND VGND VPWR VPWR sky130_fd_sc_hd__fill_1
XFILLER_0_22_65 VGND VGND VPWR VPWR sky130_fd_sc_hd__decap_6
XFILLER_0_118_3 VPWR VGND VPWR VGND sky130_ef_sc_hd__decap_12
XFILLER_0_4_825 VPWR VGND VPWR VGND sky130_ef_sc_hd__decap_12
XFILLER_0_113_137 VPWR VGND VPWR VGND sky130_ef_sc_hd__decap_12
X_6340_ _3017_ VGND VGND VPWR VPWR _0687_ sky130_fd_sc_hd__clkbuf_1
XFILLER_0_3_335 VGND VGND VPWR VPWR sky130_fd_sc_hd__fill_1
XFILLER_0_24_463 VGND VGND VPWR VPWR sky130_fd_sc_hd__fill_2
XFILLER_0_11_113 VPWR VGND VPWR VGND sky130_ef_sc_hd__decap_12
XFILLER_0_24_474 VGND VGND VPWR VPWR sky130_fd_sc_hd__fill_2
XFILLER_0_110_811 VGND VGND VPWR VPWR sky130_fd_sc_hd__fill_1
X_6271_ _2969_ VGND VGND VPWR VPWR _0666_ sky130_fd_sc_hd__clkbuf_1
XFILLER_0_121_181 VPWR VGND VPWR VGND sky130_ef_sc_hd__decap_12
X_5222_ rf.registers\[20\]\[18\] rf.registers\[21\]\[18\] rf.registers\[22\]\[18\]
+ rf.registers\[23\]\[18\] _1929_ _1930_ VGND VGND VPWR VPWR _1967_ sky130_fd_sc_hd__mux4_1
XFILLER_0_20_680 VGND VGND VPWR VPWR sky130_fd_sc_hd__decap_4
X_8010_ _3397_ rf.registers\[22\]\[24\] _3937_ VGND VGND VPWR VPWR _3942_ sky130_fd_sc_hd__mux2_1
XPHY_EDGE_ROW_135_Right_135 VGND VGND VPWR VPWR sky130_fd_sc_hd__decap_3
X_5153_ _1683_ _1893_ _1901_ VGND VGND VPWR VPWR _1902_ sky130_fd_sc_hd__o21ai_4
X_5084_ _1764_ _1836_ VGND VGND VPWR VPWR _1837_ sky130_fd_sc_hd__nand2_1
X_8912_ clknet_leaf_75_CLK _0000_ VGND VGND VPWR VPWR rf.registers\[5\]\[31\] sky130_fd_sc_hd__dfxtp_1
XFILLER_0_67_809 VPWR VGND VPWR VGND sky130_ef_sc_hd__decap_12
XFILLER_0_2_53 VPWR VGND VPWR VGND sky130_ef_sc_hd__decap_12
X_8843_ clknet_leaf_70_CLK _0955_ VGND VGND VPWR VPWR rf.registers\[15\]\[26\] sky130_fd_sc_hd__dfxtp_1
XTAP_TAPCELL_ROW_84_1559 VGND VPWR sky130_fd_sc_hd__tapvpwrvgnd_1
XFILLER_0_2_97 VPWR VGND VPWR VGND sky130_ef_sc_hd__decap_12
X_8774_ clknet_leaf_76_CLK _0886_ VGND VGND VPWR VPWR rf.registers\[0\]\[21\] sky130_fd_sc_hd__dfxtp_1
XFILLER_0_19_202 VGND VGND VPWR VPWR sky130_fd_sc_hd__fill_1
X_5986_ _2649_ _2670_ _2676_ _2691_ VGND VGND VPWR VPWR _2701_ sky130_fd_sc_hd__and4_1
X_4937_ _1693_ _1696_ VGND VGND VPWR VPWR _1697_ sky130_fd_sc_hd__or2_1
X_7725_ _3790_ VGND VGND VPWR VPWR _0275_ sky130_fd_sc_hd__clkbuf_1
XFILLER_0_59_393 VGND VGND VPWR VPWR sky130_fd_sc_hd__fill_2
XFILLER_0_129_281 VPWR VGND VPWR VGND sky130_ef_sc_hd__decap_12
X_4868_ net1 VGND VGND VPWR VPWR _1631_ sky130_fd_sc_hd__buf_4
XFILLER_0_74_352 VPWR VGND VPWR VGND sky130_ef_sc_hd__decap_12
X_7656_ _3753_ VGND VGND VPWR VPWR _0243_ sky130_fd_sc_hd__clkbuf_1
XANTENNA_20 net137 VGND VGND VPWR VPWR sky130_fd_sc_hd__diode_2
XFILLER_0_34_216 VGND VGND VPWR VPWR sky130_fd_sc_hd__fill_2
X_6607_ rf.registers\[24\]\[1\] _2989_ _3168_ VGND VGND VPWR VPWR _3170_ sky130_fd_sc_hd__mux2_1
XFILLER_0_62_558 VPWR VGND VPWR VGND sky130_ef_sc_hd__decap_12
XFILLER_0_7_685 VGND VGND VPWR VPWR sky130_fd_sc_hd__decap_6
XFILLER_0_34_238 VGND VGND VPWR VPWR sky130_fd_sc_hd__fill_1
XFILLER_0_132_413 VGND VGND VPWR VPWR sky130_fd_sc_hd__decap_6
XTAP_TAPCELL_ROW_115_2025 VGND VPWR sky130_fd_sc_hd__tapvpwrvgnd_1
XTAP_TAPCELL_ROW_99_1791 VGND VPWR sky130_fd_sc_hd__tapvpwrvgnd_1
XTAP_TAPCELL_ROW_99_1780 VGND VPWR sky130_fd_sc_hd__tapvpwrvgnd_1
Xclkbuf_3_6__f_CLK clknet_0_CLK VGND VGND VPWR VPWR clknet_3_6__leaf_CLK sky130_fd_sc_hd__clkbuf_16
X_7587_ _3384_ rf.registers\[27\]\[18\] _3708_ VGND VGND VPWR VPWR _3717_ sky130_fd_sc_hd__mux2_1
XFILLER_0_6_195 VGND VGND VPWR VPWR sky130_fd_sc_hd__fill_1
XFILLER_0_15_441 VGND VGND VPWR VPWR sky130_fd_sc_hd__decap_6
X_9326_ clknet_leaf_93_CLK _0414_ VGND VGND VPWR VPWR rf.registers\[22\]\[29\] sky130_fd_sc_hd__dfxtp_1
X_4799_ rf.registers\[0\]\[28\] rf.registers\[1\]\[28\] rf.registers\[2\]\[28\] rf.registers\[3\]\[28\]
+ _1382_ _1383_ VGND VGND VPWR VPWR _1566_ sky130_fd_sc_hd__mux4_1
X_6538_ rf.registers\[1\]\[1\] _2989_ _3131_ VGND VGND VPWR VPWR _3133_ sky130_fd_sc_hd__mux2_1
XFILLER_0_15_485 VPWR VGND VPWR VGND sky130_ef_sc_hd__decap_12
X_6469_ rf.registers\[17\]\[1\] _2989_ _3094_ VGND VGND VPWR VPWR _3096_ sky130_fd_sc_hd__mux2_1
XFILLER_0_101_833 VGND VGND VPWR VPWR sky130_fd_sc_hd__decap_6
X_9257_ clknet_leaf_84_CLK _0345_ VGND VGND VPWR VPWR rf.registers\[28\]\[24\] sky130_fd_sc_hd__dfxtp_1
X_9188_ clknet_leaf_22_CLK _0276_ VGND VGND VPWR VPWR rf.registers\[30\]\[19\] sky130_fd_sc_hd__dfxtp_1
X_8208_ _3391_ rf.registers\[21\]\[21\] _4045_ VGND VGND VPWR VPWR _4047_ sky130_fd_sc_hd__mux2_1
XFILLER_0_30_477 VGND VGND VPWR VPWR sky130_fd_sc_hd__decap_8
X_8139_ _4010_ VGND VGND VPWR VPWR _0469_ sky130_fd_sc_hd__clkbuf_1
XPHY_EDGE_ROW_102_Right_102 VGND VGND VPWR VPWR sky130_fd_sc_hd__decap_3
XFILLER_0_100_398 VGND VGND VPWR VPWR sky130_fd_sc_hd__fill_1
XTAP_TAPCELL_ROW_126_2187 VGND VPWR sky130_fd_sc_hd__tapvpwrvgnd_1
XFILLER_0_69_113 VGND VGND VPWR VPWR sky130_fd_sc_hd__decap_8
XTAP_TAPCELL_ROW_26_686 VGND VPWR sky130_fd_sc_hd__tapvpwrvgnd_1
XTAP_TAPCELL_ROW_26_697 VGND VPWR sky130_fd_sc_hd__tapvpwrvgnd_1
XFILLER_0_108_421 VGND VGND VPWR VPWR sky130_fd_sc_hd__fill_1
XFILLER_0_19_780 VGND VGND VPWR VPWR sky130_fd_sc_hd__decap_4
XFILLER_0_135_273 VGND VGND VPWR VPWR sky130_fd_sc_hd__decap_6
XFILLER_0_80_377 VPWR VGND VPWR VGND sky130_ef_sc_hd__decap_12
XFILLER_0_34_783 VGND VGND VPWR VPWR sky130_fd_sc_hd__fill_1
XFILLER_0_0_327 VGND VGND VPWR VPWR sky130_fd_sc_hd__fill_1
XFILLER_0_1_839 VGND VGND VPWR VPWR sky130_fd_sc_hd__fill_1
XTAP_TAPCELL_ROW_55_1127 VGND VPWR sky130_fd_sc_hd__tapvpwrvgnd_1
XFILLER_0_0_349 VGND VGND VPWR VPWR sky130_fd_sc_hd__fill_2
XFILLER_0_84_27 VGND VGND VPWR VPWR sky130_fd_sc_hd__fill_1
XFILLER_0_88_433 VPWR VGND VPWR VGND sky130_ef_sc_hd__decap_12
XFILLER_0_88_477 VGND VGND VPWR VPWR sky130_fd_sc_hd__decap_8
XFILLER_0_49_809 VPWR VGND VPWR VGND sky130_ef_sc_hd__decap_12
X_5840_ _2521_ _2562_ _2233_ VGND VGND VPWR VPWR _2563_ sky130_fd_sc_hd__mux2_1
XTAP_TAPCELL_ROW_45_973 VGND VPWR sky130_fd_sc_hd__tapvpwrvgnd_1
XFILLER_0_124_77 VGND VGND VPWR VPWR sky130_fd_sc_hd__decap_6
XTAP_TAPCELL_ROW_66_1289 VGND VPWR sky130_fd_sc_hd__tapvpwrvgnd_1
XFILLER_0_29_544 VGND VGND VPWR VPWR sky130_fd_sc_hd__decap_4
X_5771_ _2259_ _2369_ _2496_ VGND VGND VPWR VPWR _2497_ sky130_fd_sc_hd__a21oi_1
XFILLER_0_33_75 VGND VGND VPWR VPWR sky130_fd_sc_hd__fill_2
XFILLER_0_127_741 VPWR VGND VPWR VGND sky130_ef_sc_hd__decap_12
X_7510_ _3676_ VGND VGND VPWR VPWR _0174_ sky130_fd_sc_hd__clkbuf_1
XFILLER_0_84_672 VPWR VGND VPWR VGND sky130_ef_sc_hd__decap_12
XFILLER_0_56_374 VGND VGND VPWR VPWR sky130_fd_sc_hd__decap_6
X_8490_ _3041_ rf.registers\[14\]\[26\] _4189_ VGND VGND VPWR VPWR _4196_ sky130_fd_sc_hd__mux2_1
X_4722_ rf.registers\[24\]\[24\] rf.registers\[25\]\[24\] rf.registers\[26\]\[24\]
+ rf.registers\[27\]\[24\] _1125_ _1128_ VGND VGND VPWR VPWR _1493_ sky130_fd_sc_hd__mux4_1
XFILLER_0_127_785 VPWR VGND VPWR VGND sky130_ef_sc_hd__decap_12
XFILLER_0_126_251 VGND VGND VPWR VPWR sky130_fd_sc_hd__fill_1
X_7441_ _3374_ rf.registers\[29\]\[13\] _3636_ VGND VGND VPWR VPWR _3640_ sky130_fd_sc_hd__mux2_1
XFILLER_0_114_402 VGND VGND VPWR VPWR sky130_fd_sc_hd__fill_2
XFILLER_0_99_7 VPWR VGND VPWR VGND sky130_ef_sc_hd__decap_12
XFILLER_0_56_385 VGND VGND VPWR VPWR sky130_fd_sc_hd__fill_2
XFILLER_0_44_525 VGND VGND VPWR VPWR sky130_fd_sc_hd__fill_1
Xinput40 WD3[4] VGND VGND VPWR VPWR net40 sky130_fd_sc_hd__clkbuf_4
XFILLER_0_114_413 VGND VGND VPWR VPWR sky130_fd_sc_hd__decap_6
X_4653_ _1282_ _1420_ _1428_ VGND VGND VPWR VPWR _1429_ sky130_fd_sc_hd__o21ai_4
XFILLER_0_31_208 VGND VGND VPWR VPWR sky130_fd_sc_hd__fill_2
X_7372_ rf.registers\[8\]\[13\] _3305_ _3599_ VGND VGND VPWR VPWR _3603_ sky130_fd_sc_hd__mux2_1
X_4584_ rf.registers\[28\]\[16\] rf.registers\[29\]\[16\] rf.registers\[30\]\[16\]
+ rf.registers\[31\]\[16\] _1126_ _1129_ VGND VGND VPWR VPWR _1363_ sky130_fd_sc_hd__mux4_1
XFILLER_0_25_783 VGND VGND VPWR VPWR sky130_fd_sc_hd__fill_1
XFILLER_0_25_794 VPWR VGND VPWR VGND sky130_ef_sc_hd__decap_12
XFILLER_0_31_219 VGND VGND VPWR VPWR sky130_fd_sc_hd__decap_4
X_6323_ rf.registers\[12\]\[9\] _3005_ _2987_ VGND VGND VPWR VPWR _3006_ sky130_fd_sc_hd__mux2_1
XFILLER_0_101_129 VGND VGND VPWR VPWR sky130_fd_sc_hd__fill_2
X_9111_ clknet_leaf_58_CLK _0199_ VGND VGND VPWR VPWR rf.registers\[27\]\[6\] sky130_fd_sc_hd__dfxtp_1
XFILLER_0_12_433 VPWR VGND VPWR VGND sky130_ef_sc_hd__decap_12
XFILLER_0_40_753 VGND VGND VPWR VPWR sky130_fd_sc_hd__decap_3
X_9042_ clknet_leaf_42_CLK _0130_ VGND VGND VPWR VPWR rf.registers\[29\]\[1\] sky130_fd_sc_hd__dfxtp_1
X_6254_ _1615_ _2193_ VGND VGND VPWR VPWR _2954_ sky130_fd_sc_hd__xnor2_1
XFILLER_0_12_477 VPWR VGND VPWR VGND sky130_ef_sc_hd__decap_12
X_5205_ _1929_ VGND VGND VPWR VPWR _1951_ sky130_fd_sc_hd__buf_4
XFILLER_0_58_72 VPWR VGND VPWR VGND sky130_ef_sc_hd__decap_12
X_6185_ net68 _2887_ VGND VGND VPWR VPWR _2889_ sky130_fd_sc_hd__and2_1
XFILLER_0_42_3 VPWR VGND VPWR VGND sky130_ef_sc_hd__decap_12
XFILLER_0_99_709 VPWR VGND VPWR VGND sky130_ef_sc_hd__decap_12
X_5136_ _1884_ _1885_ _1698_ VGND VGND VPWR VPWR _1886_ sky130_fd_sc_hd__mux2_1
X_5067_ _1741_ _1820_ _1660_ VGND VGND VPWR VPWR _1821_ sky130_fd_sc_hd__o21a_1
XTAP_TAPCELL_ROW_4_359 VGND VPWR sky130_fd_sc_hd__tapvpwrvgnd_1
XFILLER_0_67_617 VPWR VGND VPWR VGND sky130_ef_sc_hd__decap_12
XFILLER_0_39_308 VGND VGND VPWR VPWR sky130_fd_sc_hd__fill_2
X_8826_ clknet_leaf_33_CLK _0938_ VGND VGND VPWR VPWR rf.registers\[15\]\[9\] sky130_fd_sc_hd__dfxtp_1
XFILLER_0_137_505 VPWR VGND VPWR VGND sky130_ef_sc_hd__decap_12
X_8757_ clknet_leaf_49_CLK _0869_ VGND VGND VPWR VPWR rf.registers\[0\]\[4\] sky130_fd_sc_hd__dfxtp_1
XFILLER_0_82_609 VGND VGND VPWR VPWR sky130_fd_sc_hd__fill_1
X_5969_ net106 _2518_ VGND VGND VPWR VPWR _2686_ sky130_fd_sc_hd__nand2_1
XFILLER_0_47_330 VGND VGND VPWR VPWR sky130_fd_sc_hd__decap_6
X_7708_ _3367_ rf.registers\[30\]\[10\] _3781_ VGND VGND VPWR VPWR _3782_ sky130_fd_sc_hd__mux2_1
XTAP_TAPCELL_ROW_23_645 VGND VPWR sky130_fd_sc_hd__tapvpwrvgnd_1
XFILLER_0_62_322 VGND VGND VPWR VPWR sky130_fd_sc_hd__decap_4
X_8688_ clknet_leaf_76_CLK _0800_ VGND VGND VPWR VPWR rf.registers\[1\]\[31\] sky130_fd_sc_hd__dfxtp_1
XFILLER_0_132_221 VPWR VGND VPWR VGND sky130_ef_sc_hd__decap_12
X_7639_ rf.registers\[2\]\[10\] _3298_ _3744_ VGND VGND VPWR VPWR _3745_ sky130_fd_sc_hd__mux2_1
XFILLER_0_62_355 VGND VGND VPWR VPWR sky130_fd_sc_hd__decap_8
XFILLER_0_16_761 VGND VGND VPWR VPWR sky130_fd_sc_hd__fill_1
XFILLER_0_23_709 VPWR VGND VPWR VGND sky130_ef_sc_hd__decap_12
XFILLER_0_35_569 VGND VGND VPWR VPWR sky130_fd_sc_hd__fill_1
XFILLER_0_133_777 VGND VGND VPWR VPWR sky130_fd_sc_hd__decap_6
XFILLER_0_105_446 VGND VGND VPWR VPWR sky130_fd_sc_hd__fill_2
XFILLER_0_132_265 VPWR VGND VPWR VGND sky130_ef_sc_hd__decap_12
XFILLER_0_120_416 VGND VGND VPWR VPWR sky130_fd_sc_hd__decap_4
X_9309_ clknet_leaf_23_CLK _0397_ VGND VGND VPWR VPWR rf.registers\[22\]\[12\] sky130_fd_sc_hd__dfxtp_1
XFILLER_0_15_293 VPWR VGND VPWR VGND sky130_ef_sc_hd__decap_12
XFILLER_0_30_230 VGND VGND VPWR VPWR sky130_fd_sc_hd__fill_2
XFILLER_0_31_797 VPWR VGND VPWR VGND sky130_ef_sc_hd__decap_12
XTAP_TAPCELL_ROW_128_2216 VGND VPWR sky130_fd_sc_hd__tapvpwrvgnd_1
XFILLER_0_101_685 VPWR VGND VPWR VGND sky130_ef_sc_hd__decap_12
XTAP_TAPCELL_ROW_128_2227 VGND VPWR sky130_fd_sc_hd__tapvpwrvgnd_1
XTAP_TAPCELL_ROW_50_1046 VGND VPWR sky130_fd_sc_hd__tapvpwrvgnd_1
XTAP_TAPCELL_ROW_50_1057 VGND VPWR sky130_fd_sc_hd__tapvpwrvgnd_1
XFILLER_0_85_447 VGND VGND VPWR VPWR sky130_fd_sc_hd__fill_1
XTAP_TAPCELL_ROW_42_932 VGND VPWR sky130_fd_sc_hd__tapvpwrvgnd_1
XFILLER_0_109_741 VPWR VGND VPWR VGND sky130_ef_sc_hd__decap_12
XFILLER_0_108_251 VGND VGND VPWR VPWR sky130_fd_sc_hd__fill_1
XFILLER_0_109_785 VPWR VGND VPWR VGND sky130_ef_sc_hd__decap_12
XFILLER_0_80_141 VGND VGND VPWR VPWR sky130_fd_sc_hd__fill_1
XFILLER_0_80_130 VGND VGND VPWR VPWR sky130_fd_sc_hd__decap_3
XFILLER_0_124_755 VGND VGND VPWR VPWR sky130_fd_sc_hd__fill_1
XFILLER_0_81_697 VPWR VGND VPWR VGND sky130_ef_sc_hd__decap_12
XFILLER_0_80_185 VGND VGND VPWR VPWR sky130_fd_sc_hd__fill_2
XFILLER_0_79_49 VGND VGND VPWR VPWR sky130_fd_sc_hd__decap_4
XFILLER_0_22_731 VPWR VGND VPWR VGND sky130_ef_sc_hd__decap_12
XFILLER_0_22_775 VPWR VGND VPWR VGND sky130_ef_sc_hd__decap_12
XFILLER_0_21_285 VGND VGND VPWR VPWR sky130_fd_sc_hd__fill_1
XFILLER_0_119_55 VGND VGND VPWR VPWR sky130_fd_sc_hd__fill_1
X_7990_ _3931_ VGND VGND VPWR VPWR _0399_ sky130_fd_sc_hd__clkbuf_1
XTAP_TAPCELL_ROW_68_1318 VGND VPWR sky130_fd_sc_hd__tapvpwrvgnd_1
XTAP_TAPCELL_ROW_1_318 VGND VPWR sky130_fd_sc_hd__tapvpwrvgnd_1
XFILLER_0_135_43 VPWR VGND VPWR VGND sky130_ef_sc_hd__decap_12
X_6941_ net15 VGND VGND VPWR VPWR _3367_ sky130_fd_sc_hd__clkbuf_2
XFILLER_0_89_753 VPWR VGND VPWR VGND sky130_ef_sc_hd__decap_12
XFILLER_0_88_241 VGND VGND VPWR VPWR sky130_fd_sc_hd__fill_2
XFILLER_0_44_41 VGND VGND VPWR VPWR sky130_fd_sc_hd__decap_4
XFILLER_0_89_797 VPWR VGND VPWR VGND sky130_ef_sc_hd__decap_12
XFILLER_0_49_617 VGND VGND VPWR VPWR sky130_fd_sc_hd__fill_1
X_6872_ _3277_ VGND VGND VPWR VPWR _3320_ sky130_fd_sc_hd__buf_4
XTAP_TAPCELL_ROW_81_1518 VGND VPWR sky130_fd_sc_hd__tapvpwrvgnd_1
X_8611_ clknet_leaf_6_CLK _0723_ VGND VGND VPWR VPWR rf.registers\[11\]\[18\] sky130_fd_sc_hd__dfxtp_1
X_5823_ _2544_ _2546_ VGND VGND VPWR VPWR _2547_ sky130_fd_sc_hd__nand2_1
XFILLER_0_9_725 VGND VGND VPWR VPWR sky130_fd_sc_hd__decap_3
X_8542_ _3026_ rf.registers\[13\]\[19\] _4216_ VGND VGND VPWR VPWR _4223_ sky130_fd_sc_hd__mux2_1
XFILLER_0_17_503 VGND VGND VPWR VPWR sky130_fd_sc_hd__fill_1
XFILLER_0_72_642 VGND VGND VPWR VPWR sky130_fd_sc_hd__fill_2
X_5754_ net107 _2473_ _2479_ VGND VGND VPWR VPWR _2480_ sky130_fd_sc_hd__o21a_1
XTAP_TAPCELL_ROW_20_604 VGND VPWR sky130_fd_sc_hd__tapvpwrvgnd_1
Xclkbuf_leaf_94_CLK clknet_3_0__leaf_CLK VGND VGND VPWR VPWR clknet_leaf_94_CLK sky130_fd_sc_hd__clkbuf_8
XFILLER_0_72_675 VPWR VGND VPWR VGND sky130_ef_sc_hd__decap_12
XFILLER_0_71_141 VPWR VGND VPWR VGND sky130_ef_sc_hd__decap_12
X_8473_ _3024_ rf.registers\[14\]\[18\] _4178_ VGND VGND VPWR VPWR _4187_ sky130_fd_sc_hd__mux2_1
X_4705_ rf.registers\[20\]\[23\] rf.registers\[21\]\[23\] rf.registers\[22\]\[23\]
+ rf.registers\[23\]\[23\] _1329_ _1330_ VGND VGND VPWR VPWR _1477_ sky130_fd_sc_hd__mux4_1
X_5685_ _2260_ _2289_ _2291_ VGND VGND VPWR VPWR _2414_ sky130_fd_sc_hd__nand3_1
XFILLER_0_115_777 VGND VGND VPWR VPWR sky130_fd_sc_hd__decap_6
X_7424_ _3357_ rf.registers\[29\]\[5\] _3625_ VGND VGND VPWR VPWR _3631_ sky130_fd_sc_hd__mux2_1
X_4636_ _1409_ _1412_ _1397_ VGND VGND VPWR VPWR _1413_ sky130_fd_sc_hd__mux2_1
XFILLER_0_60_837 VGND VGND VPWR VPWR sky130_fd_sc_hd__fill_2
XFILLER_0_8_41 VPWR VGND VPWR VGND sky130_ef_sc_hd__decap_12
XFILLER_0_32_539 VGND VGND VPWR VPWR sky130_fd_sc_hd__fill_1
XFILLER_0_130_725 VPWR VGND VPWR VGND sky130_ef_sc_hd__decap_12
X_7355_ rf.registers\[8\]\[5\] _3288_ _3588_ VGND VGND VPWR VPWR _3594_ sky130_fd_sc_hd__mux2_1
XFILLER_0_130_769 VPWR VGND VPWR VGND sky130_ef_sc_hd__decap_12
X_6306_ _2994_ VGND VGND VPWR VPWR _0676_ sky130_fd_sc_hd__clkbuf_1
X_4567_ rf.registers\[16\]\[15\] rf.registers\[17\]\[15\] rf.registers\[18\]\[15\]
+ rf.registers\[19\]\[15\] _1329_ _1330_ VGND VGND VPWR VPWR _1347_ sky130_fd_sc_hd__mux4_1
XTAP_TAPCELL_ROW_9_429 VGND VPWR sky130_fd_sc_hd__tapvpwrvgnd_1
XFILLER_0_8_85 VPWR VGND VPWR VGND sky130_ef_sc_hd__decap_12
XFILLER_0_40_572 VGND VGND VPWR VPWR sky130_fd_sc_hd__decap_3
X_4498_ _1281_ VGND VGND VPWR VPWR net83 sky130_fd_sc_hd__buf_2
X_7286_ _3557_ VGND VGND VPWR VPWR _0069_ sky130_fd_sc_hd__clkbuf_1
XFILLER_0_13_797 VPWR VGND VPWR VGND sky130_ef_sc_hd__decap_12
X_9025_ clknet_leaf_15_CLK _0113_ VGND VGND VPWR VPWR rf.registers\[8\]\[16\] sky130_fd_sc_hd__dfxtp_1
X_6237_ _2386_ _2805_ _2937_ _2559_ VGND VGND VPWR VPWR _2938_ sky130_fd_sc_hd__a211o_1
X_6168_ net97 _2203_ _2820_ VGND VGND VPWR VPWR _2873_ sky130_fd_sc_hd__or3_1
X_5119_ _1693_ _1869_ _1660_ VGND VGND VPWR VPWR _1870_ sky130_fd_sc_hd__o21a_1
X_6099_ _1158_ _2265_ _2519_ VGND VGND VPWR VPWR _2808_ sky130_fd_sc_hd__and3_1
XTAP_TAPCELL_ROW_28_715 VGND VPWR sky130_fd_sc_hd__tapvpwrvgnd_1
XTAP_TAPCELL_ROW_123_2146 VGND VPWR sky130_fd_sc_hd__tapvpwrvgnd_1
XTAP_TAPCELL_ROW_28_726 VGND VPWR sky130_fd_sc_hd__tapvpwrvgnd_1
XFILLER_0_79_285 VGND VGND VPWR VPWR sky130_fd_sc_hd__fill_1
X_8809_ clknet_leaf_73_CLK _0921_ VGND VGND VPWR VPWR rf.registers\[16\]\[24\] sky130_fd_sc_hd__dfxtp_1
XFILLER_0_137_335 VGND VGND VPWR VPWR sky130_fd_sc_hd__fill_1
XFILLER_0_82_417 VGND VGND VPWR VPWR sky130_fd_sc_hd__decap_3
XFILLER_0_125_508 VGND VGND VPWR VPWR sky130_fd_sc_hd__fill_1
XFILLER_0_75_491 VGND VGND VPWR VPWR sky130_fd_sc_hd__decap_8
Xclkbuf_leaf_85_CLK clknet_3_2__leaf_CLK VGND VGND VPWR VPWR clknet_leaf_85_CLK sky130_fd_sc_hd__clkbuf_8
XFILLER_0_62_141 VGND VGND VPWR VPWR sky130_fd_sc_hd__fill_1
XFILLER_0_35_344 VGND VGND VPWR VPWR sky130_fd_sc_hd__decap_4
XFILLER_0_106_755 VGND VGND VPWR VPWR sky130_fd_sc_hd__fill_1
XFILLER_0_63_697 VPWR VGND VPWR VGND sky130_ef_sc_hd__decap_12
XFILLER_0_23_517 VPWR VGND VPWR VGND sky130_ef_sc_hd__decap_12
XFILLER_0_35_388 VGND VGND VPWR VPWR sky130_fd_sc_hd__fill_1
XFILLER_0_50_336 VGND VGND VPWR VPWR sky130_fd_sc_hd__fill_1
XTAP_TAPCELL_ROW_108_1919 VGND VPWR sky130_fd_sc_hd__tapvpwrvgnd_1
XFILLER_0_86_701 VPWR VGND VPWR VGND sky130_ef_sc_hd__decap_12
XFILLER_0_85_200 VGND VGND VPWR VPWR sky130_fd_sc_hd__decap_4
XFILLER_0_105_57 VPWR VGND VPWR VGND sky130_ef_sc_hd__decap_12
XTAP_TAPCELL_ROW_63_1248 VGND VPWR sky130_fd_sc_hd__tapvpwrvgnd_1
XFILLER_0_14_77 VGND VGND VPWR VPWR sky130_fd_sc_hd__decap_6
XFILLER_0_39_661 VGND VGND VPWR VPWR sky130_fd_sc_hd__fill_2
XFILLER_0_128_357 VGND VGND VPWR VPWR sky130_fd_sc_hd__decap_6
Xclkbuf_leaf_76_CLK clknet_3_3__leaf_CLK VGND VGND VPWR VPWR clknet_leaf_76_CLK sky130_fd_sc_hd__clkbuf_8
XFILLER_0_6_717 VGND VGND VPWR VPWR sky130_fd_sc_hd__fill_1
XFILLER_0_5_205 VPWR VGND VPWR VGND sky130_ef_sc_hd__decap_12
X_5470_ _1205_ _1221_ VGND VGND VPWR VPWR _2201_ sky130_fd_sc_hd__nand2_1
XFILLER_0_5_249 VPWR VGND VPWR VGND sky130_ef_sc_hd__decap_12
XFILLER_0_42_837 VGND VGND VPWR VPWR sky130_fd_sc_hd__fill_2
XFILLER_0_112_725 VPWR VGND VPWR VGND sky130_ef_sc_hd__decap_12
XFILLER_0_100_3 VPWR VGND VPWR VGND sky130_ef_sc_hd__decap_12
X_4421_ rf.registers\[28\]\[7\] rf.registers\[29\]\[7\] rf.registers\[30\]\[7\] rf.registers\[31\]\[7\]
+ _1119_ _1122_ VGND VGND VPWR VPWR _1209_ sky130_fd_sc_hd__mux4_1
XFILLER_0_53_196 VGND VGND VPWR VPWR sky130_fd_sc_hd__fill_2
XFILLER_0_112_769 VPWR VGND VPWR VGND sky130_ef_sc_hd__decap_12
X_4352_ _1030_ VGND VGND VPWR VPWR _1143_ sky130_fd_sc_hd__buf_4
X_7140_ _3479_ VGND VGND VPWR VPWR _3480_ sky130_fd_sc_hd__buf_4
XFILLER_0_22_583 VGND VGND VPWR VPWR sky130_fd_sc_hd__decap_4
X_7071_ _3091_ _3406_ VGND VGND VPWR VPWR _3443_ sky130_fd_sc_hd__nor2_2
X_4283_ _1076_ VGND VGND VPWR VPWR net92 sky130_fd_sc_hd__clkbuf_8
X_6022_ _2734_ _2735_ VGND VGND VPWR VPWR _2736_ sky130_fd_sc_hd__nor2_1
X_7973_ _3922_ VGND VGND VPWR VPWR _0391_ sky130_fd_sc_hd__clkbuf_1
X_6924_ _3355_ rf.registers\[15\]\[4\] _3347_ VGND VGND VPWR VPWR _3356_ sky130_fd_sc_hd__mux2_1
XFILLER_0_49_447 VGND VGND VPWR VPWR sky130_fd_sc_hd__fill_1
XFILLER_0_119_335 VGND VGND VPWR VPWR sky130_fd_sc_hd__fill_1
X_6855_ _3308_ VGND VGND VPWR VPWR _0911_ sky130_fd_sc_hd__clkbuf_1
XFILLER_0_76_277 VGND VGND VPWR VPWR sky130_fd_sc_hd__decap_4
XFILLER_0_64_417 VGND VGND VPWR VPWR sky130_fd_sc_hd__decap_3
XFILLER_0_92_737 VPWR VGND VPWR VGND sky130_ef_sc_hd__decap_12
X_9574_ clknet_leaf_78_CLK _0662_ VGND VGND VPWR VPWR rf.registers\[13\]\[21\] sky130_fd_sc_hd__dfxtp_1
X_5806_ _1158_ _1180_ VGND VGND VPWR VPWR _2531_ sky130_fd_sc_hd__nand2_2
X_6786_ rf.registers\[0\]\[21\] _3031_ _3263_ VGND VGND VPWR VPWR _3265_ sky130_fd_sc_hd__mux2_1
Xclkbuf_leaf_67_CLK clknet_3_2__leaf_CLK VGND VGND VPWR VPWR clknet_leaf_67_CLK sky130_fd_sc_hd__clkbuf_8
XFILLER_0_135_839 VGND VGND VPWR VPWR sky130_fd_sc_hd__fill_1
X_8525_ _3010_ rf.registers\[13\]\[11\] _4205_ VGND VGND VPWR VPWR _4214_ sky130_fd_sc_hd__mux2_1
XTAP_TAPCELL_ROW_33_795 VGND VPWR sky130_fd_sc_hd__tapvpwrvgnd_1
X_5737_ _1056_ _1727_ _2207_ _2255_ VGND VGND VPWR VPWR _2464_ sky130_fd_sc_hd__o31a_1
XPHY_EDGE_ROW_70_Left_209 VGND VGND VPWR VPWR sky130_fd_sc_hd__decap_3
X_8456_ _4166_ VGND VGND VPWR VPWR _4178_ sky130_fd_sc_hd__clkbuf_8
XFILLER_0_60_623 VGND VGND VPWR VPWR sky130_fd_sc_hd__fill_2
XFILLER_0_44_174 VGND VGND VPWR VPWR sky130_fd_sc_hd__fill_1
XTAP_TAPCELL_ROW_94_1709 VGND VPWR sky130_fd_sc_hd__tapvpwrvgnd_1
X_7407_ rf.registers\[8\]\[30\] _3340_ _3587_ VGND VGND VPWR VPWR _3621_ sky130_fd_sc_hd__mux2_1
XFILLER_0_60_645 VPWR VGND VPWR VGND sky130_ef_sc_hd__decap_12
X_5668_ _2263_ VGND VGND VPWR VPWR _2398_ sky130_fd_sc_hd__buf_2
XFILLER_0_5_783 VGND VGND VPWR VPWR sky130_fd_sc_hd__fill_1
X_8387_ _4141_ VGND VGND VPWR VPWR _0586_ sky130_fd_sc_hd__clkbuf_1
X_4619_ rf.registers\[16\]\[18\] rf.registers\[17\]\[18\] rf.registers\[18\]\[18\]
+ rf.registers\[19\]\[18\] _1393_ _1394_ VGND VGND VPWR VPWR _1396_ sky130_fd_sc_hd__mux4_1
X_5599_ _1888_ _2207_ _2212_ VGND VGND VPWR VPWR _2329_ sky130_fd_sc_hd__o21ai_1
XFILLER_0_102_257 VGND VGND VPWR VPWR sky130_fd_sc_hd__fill_1
X_7338_ _3584_ VGND VGND VPWR VPWR _0094_ sky130_fd_sc_hd__clkbuf_1
X_7269_ rf.registers\[19\]\[29\] _3338_ _3538_ VGND VGND VPWR VPWR _3548_ sky130_fd_sc_hd__mux2_1
X_9008_ clknet_leaf_76_CLK _0096_ VGND VGND VPWR VPWR rf.registers\[3\]\[31\] sky130_fd_sc_hd__dfxtp_1
XFILLER_0_68_701 VPWR VGND VPWR VGND sky130_ef_sc_hd__decap_12
XFILLER_0_68_734 VPWR VGND VPWR VGND sky130_ef_sc_hd__decap_12
XFILLER_0_67_222 VGND VGND VPWR VPWR sky130_fd_sc_hd__fill_2
XTAP_TAPCELL_ROW_103_1849 VGND VPWR sky130_fd_sc_hd__tapvpwrvgnd_1
XTAP_TAPCELL_ROW_103_1838 VGND VPWR sky130_fd_sc_hd__tapvpwrvgnd_1
XFILLER_0_67_266 VGND VGND VPWR VPWR sky130_fd_sc_hd__decap_4
XPHY_EDGE_ROW_109_Left_248 VGND VGND VPWR VPWR sky130_fd_sc_hd__decap_3
Xclkbuf_leaf_58_CLK clknet_3_6__leaf_CLK VGND VGND VPWR VPWR clknet_leaf_58_CLK sky130_fd_sc_hd__clkbuf_8
XFILLER_0_55_428 VGND VGND VPWR VPWR sky130_fd_sc_hd__fill_2
XTAP_TAPCELL_ROW_136_2337 VGND VPWR sky130_fd_sc_hd__tapvpwrvgnd_1
XFILLER_0_125_305 VPWR VGND VPWR VGND sky130_ef_sc_hd__decap_12
XFILLER_0_24_804 VGND VGND VPWR VPWR sky130_fd_sc_hd__decap_8
XFILLER_0_125_349 VPWR VGND VPWR VGND sky130_ef_sc_hd__decap_12
XFILLER_0_3_709 VPWR VGND VPWR VGND sky130_ef_sc_hd__decap_12
XFILLER_0_24_837 VGND VGND VPWR VPWR sky130_fd_sc_hd__fill_2
Xclkload29 clknet_leaf_19_CLK VGND VGND VPWR VPWR clkload29/Y sky130_fd_sc_hd__clkinvlp_4
XFILLER_0_51_634 VGND VGND VPWR VPWR sky130_fd_sc_hd__decap_8
XTAP_TAPCELL_ROW_11_467 VGND VPWR sky130_fd_sc_hd__tapvpwrvgnd_1
Xclkload18 clknet_leaf_94_CLK VGND VGND VPWR VPWR clkload18/Y sky130_fd_sc_hd__clkinv_4
XFILLER_0_133_393 VPWR VGND VPWR VGND sky130_ef_sc_hd__decap_12
XFILLER_0_51_678 VPWR VGND VPWR VGND sky130_ef_sc_hd__decap_12
XFILLER_0_50_177 VGND VGND VPWR VPWR sky130_fd_sc_hd__fill_1
XPHY_EDGE_ROW_118_Left_257 VGND VGND VPWR VPWR sky130_fd_sc_hd__decap_3
XFILLER_0_92_27 VGND VGND VPWR VPWR sky130_fd_sc_hd__fill_1
XFILLER_0_92_49 VGND VGND VPWR VPWR sky130_fd_sc_hd__decap_3
X_4970_ _1683_ VGND VGND VPWR VPWR _1728_ sky130_fd_sc_hd__buf_8
XTAP_TAPCELL_ROW_19_578 VGND VPWR sky130_fd_sc_hd__tapvpwrvgnd_1
XTAP_TAPCELL_ROW_19_589 VGND VPWR sky130_fd_sc_hd__tapvpwrvgnd_1
XFILLER_0_128_121 VPWR VGND VPWR VGND sky130_ef_sc_hd__decap_12
XPHY_EDGE_ROW_127_Left_266 VGND VGND VPWR VPWR sky130_fd_sc_hd__decap_3
XFILLER_0_129_666 VGND VGND VPWR VPWR sky130_fd_sc_hd__decap_6
Xclkbuf_leaf_49_CLK clknet_3_6__leaf_CLK VGND VGND VPWR VPWR clknet_leaf_49_CLK sky130_fd_sc_hd__clkbuf_8
XFILLER_0_74_737 VPWR VGND VPWR VGND sky130_ef_sc_hd__decap_12
XFILLER_0_73_225 VPWR VGND VPWR VGND sky130_ef_sc_hd__decap_12
X_6640_ rf.registers\[24\]\[17\] _3022_ _3179_ VGND VGND VPWR VPWR _3187_ sky130_fd_sc_hd__mux2_1
XFILLER_0_58_288 VPWR VGND VPWR VGND sky130_ef_sc_hd__decap_12
XFILLER_0_132_77 VGND VGND VPWR VPWR sky130_fd_sc_hd__decap_6
XFILLER_0_128_165 VPWR VGND VPWR VGND sky130_ef_sc_hd__decap_12
XFILLER_0_117_839 VGND VGND VPWR VPWR sky130_fd_sc_hd__fill_1
X_6571_ rf.registers\[1\]\[17\] _3022_ _3142_ VGND VGND VPWR VPWR _3150_ sky130_fd_sc_hd__mux2_1
XFILLER_0_61_409 VGND VGND VPWR VPWR sky130_fd_sc_hd__fill_1
XFILLER_0_6_525 VGND VGND VPWR VPWR sky130_fd_sc_hd__decap_6
XFILLER_0_27_631 VGND VGND VPWR VPWR sky130_fd_sc_hd__decap_4
XFILLER_0_82_781 VPWR VGND VPWR VGND sky130_ef_sc_hd__decap_12
X_8310_ rf.registers\[20\]\[5\] net41 _4095_ VGND VGND VPWR VPWR _4101_ sky130_fd_sc_hd__mux2_1
X_5522_ _1096_ _1114_ VGND VGND VPWR VPWR _2253_ sky130_fd_sc_hd__nor2_1
XTAP_TAPCELL_ROW_30_743 VGND VPWR sky130_fd_sc_hd__tapvpwrvgnd_1
XTAP_TAPCELL_ROW_30_754 VGND VPWR sky130_fd_sc_hd__tapvpwrvgnd_1
X_9290_ clknet_leaf_85_CLK _0378_ VGND VGND VPWR VPWR rf.registers\[23\]\[25\] sky130_fd_sc_hd__dfxtp_1
X_8241_ _4064_ VGND VGND VPWR VPWR _0517_ sky130_fd_sc_hd__clkbuf_1
XTAP_TAPCELL_ROW_76_1439 VGND VPWR sky130_fd_sc_hd__tapvpwrvgnd_1
X_5453_ rf.registers\[4\]\[31\] rf.registers\[5\]\[31\] rf.registers\[6\]\[31\] rf.registers\[7\]\[31\]
+ _2086_ _2087_ VGND VGND VPWR VPWR _2185_ sky130_fd_sc_hd__mux4_1
XPHY_EDGE_ROW_136_Left_275 VGND VGND VPWR VPWR sky130_fd_sc_hd__decap_3
X_8172_ _3355_ rf.registers\[21\]\[4\] _4023_ VGND VGND VPWR VPWR _4028_ sky130_fd_sc_hd__mux2_1
X_4404_ rf.registers\[12\]\[6\] rf.registers\[13\]\[6\] rf.registers\[14\]\[6\] rf.registers\[15\]\[6\]
+ _1191_ _1192_ VGND VGND VPWR VPWR _1193_ sky130_fd_sc_hd__mux4_1
X_5384_ rf.registers\[24\]\[27\] rf.registers\[25\]\[27\] rf.registers\[26\]\[27\]
+ rf.registers\[27\]\[27\] _2086_ _2087_ VGND VGND VPWR VPWR _2120_ sky130_fd_sc_hd__mux4_1
X_4335_ _1125_ VGND VGND VPWR VPWR _1126_ sky130_fd_sc_hd__clkbuf_8
XFILLER_0_10_553 VGND VGND VPWR VPWR sky130_fd_sc_hd__fill_2
XFILLER_0_10_531 VGND VGND VPWR VPWR sky130_fd_sc_hd__fill_1
X_7123_ rf.registers\[5\]\[24\] _3328_ _3466_ VGND VGND VPWR VPWR _3471_ sky130_fd_sc_hd__mux2_1
X_4266_ _1025_ _1059_ VGND VGND VPWR VPWR _1060_ sky130_fd_sc_hd__nand2_1
X_7054_ _3434_ VGND VGND VPWR VPWR _0984_ sky130_fd_sc_hd__clkbuf_1
XFILLER_0_66_94 VGND VGND VPWR VPWR sky130_fd_sc_hd__fill_2
X_6005_ _1158_ _2317_ _2319_ VGND VGND VPWR VPWR _2720_ sky130_fd_sc_hd__or3_1
XTAP_TAPCELL_ROW_38_865 VGND VPWR sky130_fd_sc_hd__tapvpwrvgnd_1
XTAP_TAPCELL_ROW_120_2105 VGND VPWR sky130_fd_sc_hd__tapvpwrvgnd_1
X_7956_ _2980_ rf.registers\[23\]\[31\] _3878_ VGND VGND VPWR VPWR _3913_ sky130_fd_sc_hd__mux2_1
XTAP_TAPCELL_ROW_38_876 VGND VPWR sky130_fd_sc_hd__tapvpwrvgnd_1
X_7887_ _2980_ rf.registers\[28\]\[31\] _3841_ VGND VGND VPWR VPWR _3876_ sky130_fd_sc_hd__mux2_1
X_6907_ _3343_ VGND VGND VPWR VPWR _0928_ sky130_fd_sc_hd__clkbuf_1
X_6838_ rf.registers\[16\]\[9\] _3296_ _3278_ VGND VGND VPWR VPWR _3297_ sky130_fd_sc_hd__mux2_1
XFILLER_0_65_726 VGND VGND VPWR VPWR sky130_fd_sc_hd__fill_2
X_9557_ clknet_leaf_48_CLK _0645_ VGND VGND VPWR VPWR rf.registers\[13\]\[4\] sky130_fd_sc_hd__dfxtp_1
XFILLER_0_9_385 VGND VGND VPWR VPWR sky130_fd_sc_hd__decap_6
XFILLER_0_123_809 VPWR VGND VPWR VGND sky130_ef_sc_hd__decap_12
X_6769_ rf.registers\[0\]\[13\] _3014_ _3252_ VGND VGND VPWR VPWR _3256_ sky130_fd_sc_hd__mux2_1
X_8508_ _2967_ VGND VGND VPWR VPWR _4205_ sky130_fd_sc_hd__buf_6
XTAP_TAPCELL_ROW_118_2067 VGND VPWR sky130_fd_sc_hd__tapvpwrvgnd_1
X_9488_ clknet_leaf_62_CLK _0576_ VGND VGND VPWR VPWR rf.registers\[20\]\[31\] sky130_fd_sc_hd__dfxtp_1
X_8439_ _4169_ VGND VGND VPWR VPWR _0610_ sky130_fd_sc_hd__clkbuf_1
XFILLER_0_33_667 VGND VGND VPWR VPWR sky130_fd_sc_hd__decap_4
XTAP_TAPCELL_ROW_131_2267 VGND VPWR sky130_fd_sc_hd__tapvpwrvgnd_1
XFILLER_0_130_363 VGND VGND VPWR VPWR sky130_fd_sc_hd__fill_1
XFILLER_0_13_391 VGND VGND VPWR VPWR sky130_fd_sc_hd__fill_1
XFILLER_0_68_520 VGND VGND VPWR VPWR sky130_fd_sc_hd__fill_1
XTAP_TAPCELL_ROW_47_1007 VGND VPWR sky130_fd_sc_hd__tapvpwrvgnd_1
XTAP_TAPCELL_ROW_16_537 VGND VPWR sky130_fd_sc_hd__tapvpwrvgnd_1
XTAP_TAPCELL_ROW_60_1207 VGND VPWR sky130_fd_sc_hd__tapvpwrvgnd_1
XFILLER_0_56_737 VPWR VGND VPWR VGND sky130_ef_sc_hd__decap_12
XFILLER_0_55_225 VGND VGND VPWR VPWR sky130_fd_sc_hd__decap_4
XFILLER_0_125_113 VPWR VGND VPWR VGND sky130_ef_sc_hd__decap_12
XFILLER_0_71_729 VPWR VGND VPWR VGND sky130_ef_sc_hd__decap_12
XFILLER_0_71_718 VGND VGND VPWR VPWR sky130_fd_sc_hd__decap_8
XFILLER_0_64_781 VPWR VGND VPWR VGND sky130_ef_sc_hd__decap_12
XFILLER_0_36_472 VGND VGND VPWR VPWR sky130_fd_sc_hd__decap_4
XFILLER_0_43_409 VPWR VGND VPWR VGND sky130_ef_sc_hd__decap_12
XFILLER_0_113_308 VGND VGND VPWR VPWR sky130_fd_sc_hd__decap_4
XFILLER_0_11_45 VGND VGND VPWR VPWR sky130_fd_sc_hd__decap_8
XFILLER_0_3_517 VPWR VGND VPWR VGND sky130_ef_sc_hd__decap_12
XFILLER_0_24_634 VGND VGND VPWR VPWR sky130_fd_sc_hd__decap_8
XPHY_EDGE_ROW_116_Right_116 VGND VGND VPWR VPWR sky130_fd_sc_hd__decap_3
XFILLER_0_106_393 VGND VGND VPWR VPWR sky130_fd_sc_hd__decap_8
XFILLER_0_106_371 VGND VGND VPWR VPWR sky130_fd_sc_hd__fill_1
XFILLER_0_11_317 VPWR VGND VPWR VGND sky130_ef_sc_hd__decap_12
XFILLER_0_121_385 VGND VGND VPWR VPWR sky130_fd_sc_hd__decap_6
XTAP_TAPCELL_ROW_58_1169 VGND VPWR sky130_fd_sc_hd__tapvpwrvgnd_1
XTAP_TAPCELL_ROW_71_1369 VGND VPWR sky130_fd_sc_hd__tapvpwrvgnd_1
XTAP_TAPCELL_ROW_71_1358 VGND VPWR sky130_fd_sc_hd__tapvpwrvgnd_1
Xinput5 A1[4] VGND VGND VPWR VPWR net5 sky130_fd_sc_hd__buf_4
XFILLER_0_127_55 VGND VGND VPWR VPWR sky130_fd_sc_hd__fill_1
XFILLER_0_36_53 VGND VGND VPWR VPWR sky130_fd_sc_hd__decap_3
X_7810_ _3835_ VGND VGND VPWR VPWR _0315_ sky130_fd_sc_hd__clkbuf_1
X_8790_ clknet_leaf_57_CLK _0902_ VGND VGND VPWR VPWR rf.registers\[16\]\[5\] sky130_fd_sc_hd__dfxtp_1
X_4953_ rf.registers\[20\]\[4\] rf.registers\[21\]\[4\] rf.registers\[22\]\[4\] rf.registers\[23\]\[4\]
+ _1631_ _1632_ VGND VGND VPWR VPWR _1712_ sky130_fd_sc_hd__mux4_1
XTAP_TAPCELL_ROW_86_1590 VGND VPWR sky130_fd_sc_hd__tapvpwrvgnd_1
XFILLER_0_52_41 VPWR VGND VPWR VGND sky130_ef_sc_hd__decap_12
X_7741_ _2970_ rf.registers\[30\]\[26\] _3792_ VGND VGND VPWR VPWR _3799_ sky130_fd_sc_hd__mux2_1
XTAP_TAPCELL_ROW_35_824 VGND VPWR sky130_fd_sc_hd__tapvpwrvgnd_1
XFILLER_0_86_383 VPWR VGND VPWR VGND sky130_ef_sc_hd__decap_12
XFILLER_0_86_372 VGND VGND VPWR VPWR sky130_fd_sc_hd__fill_2
XFILLER_0_59_586 VGND VGND VPWR VPWR sky130_fd_sc_hd__decap_3
X_7672_ rf.registers\[2\]\[26\] _3332_ _3755_ VGND VGND VPWR VPWR _3762_ sky130_fd_sc_hd__mux2_1
X_4884_ _1644_ _1645_ _1635_ VGND VGND VPWR VPWR _1646_ sky130_fd_sc_hd__mux2_1
X_6623_ rf.registers\[24\]\[9\] _3005_ _3168_ VGND VGND VPWR VPWR _3178_ sky130_fd_sc_hd__mux2_1
X_9411_ clknet_leaf_5_CLK _0499_ VGND VGND VPWR VPWR rf.registers\[21\]\[18\] sky130_fd_sc_hd__dfxtp_1
XFILLER_0_52_85 VGND VGND VPWR VPWR sky130_fd_sc_hd__fill_2
XFILLER_0_105_809 VPWR VGND VPWR VGND sky130_ef_sc_hd__decap_12
XFILLER_0_74_578 VGND VGND VPWR VPWR sky130_fd_sc_hd__fill_1
XFILLER_0_6_333 VPWR VGND VPWR VGND sky130_ef_sc_hd__decap_12
XFILLER_0_27_472 VGND VGND VPWR VPWR sky130_fd_sc_hd__decap_8
XFILLER_0_131_105 VGND VGND VPWR VPWR sky130_fd_sc_hd__decap_6
X_6554_ rf.registers\[1\]\[9\] _3005_ _3131_ VGND VGND VPWR VPWR _3141_ sky130_fd_sc_hd__mux2_1
X_9342_ clknet_leaf_14_CLK _0430_ VGND VGND VPWR VPWR rf.registers\[7\]\[13\] sky130_fd_sc_hd__dfxtp_1
XFILLER_0_6_377 VPWR VGND VPWR VGND sky130_ef_sc_hd__decap_12
X_9273_ clknet_leaf_37_CLK _0361_ VGND VGND VPWR VPWR rf.registers\[23\]\[8\] sky130_fd_sc_hd__dfxtp_1
X_6485_ rf.registers\[17\]\[9\] _3005_ _3094_ VGND VGND VPWR VPWR _3104_ sky130_fd_sc_hd__mux2_1
XFILLER_0_14_133 VGND VGND VPWR VPWR sky130_fd_sc_hd__decap_6
X_5505_ _1095_ VGND VGND VPWR VPWR _2236_ sky130_fd_sc_hd__buf_4
XFILLER_0_131_149 VPWR VGND VPWR VGND sky130_ef_sc_hd__decap_12
XFILLER_0_72_3 VPWR VGND VPWR VGND sky130_ef_sc_hd__decap_12
XFILLER_0_14_177 VPWR VGND VPWR VGND sky130_ef_sc_hd__decap_12
X_8224_ _3047_ rf.registers\[21\]\[29\] _4045_ VGND VGND VPWR VPWR _4055_ sky130_fd_sc_hd__mux2_1
X_5436_ rf.registers\[24\]\[30\] rf.registers\[25\]\[30\] rf.registers\[26\]\[30\]
+ rf.registers\[27\]\[30\] _2109_ _2110_ VGND VGND VPWR VPWR _2169_ sky130_fd_sc_hd__mux4_1
X_5367_ _1950_ _2103_ VGND VGND VPWR VPWR _2104_ sky130_fd_sc_hd__or2_1
X_8155_ _4018_ VGND VGND VPWR VPWR _0477_ sky130_fd_sc_hd__clkbuf_1
X_4318_ rf.registers\[8\]\[3\] rf.registers\[9\]\[3\] rf.registers\[10\]\[3\] rf.registers\[11\]\[3\]
+ _1077_ _1078_ VGND VGND VPWR VPWR _1110_ sky130_fd_sc_hd__mux4_1
X_7106_ rf.registers\[5\]\[16\] _3311_ _3455_ VGND VGND VPWR VPWR _3462_ sky130_fd_sc_hd__mux2_1
X_5298_ rf.registers\[12\]\[22\] rf.registers\[13\]\[22\] rf.registers\[14\]\[22\]
+ rf.registers\[15\]\[22\] _1735_ _1737_ VGND VGND VPWR VPWR _2039_ sky130_fd_sc_hd__mux4_1
X_8086_ rf.registers\[7\]\[28\] _3336_ _3973_ VGND VGND VPWR VPWR _3982_ sky130_fd_sc_hd__mux2_1
X_4249_ _1043_ VGND VGND VPWR VPWR _1044_ sky130_fd_sc_hd__buf_4
X_7037_ _3425_ VGND VGND VPWR VPWR _0976_ sky130_fd_sc_hd__clkbuf_1
X_8988_ clknet_leaf_31_CLK _0076_ VGND VGND VPWR VPWR rf.registers\[3\]\[11\] sky130_fd_sc_hd__dfxtp_1
XFILLER_0_84_309 VGND VGND VPWR VPWR sky130_fd_sc_hd__fill_1
X_7939_ _3904_ VGND VGND VPWR VPWR _0375_ sky130_fd_sc_hd__clkbuf_1
XFILLER_0_93_821 VPWR VGND VPWR VGND sky130_ef_sc_hd__decap_12
XFILLER_0_77_372 VPWR VGND VPWR VGND sky130_ef_sc_hd__decap_12
XFILLER_0_65_534 VGND VGND VPWR VPWR sky130_fd_sc_hd__decap_4
XFILLER_0_37_225 VGND VGND VPWR VPWR sky130_fd_sc_hd__fill_1
XFILLER_0_80_504 VGND VGND VPWR VPWR sky130_fd_sc_hd__fill_1
XFILLER_0_53_729 VPWR VGND VPWR VGND sky130_ef_sc_hd__decap_12
XFILLER_0_9_193 VPWR VGND VPWR VGND sky130_ef_sc_hd__decap_12
XFILLER_0_46_781 VPWR VGND VPWR VGND sky130_ef_sc_hd__decap_12
XFILLER_0_21_615 VGND VGND VPWR VPWR sky130_fd_sc_hd__fill_1
XFILLER_0_21_637 VGND VGND VPWR VPWR sky130_fd_sc_hd__decap_8
XFILLER_0_20_136 VGND VGND VPWR VPWR sky130_fd_sc_hd__fill_1
XTAP_TAPCELL_ROW_111_1959 VGND VPWR sky130_fd_sc_hd__tapvpwrvgnd_1
XTAP_TAPCELL_ROW_53_1088 VGND VPWR sky130_fd_sc_hd__tapvpwrvgnd_1
XTAP_TAPCELL_ROW_53_1099 VGND VPWR sky130_fd_sc_hd__tapvpwrvgnd_1
XFILLER_0_88_648 VGND VGND VPWR VPWR sky130_fd_sc_hd__fill_2
XFILLER_0_87_169 VGND VGND VPWR VPWR sky130_fd_sc_hd__fill_2
XFILLER_0_56_523 VGND VGND VPWR VPWR sky130_fd_sc_hd__fill_1
XFILLER_0_138_293 VPWR VGND VPWR VGND sky130_ef_sc_hd__decap_12
XFILLER_0_113_57 VPWR VGND VPWR VGND sky130_ef_sc_hd__decap_12
XFILLER_0_56_589 VGND VGND VPWR VPWR sky130_fd_sc_hd__decap_4
XFILLER_0_43_206 VGND VGND VPWR VPWR sky130_fd_sc_hd__decap_8
XFILLER_0_44_729 VGND VGND VPWR VPWR sky130_fd_sc_hd__decap_4
XFILLER_0_126_477 VGND VGND VPWR VPWR sky130_fd_sc_hd__fill_1
XFILLER_0_98_15 VPWR VGND VPWR VGND sky130_ef_sc_hd__decap_12
XFILLER_0_71_537 VGND VGND VPWR VPWR sky130_fd_sc_hd__fill_1
XFILLER_0_36_280 VGND VGND VPWR VPWR sky130_fd_sc_hd__fill_2
XFILLER_0_113_105 VGND VGND VPWR VPWR sky130_fd_sc_hd__decap_6
XFILLER_0_4_837 VGND VGND VPWR VPWR sky130_fd_sc_hd__decap_4
XTAP_TAPCELL_ROW_40_893 VGND VPWR sky130_fd_sc_hd__tapvpwrvgnd_1
XFILLER_0_113_149 VPWR VGND VPWR VGND sky130_ef_sc_hd__decap_12
XFILLER_0_51_261 VGND VGND VPWR VPWR sky130_fd_sc_hd__decap_3
XFILLER_0_122_661 VPWR VGND VPWR VGND sky130_ef_sc_hd__decap_12
XFILLER_0_11_125 VPWR VGND VPWR VGND sky130_ef_sc_hd__decap_12
X_6270_ _2963_ rf.registers\[13\]\[25\] _2968_ VGND VGND VPWR VPWR _2969_ sky130_fd_sc_hd__mux2_1
XFILLER_0_121_193 VPWR VGND VPWR VGND sky130_ef_sc_hd__decap_12
XFILLER_0_11_169 VPWR VGND VPWR VGND sky130_ef_sc_hd__decap_12
X_5221_ _1966_ VGND VGND VPWR VPWR net57 sky130_fd_sc_hd__inv_2
X_5152_ _1651_ _1896_ _1898_ _1900_ _1709_ VGND VGND VPWR VPWR _1901_ sky130_fd_sc_hd__a221o_1
XFILLER_0_47_30 VPWR VGND VPWR VGND sky130_ef_sc_hd__decap_12
X_5083_ _1834_ _1835_ _1693_ VGND VGND VPWR VPWR _1836_ sky130_fd_sc_hd__mux2_1
X_8911_ clknet_leaf_74_CLK _1023_ VGND VGND VPWR VPWR rf.registers\[5\]\[30\] sky130_fd_sc_hd__dfxtp_1
XFILLER_0_2_65 VPWR VGND VPWR VGND sky130_ef_sc_hd__decap_12
X_8842_ clknet_leaf_71_CLK _0954_ VGND VGND VPWR VPWR rf.registers\[15\]\[25\] sky130_fd_sc_hd__dfxtp_1
XFILLER_0_66_309 VGND VGND VPWR VPWR sky130_fd_sc_hd__decap_3
XFILLER_0_59_350 VGND VGND VPWR VPWR sky130_fd_sc_hd__fill_1
X_8773_ clknet_leaf_73_CLK _0885_ VGND VGND VPWR VPWR rf.registers\[0\]\[20\] sky130_fd_sc_hd__dfxtp_1
XFILLER_0_137_709 VPWR VGND VPWR VGND sky130_ef_sc_hd__decap_12
XFILLER_0_75_821 VPWR VGND VPWR VGND sky130_ef_sc_hd__decap_12
X_7724_ _3384_ rf.registers\[30\]\[18\] _3781_ VGND VGND VPWR VPWR _3790_ sky130_fd_sc_hd__mux2_1
X_5985_ _2541_ _2694_ _2700_ VGND VGND VPWR VPWR net119 sky130_fd_sc_hd__o21ai_2
X_4936_ rf.registers\[8\]\[3\] rf.registers\[9\]\[3\] rf.registers\[10\]\[3\] rf.registers\[11\]\[3\]
+ _1694_ _1695_ VGND VGND VPWR VPWR _1696_ sky130_fd_sc_hd__mux4_1
XFILLER_0_74_320 VGND VGND VPWR VPWR sky130_fd_sc_hd__fill_1
XFILLER_0_19_225 VGND VGND VPWR VPWR sky130_fd_sc_hd__fill_2
XFILLER_0_129_293 VPWR VGND VPWR VGND sky130_ef_sc_hd__decap_12
X_4867_ net3 VGND VGND VPWR VPWR _1630_ sky130_fd_sc_hd__buf_4
XFILLER_0_90_813 VPWR VGND VPWR VGND sky130_ef_sc_hd__decap_12
X_7655_ rf.registers\[2\]\[18\] _3315_ _3744_ VGND VGND VPWR VPWR _3753_ sky130_fd_sc_hd__mux2_1
XANTENNA_10 net27 VGND VGND VPWR VPWR sky130_fd_sc_hd__diode_2
XFILLER_0_35_729 VGND VGND VPWR VPWR sky130_fd_sc_hd__decap_8
X_6606_ _3169_ VGND VGND VPWR VPWR _0801_ sky130_fd_sc_hd__clkbuf_1
X_7586_ _3716_ VGND VGND VPWR VPWR _0210_ sky130_fd_sc_hd__clkbuf_1
XFILLER_0_6_141 VPWR VGND VPWR VGND sky130_ef_sc_hd__decap_12
X_6537_ _3132_ VGND VGND VPWR VPWR _0769_ sky130_fd_sc_hd__clkbuf_1
XFILLER_0_117_499 VGND VGND VPWR VPWR sky130_fd_sc_hd__fill_1
XTAP_TAPCELL_ROW_115_2026 VGND VPWR sky130_fd_sc_hd__tapvpwrvgnd_1
XTAP_TAPCELL_ROW_99_1781 VGND VPWR sky130_fd_sc_hd__tapvpwrvgnd_1
X_9325_ clknet_leaf_94_CLK _0413_ VGND VGND VPWR VPWR rf.registers\[22\]\[28\] sky130_fd_sc_hd__dfxtp_1
X_4798_ rf.registers\[4\]\[28\] rf.registers\[5\]\[28\] rf.registers\[6\]\[28\] rf.registers\[7\]\[28\]
+ _1382_ _1383_ VGND VGND VPWR VPWR _1565_ sky130_fd_sc_hd__mux4_1
XFILLER_0_43_762 VPWR VGND VPWR VGND sky130_ef_sc_hd__decap_12
XTAP_TAPCELL_ROW_99_1792 VGND VPWR sky130_fd_sc_hd__tapvpwrvgnd_1
XFILLER_0_15_497 VGND VGND VPWR VPWR sky130_fd_sc_hd__decap_6
XFILLER_0_42_250 VGND VGND VPWR VPWR sky130_fd_sc_hd__fill_2
X_6468_ _3095_ VGND VGND VPWR VPWR _0737_ sky130_fd_sc_hd__clkbuf_1
X_9256_ clknet_leaf_2_CLK _0344_ VGND VGND VPWR VPWR rf.registers\[28\]\[23\] sky130_fd_sc_hd__dfxtp_1
X_6399_ rf.registers\[11\]\[1\] _2989_ _3056_ VGND VGND VPWR VPWR _3058_ sky130_fd_sc_hd__mux2_1
X_9187_ clknet_leaf_4_CLK _0275_ VGND VGND VPWR VPWR rf.registers\[30\]\[18\] sky130_fd_sc_hd__dfxtp_1
X_5419_ rf.registers\[28\]\[29\] rf.registers\[29\]\[29\] rf.registers\[30\]\[29\]
+ rf.registers\[31\]\[29\] _1959_ _1960_ VGND VGND VPWR VPWR _2153_ sky130_fd_sc_hd__mux4_1
X_8207_ _4046_ VGND VGND VPWR VPWR _0501_ sky130_fd_sc_hd__clkbuf_1
X_8138_ _3388_ rf.registers\[26\]\[20\] _4009_ VGND VGND VPWR VPWR _4010_ sky130_fd_sc_hd__mux2_1
X_8069_ _3950_ VGND VGND VPWR VPWR _3973_ sky130_fd_sc_hd__buf_4
XTAP_TAPCELL_ROW_126_2188 VGND VPWR sky130_fd_sc_hd__tapvpwrvgnd_1
XFILLER_0_84_139 VGND VGND VPWR VPWR sky130_fd_sc_hd__fill_1
XTAP_TAPCELL_ROW_26_687 VGND VPWR sky130_fd_sc_hd__tapvpwrvgnd_1
XFILLER_0_93_673 VPWR VGND VPWR VGND sky130_ef_sc_hd__decap_12
XFILLER_0_65_375 VGND VGND VPWR VPWR sky130_fd_sc_hd__fill_1
XFILLER_0_38_589 VGND VGND VPWR VPWR sky130_fd_sc_hd__decap_8
XFILLER_0_108_455 VGND VGND VPWR VPWR sky130_fd_sc_hd__fill_2
XFILLER_0_123_447 VGND VGND VPWR VPWR sky130_fd_sc_hd__fill_1
XFILLER_0_80_389 VGND VGND VPWR VPWR sky130_fd_sc_hd__decap_4
XFILLER_0_61_570 VPWR VGND VPWR VGND sky130_ef_sc_hd__decap_12
XFILLER_0_68_29 VGND VGND VPWR VPWR sky130_fd_sc_hd__decap_6
XTAP_TAPCELL_ROW_55_1128 VGND VPWR sky130_fd_sc_hd__tapvpwrvgnd_1
XTAP_TAPCELL_ROW_6_390 VGND VPWR sky130_fd_sc_hd__tapvpwrvgnd_1
XFILLER_0_17_55 VGND VGND VPWR VPWR sky130_fd_sc_hd__fill_1
XFILLER_0_88_412 VGND VGND VPWR VPWR sky130_fd_sc_hd__fill_1
XFILLER_0_88_445 VPWR VGND VPWR VGND sky130_ef_sc_hd__decap_12
XFILLER_0_119_709 VPWR VGND VPWR VGND sky130_ef_sc_hd__decap_12
XFILLER_0_57_821 VPWR VGND VPWR VGND sky130_ef_sc_hd__decap_12
XFILLER_0_130_3 VPWR VGND VPWR VGND sky130_ef_sc_hd__decap_12
X_5770_ _2494_ _2495_ _1076_ VGND VGND VPWR VPWR _2496_ sky130_fd_sc_hd__o21a_1
XTAP_TAPCELL_ROW_45_974 VGND VPWR sky130_fd_sc_hd__tapvpwrvgnd_1
XFILLER_0_84_684 VPWR VGND VPWR VGND sky130_ef_sc_hd__decap_12
XFILLER_0_72_813 VPWR VGND VPWR VGND sky130_ef_sc_hd__decap_12
X_4721_ _1492_ VGND VGND VPWR VPWR net96 sky130_fd_sc_hd__inv_2
XFILLER_0_17_729 VPWR VGND VPWR VGND sky130_ef_sc_hd__decap_12
XFILLER_0_127_753 VPWR VGND VPWR VGND sky130_ef_sc_hd__decap_12
X_7440_ _3639_ VGND VGND VPWR VPWR _0141_ sky130_fd_sc_hd__clkbuf_1
X_4652_ _1422_ _1424_ _1427_ _1301_ _1307_ VGND VGND VPWR VPWR _1428_ sky130_fd_sc_hd__a221o_1
XFILLER_0_4_601 VPWR VGND VPWR VGND sky130_ef_sc_hd__decap_12
XFILLER_0_127_797 VPWR VGND VPWR VGND sky130_ef_sc_hd__decap_12
XFILLER_0_3_111 VGND VGND VPWR VPWR sky130_fd_sc_hd__fill_1
Xinput30 WD3[24] VGND VGND VPWR VPWR net30 sky130_fd_sc_hd__clkbuf_2
Xinput41 WD3[5] VGND VGND VPWR VPWR net41 sky130_fd_sc_hd__buf_2
X_7371_ _3602_ VGND VGND VPWR VPWR _0109_ sky130_fd_sc_hd__clkbuf_1
X_4583_ _1197_ _1361_ VGND VGND VPWR VPWR _1362_ sky130_fd_sc_hd__nand2_1
X_9110_ clknet_leaf_59_CLK _0198_ VGND VGND VPWR VPWR rf.registers\[27\]\[5\] sky130_fd_sc_hd__dfxtp_1
XFILLER_0_12_401 VPWR VGND VPWR VGND sky130_ef_sc_hd__decap_12
XFILLER_0_4_645 VPWR VGND VPWR VGND sky130_ef_sc_hd__decap_12
X_6322_ net45 VGND VGND VPWR VPWR _3005_ sky130_fd_sc_hd__clkbuf_2
XFILLER_0_101_108 VGND VGND VPWR VPWR sky130_fd_sc_hd__fill_1
XFILLER_0_52_592 VGND VGND VPWR VPWR sky130_fd_sc_hd__decap_3
XFILLER_0_12_445 VPWR VGND VPWR VGND sky130_ef_sc_hd__decap_12
XFILLER_0_40_732 VGND VGND VPWR VPWR sky130_fd_sc_hd__decap_4
X_9041_ clknet_leaf_39_CLK _0129_ VGND VGND VPWR VPWR rf.registers\[29\]\[0\] sky130_fd_sc_hd__dfxtp_1
X_6253_ _1599_ _2941_ _2709_ VGND VGND VPWR VPWR _2953_ sky130_fd_sc_hd__a21o_1
XFILLER_0_12_489 VPWR VGND VPWR VGND sky130_ef_sc_hd__decap_12
X_5204_ _1744_ VGND VGND VPWR VPWR _1950_ sky130_fd_sc_hd__buf_4
XFILLER_0_110_686 VPWR VGND VPWR VGND sky130_ef_sc_hd__decap_12
X_6184_ net68 _2887_ VGND VGND VPWR VPWR _2888_ sky130_fd_sc_hd__nor2_1
X_5135_ rf.registers\[0\]\[13\] rf.registers\[1\]\[13\] rf.registers\[2\]\[13\] rf.registers\[3\]\[13\]
+ _1816_ _1817_ VGND VGND VPWR VPWR _1885_ sky130_fd_sc_hd__mux4_1
X_5066_ rf.registers\[0\]\[9\] rf.registers\[1\]\[9\] rf.registers\[2\]\[9\] rf.registers\[3\]\[9\]
+ _1734_ _1797_ VGND VGND VPWR VPWR _1820_ sky130_fd_sc_hd__mux4_1
XFILLER_0_74_83 VGND VGND VPWR VPWR sky130_fd_sc_hd__fill_1
X_8825_ clknet_leaf_46_CLK _0937_ VGND VGND VPWR VPWR rf.registers\[15\]\[8\] sky130_fd_sc_hd__dfxtp_1
XFILLER_0_67_629 VPWR VGND VPWR VGND sky130_ef_sc_hd__decap_12
XFILLER_0_137_517 VPWR VGND VPWR VGND sky130_ef_sc_hd__decap_12
X_8756_ clknet_leaf_41_CLK _0868_ VGND VGND VPWR VPWR rf.registers\[0\]\[3\] sky130_fd_sc_hd__dfxtp_1
X_5968_ _2296_ _2527_ VGND VGND VPWR VPWR _2685_ sky130_fd_sc_hd__or2_1
X_4919_ _1678_ _1679_ _1630_ VGND VGND VPWR VPWR _1680_ sky130_fd_sc_hd__mux2_1
XFILLER_0_75_673 VPWR VGND VPWR VGND sky130_ef_sc_hd__decap_12
X_7707_ _3769_ VGND VGND VPWR VPWR _3781_ sky130_fd_sc_hd__clkbuf_8
XTAP_TAPCELL_ROW_23_646 VGND VPWR sky130_fd_sc_hd__tapvpwrvgnd_1
XFILLER_0_90_643 VGND VGND VPWR VPWR sky130_fd_sc_hd__fill_1
XFILLER_0_90_632 VGND VGND VPWR VPWR sky130_fd_sc_hd__fill_2
XFILLER_0_74_161 VGND VGND VPWR VPWR sky130_fd_sc_hd__fill_1
X_8687_ clknet_leaf_61_CLK _0799_ VGND VGND VPWR VPWR rf.registers\[1\]\[30\] sky130_fd_sc_hd__dfxtp_1
X_5899_ _2619_ VGND VGND VPWR VPWR net114 sky130_fd_sc_hd__clkbuf_1
XFILLER_0_35_526 VGND VGND VPWR VPWR sky130_fd_sc_hd__decap_8
XFILLER_0_90_654 VGND VGND VPWR VPWR sky130_fd_sc_hd__fill_2
X_7638_ _3732_ VGND VGND VPWR VPWR _3744_ sky130_fd_sc_hd__buf_4
XFILLER_0_7_461 VPWR VGND VPWR VGND sky130_ef_sc_hd__decap_12
XFILLER_0_132_233 VPWR VGND VPWR VGND sky130_ef_sc_hd__decap_12
XFILLER_0_90_698 VGND VGND VPWR VPWR sky130_fd_sc_hd__fill_2
X_7569_ _3707_ VGND VGND VPWR VPWR _0202_ sky130_fd_sc_hd__clkbuf_1
XFILLER_0_15_261 VPWR VGND VPWR VGND sky130_ef_sc_hd__decap_12
XFILLER_0_132_277 VPWR VGND VPWR VGND sky130_ef_sc_hd__decap_12
X_9308_ clknet_leaf_27_CLK _0396_ VGND VGND VPWR VPWR rf.registers\[22\]\[11\] sky130_fd_sc_hd__dfxtp_1
XFILLER_0_31_732 VGND VGND VPWR VPWR sky130_fd_sc_hd__fill_1
X_9239_ clknet_leaf_32_CLK _0327_ VGND VGND VPWR VPWR rf.registers\[28\]\[6\] sky130_fd_sc_hd__dfxtp_1
XFILLER_0_30_253 VGND VGND VPWR VPWR sky130_fd_sc_hd__fill_2
XFILLER_0_100_141 VGND VGND VPWR VPWR sky130_fd_sc_hd__fill_1
XFILLER_0_30_297 VGND VGND VPWR VPWR sky130_fd_sc_hd__decap_4
XTAP_TAPCELL_ROW_128_2217 VGND VPWR sky130_fd_sc_hd__tapvpwrvgnd_1
XFILLER_0_101_697 VPWR VGND VPWR VGND sky130_ef_sc_hd__decap_12
XTAP_TAPCELL_ROW_50_1047 VGND VPWR sky130_fd_sc_hd__tapvpwrvgnd_1
XFILLER_0_85_415 VPWR VGND VPWR VGND sky130_ef_sc_hd__decap_12
XFILLER_0_39_821 VPWR VGND VPWR VGND sky130_ef_sc_hd__decap_12
XFILLER_0_54_813 VPWR VGND VPWR VGND sky130_ef_sc_hd__decap_12
XTAP_TAPCELL_ROW_42_933 VGND VPWR sky130_fd_sc_hd__tapvpwrvgnd_1
XFILLER_0_124_701 VPWR VGND VPWR VGND sky130_ef_sc_hd__decap_12
XFILLER_0_109_753 VPWR VGND VPWR VGND sky130_ef_sc_hd__decap_12
XFILLER_0_109_797 VPWR VGND VPWR VGND sky130_ef_sc_hd__decap_12
XFILLER_0_80_120 VGND VGND VPWR VPWR sky130_fd_sc_hd__decap_6
XFILLER_0_22_710 VGND VGND VPWR VPWR sky130_fd_sc_hd__decap_3
XFILLER_0_1_615 VGND VGND VPWR VPWR sky130_fd_sc_hd__fill_1
XFILLER_0_22_743 VGND VGND VPWR VPWR sky130_fd_sc_hd__fill_2
XFILLER_0_22_754 VGND VGND VPWR VPWR sky130_fd_sc_hd__fill_2
XFILLER_0_104_491 VGND VGND VPWR VPWR sky130_fd_sc_hd__fill_1
XFILLER_0_21_242 VGND VGND VPWR VPWR sky130_fd_sc_hd__fill_1
XFILLER_0_22_787 VPWR VGND VPWR VGND sky130_ef_sc_hd__decap_12
X_6940_ _3366_ VGND VGND VPWR VPWR _0938_ sky130_fd_sc_hd__clkbuf_1
XFILLER_0_89_721 VGND VGND VPWR VPWR sky130_fd_sc_hd__decap_6
XTAP_TAPCELL_ROW_68_1319 VGND VPWR sky130_fd_sc_hd__tapvpwrvgnd_1
XTAP_TAPCELL_ROW_1_308 VGND VPWR sky130_fd_sc_hd__tapvpwrvgnd_1
XTAP_TAPCELL_ROW_1_319 VGND VPWR sky130_fd_sc_hd__tapvpwrvgnd_1
XFILLER_0_135_55 VGND VGND VPWR VPWR sky130_fd_sc_hd__fill_1
XFILLER_0_89_765 VPWR VGND VPWR VGND sky130_ef_sc_hd__decap_12
XTAP_TAPCELL_ROW_81_1508 VGND VPWR sky130_fd_sc_hd__tapvpwrvgnd_1
X_6871_ net26 VGND VGND VPWR VPWR _3319_ sky130_fd_sc_hd__buf_2
XTAP_TAPCELL_ROW_81_1519 VGND VPWR sky130_fd_sc_hd__tapvpwrvgnd_1
X_8610_ clknet_leaf_12_CLK _0722_ VGND VGND VPWR VPWR rf.registers\[11\]\[17\] sky130_fd_sc_hd__dfxtp_1
XFILLER_0_57_640 VPWR VGND VPWR VGND sky130_ef_sc_hd__decap_12
X_5822_ _2545_ VGND VGND VPWR VPWR _2546_ sky130_fd_sc_hd__inv_2
X_8541_ _4222_ VGND VGND VPWR VPWR _0659_ sky130_fd_sc_hd__clkbuf_1
XFILLER_0_57_673 VPWR VGND VPWR VGND sky130_ef_sc_hd__decap_12
X_5753_ _2392_ VGND VGND VPWR VPWR _2479_ sky130_fd_sc_hd__buf_2
XFILLER_0_115_701 VPWR VGND VPWR VGND sky130_ef_sc_hd__decap_12
XFILLER_0_72_632 VGND VGND VPWR VPWR sky130_fd_sc_hd__decap_3
XFILLER_0_60_41 VPWR VGND VPWR VGND sky130_ef_sc_hd__decap_12
X_4704_ _1476_ VGND VGND VPWR VPWR net95 sky130_fd_sc_hd__buf_2
XTAP_TAPCELL_ROW_20_605 VGND VPWR sky130_fd_sc_hd__tapvpwrvgnd_1
X_8472_ _4186_ VGND VGND VPWR VPWR _0626_ sky130_fd_sc_hd__clkbuf_1
XFILLER_0_60_805 VGND VGND VPWR VPWR sky130_fd_sc_hd__decap_6
XFILLER_0_60_85 VGND VGND VPWR VPWR sky130_fd_sc_hd__decap_4
X_5684_ _2320_ _2404_ _2408_ _2412_ _2398_ VGND VGND VPWR VPWR _2413_ sky130_fd_sc_hd__o221a_1
X_7423_ _3630_ VGND VGND VPWR VPWR _0133_ sky130_fd_sc_hd__clkbuf_1
XFILLER_0_72_687 VPWR VGND VPWR VGND sky130_ef_sc_hd__decap_12
XFILLER_0_71_175 VGND VGND VPWR VPWR sky130_fd_sc_hd__fill_1
XFILLER_0_71_153 VGND VGND VPWR VPWR sky130_fd_sc_hd__decap_6
X_4635_ rf.registers\[0\]\[18\] rf.registers\[1\]\[18\] rf.registers\[2\]\[18\] rf.registers\[3\]\[18\]
+ _1410_ _1411_ VGND VGND VPWR VPWR _1412_ sky130_fd_sc_hd__mux4_1
XFILLER_0_44_389 VGND VGND VPWR VPWR sky130_fd_sc_hd__decap_3
X_4566_ rf.registers\[28\]\[15\] rf.registers\[29\]\[15\] rf.registers\[30\]\[15\]
+ rf.registers\[31\]\[15\] _1294_ _1295_ VGND VGND VPWR VPWR _1346_ sky130_fd_sc_hd__mux4_1
XFILLER_0_102_417 VGND VGND VPWR VPWR sky130_fd_sc_hd__decap_3
XTAP_TAPCELL_ROW_96_1740 VGND VPWR sky130_fd_sc_hd__tapvpwrvgnd_1
X_7354_ _3593_ VGND VGND VPWR VPWR _0101_ sky130_fd_sc_hd__clkbuf_1
XFILLER_0_8_53 VPWR VGND VPWR VGND sky130_ef_sc_hd__decap_12
XFILLER_0_4_475 VGND VGND VPWR VPWR sky130_fd_sc_hd__fill_1
XFILLER_0_130_737 VPWR VGND VPWR VGND sky130_ef_sc_hd__decap_12
X_6305_ rf.registers\[12\]\[3\] _2993_ _2987_ VGND VGND VPWR VPWR _2994_ sky130_fd_sc_hd__mux2_1
XFILLER_0_12_253 VPWR VGND VPWR VGND sky130_ef_sc_hd__decap_12
XFILLER_0_8_97 VPWR VGND VPWR VGND sky130_ef_sc_hd__decap_12
X_4497_ _1116_ _1272_ _1276_ _1280_ VGND VGND VPWR VPWR _1281_ sky130_fd_sc_hd__o22a_1
X_7285_ rf.registers\[3\]\[4\] _3286_ _3552_ VGND VGND VPWR VPWR _3557_ sky130_fd_sc_hd__mux2_1
X_9024_ clknet_leaf_18_CLK _0112_ VGND VGND VPWR VPWR rf.registers\[8\]\[15\] sky130_fd_sc_hd__dfxtp_1
X_6236_ _2920_ _2869_ _2936_ VGND VGND VPWR VPWR _2937_ sky130_fd_sc_hd__o21ai_1
XFILLER_0_85_71 VPWR VGND VPWR VGND sky130_ef_sc_hd__decap_12
X_6167_ _2318_ _2869_ _2871_ VGND VGND VPWR VPWR _2872_ sky130_fd_sc_hd__o21bai_2
X_5118_ rf.registers\[0\]\[12\] rf.registers\[1\]\[12\] rf.registers\[2\]\[12\] rf.registers\[3\]\[12\]
+ _1816_ _1817_ VGND VGND VPWR VPWR _1869_ sky130_fd_sc_hd__mux4_1
X_6098_ _2560_ _2806_ VGND VGND VPWR VPWR _2807_ sky130_fd_sc_hd__nor2_1
XTAP_TAPCELL_ROW_123_2147 VGND VPWR sky130_fd_sc_hd__tapvpwrvgnd_1
X_5049_ rf.registers\[0\]\[8\] rf.registers\[1\]\[8\] rf.registers\[2\]\[8\] rf.registers\[3\]\[8\]
+ _1694_ _1704_ VGND VGND VPWR VPWR _1804_ sky130_fd_sc_hd__mux4_1
XTAP_TAPCELL_ROW_28_716 VGND VPWR sky130_fd_sc_hd__tapvpwrvgnd_1
XTAP_TAPCELL_ROW_28_727 VGND VPWR sky130_fd_sc_hd__tapvpwrvgnd_1
XFILLER_0_79_264 VGND VGND VPWR VPWR sky130_fd_sc_hd__decap_3
XFILLER_0_67_415 VGND VGND VPWR VPWR sky130_fd_sc_hd__decap_4
XFILLER_0_39_128 VGND VGND VPWR VPWR sky130_fd_sc_hd__decap_3
X_8808_ clknet_leaf_1_CLK _0920_ VGND VGND VPWR VPWR rf.registers\[16\]\[23\] sky130_fd_sc_hd__dfxtp_1
XTAP_TAPCELL_ROW_105_1880 VGND VPWR sky130_fd_sc_hd__tapvpwrvgnd_1
XFILLER_0_48_640 VGND VGND VPWR VPWR sky130_fd_sc_hd__decap_4
XFILLER_0_36_813 VPWR VGND VPWR VGND sky130_ef_sc_hd__decap_12
XFILLER_0_75_470 VGND VGND VPWR VPWR sky130_fd_sc_hd__decap_8
X_8739_ clknet_leaf_6_CLK _0851_ VGND VGND VPWR VPWR rf.registers\[10\]\[18\] sky130_fd_sc_hd__dfxtp_1
XFILLER_0_47_161 VGND VGND VPWR VPWR sky130_fd_sc_hd__decap_6
XFILLER_0_106_701 VPWR VGND VPWR VGND sky130_ef_sc_hd__decap_12
XFILLER_0_8_781 VPWR VGND VPWR VGND sky130_ef_sc_hd__decap_12
XTAP_TAPCELL_ROW_138_2390 VGND VPWR sky130_fd_sc_hd__tapvpwrvgnd_1
XFILLER_0_105_222 VGND VGND VPWR VPWR sky130_fd_sc_hd__fill_2
XFILLER_0_23_529 VPWR VGND VPWR VGND sky130_ef_sc_hd__decap_12
XFILLER_0_62_197 VGND VGND VPWR VPWR sky130_fd_sc_hd__fill_2
XFILLER_0_50_326 VGND VGND VPWR VPWR sky130_fd_sc_hd__fill_1
XFILLER_0_16_581 VGND VGND VPWR VPWR sky130_fd_sc_hd__decap_6
XFILLER_0_86_713 VPWR VGND VPWR VGND sky130_ef_sc_hd__decap_12
XFILLER_0_86_757 VPWR VGND VPWR VGND sky130_ef_sc_hd__decap_12
XFILLER_0_105_69 VGND VGND VPWR VPWR sky130_fd_sc_hd__decap_8
XFILLER_0_73_418 VPWR VGND VPWR VGND sky130_ef_sc_hd__decap_12
XTAP_TAPCELL_ROW_63_1249 VGND VPWR sky130_fd_sc_hd__tapvpwrvgnd_1
XTAP_TAPCELL_ROW_63_1238 VGND VPWR sky130_fd_sc_hd__tapvpwrvgnd_1
XFILLER_0_39_673 VGND VGND VPWR VPWR sky130_fd_sc_hd__decap_8
XFILLER_0_109_572 VGND VGND VPWR VPWR sky130_fd_sc_hd__fill_2
XFILLER_0_54_643 VGND VGND VPWR VPWR sky130_fd_sc_hd__fill_1
XFILLER_0_53_120 VGND VGND VPWR VPWR sky130_fd_sc_hd__fill_1
XFILLER_0_5_217 VGND VGND VPWR VPWR sky130_fd_sc_hd__decap_6
XFILLER_0_124_542 VGND VGND VPWR VPWR sky130_fd_sc_hd__fill_1
XFILLER_0_121_57 VPWR VGND VPWR VGND sky130_ef_sc_hd__decap_12
X_4420_ _1206_ _1207_ _1163_ VGND VGND VPWR VPWR _1208_ sky130_fd_sc_hd__mux2_1
XFILLER_0_112_737 VPWR VGND VPWR VGND sky130_ef_sc_hd__decap_12
XTAP_TAPCELL_ROW_78_1470 VGND VPWR sky130_fd_sc_hd__tapvpwrvgnd_1
X_4351_ _1137_ _1141_ VGND VGND VPWR VPWR _1142_ sky130_fd_sc_hd__or2_1
XFILLER_0_10_735 VPWR VGND VPWR VGND sky130_ef_sc_hd__decap_12
XFILLER_0_39_31 VPWR VGND VPWR VGND sky130_ef_sc_hd__decap_12
XFILLER_0_120_781 VPWR VGND VPWR VGND sky130_ef_sc_hd__decap_12
X_7070_ _3442_ VGND VGND VPWR VPWR _0992_ sky130_fd_sc_hd__clkbuf_1
XFILLER_0_10_757 VPWR VGND VPWR VGND sky130_ef_sc_hd__decap_12
X_4282_ _1075_ VGND VGND VPWR VPWR _1076_ sky130_fd_sc_hd__buf_2
XTAP_TAPCELL_ROW_91_1670 VGND VPWR sky130_fd_sc_hd__tapvpwrvgnd_1
X_6021_ _1966_ _2732_ VGND VGND VPWR VPWR _2735_ sky130_fd_sc_hd__nor2_1
X_7972_ _3359_ rf.registers\[22\]\[6\] _3915_ VGND VGND VPWR VPWR _3922_ sky130_fd_sc_hd__mux2_1
X_6923_ net40 VGND VGND VPWR VPWR _3355_ sky130_fd_sc_hd__clkbuf_2
X_6854_ rf.registers\[16\]\[14\] _3307_ _3299_ VGND VGND VPWR VPWR _3308_ sky130_fd_sc_hd__mux2_1
XFILLER_0_76_267 VGND VGND VPWR VPWR sky130_fd_sc_hd__fill_1
XFILLER_0_49_459 VGND VGND VPWR VPWR sky130_fd_sc_hd__fill_2
XFILLER_0_92_749 VGND VGND VPWR VPWR sky130_fd_sc_hd__decap_6
XFILLER_0_71_84 VGND VGND VPWR VPWR sky130_fd_sc_hd__decap_4
X_9573_ clknet_leaf_9_CLK _0661_ VGND VGND VPWR VPWR rf.registers\[13\]\[20\] sky130_fd_sc_hd__dfxtp_1
X_5805_ _2463_ _2524_ _2529_ _2326_ VGND VGND VPWR VPWR _2530_ sky130_fd_sc_hd__o211a_1
XFILLER_0_18_813 VPWR VGND VPWR VGND sky130_ef_sc_hd__decap_12
X_6785_ _3264_ VGND VGND VPWR VPWR _0885_ sky130_fd_sc_hd__clkbuf_1
XFILLER_0_45_621 VGND VGND VPWR VPWR sky130_fd_sc_hd__fill_2
X_8524_ _4213_ VGND VGND VPWR VPWR _0651_ sky130_fd_sc_hd__clkbuf_1
XFILLER_0_72_440 VGND VGND VPWR VPWR sky130_fd_sc_hd__decap_8
XFILLER_0_9_589 VGND VGND VPWR VPWR sky130_fd_sc_hd__decap_6
X_5736_ _1113_ _2462_ VGND VGND VPWR VPWR _2463_ sky130_fd_sc_hd__nand2_4
XTAP_TAPCELL_ROW_33_796 VGND VPWR sky130_fd_sc_hd__tapvpwrvgnd_1
X_8455_ _4177_ VGND VGND VPWR VPWR _0618_ sky130_fd_sc_hd__clkbuf_1
X_5667_ _2321_ _2396_ VGND VGND VPWR VPWR _2397_ sky130_fd_sc_hd__xnor2_1
X_4618_ rf.registers\[20\]\[18\] rf.registers\[21\]\[18\] rf.registers\[22\]\[18\]
+ rf.registers\[23\]\[18\] _1393_ _1394_ VGND VGND VPWR VPWR _1395_ sky130_fd_sc_hd__mux4_1
XFILLER_0_60_657 VPWR VGND VPWR VGND sky130_ef_sc_hd__decap_12
X_7406_ _3620_ VGND VGND VPWR VPWR _0126_ sky130_fd_sc_hd__clkbuf_1
X_8386_ rf.registers\[18\]\[9\] net45 _4131_ VGND VGND VPWR VPWR _4141_ sky130_fd_sc_hd__mux2_1
X_5598_ _1902_ _2207_ _2243_ VGND VGND VPWR VPWR _2328_ sky130_fd_sc_hd__o21ai_1
X_4549_ _1173_ VGND VGND VPWR VPWR _1330_ sky130_fd_sc_hd__buf_4
XFILLER_0_13_573 VGND VGND VPWR VPWR sky130_fd_sc_hd__fill_2
X_7337_ rf.registers\[3\]\[29\] _3338_ _3574_ VGND VGND VPWR VPWR _3584_ sky130_fd_sc_hd__mux2_1
X_7268_ _3547_ VGND VGND VPWR VPWR _0061_ sky130_fd_sc_hd__clkbuf_1
X_9007_ clknet_leaf_74_CLK _0095_ VGND VGND VPWR VPWR rf.registers\[3\]\[30\] sky130_fd_sc_hd__dfxtp_1
X_6219_ net81 _2283_ _2381_ VGND VGND VPWR VPWR _2921_ sky130_fd_sc_hd__a21oi_1
X_7199_ rf.registers\[4\]\[28\] _3336_ _3502_ VGND VGND VPWR VPWR _3511_ sky130_fd_sc_hd__mux2_1
XFILLER_0_68_713 VGND VGND VPWR VPWR sky130_fd_sc_hd__decap_6
XFILLER_0_68_757 VPWR VGND VPWR VGND sky130_ef_sc_hd__decap_12
XFILLER_0_68_746 VGND VGND VPWR VPWR sky130_fd_sc_hd__decap_8
XFILLER_0_138_645 VGND VGND VPWR VPWR sky130_fd_sc_hd__decap_6
XFILLER_0_137_111 VGND VGND VPWR VPWR sky130_fd_sc_hd__fill_1
XTAP_TAPCELL_ROW_103_1839 VGND VPWR sky130_fd_sc_hd__tapvpwrvgnd_1
XFILLER_0_83_727 VGND VGND VPWR VPWR sky130_fd_sc_hd__fill_1
XFILLER_0_82_215 VGND VGND VPWR VPWR sky130_fd_sc_hd__decap_3
XFILLER_0_67_278 VGND VGND VPWR VPWR sky130_fd_sc_hd__fill_2
XFILLER_0_125_317 VPWR VGND VPWR VGND sky130_ef_sc_hd__decap_12
XTAP_TAPCELL_ROW_136_2338 VGND VPWR sky130_fd_sc_hd__tapvpwrvgnd_1
XFILLER_0_106_531 VGND VGND VPWR VPWR sky130_fd_sc_hd__fill_1
XFILLER_0_51_602 VPWR VGND VPWR VGND sky130_ef_sc_hd__decap_12
XFILLER_0_133_361 VPWR VGND VPWR VGND sky130_ef_sc_hd__decap_12
XFILLER_0_90_281 VGND VGND VPWR VPWR sky130_fd_sc_hd__fill_2
Xclkload19 clknet_leaf_3_CLK VGND VGND VPWR VPWR clkload19/Y sky130_fd_sc_hd__inv_6
XTAP_TAPCELL_ROW_11_468 VGND VPWR sky130_fd_sc_hd__tapvpwrvgnd_1
XFILLER_0_2_209 VPWR VGND VPWR VGND sky130_ef_sc_hd__decap_12
XFILLER_0_50_145 VGND VGND VPWR VPWR sky130_fd_sc_hd__fill_1
XFILLER_0_102_781 VPWR VGND VPWR VGND sky130_ef_sc_hd__decap_12
XFILLER_0_76_29 VPWR VGND VPWR VGND sky130_ef_sc_hd__decap_12
XTAP_TAPCELL_ROW_19_579 VGND VPWR sky130_fd_sc_hd__tapvpwrvgnd_1
XFILLER_0_25_77 VGND VGND VPWR VPWR sky130_fd_sc_hd__fill_1
XFILLER_0_128_133 VGND VGND VPWR VPWR sky130_fd_sc_hd__decap_6
XFILLER_0_74_749 VGND VGND VPWR VPWR sky130_fd_sc_hd__decap_6
XFILLER_0_18_109 VPWR VGND VPWR VGND sky130_ef_sc_hd__decap_12
XFILLER_0_27_621 VGND VGND VPWR VPWR sky130_fd_sc_hd__fill_1
XFILLER_0_128_177 VPWR VGND VPWR VGND sky130_ef_sc_hd__decap_12
X_6570_ _3149_ VGND VGND VPWR VPWR _0785_ sky130_fd_sc_hd__clkbuf_1
XFILLER_0_73_237 VGND VGND VPWR VPWR sky130_fd_sc_hd__decap_8
XFILLER_0_41_43 VGND VGND VPWR VPWR sky130_fd_sc_hd__fill_1
XTAP_TAPCELL_ROW_30_744 VGND VPWR sky130_fd_sc_hd__tapvpwrvgnd_1
XTAP_TAPCELL_ROW_30_755 VGND VPWR sky130_fd_sc_hd__tapvpwrvgnd_1
X_5521_ _1075_ _2219_ _2251_ VGND VGND VPWR VPWR _2252_ sky130_fd_sc_hd__or3_2
X_8240_ _2995_ rf.registers\[25\]\[4\] _4059_ VGND VGND VPWR VPWR _4064_ sky130_fd_sc_hd__mux2_1
XFILLER_0_82_793 VPWR VGND VPWR VGND sky130_ef_sc_hd__decap_12
XFILLER_0_81_281 VGND VGND VPWR VPWR sky130_fd_sc_hd__decap_3
X_5452_ _2180_ _2181_ _2182_ _2183_ _2074_ _1958_ VGND VGND VPWR VPWR _2184_ sky130_fd_sc_hd__mux4_2
X_8171_ _4027_ VGND VGND VPWR VPWR _0484_ sky130_fd_sc_hd__clkbuf_1
XFILLER_0_67_6 VPWR VGND VPWR VGND sky130_ef_sc_hd__decap_12
X_4403_ _1128_ VGND VGND VPWR VPWR _1192_ sky130_fd_sc_hd__buf_4
X_5383_ _2119_ VGND VGND VPWR VPWR net67 sky130_fd_sc_hd__inv_2
X_4334_ _1118_ VGND VGND VPWR VPWR _1125_ sky130_fd_sc_hd__clkbuf_8
X_7122_ _3470_ VGND VGND VPWR VPWR _1016_ sky130_fd_sc_hd__clkbuf_1
XFILLER_0_10_587 VGND VGND VPWR VPWR sky130_fd_sc_hd__fill_1
X_7053_ rf.registers\[6\]\[23\] _3326_ _3430_ VGND VGND VPWR VPWR _3434_ sky130_fd_sc_hd__mux2_1
X_4265_ _1057_ _1058_ _1030_ VGND VGND VPWR VPWR _1059_ sky130_fd_sc_hd__mux2_1
X_6004_ _2637_ _2718_ _2416_ VGND VGND VPWR VPWR _2719_ sky130_fd_sc_hd__mux2_1
XFILLER_0_96_307 VGND VGND VPWR VPWR sky130_fd_sc_hd__fill_1
XTAP_TAPCELL_ROW_120_2106 VGND VPWR sky130_fd_sc_hd__tapvpwrvgnd_1
XTAP_TAPCELL_ROW_38_866 VGND VPWR sky130_fd_sc_hd__tapvpwrvgnd_1
XTAP_TAPCELL_ROW_38_877 VGND VPWR sky130_fd_sc_hd__tapvpwrvgnd_1
X_7955_ _3912_ VGND VGND VPWR VPWR _0383_ sky130_fd_sc_hd__clkbuf_1
XFILLER_0_119_111 VGND VGND VPWR VPWR sky130_fd_sc_hd__fill_1
X_7886_ _3875_ VGND VGND VPWR VPWR _0351_ sky130_fd_sc_hd__clkbuf_1
X_6906_ rf.registers\[16\]\[31\] _3342_ _3277_ VGND VGND VPWR VPWR _3343_ sky130_fd_sc_hd__mux2_1
X_6837_ net45 VGND VGND VPWR VPWR _3296_ sky130_fd_sc_hd__buf_2
XFILLER_0_135_615 VGND VGND VPWR VPWR sky130_fd_sc_hd__fill_1
X_9556_ clknet_leaf_36_CLK _0644_ VGND VGND VPWR VPWR rf.registers\[13\]\[3\] sky130_fd_sc_hd__dfxtp_1
XFILLER_0_18_643 VGND VGND VPWR VPWR sky130_fd_sc_hd__fill_1
XFILLER_0_45_440 VGND VGND VPWR VPWR sky130_fd_sc_hd__decap_8
X_8507_ _4204_ VGND VGND VPWR VPWR _0643_ sky130_fd_sc_hd__clkbuf_1
X_6768_ _3255_ VGND VGND VPWR VPWR _0877_ sky130_fd_sc_hd__clkbuf_1
XFILLER_0_45_462 VGND VGND VPWR VPWR sky130_fd_sc_hd__decap_4
XFILLER_0_122_309 VPWR VGND VPWR VGND sky130_ef_sc_hd__decap_12
XTAP_TAPCELL_ROW_118_2068 VGND VPWR sky130_fd_sc_hd__tapvpwrvgnd_1
XFILLER_0_115_350 VGND VGND VPWR VPWR sky130_fd_sc_hd__decap_4
X_6699_ rf.registers\[10\]\[12\] _3012_ _3216_ VGND VGND VPWR VPWR _3219_ sky130_fd_sc_hd__mux2_1
XFILLER_0_60_421 VGND VGND VPWR VPWR sky130_fd_sc_hd__decap_3
X_5719_ _2335_ _2344_ _2234_ VGND VGND VPWR VPWR _2447_ sky130_fd_sc_hd__mux2_1
XFILLER_0_32_101 VGND VGND VPWR VPWR sky130_fd_sc_hd__fill_2
XFILLER_0_33_635 VPWR VGND VPWR VGND sky130_ef_sc_hd__decap_12
X_9487_ clknet_leaf_67_CLK _0575_ VGND VGND VPWR VPWR rf.registers\[20\]\[30\] sky130_fd_sc_hd__dfxtp_1
XFILLER_0_131_821 VPWR VGND VPWR VGND sky130_ef_sc_hd__decap_12
X_8438_ _2989_ rf.registers\[14\]\[1\] _4167_ VGND VGND VPWR VPWR _4169_ sky130_fd_sc_hd__mux2_1
X_8369_ _4132_ VGND VGND VPWR VPWR _0577_ sky130_fd_sc_hd__clkbuf_1
XFILLER_0_103_545 VGND VGND VPWR VPWR sky130_fd_sc_hd__fill_1
XTAP_TAPCELL_ROW_131_2268 VGND VPWR sky130_fd_sc_hd__tapvpwrvgnd_1
XTAP_TAPCELL_ROW_113_1990 VGND VPWR sky130_fd_sc_hd__tapvpwrvgnd_1
XTAP_TAPCELL_ROW_47_1008 VGND VPWR sky130_fd_sc_hd__tapvpwrvgnd_1
XFILLER_0_95_351 VGND VGND VPWR VPWR sky130_fd_sc_hd__decap_6
XTAP_TAPCELL_ROW_16_538 VGND VPWR sky130_fd_sc_hd__tapvpwrvgnd_1
XFILLER_0_56_749 VGND VGND VPWR VPWR sky130_fd_sc_hd__decap_6
XFILLER_0_55_259 VGND VGND VPWR VPWR sky130_fd_sc_hd__fill_1
XFILLER_0_125_125 VPWR VGND VPWR VGND sky130_ef_sc_hd__decap_12
XFILLER_0_102_15 VPWR VGND VPWR VGND sky130_ef_sc_hd__decap_12
XFILLER_0_125_169 VPWR VGND VPWR VGND sky130_ef_sc_hd__decap_12
XFILLER_0_64_793 VPWR VGND VPWR VGND sky130_ef_sc_hd__decap_12
XFILLER_0_63_281 VGND VGND VPWR VPWR sky130_fd_sc_hd__decap_6
XFILLER_0_11_57 VPWR VGND VPWR VGND sky130_ef_sc_hd__decap_12
XFILLER_0_134_681 VPWR VGND VPWR VGND sky130_ef_sc_hd__decap_12
XFILLER_0_3_529 VPWR VGND VPWR VGND sky130_ef_sc_hd__decap_12
XFILLER_0_11_329 VGND VGND VPWR VPWR sky130_fd_sc_hd__decap_6
XTAP_TAPCELL_ROW_71_1359 VGND VPWR sky130_fd_sc_hd__tapvpwrvgnd_1
Xinput6 A2[2] VGND VGND VPWR VPWR net6 sky130_fd_sc_hd__buf_2
XFILLER_0_87_841 VGND VGND VPWR VPWR sky130_fd_sc_hd__fill_1
XTAP_TAPCELL_ROW_86_1591 VGND VPWR sky130_fd_sc_hd__tapvpwrvgnd_1
X_4952_ _1711_ VGND VGND VPWR VPWR net74 sky130_fd_sc_hd__inv_2
X_7740_ _3798_ VGND VGND VPWR VPWR _0282_ sky130_fd_sc_hd__clkbuf_1
XTAP_TAPCELL_ROW_35_825 VGND VPWR sky130_fd_sc_hd__tapvpwrvgnd_1
XFILLER_0_129_453 VGND VGND VPWR VPWR sky130_fd_sc_hd__fill_1
X_4883_ rf.registers\[16\]\[1\] rf.registers\[17\]\[1\] rf.registers\[18\]\[1\] rf.registers\[19\]\[1\]
+ _1617_ _1618_ VGND VGND VPWR VPWR _1645_ sky130_fd_sc_hd__mux4_1
XFILLER_0_52_53 VGND VGND VPWR VPWR sky130_fd_sc_hd__fill_1
X_7671_ _3761_ VGND VGND VPWR VPWR _0250_ sky130_fd_sc_hd__clkbuf_1
X_6622_ _3177_ VGND VGND VPWR VPWR _0809_ sky130_fd_sc_hd__clkbuf_1
XFILLER_0_86_395 VGND VGND VPWR VPWR sky130_fd_sc_hd__decap_8
X_9410_ clknet_leaf_10_CLK _0498_ VGND VGND VPWR VPWR rf.registers\[21\]\[17\] sky130_fd_sc_hd__dfxtp_1
XFILLER_0_6_301 VGND VGND VPWR VPWR sky130_fd_sc_hd__decap_6
X_6553_ _3140_ VGND VGND VPWR VPWR _0777_ sky130_fd_sc_hd__clkbuf_1
XFILLER_0_104_309 VGND VGND VPWR VPWR sky130_fd_sc_hd__fill_1
X_9341_ clknet_leaf_18_CLK _0429_ VGND VGND VPWR VPWR rf.registers\[7\]\[12\] sky130_fd_sc_hd__dfxtp_1
XFILLER_0_6_345 VPWR VGND VPWR VGND sky130_ef_sc_hd__decap_12
XFILLER_0_113_821 VPWR VGND VPWR VGND sky130_ef_sc_hd__decap_12
X_6484_ _3103_ VGND VGND VPWR VPWR _0745_ sky130_fd_sc_hd__clkbuf_1
X_9272_ clknet_leaf_53_CLK _0360_ VGND VGND VPWR VPWR rf.registers\[23\]\[7\] sky130_fd_sc_hd__dfxtp_1
XFILLER_0_6_389 VPWR VGND VPWR VGND sky130_ef_sc_hd__decap_12
X_5504_ _2227_ _2232_ _2234_ VGND VGND VPWR VPWR _2235_ sky130_fd_sc_hd__mux2_1
X_5435_ rf.registers\[28\]\[30\] rf.registers\[29\]\[30\] rf.registers\[30\]\[30\]
+ rf.registers\[31\]\[30\] _2109_ _2110_ VGND VGND VPWR VPWR _2168_ sky130_fd_sc_hd__mux4_1
XFILLER_0_14_189 VGND VGND VPWR VPWR sky130_fd_sc_hd__decap_6
XFILLER_0_30_638 VGND VGND VPWR VPWR sky130_fd_sc_hd__decap_6
X_8223_ _4054_ VGND VGND VPWR VPWR _0509_ sky130_fd_sc_hd__clkbuf_1
XFILLER_0_42_498 VGND VGND VPWR VPWR sky130_fd_sc_hd__fill_1
XFILLER_0_65_3 VPWR VGND VPWR VGND sky130_ef_sc_hd__decap_12
XFILLER_0_11_841 VGND VGND VPWR VPWR sky130_fd_sc_hd__fill_1
XFILLER_0_100_548 VGND VGND VPWR VPWR sky130_fd_sc_hd__fill_1
X_5366_ _2101_ _2102_ _2081_ VGND VGND VPWR VPWR _2103_ sky130_fd_sc_hd__mux2_1
X_8154_ _2974_ rf.registers\[26\]\[28\] _4009_ VGND VGND VPWR VPWR _4018_ sky130_fd_sc_hd__mux2_1
X_4317_ rf.registers\[12\]\[3\] rf.registers\[13\]\[3\] rf.registers\[14\]\[3\] rf.registers\[15\]\[3\]
+ _1077_ _1078_ VGND VGND VPWR VPWR _1109_ sky130_fd_sc_hd__mux4_1
X_7105_ _3461_ VGND VGND VPWR VPWR _1008_ sky130_fd_sc_hd__clkbuf_1
X_5297_ rf.registers\[8\]\[22\] rf.registers\[9\]\[22\] rf.registers\[10\]\[22\] rf.registers\[11\]\[22\]
+ _1735_ _1737_ VGND VGND VPWR VPWR _2038_ sky130_fd_sc_hd__mux4_1
X_8085_ _3981_ VGND VGND VPWR VPWR _0444_ sky130_fd_sc_hd__clkbuf_1
X_4248_ A2[1] VGND VGND VPWR VPWR _1043_ sky130_fd_sc_hd__clkbuf_4
X_7036_ rf.registers\[6\]\[15\] _3309_ _3419_ VGND VGND VPWR VPWR _3425_ sky130_fd_sc_hd__mux2_1
XFILLER_0_96_126 VGND VGND VPWR VPWR sky130_fd_sc_hd__decap_4
X_8987_ clknet_leaf_32_CLK _0075_ VGND VGND VPWR VPWR rf.registers\[3\]\[10\] sky130_fd_sc_hd__dfxtp_1
X_7938_ _3393_ rf.registers\[23\]\[22\] _3901_ VGND VGND VPWR VPWR _3904_ sky130_fd_sc_hd__mux2_1
XFILLER_0_93_833 VGND VGND VPWR VPWR sky130_fd_sc_hd__decap_6
XFILLER_0_77_384 VGND VGND VPWR VPWR sky130_fd_sc_hd__decap_8
XFILLER_0_92_343 VGND VGND VPWR VPWR sky130_fd_sc_hd__fill_1
XFILLER_0_9_161 VGND VGND VPWR VPWR sky130_fd_sc_hd__decap_6
XFILLER_0_38_749 VGND VGND VPWR VPWR sky130_fd_sc_hd__decap_6
X_7869_ _3393_ rf.registers\[28\]\[22\] _3864_ VGND VGND VPWR VPWR _3867_ sky130_fd_sc_hd__mux2_1
XFILLER_0_92_365 VGND VGND VPWR VPWR sky130_fd_sc_hd__fill_1
XPHY_EDGE_ROW_14_Right_14 VGND VGND VPWR VPWR sky130_fd_sc_hd__decap_3
X_9539_ clknet_leaf_6_CLK _0627_ VGND VGND VPWR VPWR rf.registers\[14\]\[18\] sky130_fd_sc_hd__dfxtp_1
XFILLER_0_18_473 VGND VGND VPWR VPWR sky130_fd_sc_hd__decap_3
XFILLER_0_46_793 VPWR VGND VPWR VGND sky130_ef_sc_hd__decap_12
XFILLER_0_61_741 VPWR VGND VPWR VGND sky130_ef_sc_hd__decap_12
XFILLER_0_33_432 VGND VGND VPWR VPWR sky130_fd_sc_hd__decap_4
XFILLER_0_122_139 VGND VGND VPWR VPWR sky130_fd_sc_hd__fill_1
XFILLER_0_61_785 VPWR VGND VPWR VGND sky130_ef_sc_hd__decap_12
XFILLER_0_131_673 VPWR VGND VPWR VGND sky130_ef_sc_hd__decap_12
XPHY_EDGE_ROW_23_Right_23 VGND VGND VPWR VPWR sky130_fd_sc_hd__decap_3
XTAP_TAPCELL_ROW_53_1089 VGND VPWR sky130_fd_sc_hd__tapvpwrvgnd_1
XFILLER_0_69_841 VGND VGND VPWR VPWR sky130_fd_sc_hd__fill_1
XFILLER_0_84_811 VGND VGND VPWR VPWR sky130_fd_sc_hd__fill_1
XPHY_EDGE_ROW_32_Right_32 VGND VGND VPWR VPWR sky130_fd_sc_hd__decap_3
XFILLER_0_56_557 VGND VGND VPWR VPWR sky130_fd_sc_hd__fill_1
XFILLER_0_113_69 VPWR VGND VPWR VGND sky130_ef_sc_hd__decap_12
XFILLER_0_56_579 VGND VGND VPWR VPWR sky130_fd_sc_hd__decap_8
XFILLER_0_4_805 VGND VGND VPWR VPWR sky130_fd_sc_hd__decap_6
XFILLER_0_107_670 VGND VGND VPWR VPWR sky130_fd_sc_hd__fill_2
XFILLER_0_98_27 VGND VGND VPWR VPWR sky130_fd_sc_hd__fill_1
XFILLER_0_51_240 VGND VGND VPWR VPWR sky130_fd_sc_hd__decap_3
XTAP_TAPCELL_ROW_40_894 VGND VPWR sky130_fd_sc_hd__tapvpwrvgnd_1
XFILLER_0_3_337 VPWR VGND VPWR VGND sky130_ef_sc_hd__decap_12
XFILLER_0_24_498 VPWR VGND VPWR VGND sky130_ef_sc_hd__decap_12
XFILLER_0_122_673 VPWR VGND VPWR VGND sky130_ef_sc_hd__decap_12
XFILLER_0_121_161 VGND VGND VPWR VPWR sky130_fd_sc_hd__decap_6
XFILLER_0_110_813 VPWR VGND VPWR VGND sky130_ef_sc_hd__decap_12
X_5220_ _1940_ _1949_ _1957_ _1965_ VGND VGND VPWR VPWR _1966_ sky130_fd_sc_hd__a2bb2o_4
XFILLER_0_11_137 VPWR VGND VPWR VGND sky130_ef_sc_hd__decap_12
XPHY_EDGE_ROW_41_Right_41 VGND VGND VPWR VPWR sky130_fd_sc_hd__decap_3
X_5151_ _1693_ _1899_ _1641_ VGND VGND VPWR VPWR _1900_ sky130_fd_sc_hd__o21a_1
XFILLER_0_138_55 VGND VGND VPWR VPWR sky130_fd_sc_hd__fill_1
X_5082_ rf.registers\[12\]\[10\] rf.registers\[13\]\[10\] rf.registers\[14\]\[10\]
+ rf.registers\[15\]\[10\] _1734_ _1797_ VGND VGND VPWR VPWR _1835_ sky130_fd_sc_hd__mux4_1
XFILLER_0_47_42 VPWR VGND VPWR VGND sky130_ef_sc_hd__decap_12
X_8910_ clknet_leaf_89_CLK _1022_ VGND VGND VPWR VPWR rf.registers\[5\]\[29\] sky130_fd_sc_hd__dfxtp_1
XTAP_TAPCELL_ROW_88_1620 VGND VPWR sky130_fd_sc_hd__tapvpwrvgnd_1
XFILLER_0_79_649 VGND VGND VPWR VPWR sky130_fd_sc_hd__fill_2
X_8841_ clknet_leaf_73_CLK _0953_ VGND VGND VPWR VPWR rf.registers\[15\]\[24\] sky130_fd_sc_hd__dfxtp_1
X_8772_ clknet_leaf_16_CLK _0884_ VGND VGND VPWR VPWR rf.registers\[0\]\[19\] sky130_fd_sc_hd__dfxtp_1
XPHY_EDGE_ROW_50_Right_50 VGND VGND VPWR VPWR sky130_fd_sc_hd__decap_3
XFILLER_0_2_77 VGND VGND VPWR VPWR sky130_fd_sc_hd__decap_6
XFILLER_0_93_129 VGND VGND VPWR VPWR sky130_fd_sc_hd__fill_1
XFILLER_0_93_107 VGND VGND VPWR VPWR sky130_fd_sc_hd__decap_4
X_7723_ _3789_ VGND VGND VPWR VPWR _0274_ sky130_fd_sc_hd__clkbuf_1
X_5984_ _2550_ _2568_ _2698_ _2560_ _2699_ VGND VGND VPWR VPWR _2700_ sky130_fd_sc_hd__o221a_1
XFILLER_0_136_209 VPWR VGND VPWR VGND sky130_ef_sc_hd__decap_12
XFILLER_0_129_261 VPWR VGND VPWR VGND sky130_ef_sc_hd__decap_12
X_4935_ _1632_ VGND VGND VPWR VPWR _1695_ sky130_fd_sc_hd__buf_4
XFILLER_0_75_833 VGND VGND VPWR VPWR sky130_fd_sc_hd__decap_6
X_4866_ _1622_ _1627_ _1628_ VGND VGND VPWR VPWR _1629_ sky130_fd_sc_hd__mux2_1
XFILLER_0_90_825 VPWR VGND VPWR VGND sky130_ef_sc_hd__decap_12
XFILLER_0_74_365 VGND VGND VPWR VPWR sky130_fd_sc_hd__decap_6
XFILLER_0_74_343 VGND VGND VPWR VPWR sky130_fd_sc_hd__decap_6
X_7654_ _3752_ VGND VGND VPWR VPWR _0242_ sky130_fd_sc_hd__clkbuf_1
XANTENNA_11 net59 VGND VGND VPWR VPWR sky130_fd_sc_hd__diode_2
X_6605_ rf.registers\[24\]\[0\] _2982_ _3168_ VGND VGND VPWR VPWR _3169_ sky130_fd_sc_hd__mux2_1
X_7585_ _3382_ rf.registers\[27\]\[17\] _3708_ VGND VGND VPWR VPWR _3716_ sky130_fd_sc_hd__mux2_1
XFILLER_0_62_538 VGND VGND VPWR VPWR sky130_fd_sc_hd__decap_8
XFILLER_0_6_153 VPWR VGND VPWR VGND sky130_ef_sc_hd__decap_12
X_4797_ _1301_ _1563_ VGND VGND VPWR VPWR _1564_ sky130_fd_sc_hd__nor2_1
X_6536_ rf.registers\[1\]\[0\] _2982_ _3131_ VGND VGND VPWR VPWR _3132_ sky130_fd_sc_hd__mux2_1
XTAP_TAPCELL_ROW_115_2027 VGND VPWR sky130_fd_sc_hd__tapvpwrvgnd_1
XTAP_TAPCELL_ROW_99_1782 VGND VPWR sky130_fd_sc_hd__tapvpwrvgnd_1
X_9324_ clknet_leaf_92_CLK _0412_ VGND VGND VPWR VPWR rf.registers\[22\]\[27\] sky130_fd_sc_hd__dfxtp_1
XFILLER_0_6_197 VPWR VGND VPWR VGND sky130_ef_sc_hd__decap_12
XFILLER_0_42_273 VGND VGND VPWR VPWR sky130_fd_sc_hd__fill_1
XFILLER_0_43_774 VGND VGND VPWR VPWR sky130_fd_sc_hd__decap_8
XFILLER_0_43_785 VPWR VGND VPWR VGND sky130_ef_sc_hd__decap_12
X_6467_ rf.registers\[17\]\[0\] _2982_ _3094_ VGND VGND VPWR VPWR _3095_ sky130_fd_sc_hd__mux2_1
XFILLER_0_100_301 VGND VGND VPWR VPWR sky130_fd_sc_hd__decap_4
XFILLER_0_88_82 VGND VGND VPWR VPWR sky130_fd_sc_hd__fill_2
X_9255_ clknet_leaf_0_CLK _0343_ VGND VGND VPWR VPWR rf.registers\[28\]\[22\] sky130_fd_sc_hd__dfxtp_1
XFILLER_0_42_295 VGND VGND VPWR VPWR sky130_fd_sc_hd__fill_1
X_6398_ _3057_ VGND VGND VPWR VPWR _0705_ sky130_fd_sc_hd__clkbuf_1
XFILLER_0_112_172 VGND VGND VPWR VPWR sky130_fd_sc_hd__decap_8
X_9186_ clknet_leaf_10_CLK _0274_ VGND VGND VPWR VPWR rf.registers\[30\]\[17\] sky130_fd_sc_hd__dfxtp_1
Xoutput140 net140 VGND VGND VPWR VPWR alu_result[5] sky130_fd_sc_hd__buf_1
X_5418_ _2150_ _2151_ _1943_ VGND VGND VPWR VPWR _2152_ sky130_fd_sc_hd__mux2_1
X_8206_ _3388_ rf.registers\[21\]\[20\] _4045_ VGND VGND VPWR VPWR _4046_ sky130_fd_sc_hd__mux2_1
X_5349_ _1923_ VGND VGND VPWR VPWR _2087_ sky130_fd_sc_hd__buf_4
X_8137_ _3986_ VGND VGND VPWR VPWR _4009_ sky130_fd_sc_hd__buf_4
XFILLER_0_11_671 VGND VGND VPWR VPWR sky130_fd_sc_hd__fill_1
X_8068_ _3972_ VGND VGND VPWR VPWR _0436_ sky130_fd_sc_hd__clkbuf_1
X_7019_ rf.registers\[6\]\[7\] _3292_ _3408_ VGND VGND VPWR VPWR _3416_ sky130_fd_sc_hd__mux2_1
XTAP_TAPCELL_ROW_126_2189 VGND VPWR sky130_fd_sc_hd__tapvpwrvgnd_1
XFILLER_0_97_457 VGND VGND VPWR VPWR sky130_fd_sc_hd__decap_3
XFILLER_0_66_811 VGND VGND VPWR VPWR sky130_fd_sc_hd__fill_1
XTAP_TAPCELL_ROW_26_688 VGND VPWR sky130_fd_sc_hd__tapvpwrvgnd_1
XFILLER_0_93_685 VPWR VGND VPWR VGND sky130_ef_sc_hd__decap_12
XFILLER_0_34_763 VPWR VGND VPWR VGND sky130_ef_sc_hd__decap_12
XFILLER_0_61_582 VGND VGND VPWR VPWR sky130_fd_sc_hd__decap_8
XPHY_EDGE_ROW_12_Left_151 VGND VGND VPWR VPWR sky130_fd_sc_hd__decap_3
XFILLER_0_33_262 VGND VGND VPWR VPWR sky130_fd_sc_hd__fill_2
XFILLER_0_110_109 VGND VGND VPWR VPWR sky130_fd_sc_hd__decap_8
XTAP_TAPCELL_ROW_55_1129 VGND VPWR sky130_fd_sc_hd__tapvpwrvgnd_1
XTAP_TAPCELL_ROW_55_1118 VGND VPWR sky130_fd_sc_hd__tapvpwrvgnd_1
XFILLER_0_84_29 VGND VGND VPWR VPWR sky130_fd_sc_hd__decap_4
XTAP_TAPCELL_ROW_6_391 VGND VPWR sky130_fd_sc_hd__tapvpwrvgnd_1
XPHY_EDGE_ROW_21_Left_160 VGND VGND VPWR VPWR sky130_fd_sc_hd__decap_3
XFILLER_0_88_457 VGND VGND VPWR VPWR sky130_fd_sc_hd__fill_2
XFILLER_0_118_209 VPWR VGND VPWR VGND sky130_ef_sc_hd__decap_12
XFILLER_0_84_641 VGND VGND VPWR VPWR sky130_fd_sc_hd__decap_3
XTAP_TAPCELL_ROW_83_1550 VGND VPWR sky130_fd_sc_hd__tapvpwrvgnd_1
XFILLER_0_57_833 VGND VGND VPWR VPWR sky130_fd_sc_hd__decap_6
XTAP_TAPCELL_ROW_45_975 VGND VPWR sky130_fd_sc_hd__tapvpwrvgnd_1
XFILLER_0_127_721 VGND VGND VPWR VPWR sky130_fd_sc_hd__decap_6
XFILLER_0_83_140 VGND VGND VPWR VPWR sky130_fd_sc_hd__decap_3
X_4720_ _1282_ _1483_ _1487_ _1491_ VGND VGND VPWR VPWR _1492_ sky130_fd_sc_hd__a2bb2o_2
XFILLER_0_127_765 VPWR VGND VPWR VGND sky130_ef_sc_hd__decap_12
XFILLER_0_126_253 VPWR VGND VPWR VGND sky130_ef_sc_hd__decap_12
XFILLER_0_84_696 VGND VGND VPWR VPWR sky130_fd_sc_hd__decap_4
X_4651_ _1425_ _1426_ _1397_ VGND VGND VPWR VPWR _1427_ sky130_fd_sc_hd__mux2_1
XFILLER_0_83_162 VGND VGND VPWR VPWR sky130_fd_sc_hd__fill_1
XFILLER_0_72_825 VPWR VGND VPWR VGND sky130_ef_sc_hd__decap_12
Xinput20 WD3[15] VGND VGND VPWR VPWR net20 sky130_fd_sc_hd__clkbuf_2
XFILLER_0_4_613 VPWR VGND VPWR VGND sky130_ef_sc_hd__decap_12
XFILLER_0_37_590 VGND VGND VPWR VPWR sky130_fd_sc_hd__decap_6
Xinput31 WD3[25] VGND VGND VPWR VPWR net31 sky130_fd_sc_hd__clkbuf_2
Xinput42 WD3[6] VGND VGND VPWR VPWR net42 sky130_fd_sc_hd__clkbuf_4
X_7370_ rf.registers\[8\]\[12\] _3303_ _3599_ VGND VGND VPWR VPWR _3602_ sky130_fd_sc_hd__mux2_1
X_4582_ _1359_ _1360_ _1145_ VGND VGND VPWR VPWR _1361_ sky130_fd_sc_hd__mux2_1
XFILLER_0_12_413 VGND VGND VPWR VPWR sky130_fd_sc_hd__decap_6
XFILLER_0_4_657 VGND VGND VPWR VPWR sky130_fd_sc_hd__decap_6
X_6321_ _3004_ VGND VGND VPWR VPWR _0681_ sky130_fd_sc_hd__clkbuf_1
XFILLER_0_3_167 VGND VGND VPWR VPWR sky130_fd_sc_hd__fill_1
X_9040_ clknet_leaf_77_CLK _0128_ VGND VGND VPWR VPWR rf.registers\[8\]\[31\] sky130_fd_sc_hd__dfxtp_1
XFILLER_0_12_457 VPWR VGND VPWR VGND sky130_ef_sc_hd__decap_12
XFILLER_0_0_841 VGND VGND VPWR VPWR sky130_fd_sc_hd__fill_1
X_6252_ _2951_ _2949_ _2945_ VGND VGND VPWR VPWR _2952_ sky130_fd_sc_hd__a21oi_1
XFILLER_0_40_766 VGND VGND VPWR VPWR sky130_fd_sc_hd__decap_6
X_5203_ _1944_ _1947_ _1948_ VGND VGND VPWR VPWR _1949_ sky130_fd_sc_hd__mux2_1
XFILLER_0_58_41 VGND VGND VPWR VPWR sky130_fd_sc_hd__decap_6
X_6183_ net100 _2709_ _2884_ _2886_ VGND VGND VPWR VPWR _2887_ sky130_fd_sc_hd__o2bb2a_1
XFILLER_0_110_698 VGND VGND VPWR VPWR sky130_fd_sc_hd__fill_2
X_5134_ rf.registers\[4\]\[13\] rf.registers\[5\]\[13\] rf.registers\[6\]\[13\] rf.registers\[7\]\[13\]
+ _1816_ _1817_ VGND VGND VPWR VPWR _1884_ sky130_fd_sc_hd__mux4_1
X_5065_ _1698_ _1818_ VGND VGND VPWR VPWR _1819_ sky130_fd_sc_hd__or2_1
XFILLER_0_74_51 VGND VGND VPWR VPWR sky130_fd_sc_hd__decap_8
XFILLER_0_28_3 VPWR VGND VPWR VGND sky130_ef_sc_hd__decap_12
X_8824_ clknet_leaf_52_CLK _0936_ VGND VGND VPWR VPWR rf.registers\[15\]\[7\] sky130_fd_sc_hd__dfxtp_1
XFILLER_0_48_811 VGND VGND VPWR VPWR sky130_fd_sc_hd__fill_1
XFILLER_0_137_529 VPWR VGND VPWR VGND sky130_ef_sc_hd__decap_12
X_8755_ clknet_leaf_46_CLK _0867_ VGND VGND VPWR VPWR rf.registers\[0\]\[2\] sky130_fd_sc_hd__dfxtp_1
XFILLER_0_48_833 VGND VGND VPWR VPWR sky130_fd_sc_hd__fill_1
X_5967_ _2524_ _2683_ _2421_ VGND VGND VPWR VPWR _2684_ sky130_fd_sc_hd__mux2_1
X_4918_ rf.registers\[12\]\[2\] rf.registers\[13\]\[2\] rf.registers\[14\]\[2\] rf.registers\[15\]\[2\]
+ _1624_ _1625_ VGND VGND VPWR VPWR _1679_ sky130_fd_sc_hd__mux4_1
X_7706_ _3780_ VGND VGND VPWR VPWR _0266_ sky130_fd_sc_hd__clkbuf_1
X_8686_ clknet_leaf_92_CLK _0798_ VGND VGND VPWR VPWR rf.registers\[1\]\[29\] sky130_fd_sc_hd__dfxtp_1
XTAP_TAPCELL_ROW_23_647 VGND VPWR sky130_fd_sc_hd__tapvpwrvgnd_1
XFILLER_0_35_505 VGND VGND VPWR VPWR sky130_fd_sc_hd__decap_4
X_7637_ _3743_ VGND VGND VPWR VPWR _0234_ sky130_fd_sc_hd__clkbuf_1
XFILLER_0_75_685 VPWR VGND VPWR VGND sky130_ef_sc_hd__decap_12
X_5898_ _2608_ _2618_ _2391_ VGND VGND VPWR VPWR _2619_ sky130_fd_sc_hd__mux2_1
X_4849_ _1611_ _1612_ _1154_ VGND VGND VPWR VPWR _1613_ sky130_fd_sc_hd__mux2_1
XFILLER_0_7_473 VPWR VGND VPWR VGND sky130_ef_sc_hd__decap_12
XFILLER_0_132_245 VGND VGND VPWR VPWR sky130_fd_sc_hd__decap_6
XFILLER_0_117_297 VGND VGND VPWR VPWR sky130_fd_sc_hd__fill_2
X_7568_ _3365_ rf.registers\[27\]\[9\] _3697_ VGND VGND VPWR VPWR _3707_ sky130_fd_sc_hd__mux2_1
XFILLER_0_62_368 VGND VGND VPWR VPWR sky130_fd_sc_hd__decap_8
X_7499_ _3670_ VGND VGND VPWR VPWR _0169_ sky130_fd_sc_hd__clkbuf_1
X_9307_ clknet_leaf_37_CLK _0395_ VGND VGND VPWR VPWR rf.registers\[22\]\[10\] sky130_fd_sc_hd__dfxtp_1
XFILLER_0_15_273 VGND VGND VPWR VPWR sky130_fd_sc_hd__decap_6
X_6519_ rf.registers\[17\]\[25\] _3039_ _3116_ VGND VGND VPWR VPWR _3122_ sky130_fd_sc_hd__mux2_1
XFILLER_0_30_221 VGND VGND VPWR VPWR sky130_fd_sc_hd__decap_6
XFILLER_0_132_289 VPWR VGND VPWR VGND sky130_ef_sc_hd__decap_12
X_9238_ clknet_leaf_13_CLK _0326_ VGND VGND VPWR VPWR rf.registers\[28\]\[5\] sky130_fd_sc_hd__dfxtp_1
X_9169_ clknet_leaf_39_CLK _0257_ VGND VGND VPWR VPWR rf.registers\[30\]\[0\] sky130_fd_sc_hd__dfxtp_1
XTAP_TAPCELL_ROW_128_2218 VGND VPWR sky130_fd_sc_hd__tapvpwrvgnd_1
XTAP_TAPCELL_ROW_50_1048 VGND VPWR sky130_fd_sc_hd__tapvpwrvgnd_1
XTAP_TAPCELL_ROW_3_350 VGND VPWR sky130_fd_sc_hd__tapvpwrvgnd_1
XFILLER_0_98_755 VGND VGND VPWR VPWR sky130_fd_sc_hd__fill_1
XFILLER_0_85_427 VPWR VGND VPWR VGND sky130_ef_sc_hd__decap_12
XFILLER_0_85_405 VGND VGND VPWR VPWR sky130_fd_sc_hd__decap_6
XFILLER_0_57_107 VGND VGND VPWR VPWR sky130_fd_sc_hd__fill_2
XFILLER_0_128_507 VGND VGND VPWR VPWR sky130_fd_sc_hd__fill_2
XFILLER_0_85_449 VGND VGND VPWR VPWR sky130_fd_sc_hd__decap_4
XFILLER_0_39_833 VGND VGND VPWR VPWR sky130_fd_sc_hd__decap_6
XTAP_TAPCELL_ROW_42_923 VGND VPWR sky130_fd_sc_hd__tapvpwrvgnd_1
XTAP_TAPCELL_ROW_65_1280 VGND VPWR sky130_fd_sc_hd__tapvpwrvgnd_1
XFILLER_0_38_343 VGND VGND VPWR VPWR sky130_fd_sc_hd__decap_3
XFILLER_0_38_365 VGND VGND VPWR VPWR sky130_fd_sc_hd__fill_2
XTAP_TAPCELL_ROW_42_934 VGND VPWR sky130_fd_sc_hd__tapvpwrvgnd_1
XFILLER_0_109_765 VPWR VGND VPWR VGND sky130_ef_sc_hd__decap_12
XFILLER_0_54_825 VPWR VGND VPWR VGND sky130_ef_sc_hd__decap_12
XFILLER_0_124_713 VPWR VGND VPWR VGND sky130_ef_sc_hd__decap_12
XFILLER_0_108_253 VGND VGND VPWR VPWR sky130_fd_sc_hd__decap_4
XFILLER_0_124_757 VPWR VGND VPWR VGND sky130_ef_sc_hd__decap_12
XFILLER_0_123_223 VGND VGND VPWR VPWR sky130_fd_sc_hd__fill_1
XFILLER_0_110_15 VPWR VGND VPWR VGND sky130_ef_sc_hd__decap_12
XFILLER_0_41_508 VGND VGND VPWR VPWR sky130_fd_sc_hd__decap_3
XFILLER_0_22_799 VPWR VGND VPWR VGND sky130_ef_sc_hd__decap_12
XFILLER_0_119_57 VPWR VGND VPWR VGND sky130_ef_sc_hd__decap_12
XTAP_TAPCELL_ROW_1_309 VGND VPWR sky130_fd_sc_hd__tapvpwrvgnd_1
XFILLER_0_89_777 VGND VGND VPWR VPWR sky130_fd_sc_hd__decap_6
X_6870_ _3318_ VGND VGND VPWR VPWR _0916_ sky130_fd_sc_hd__clkbuf_1
XTAP_TAPCELL_ROW_81_1509 VGND VPWR sky130_fd_sc_hd__tapvpwrvgnd_1
XFILLER_0_76_427 VGND VGND VPWR VPWR sky130_fd_sc_hd__fill_1
X_5821_ net78 _2543_ VGND VGND VPWR VPWR _2545_ sky130_fd_sc_hd__and2_1
XFILLER_0_9_705 VPWR VGND VPWR VGND sky130_ef_sc_hd__decap_12
XFILLER_0_48_129 VGND VGND VPWR VPWR sky130_fd_sc_hd__fill_2
X_8540_ _3024_ rf.registers\[13\]\[18\] _4216_ VGND VGND VPWR VPWR _4222_ sky130_fd_sc_hd__mux2_1
XFILLER_0_57_652 VPWR VGND VPWR VGND sky130_ef_sc_hd__decap_12
X_5752_ _2461_ _2471_ _2399_ _2478_ VGND VGND VPWR VPWR net139 sky130_fd_sc_hd__o2bb2a_1
XFILLER_0_17_505 VPWR VGND VPWR VGND sky130_ef_sc_hd__decap_12
XFILLER_0_84_471 VGND VGND VPWR VPWR sky130_fd_sc_hd__decap_4
XFILLER_0_60_53 VPWR VGND VPWR VGND sky130_ef_sc_hd__decap_12
XFILLER_0_57_685 VPWR VGND VPWR VGND sky130_ef_sc_hd__decap_12
X_4703_ _1282_ _1467_ _1471_ _1475_ VGND VGND VPWR VPWR _1476_ sky130_fd_sc_hd__o22a_2
XTAP_TAPCELL_ROW_20_606 VGND VPWR sky130_fd_sc_hd__tapvpwrvgnd_1
XFILLER_0_115_713 VPWR VGND VPWR VGND sky130_ef_sc_hd__decap_12
X_8471_ _3022_ rf.registers\[14\]\[17\] _4178_ VGND VGND VPWR VPWR _4186_ sky130_fd_sc_hd__mux2_1
X_5683_ _2240_ _2409_ _2411_ _2266_ VGND VGND VPWR VPWR _2412_ sky130_fd_sc_hd__a211o_1
X_7422_ _3355_ rf.registers\[29\]\[4\] _3625_ VGND VGND VPWR VPWR _3630_ sky130_fd_sc_hd__mux2_1
XFILLER_0_72_699 VGND VGND VPWR VPWR sky130_fd_sc_hd__fill_1
XFILLER_0_4_421 VPWR VGND VPWR VGND sky130_ef_sc_hd__decap_12
X_4634_ _1295_ VGND VGND VPWR VPWR _1411_ sky130_fd_sc_hd__clkbuf_4
XFILLER_0_102_407 VGND VGND VPWR VPWR sky130_fd_sc_hd__decap_4
X_4565_ rf.registers\[24\]\[15\] rf.registers\[25\]\[15\] rf.registers\[26\]\[15\]
+ rf.registers\[27\]\[15\] _1329_ _1330_ VGND VGND VPWR VPWR _1345_ sky130_fd_sc_hd__mux4_1
XTAP_TAPCELL_ROW_96_1741 VGND VPWR sky130_fd_sc_hd__tapvpwrvgnd_1
X_7353_ rf.registers\[8\]\[4\] _3286_ _3588_ VGND VGND VPWR VPWR _3593_ sky130_fd_sc_hd__mux2_1
XFILLER_0_12_221 VPWR VGND VPWR VGND sky130_ef_sc_hd__decap_12
XFILLER_0_8_65 VPWR VGND VPWR VGND sky130_ef_sc_hd__decap_12
XFILLER_0_25_593 VGND VGND VPWR VPWR sky130_fd_sc_hd__fill_1
XFILLER_0_130_749 VGND VGND VPWR VPWR sky130_fd_sc_hd__decap_6
X_6304_ net39 VGND VGND VPWR VPWR _2993_ sky130_fd_sc_hd__clkbuf_2
X_7284_ _3556_ VGND VGND VPWR VPWR _0068_ sky130_fd_sc_hd__clkbuf_1
X_4496_ _1135_ _1279_ _1024_ VGND VGND VPWR VPWR _1280_ sky130_fd_sc_hd__a21o_1
X_9023_ clknet_leaf_28_CLK _0111_ VGND VGND VPWR VPWR rf.registers\[8\]\[14\] sky130_fd_sc_hd__dfxtp_1
XFILLER_0_12_265 VPWR VGND VPWR VGND sky130_ef_sc_hd__decap_12
XPHY_EDGE_ROW_4_Right_4 VGND VGND VPWR VPWR sky130_fd_sc_hd__decap_3
XFILLER_0_0_671 VGND VGND VPWR VPWR sky130_fd_sc_hd__fill_1
XFILLER_0_0_682 VPWR VGND VPWR VGND sky130_ef_sc_hd__decap_12
X_6235_ net92 _2900_ _2935_ VGND VGND VPWR VPWR _2936_ sky130_fd_sc_hd__a21o_1
XFILLER_0_85_61 VGND VGND VPWR VPWR sky130_fd_sc_hd__fill_1
XFILLER_0_85_50 VGND VGND VPWR VPWR sky130_fd_sc_hd__fill_2
X_6166_ _2296_ _2870_ _2804_ _2240_ _2559_ VGND VGND VPWR VPWR _2871_ sky130_fd_sc_hd__a221o_1
XFILLER_0_99_519 VGND VGND VPWR VPWR sky130_fd_sc_hd__decap_4
X_5117_ _1698_ _1867_ VGND VGND VPWR VPWR _1868_ sky130_fd_sc_hd__or2_1
XFILLER_0_85_83 VGND VGND VPWR VPWR sky130_fd_sc_hd__fill_1
X_6097_ _2801_ _2805_ _2421_ VGND VGND VPWR VPWR _2806_ sky130_fd_sc_hd__mux2_1
X_5048_ _1707_ _1802_ VGND VGND VPWR VPWR _1803_ sky130_fd_sc_hd__or2_1
XTAP_TAPCELL_ROW_28_717 VGND VPWR sky130_fd_sc_hd__tapvpwrvgnd_1
XTAP_TAPCELL_ROW_123_2148 VGND VPWR sky130_fd_sc_hd__tapvpwrvgnd_1
XFILLER_0_94_235 VGND VGND VPWR VPWR sky130_fd_sc_hd__fill_2
X_8807_ clknet_leaf_0_CLK _0919_ VGND VGND VPWR VPWR rf.registers\[16\]\[22\] sky130_fd_sc_hd__dfxtp_1
XFILLER_0_137_337 VPWR VGND VPWR VGND sky130_ef_sc_hd__decap_12
XTAP_TAPCELL_ROW_105_1881 VGND VPWR sky130_fd_sc_hd__tapvpwrvgnd_1
XTAP_TAPCELL_ROW_105_1870 VGND VPWR sky130_fd_sc_hd__tapvpwrvgnd_1
X_8738_ clknet_leaf_11_CLK _0850_ VGND VGND VPWR VPWR rf.registers\[10\]\[17\] sky130_fd_sc_hd__dfxtp_1
X_6999_ _3404_ VGND VGND VPWR VPWR _0959_ sky130_fd_sc_hd__clkbuf_1
XFILLER_0_36_825 VPWR VGND VPWR VGND sky130_ef_sc_hd__decap_12
XFILLER_0_106_713 VPWR VGND VPWR VGND sky130_ef_sc_hd__decap_12
X_8669_ clknet_leaf_17_CLK _0781_ VGND VGND VPWR VPWR rf.registers\[1\]\[12\] sky130_fd_sc_hd__dfxtp_1
XFILLER_0_90_441 VGND VGND VPWR VPWR sky130_fd_sc_hd__decap_6
XTAP_TAPCELL_ROW_138_2391 VGND VPWR sky130_fd_sc_hd__tapvpwrvgnd_1
XTAP_TAPCELL_ROW_138_2380 VGND VPWR sky130_fd_sc_hd__tapvpwrvgnd_1
XFILLER_0_106_757 VPWR VGND VPWR VGND sky130_ef_sc_hd__decap_12
XFILLER_0_90_463 VGND VGND VPWR VPWR sky130_fd_sc_hd__fill_1
XFILLER_0_51_839 VGND VGND VPWR VPWR sky130_fd_sc_hd__fill_1
XFILLER_0_50_316 VGND VGND VPWR VPWR sky130_fd_sc_hd__fill_1
XFILLER_0_8_793 VPWR VGND VPWR VGND sky130_ef_sc_hd__decap_12
XFILLER_0_7_281 VPWR VGND VPWR VGND sky130_ef_sc_hd__decap_12
XFILLER_0_121_727 VGND VGND VPWR VPWR sky130_fd_sc_hd__fill_1
XTAP_TAPCELL_ROW_8_420 VGND VPWR sky130_fd_sc_hd__tapvpwrvgnd_1
XFILLER_0_105_15 VPWR VGND VPWR VGND sky130_ef_sc_hd__decap_12
XFILLER_0_86_725 VPWR VGND VPWR VGND sky130_ef_sc_hd__decap_12
XFILLER_0_86_769 VPWR VGND VPWR VGND sky130_ef_sc_hd__decap_12
XTAP_TAPCELL_ROW_63_1239 VGND VPWR sky130_fd_sc_hd__tapvpwrvgnd_1
XFILLER_0_39_641 VPWR VGND VPWR VGND sky130_ef_sc_hd__decap_12
XFILLER_0_85_279 VGND VGND VPWR VPWR sky130_fd_sc_hd__fill_1
XFILLER_0_124_521 VGND VGND VPWR VPWR sky130_fd_sc_hd__fill_1
XFILLER_0_121_69 VPWR VGND VPWR VGND sky130_ef_sc_hd__decap_12
XFILLER_0_112_749 VGND VGND VPWR VPWR sky130_fd_sc_hd__decap_6
X_4350_ rf.registers\[8\]\[4\] rf.registers\[9\]\[4\] rf.registers\[10\]\[4\] rf.registers\[11\]\[4\]
+ _1139_ _1140_ VGND VGND VPWR VPWR _1141_ sky130_fd_sc_hd__mux4_1
XTAP_TAPCELL_ROW_78_1471 VGND VPWR sky130_fd_sc_hd__tapvpwrvgnd_1
XFILLER_0_10_725 VGND VGND VPWR VPWR sky130_fd_sc_hd__decap_4
XFILLER_0_10_769 VPWR VGND VPWR VGND sky130_ef_sc_hd__decap_12
XFILLER_0_10_747 VGND VGND VPWR VPWR sky130_fd_sc_hd__decap_8
XFILLER_0_39_43 VGND VGND VPWR VPWR sky130_fd_sc_hd__decap_6
X_4281_ _1074_ VGND VGND VPWR VPWR _1075_ sky130_fd_sc_hd__inv_2
XFILLER_0_120_793 VPWR VGND VPWR VGND sky130_ef_sc_hd__decap_12
XTAP_TAPCELL_ROW_91_1671 VGND VPWR sky130_fd_sc_hd__tapvpwrvgnd_1
XTAP_TAPCELL_ROW_91_1660 VGND VPWR sky130_fd_sc_hd__tapvpwrvgnd_1
X_6020_ _2733_ VGND VGND VPWR VPWR _2734_ sky130_fd_sc_hd__inv_2
XFILLER_0_55_31 VPWR VGND VPWR VGND sky130_ef_sc_hd__decap_12
X_7971_ _3921_ VGND VGND VPWR VPWR _0390_ sky130_fd_sc_hd__clkbuf_1
X_6922_ _3354_ VGND VGND VPWR VPWR _0932_ sky130_fd_sc_hd__clkbuf_1
XFILLER_0_89_552 VGND VGND VPWR VPWR sky130_fd_sc_hd__decap_8
X_6853_ net19 VGND VGND VPWR VPWR _3307_ sky130_fd_sc_hd__clkbuf_2
XFILLER_0_49_449 VGND VGND VPWR VPWR sky130_fd_sc_hd__fill_1
X_5804_ _2386_ _2527_ _2528_ _2266_ VGND VGND VPWR VPWR _2529_ sky130_fd_sc_hd__a211o_1
X_9572_ clknet_leaf_20_CLK _0660_ VGND VGND VPWR VPWR rf.registers\[13\]\[19\] sky130_fd_sc_hd__dfxtp_1
XFILLER_0_57_471 VGND VGND VPWR VPWR sky130_fd_sc_hd__decap_6
XFILLER_0_18_825 VGND VGND VPWR VPWR sky130_fd_sc_hd__decap_8
X_6784_ rf.registers\[0\]\[20\] _3028_ _3263_ VGND VGND VPWR VPWR _3264_ sky130_fd_sc_hd__mux2_1
XFILLER_0_134_307 VGND VGND VPWR VPWR sky130_fd_sc_hd__fill_1
X_8523_ _3007_ rf.registers\[13\]\[10\] _4205_ VGND VGND VPWR VPWR _4213_ sky130_fd_sc_hd__mux2_1
XFILLER_0_72_430 VGND VGND VPWR VPWR sky130_fd_sc_hd__decap_6
X_5735_ net107 _2319_ VGND VGND VPWR VPWR _2462_ sky130_fd_sc_hd__nor2_4
XFILLER_0_17_335 VGND VGND VPWR VPWR sky130_fd_sc_hd__fill_1
XTAP_TAPCELL_ROW_33_797 VGND VPWR sky130_fd_sc_hd__tapvpwrvgnd_1
X_8454_ _3005_ rf.registers\[14\]\[9\] _4167_ VGND VGND VPWR VPWR _4177_ sky130_fd_sc_hd__mux2_1
XFILLER_0_5_741 VPWR VGND VPWR VGND sky130_ef_sc_hd__decap_12
XFILLER_0_33_839 VGND VGND VPWR VPWR sky130_fd_sc_hd__fill_1
X_5666_ _2394_ _2395_ VGND VGND VPWR VPWR _2396_ sky130_fd_sc_hd__or2b_1
XFILLER_0_60_636 VGND VGND VPWR VPWR sky130_fd_sc_hd__decap_8
XFILLER_0_4_251 VGND VGND VPWR VPWR sky130_fd_sc_hd__fill_1
X_4617_ _1123_ VGND VGND VPWR VPWR _1394_ sky130_fd_sc_hd__clkbuf_4
X_7405_ rf.registers\[8\]\[29\] _3338_ _3610_ VGND VGND VPWR VPWR _3620_ sky130_fd_sc_hd__mux2_1
X_8385_ _4140_ VGND VGND VPWR VPWR _0585_ sky130_fd_sc_hd__clkbuf_1
XFILLER_0_103_727 VGND VGND VPWR VPWR sky130_fd_sc_hd__fill_1
XFILLER_0_60_669 VPWR VGND VPWR VGND sky130_ef_sc_hd__decap_12
XFILLER_0_5_785 VPWR VGND VPWR VGND sky130_ef_sc_hd__decap_12
XFILLER_0_13_541 VPWR VGND VPWR VGND sky130_ef_sc_hd__decap_12
X_5597_ _2320_ _2325_ _2326_ VGND VGND VPWR VPWR _2327_ sky130_fd_sc_hd__o21ai_1
X_4548_ _1147_ VGND VGND VPWR VPWR _1329_ sky130_fd_sc_hd__clkbuf_8
X_7336_ _3583_ VGND VGND VPWR VPWR _0093_ sky130_fd_sc_hd__clkbuf_1
X_4479_ rf.registers\[0\]\[10\] rf.registers\[1\]\[10\] rf.registers\[2\]\[10\] rf.registers\[3\]\[10\]
+ _1118_ _1127_ VGND VGND VPWR VPWR _1264_ sky130_fd_sc_hd__mux4_1
XFILLER_0_3_9 VPWR VGND VPWR VGND sky130_ef_sc_hd__decap_12
X_7267_ rf.registers\[19\]\[28\] _3336_ _3538_ VGND VGND VPWR VPWR _3547_ sky130_fd_sc_hd__mux2_1
X_6218_ _1096_ _1113_ VGND VGND VPWR VPWR _2920_ sky130_fd_sc_hd__nand2_1
X_9006_ clknet_leaf_91_CLK _0094_ VGND VGND VPWR VPWR rf.registers\[3\]\[29\] sky130_fd_sc_hd__dfxtp_1
X_7198_ _3510_ VGND VGND VPWR VPWR _0028_ sky130_fd_sc_hd__clkbuf_1
XFILLER_0_99_305 VGND VGND VPWR VPWR sky130_fd_sc_hd__decap_4
X_6149_ _2854_ _2855_ _2391_ VGND VGND VPWR VPWR _2856_ sky130_fd_sc_hd__o21a_1
XTAP_TAPCELL_ROW_107_1910 VGND VPWR sky130_fd_sc_hd__tapvpwrvgnd_1
XPHY_EDGE_ROW_79_Right_79 VGND VGND VPWR VPWR sky130_fd_sc_hd__decap_3
XFILLER_0_68_769 VPWR VGND VPWR VGND sky130_ef_sc_hd__decap_12
XFILLER_0_138_657 VPWR VGND VPWR VGND sky130_ef_sc_hd__decap_12
XFILLER_0_137_167 VGND VGND VPWR VPWR sky130_fd_sc_hd__fill_1
XFILLER_0_125_329 VGND VGND VPWR VPWR sky130_fd_sc_hd__decap_6
XFILLER_0_82_249 VGND VGND VPWR VPWR sky130_fd_sc_hd__decap_3
XTAP_TAPCELL_ROW_136_2339 VGND VPWR sky130_fd_sc_hd__tapvpwrvgnd_1
XFILLER_0_134_841 VGND VGND VPWR VPWR sky130_fd_sc_hd__fill_1
XFILLER_0_91_783 VGND VGND VPWR VPWR sky130_fd_sc_hd__fill_1
XFILLER_0_51_614 VGND VGND VPWR VPWR sky130_fd_sc_hd__fill_2
XFILLER_0_36_688 VPWR VGND VPWR VGND sky130_ef_sc_hd__decap_12
XPHY_EDGE_ROW_88_Right_88 VGND VGND VPWR VPWR sky130_fd_sc_hd__decap_3
XTAP_TAPCELL_ROW_11_469 VGND VPWR sky130_fd_sc_hd__tapvpwrvgnd_1
XTAP_TAPCELL_ROW_11_458 VGND VPWR sky130_fd_sc_hd__tapvpwrvgnd_1
XFILLER_0_23_316 VGND VGND VPWR VPWR sky130_fd_sc_hd__fill_1
XFILLER_0_133_373 VPWR VGND VPWR VGND sky130_ef_sc_hd__decap_12
XFILLER_0_121_502 VGND VGND VPWR VPWR sky130_fd_sc_hd__fill_2
XFILLER_0_106_598 VGND VGND VPWR VPWR sky130_fd_sc_hd__fill_2
XFILLER_0_51_669 VGND VGND VPWR VPWR sky130_fd_sc_hd__decap_3
XFILLER_0_31_371 VGND VGND VPWR VPWR sky130_fd_sc_hd__decap_8
XFILLER_0_102_793 VPWR VGND VPWR VGND sky130_ef_sc_hd__decap_12
XFILLER_0_101_270 VGND VGND VPWR VPWR sky130_fd_sc_hd__fill_1
XTAP_TAPCELL_ROW_73_1390 VGND VPWR sky130_fd_sc_hd__tapvpwrvgnd_1
XPHY_EDGE_ROW_97_Right_97 VGND VGND VPWR VPWR sky130_fd_sc_hd__decap_3
XFILLER_0_92_29 VPWR VGND VPWR VGND sky130_ef_sc_hd__decap_12
XFILLER_0_98_360 VGND VGND VPWR VPWR sky130_fd_sc_hd__decap_4
XFILLER_0_98_393 VGND VGND VPWR VPWR sky130_fd_sc_hd__fill_1
XFILLER_0_116_307 VGND VGND VPWR VPWR sky130_fd_sc_hd__fill_1
XPHY_EDGE_ROW_4_Left_143 VGND VGND VPWR VPWR sky130_fd_sc_hd__decap_3
XFILLER_0_128_189 VGND VGND VPWR VPWR sky130_fd_sc_hd__decap_6
XFILLER_0_125_841 VGND VGND VPWR VPWR sky130_fd_sc_hd__fill_1
XTAP_TAPCELL_ROW_30_745 VGND VPWR sky130_fd_sc_hd__tapvpwrvgnd_1
XTAP_TAPCELL_ROW_30_756 VGND VPWR sky130_fd_sc_hd__tapvpwrvgnd_1
X_5520_ _1056_ _1643_ VGND VGND VPWR VPWR _2251_ sky130_fd_sc_hd__or2_1
XFILLER_0_81_271 VGND VGND VPWR VPWR sky130_fd_sc_hd__decap_8
XFILLER_0_15_839 VGND VGND VPWR VPWR sky130_fd_sc_hd__fill_1
XTAP_TAPCELL_ROW_93_1700 VGND VPWR sky130_fd_sc_hd__tapvpwrvgnd_1
X_5451_ rf.registers\[20\]\[31\] rf.registers\[21\]\[31\] rf.registers\[22\]\[31\]
+ rf.registers\[23\]\[31\] _2109_ _2110_ VGND VGND VPWR VPWR _2183_ sky130_fd_sc_hd__mux4_1
XFILLER_0_42_658 VGND VGND VPWR VPWR sky130_fd_sc_hd__decap_8
X_8170_ _3353_ rf.registers\[21\]\[3\] _4023_ VGND VGND VPWR VPWR _4027_ sky130_fd_sc_hd__mux2_1
X_4402_ _1125_ VGND VGND VPWR VPWR _1191_ sky130_fd_sc_hd__clkbuf_8
XFILLER_0_2_755 VGND VGND VPWR VPWR sky130_fd_sc_hd__fill_1
X_5382_ _1964_ _2104_ _2108_ _2118_ VGND VGND VPWR VPWR _2119_ sky130_fd_sc_hd__a31oi_4
XFILLER_0_41_179 VPWR VGND VPWR VGND sky130_ef_sc_hd__decap_12
X_4333_ rf.registers\[24\]\[4\] rf.registers\[25\]\[4\] rf.registers\[26\]\[4\] rf.registers\[27\]\[4\]
+ _1120_ _1123_ VGND VGND VPWR VPWR _1124_ sky130_fd_sc_hd__mux4_1
XFILLER_0_10_533 VPWR VGND VPWR VGND sky130_ef_sc_hd__decap_12
X_7121_ rf.registers\[5\]\[23\] _3326_ _3466_ VGND VGND VPWR VPWR _3470_ sky130_fd_sc_hd__mux2_1
X_4264_ rf.registers\[16\]\[1\] rf.registers\[17\]\[1\] rf.registers\[18\]\[1\] rf.registers\[19\]\[1\]
+ _1041_ _1043_ VGND VGND VPWR VPWR _1058_ sky130_fd_sc_hd__mux4_1
XFILLER_0_10_577 VGND VGND VPWR VPWR sky130_fd_sc_hd__decap_4
X_7052_ _3433_ VGND VGND VPWR VPWR _0983_ sky130_fd_sc_hd__clkbuf_1
XFILLER_0_10_599 VGND VGND VPWR VPWR sky130_fd_sc_hd__fill_1
XFILLER_0_5_55 VGND VGND VPWR VPWR sky130_fd_sc_hd__fill_1
X_6003_ _2681_ _2717_ _2259_ VGND VGND VPWR VPWR _2718_ sky130_fd_sc_hd__mux2_1
XFILLER_0_97_809 VPWR VGND VPWR VGND sky130_ef_sc_hd__decap_12
X_7954_ _2978_ rf.registers\[23\]\[30\] _3878_ VGND VGND VPWR VPWR _3912_ sky130_fd_sc_hd__mux2_1
XTAP_TAPCELL_ROW_120_2107 VGND VPWR sky130_fd_sc_hd__tapvpwrvgnd_1
X_6905_ net38 VGND VGND VPWR VPWR _3342_ sky130_fd_sc_hd__buf_2
XFILLER_0_10_3 VPWR VGND VPWR VGND sky130_ef_sc_hd__decap_12
XTAP_TAPCELL_ROW_38_867 VGND VPWR sky130_fd_sc_hd__tapvpwrvgnd_1
X_7885_ _2978_ rf.registers\[28\]\[30\] _3841_ VGND VGND VPWR VPWR _3875_ sky130_fd_sc_hd__mux2_1
X_6836_ _3295_ VGND VGND VPWR VPWR _0905_ sky130_fd_sc_hd__clkbuf_1
XFILLER_0_49_279 VGND VGND VPWR VPWR sky130_fd_sc_hd__fill_1
X_9555_ clknet_leaf_44_CLK _0643_ VGND VGND VPWR VPWR rf.registers\[13\]\[2\] sky130_fd_sc_hd__dfxtp_1
XFILLER_0_119_167 VGND VGND VPWR VPWR sky130_fd_sc_hd__fill_1
X_6767_ rf.registers\[0\]\[12\] _3012_ _3252_ VGND VGND VPWR VPWR _3255_ sky130_fd_sc_hd__mux2_1
XPHY_EDGE_ROW_59_Left_198 VGND VGND VPWR VPWR sky130_fd_sc_hd__decap_3
XFILLER_0_128_690 VGND VGND VPWR VPWR sky130_fd_sc_hd__decap_8
X_8506_ _2991_ rf.registers\[13\]\[2\] _2968_ VGND VGND VPWR VPWR _4204_ sky130_fd_sc_hd__mux2_1
XFILLER_0_107_329 VGND VGND VPWR VPWR sky130_fd_sc_hd__decap_3
X_5718_ _2444_ _2445_ _2237_ VGND VGND VPWR VPWR _2446_ sky130_fd_sc_hd__mux2_1
XTAP_TAPCELL_ROW_118_2069 VGND VPWR sky130_fd_sc_hd__tapvpwrvgnd_1
X_6698_ _3218_ VGND VGND VPWR VPWR _0844_ sky130_fd_sc_hd__clkbuf_1
XFILLER_0_73_783 VGND VGND VPWR VPWR sky130_fd_sc_hd__fill_1
X_9486_ clknet_leaf_93_CLK _0574_ VGND VGND VPWR VPWR rf.registers\[20\]\[29\] sky130_fd_sc_hd__dfxtp_1
XFILLER_0_33_625 VGND VGND VPWR VPWR sky130_fd_sc_hd__decap_3
XFILLER_0_33_647 VPWR VGND VPWR VGND sky130_ef_sc_hd__decap_12
XFILLER_0_131_833 VGND VGND VPWR VPWR sky130_fd_sc_hd__decap_6
X_8437_ _4168_ VGND VGND VPWR VPWR _0609_ sky130_fd_sc_hd__clkbuf_1
XFILLER_0_115_373 VGND VGND VPWR VPWR sky130_fd_sc_hd__decap_4
XFILLER_0_60_433 VGND VGND VPWR VPWR sky130_fd_sc_hd__fill_2
XFILLER_0_21_809 VPWR VGND VPWR VGND sky130_ef_sc_hd__decap_12
X_5649_ _2241_ _2288_ VGND VGND VPWR VPWR _2379_ sky130_fd_sc_hd__nand2_1
XTAP_TAPCELL_ROW_131_2258 VGND VPWR sky130_fd_sc_hd__tapvpwrvgnd_1
XFILLER_0_130_321 VPWR VGND VPWR VGND sky130_ef_sc_hd__decap_12
X_8368_ rf.registers\[18\]\[0\] net14 _4131_ VGND VGND VPWR VPWR _4132_ sky130_fd_sc_hd__mux2_1
XTAP_TAPCELL_ROW_131_2269 VGND VPWR sky130_fd_sc_hd__tapvpwrvgnd_1
XFILLER_0_130_365 VPWR VGND VPWR VGND sky130_ef_sc_hd__decap_12
XFILLER_0_13_393 VPWR VGND VPWR VGND sky130_ef_sc_hd__decap_12
X_7319_ rf.registers\[3\]\[20\] _3319_ _3574_ VGND VGND VPWR VPWR _3575_ sky130_fd_sc_hd__mux2_1
X_8299_ _4094_ VGND VGND VPWR VPWR _4095_ sky130_fd_sc_hd__clkbuf_8
XTAP_TAPCELL_ROW_113_1991 VGND VPWR sky130_fd_sc_hd__tapvpwrvgnd_1
XPHY_EDGE_ROW_130_Right_130 VGND VGND VPWR VPWR sky130_fd_sc_hd__decap_3
XFILLER_0_68_533 VGND VGND VPWR VPWR sky130_fd_sc_hd__fill_1
XTAP_TAPCELL_ROW_47_1009 VGND VPWR sky130_fd_sc_hd__tapvpwrvgnd_1
XFILLER_0_95_341 VGND VGND VPWR VPWR sky130_fd_sc_hd__fill_1
XFILLER_0_68_566 VGND VGND VPWR VPWR sky130_fd_sc_hd__fill_1
XTAP_TAPCELL_ROW_16_539 VGND VPWR sky130_fd_sc_hd__tapvpwrvgnd_1
XFILLER_0_138_421 VGND VGND VPWR VPWR sky130_fd_sc_hd__fill_2
XFILLER_0_28_408 VGND VGND VPWR VPWR sky130_fd_sc_hd__decap_3
XFILLER_0_95_396 VGND VGND VPWR VPWR sky130_fd_sc_hd__decap_8
XFILLER_0_125_137 VPWR VGND VPWR VGND sky130_ef_sc_hd__decap_12
XFILLER_0_107_841 VGND VGND VPWR VPWR sky130_fd_sc_hd__fill_1
XFILLER_0_102_27 VGND VGND VPWR VPWR sky130_fd_sc_hd__fill_1
XFILLER_0_70_219 VGND VGND VPWR VPWR sky130_fd_sc_hd__fill_1
XFILLER_0_23_113 VGND VGND VPWR VPWR sky130_fd_sc_hd__fill_1
XFILLER_0_134_693 VGND VGND VPWR VPWR sky130_fd_sc_hd__decap_6
XFILLER_0_122_811 VGND VGND VPWR VPWR sky130_fd_sc_hd__fill_1
XFILLER_0_106_362 VGND VGND VPWR VPWR sky130_fd_sc_hd__fill_2
XFILLER_0_11_69 VPWR VGND VPWR VGND sky130_ef_sc_hd__decap_12
XFILLER_0_133_181 VPWR VGND VPWR VGND sky130_ef_sc_hd__decap_12
XTAP_TAPCELL_ROW_75_1430 VGND VPWR sky130_fd_sc_hd__tapvpwrvgnd_1
Xinput7 A2[3] VGND VGND VPWR VPWR net7 sky130_fd_sc_hd__buf_1
XFILLER_0_127_57 VPWR VGND VPWR VGND sky130_ef_sc_hd__decap_12
XFILLER_0_79_809 VPWR VGND VPWR VGND sky130_ef_sc_hd__decap_12
XFILLER_0_59_500 VGND VGND VPWR VPWR sky130_fd_sc_hd__decap_4
X_4951_ _1683_ _1692_ _1710_ VGND VGND VPWR VPWR _1711_ sky130_fd_sc_hd__o21ai_4
XTAP_TAPCELL_ROW_86_1592 VGND VPWR sky130_fd_sc_hd__tapvpwrvgnd_1
XTAP_TAPCELL_ROW_35_826 VGND VPWR sky130_fd_sc_hd__tapvpwrvgnd_1
X_4882_ rf.registers\[20\]\[1\] rf.registers\[21\]\[1\] rf.registers\[22\]\[1\] rf.registers\[23\]\[1\]
+ _1617_ _1618_ VGND VGND VPWR VPWR _1644_ sky130_fd_sc_hd__mux4_1
X_7670_ rf.registers\[2\]\[25\] _3330_ _3755_ VGND VGND VPWR VPWR _3761_ sky130_fd_sc_hd__mux2_1
XFILLER_0_46_205 VGND VGND VPWR VPWR sky130_fd_sc_hd__fill_2
X_6621_ rf.registers\[24\]\[8\] _3003_ _3168_ VGND VGND VPWR VPWR _3177_ sky130_fd_sc_hd__mux2_1
X_9340_ clknet_leaf_13_CLK _0428_ VGND VGND VPWR VPWR rf.registers\[7\]\[11\] sky130_fd_sc_hd__dfxtp_1
X_6552_ rf.registers\[1\]\[8\] _3003_ _3131_ VGND VGND VPWR VPWR _3140_ sky130_fd_sc_hd__mux2_1
XFILLER_0_55_783 VGND VGND VPWR VPWR sky130_fd_sc_hd__fill_1
XFILLER_0_54_282 VGND VGND VPWR VPWR sky130_fd_sc_hd__decap_8
XFILLER_0_6_357 VGND VGND VPWR VPWR sky130_fd_sc_hd__decap_6
XFILLER_0_15_614 VGND VGND VPWR VPWR sky130_fd_sc_hd__fill_2
XFILLER_0_113_833 VGND VGND VPWR VPWR sky130_fd_sc_hd__decap_6
X_6483_ rf.registers\[17\]\[8\] _3003_ _3094_ VGND VGND VPWR VPWR _3103_ sky130_fd_sc_hd__mux2_1
X_9271_ clknet_leaf_56_CLK _0359_ VGND VGND VPWR VPWR rf.registers\[23\]\[6\] sky130_fd_sc_hd__dfxtp_1
X_5503_ _2233_ VGND VGND VPWR VPWR _2234_ sky130_fd_sc_hd__clkbuf_4
X_8222_ _3045_ rf.registers\[21\]\[28\] _4045_ VGND VGND VPWR VPWR _4054_ sky130_fd_sc_hd__mux2_1
X_5434_ rf.registers\[16\]\[30\] rf.registers\[17\]\[30\] rf.registers\[18\]\[30\]
+ rf.registers\[19\]\[30\] _2070_ _2071_ VGND VGND VPWR VPWR _2167_ sky130_fd_sc_hd__mux4_1
XFILLER_0_112_365 VGND VGND VPWR VPWR sky130_fd_sc_hd__decap_3
X_8153_ _4017_ VGND VGND VPWR VPWR _0476_ sky130_fd_sc_hd__clkbuf_1
X_7104_ rf.registers\[5\]\[15\] _3309_ _3455_ VGND VGND VPWR VPWR _3461_ sky130_fd_sc_hd__mux2_1
XFILLER_0_77_51 VGND VGND VPWR VPWR sky130_fd_sc_hd__decap_4
XFILLER_0_58_3 VPWR VGND VPWR VGND sky130_ef_sc_hd__decap_12
XFILLER_0_10_363 VGND VGND VPWR VPWR sky130_fd_sc_hd__fill_1
X_5365_ rf.registers\[16\]\[26\] rf.registers\[17\]\[26\] rf.registers\[18\]\[26\]
+ rf.registers\[19\]\[26\] _2070_ _2071_ VGND VGND VPWR VPWR _2102_ sky130_fd_sc_hd__mux4_1
X_4316_ _1025_ _1107_ VGND VGND VPWR VPWR _1108_ sky130_fd_sc_hd__nand2_1
X_8084_ rf.registers\[7\]\[27\] _3334_ _3973_ VGND VGND VPWR VPWR _3981_ sky130_fd_sc_hd__mux2_1
X_5296_ _2033_ _2034_ _2035_ _2036_ _1741_ _1742_ VGND VGND VPWR VPWR _2037_ sky130_fd_sc_hd__mux4_1
X_4247_ _1041_ VGND VGND VPWR VPWR _1042_ sky130_fd_sc_hd__buf_4
X_7035_ _3424_ VGND VGND VPWR VPWR _0975_ sky130_fd_sc_hd__clkbuf_1
XFILLER_0_93_72 VGND VGND VPWR VPWR sky130_fd_sc_hd__fill_1
X_8986_ clknet_leaf_35_CLK _0074_ VGND VGND VPWR VPWR rf.registers\[3\]\[9\] sky130_fd_sc_hd__dfxtp_1
XPHY_EDGE_ROW_67_Left_206 VGND VGND VPWR VPWR sky130_fd_sc_hd__decap_3
X_7937_ _3903_ VGND VGND VPWR VPWR _0374_ sky130_fd_sc_hd__clkbuf_1
XFILLER_0_65_503 VGND VGND VPWR VPWR sky130_fd_sc_hd__fill_1
X_7868_ _3866_ VGND VGND VPWR VPWR _0342_ sky130_fd_sc_hd__clkbuf_1
XFILLER_0_38_717 VPWR VGND VPWR VGND sky130_ef_sc_hd__decap_12
X_6819_ net39 VGND VGND VPWR VPWR _3284_ sky130_fd_sc_hd__clkbuf_2
X_7799_ rf.registers\[9\]\[21\] _3322_ _3828_ VGND VGND VPWR VPWR _3830_ sky130_fd_sc_hd__mux2_1
XFILLER_0_18_430 VPWR VGND VPWR VGND sky130_ef_sc_hd__decap_12
XFILLER_0_135_457 VGND VGND VPWR VPWR sky130_fd_sc_hd__decap_3
X_9538_ clknet_leaf_11_CLK _0626_ VGND VGND VPWR VPWR rf.registers\[14\]\[17\] sky130_fd_sc_hd__dfxtp_1
XFILLER_0_45_260 VGND VGND VPWR VPWR sky130_fd_sc_hd__fill_2
X_9469_ clknet_leaf_23_CLK _0557_ VGND VGND VPWR VPWR rf.registers\[20\]\[12\] sky130_fd_sc_hd__dfxtp_1
XFILLER_0_104_811 VGND VGND VPWR VPWR sky130_fd_sc_hd__fill_1
XFILLER_0_61_753 VPWR VGND VPWR VGND sky130_ef_sc_hd__decap_12
XFILLER_0_60_230 VGND VGND VPWR VPWR sky130_fd_sc_hd__fill_2
XFILLER_0_115_181 VPWR VGND VPWR VGND sky130_ef_sc_hd__decap_12
XFILLER_0_61_797 VPWR VGND VPWR VGND sky130_ef_sc_hd__decap_12
XFILLER_0_21_617 VGND VGND VPWR VPWR sky130_fd_sc_hd__decap_4
XFILLER_0_131_685 VPWR VGND VPWR VGND sky130_ef_sc_hd__decap_12
XPHY_EDGE_ROW_76_Left_215 VGND VGND VPWR VPWR sky130_fd_sc_hd__decap_3
XFILLER_0_130_195 VGND VGND VPWR VPWR sky130_fd_sc_hd__fill_1
XTAP_TAPCELL_ROW_57_1160 VGND VPWR sky130_fd_sc_hd__tapvpwrvgnd_1
XPHY_EDGE_ROW_85_Left_224 VGND VGND VPWR VPWR sky130_fd_sc_hd__decap_3
XFILLER_0_96_661 VGND VGND VPWR VPWR sky130_fd_sc_hd__fill_2
XFILLER_0_113_15 VPWR VGND VPWR VGND sky130_ef_sc_hd__decap_12
XFILLER_0_3_305 VPWR VGND VPWR VGND sky130_ef_sc_hd__decap_12
XTAP_TAPCELL_ROW_40_895 VGND VPWR sky130_fd_sc_hd__tapvpwrvgnd_1
XPHY_EDGE_ROW_94_Left_233 VGND VGND VPWR VPWR sky130_fd_sc_hd__decap_3
XFILLER_0_11_105 VGND VGND VPWR VPWR sky130_fd_sc_hd__decap_6
XFILLER_0_3_349 VPWR VGND VPWR VGND sky130_ef_sc_hd__decap_12
XFILLER_0_110_825 VPWR VGND VPWR VGND sky130_ef_sc_hd__decap_12
XFILLER_0_51_296 VGND VGND VPWR VPWR sky130_fd_sc_hd__fill_1
XFILLER_0_122_685 VPWR VGND VPWR VGND sky130_ef_sc_hd__decap_12
XFILLER_0_11_149 VPWR VGND VPWR VGND sky130_ef_sc_hd__decap_12
X_5150_ rf.registers\[0\]\[14\] rf.registers\[1\]\[14\] rf.registers\[2\]\[14\] rf.registers\[3\]\[14\]
+ _1694_ _1695_ VGND VGND VPWR VPWR _1899_ sky130_fd_sc_hd__mux4_1
XFILLER_0_20_694 VGND VGND VPWR VPWR sky130_fd_sc_hd__decap_6
X_5081_ rf.registers\[8\]\[10\] rf.registers\[9\]\[10\] rf.registers\[10\]\[10\] rf.registers\[11\]\[10\]
+ _1734_ _1797_ VGND VGND VPWR VPWR _1834_ sky130_fd_sc_hd__mux4_1
XFILLER_0_47_54 VGND VGND VPWR VPWR sky130_fd_sc_hd__fill_2
XFILLER_0_138_89 VPWR VGND VPWR VGND sky130_ef_sc_hd__decap_12
XTAP_TAPCELL_ROW_88_1621 VGND VPWR sky130_fd_sc_hd__tapvpwrvgnd_1
XFILLER_0_79_617 VPWR VGND VPWR VGND sky130_ef_sc_hd__decap_12
X_8840_ clknet_leaf_2_CLK _0952_ VGND VGND VPWR VPWR rf.registers\[15\]\[23\] sky130_fd_sc_hd__dfxtp_1
X_8771_ clknet_leaf_7_CLK _0883_ VGND VGND VPWR VPWR rf.registers\[0\]\[18\] sky130_fd_sc_hd__dfxtp_1
X_5983_ _2555_ _2571_ _2642_ _2440_ VGND VGND VPWR VPWR _2699_ sky130_fd_sc_hd__o22a_1
X_4934_ _1631_ VGND VGND VPWR VPWR _1694_ sky130_fd_sc_hd__clkbuf_8
X_7722_ _3382_ rf.registers\[30\]\[17\] _3781_ VGND VGND VPWR VPWR _3789_ sky130_fd_sc_hd__mux2_1
XFILLER_0_47_514 VGND VGND VPWR VPWR sky130_fd_sc_hd__decap_4
XFILLER_0_59_385 VGND VGND VPWR VPWR sky130_fd_sc_hd__fill_1
XFILLER_0_129_273 VGND VGND VPWR VPWR sky130_fd_sc_hd__decap_6
X_4865_ net4 VGND VGND VPWR VPWR _1628_ sky130_fd_sc_hd__clkbuf_8
X_7653_ rf.registers\[2\]\[17\] _3313_ _3744_ VGND VGND VPWR VPWR _3752_ sky130_fd_sc_hd__mux2_1
XANTENNA_12 net66 VGND VGND VPWR VPWR sky130_fd_sc_hd__diode_2
XFILLER_0_35_709 VPWR VGND VPWR VGND sky130_ef_sc_hd__decap_12
XFILLER_0_90_837 VGND VGND VPWR VPWR sky130_fd_sc_hd__fill_2
X_7584_ _3715_ VGND VGND VPWR VPWR _0209_ sky130_fd_sc_hd__clkbuf_1
X_6604_ _3167_ VGND VGND VPWR VPWR _3168_ sky130_fd_sc_hd__clkbuf_8
XFILLER_0_6_121 VPWR VGND VPWR VGND sky130_ef_sc_hd__decap_12
X_4796_ _1561_ _1562_ _1381_ VGND VGND VPWR VPWR _1563_ sky130_fd_sc_hd__mux2_1
XTAP_TAPCELL_ROW_115_2028 VGND VPWR sky130_fd_sc_hd__tapvpwrvgnd_1
X_6535_ _3130_ VGND VGND VPWR VPWR _3131_ sky130_fd_sc_hd__buf_4
XFILLER_0_7_699 VGND VGND VPWR VPWR sky130_fd_sc_hd__decap_8
XFILLER_0_6_165 VPWR VGND VPWR VGND sky130_ef_sc_hd__decap_12
X_9323_ clknet_leaf_70_CLK _0411_ VGND VGND VPWR VPWR rf.registers\[22\]\[26\] sky130_fd_sc_hd__dfxtp_1
XFILLER_0_43_742 VPWR VGND VPWR VGND sky130_ef_sc_hd__decap_12
XTAP_TAPCELL_ROW_99_1783 VGND VPWR sky130_fd_sc_hd__tapvpwrvgnd_1
X_9254_ clknet_leaf_9_CLK _0342_ VGND VGND VPWR VPWR rf.registers\[28\]\[21\] sky130_fd_sc_hd__dfxtp_1
XFILLER_0_43_797 VPWR VGND VPWR VGND sky130_ef_sc_hd__decap_12
X_6466_ _3093_ VGND VGND VPWR VPWR _3094_ sky130_fd_sc_hd__buf_4
XFILLER_0_30_447 VGND VGND VPWR VPWR sky130_fd_sc_hd__fill_1
X_8205_ _4022_ VGND VGND VPWR VPWR _4045_ sky130_fd_sc_hd__buf_4
X_6397_ rf.registers\[11\]\[0\] _2982_ _3056_ VGND VGND VPWR VPWR _3057_ sky130_fd_sc_hd__mux2_1
X_9185_ clknet_leaf_19_CLK _0273_ VGND VGND VPWR VPWR rf.registers\[30\]\[16\] sky130_fd_sc_hd__dfxtp_1
Xoutput130 net130 VGND VGND VPWR VPWR alu_result[25] sky130_fd_sc_hd__buf_1
Xoutput141 net141 VGND VGND VPWR VPWR alu_result[6] sky130_fd_sc_hd__buf_1
X_5417_ rf.registers\[16\]\[29\] rf.registers\[17\]\[29\] rf.registers\[18\]\[29\]
+ rf.registers\[19\]\[29\] _1959_ _1960_ VGND VGND VPWR VPWR _2151_ sky130_fd_sc_hd__mux4_1
X_8136_ _4008_ VGND VGND VPWR VPWR _0468_ sky130_fd_sc_hd__clkbuf_1
X_5348_ _1922_ VGND VGND VPWR VPWR _2086_ sky130_fd_sc_hd__clkbuf_8
XTAP_TAPCELL_ROW_110_1950 VGND VPWR sky130_fd_sc_hd__tapvpwrvgnd_1
X_8067_ rf.registers\[7\]\[19\] _3317_ _3962_ VGND VGND VPWR VPWR _3972_ sky130_fd_sc_hd__mux2_1
X_7018_ _3415_ VGND VGND VPWR VPWR _0967_ sky130_fd_sc_hd__clkbuf_1
X_5279_ rf.registers\[24\]\[21\] rf.registers\[25\]\[21\] rf.registers\[26\]\[21\]
+ rf.registers\[27\]\[21\] _1922_ _1923_ VGND VGND VPWR VPWR _2021_ sky130_fd_sc_hd__mux4_1
XFILLER_0_97_447 VGND VGND VPWR VPWR sky130_fd_sc_hd__fill_1
X_8969_ clknet_leaf_72_CLK _0057_ VGND VGND VPWR VPWR rf.registers\[19\]\[24\] sky130_fd_sc_hd__dfxtp_1
XTAP_TAPCELL_ROW_26_689 VGND VPWR sky130_fd_sc_hd__tapvpwrvgnd_1
XFILLER_0_92_130 VGND VGND VPWR VPWR sky130_fd_sc_hd__fill_1
XFILLER_0_136_755 VGND VGND VPWR VPWR sky130_fd_sc_hd__fill_1
XFILLER_0_93_697 VPWR VGND VPWR VGND sky130_ef_sc_hd__decap_12
XFILLER_0_65_388 VGND VGND VPWR VPWR sky130_fd_sc_hd__fill_1
XFILLER_0_53_517 VGND VGND VPWR VPWR sky130_fd_sc_hd__decap_4
XFILLER_0_61_561 VGND VGND VPWR VPWR sky130_fd_sc_hd__decap_6
XFILLER_0_1_809 VPWR VGND VPWR VGND sky130_ef_sc_hd__decap_12
XFILLER_0_33_241 VGND VGND VPWR VPWR sky130_fd_sc_hd__fill_2
XFILLER_0_34_775 VGND VGND VPWR VPWR sky130_fd_sc_hd__decap_4
XTAP_TAPCELL_ROW_55_1119 VGND VPWR sky130_fd_sc_hd__tapvpwrvgnd_1
XFILLER_0_108_15 VPWR VGND VPWR VGND sky130_ef_sc_hd__decap_12
XTAP_TAPCELL_ROW_6_392 VGND VPWR sky130_fd_sc_hd__tapvpwrvgnd_1
XFILLER_0_17_57 VPWR VGND VPWR VGND sky130_ef_sc_hd__decap_12
XTAP_TAPCELL_ROW_83_1540 VGND VPWR sky130_fd_sc_hd__tapvpwrvgnd_1
XFILLER_0_29_503 VGND VGND VPWR VPWR sky130_fd_sc_hd__fill_1
XTAP_TAPCELL_ROW_83_1551 VGND VPWR sky130_fd_sc_hd__tapvpwrvgnd_1
XFILLER_0_8_419 VGND VGND VPWR VPWR sky130_fd_sc_hd__fill_1
XTAP_TAPCELL_ROW_45_976 VGND VPWR sky130_fd_sc_hd__tapvpwrvgnd_1
XFILLER_0_126_221 VPWR VGND VPWR VGND sky130_ef_sc_hd__decap_12
X_4650_ rf.registers\[0\]\[19\] rf.registers\[1\]\[19\] rf.registers\[2\]\[19\] rf.registers\[3\]\[19\]
+ _1410_ _1411_ VGND VGND VPWR VPWR _1426_ sky130_fd_sc_hd__mux4_1
XFILLER_0_72_837 VGND VGND VPWR VPWR sky130_fd_sc_hd__fill_2
Xinput10 A3[1] VGND VGND VPWR VPWR net10 sky130_fd_sc_hd__buf_4
XFILLER_0_127_777 VGND VGND VPWR VPWR sky130_fd_sc_hd__decap_6
XFILLER_0_126_265 VPWR VGND VPWR VGND sky130_ef_sc_hd__decap_12
XFILLER_0_116_3 VPWR VGND VPWR VGND sky130_ef_sc_hd__decap_12
Xinput21 WD3[16] VGND VGND VPWR VPWR net21 sky130_fd_sc_hd__buf_1
XFILLER_0_4_625 VGND VGND VPWR VPWR sky130_fd_sc_hd__decap_8
Xinput43 WD3[7] VGND VGND VPWR VPWR net43 sky130_fd_sc_hd__clkbuf_4
X_6320_ rf.registers\[12\]\[8\] _3003_ _2987_ VGND VGND VPWR VPWR _3004_ sky130_fd_sc_hd__mux2_1
X_4581_ rf.registers\[16\]\[16\] rf.registers\[17\]\[16\] rf.registers\[18\]\[16\]
+ rf.registers\[19\]\[16\] _1191_ _1192_ VGND VGND VPWR VPWR _1360_ sky130_fd_sc_hd__mux4_1
XFILLER_0_71_369 VGND VGND VPWR VPWR sky130_fd_sc_hd__decap_6
XFILLER_0_3_113 VPWR VGND VPWR VGND sky130_ef_sc_hd__decap_12
Xinput32 WD3[26] VGND VGND VPWR VPWR net32 sky130_fd_sc_hd__buf_2
XFILLER_0_40_701 VGND VGND VPWR VPWR sky130_fd_sc_hd__fill_2
XFILLER_0_40_745 VGND VGND VPWR VPWR sky130_fd_sc_hd__decap_8
XFILLER_0_122_471 VGND VGND VPWR VPWR sky130_fd_sc_hd__fill_2
XFILLER_0_12_469 VGND VGND VPWR VPWR sky130_fd_sc_hd__decap_6
X_6251_ _2946_ VGND VGND VPWR VPWR _2951_ sky130_fd_sc_hd__inv_2
Xclkbuf_leaf_30_CLK clknet_3_4__leaf_CLK VGND VGND VPWR VPWR clknet_leaf_30_CLK sky130_fd_sc_hd__clkbuf_8
X_5202_ _1744_ VGND VGND VPWR VPWR _1948_ sky130_fd_sc_hd__buf_4
X_6182_ _2479_ _2885_ VGND VGND VPWR VPWR _2886_ sky130_fd_sc_hd__nand2_1
X_5133_ _1764_ _1882_ VGND VGND VPWR VPWR _1883_ sky130_fd_sc_hd__nand2_1
X_5064_ rf.registers\[4\]\[9\] rf.registers\[5\]\[9\] rf.registers\[6\]\[9\] rf.registers\[7\]\[9\]
+ _1816_ _1817_ VGND VGND VPWR VPWR _1818_ sky130_fd_sc_hd__mux4_1
XFILLER_0_79_425 VGND VGND VPWR VPWR sky130_fd_sc_hd__decap_3
XFILLER_0_74_85 VGND VGND VPWR VPWR sky130_fd_sc_hd__fill_2
XFILLER_0_79_458 VGND VGND VPWR VPWR sky130_fd_sc_hd__decap_6
X_8823_ clknet_leaf_58_CLK _0935_ VGND VGND VPWR VPWR rf.registers\[15\]\[6\] sky130_fd_sc_hd__dfxtp_1
X_8754_ clknet_leaf_46_CLK _0866_ VGND VGND VPWR VPWR rf.registers\[0\]\[1\] sky130_fd_sc_hd__dfxtp_1
XFILLER_0_59_182 VPWR VGND VPWR VGND sky130_ef_sc_hd__decap_12
X_5966_ _2604_ _2682_ _2340_ VGND VGND VPWR VPWR _2683_ sky130_fd_sc_hd__mux2_1
X_4917_ rf.registers\[8\]\[2\] rf.registers\[9\]\[2\] rf.registers\[10\]\[2\] rf.registers\[11\]\[2\]
+ _1624_ _1625_ VGND VGND VPWR VPWR _1678_ sky130_fd_sc_hd__mux4_1
X_7705_ _3365_ rf.registers\[30\]\[9\] _3770_ VGND VGND VPWR VPWR _3780_ sky130_fd_sc_hd__mux2_1
XFILLER_0_75_653 VPWR VGND VPWR VGND sky130_ef_sc_hd__decap_12
X_5897_ _2614_ _2617_ VGND VGND VPWR VPWR _2618_ sky130_fd_sc_hd__xor2_1
XTAP_TAPCELL_ROW_23_648 VGND VPWR sky130_fd_sc_hd__tapvpwrvgnd_1
X_8685_ clknet_leaf_90_CLK _0797_ VGND VGND VPWR VPWR rf.registers\[1\]\[28\] sky130_fd_sc_hd__dfxtp_1
XFILLER_0_118_755 VGND VGND VPWR VPWR sky130_fd_sc_hd__fill_1
X_7636_ rf.registers\[2\]\[9\] _3296_ _3733_ VGND VGND VPWR VPWR _3743_ sky130_fd_sc_hd__mux2_1
XFILLER_0_75_697 VPWR VGND VPWR VGND sky130_ef_sc_hd__decap_12
XFILLER_0_62_303 VGND VGND VPWR VPWR sky130_fd_sc_hd__decap_4
X_4848_ rf.registers\[0\]\[31\] rf.registers\[1\]\[31\] rf.registers\[2\]\[31\] rf.registers\[3\]\[31\]
+ _1172_ _1173_ VGND VGND VPWR VPWR _1612_ sky130_fd_sc_hd__mux4_1
XFILLER_0_7_441 VGND VGND VPWR VPWR sky130_fd_sc_hd__decap_6
XFILLER_0_7_485 VPWR VGND VPWR VGND sky130_ef_sc_hd__decap_12
XFILLER_0_16_731 VPWR VGND VPWR VGND sky130_ef_sc_hd__decap_12
X_7567_ _3706_ VGND VGND VPWR VPWR _0201_ sky130_fd_sc_hd__clkbuf_1
XFILLER_0_90_678 VPWR VGND VPWR VGND sky130_ef_sc_hd__decap_12
X_9306_ clknet_leaf_56_CLK _0394_ VGND VGND VPWR VPWR rf.registers\[22\]\[9\] sky130_fd_sc_hd__dfxtp_1
X_4779_ _1381_ _1546_ VGND VGND VPWR VPWR _1547_ sky130_fd_sc_hd__and2_1
XFILLER_0_43_561 VPWR VGND VPWR VGND sky130_ef_sc_hd__decap_12
XFILLER_0_120_408 VGND VGND VPWR VPWR sky130_fd_sc_hd__decap_4
X_7498_ _3363_ rf.registers\[31\]\[8\] _3661_ VGND VGND VPWR VPWR _3670_ sky130_fd_sc_hd__mux2_1
XFILLER_0_70_380 VGND VGND VPWR VPWR sky130_fd_sc_hd__fill_2
XFILLER_0_30_200 VGND VGND VPWR VPWR sky130_fd_sc_hd__fill_2
X_6518_ _3121_ VGND VGND VPWR VPWR _0761_ sky130_fd_sc_hd__clkbuf_1
XFILLER_0_113_460 VGND VGND VPWR VPWR sky130_fd_sc_hd__fill_1
X_9237_ clknet_leaf_48_CLK _0325_ VGND VGND VPWR VPWR rf.registers\[28\]\[4\] sky130_fd_sc_hd__dfxtp_1
X_6449_ rf.registers\[11\]\[25\] _3039_ _3078_ VGND VGND VPWR VPWR _3084_ sky130_fd_sc_hd__mux2_1
Xclkbuf_leaf_21_CLK clknet_3_1__leaf_CLK VGND VGND VPWR VPWR clknet_leaf_21_CLK sky130_fd_sc_hd__clkbuf_8
X_9168_ clknet_leaf_76_CLK _0256_ VGND VGND VPWR VPWR rf.registers\[2\]\[31\] sky130_fd_sc_hd__dfxtp_1
X_8119_ _3370_ rf.registers\[26\]\[11\] _3998_ VGND VGND VPWR VPWR _4000_ sky130_fd_sc_hd__mux2_1
XFILLER_0_100_165 VGND VGND VPWR VPWR sky130_fd_sc_hd__fill_1
XTAP_TAPCELL_ROW_128_2219 VGND VPWR sky130_fd_sc_hd__tapvpwrvgnd_1
X_9099_ clknet_leaf_85_CLK _0187_ VGND VGND VPWR VPWR rf.registers\[31\]\[26\] sky130_fd_sc_hd__dfxtp_1
XTAP_TAPCELL_ROW_50_1049 VGND VPWR sky130_fd_sc_hd__tapvpwrvgnd_1
XFILLER_0_98_701 VPWR VGND VPWR VGND sky130_ef_sc_hd__decap_12
XTAP_TAPCELL_ROW_3_351 VGND VPWR sky130_fd_sc_hd__tapvpwrvgnd_1
XTAP_TAPCELL_ROW_3_340 VGND VPWR sky130_fd_sc_hd__tapvpwrvgnd_1
XFILLER_0_85_439 VGND VGND VPWR VPWR sky130_fd_sc_hd__decap_8
Xclkbuf_leaf_88_CLK clknet_3_0__leaf_CLK VGND VGND VPWR VPWR clknet_leaf_88_CLK sky130_fd_sc_hd__clkbuf_8
XTAP_TAPCELL_ROW_65_1281 VGND VPWR sky130_fd_sc_hd__tapvpwrvgnd_1
XTAP_TAPCELL_ROW_65_1270 VGND VPWR sky130_fd_sc_hd__tapvpwrvgnd_1
XTAP_TAPCELL_ROW_42_924 VGND VPWR sky130_fd_sc_hd__tapvpwrvgnd_1
XTAP_TAPCELL_ROW_42_935 VGND VPWR sky130_fd_sc_hd__tapvpwrvgnd_1
XFILLER_0_54_837 VGND VGND VPWR VPWR sky130_fd_sc_hd__fill_2
XFILLER_0_53_303 VGND VGND VPWR VPWR sky130_fd_sc_hd__decap_4
XFILLER_0_38_388 VGND VGND VPWR VPWR sky130_fd_sc_hd__fill_1
XFILLER_0_124_725 VPWR VGND VPWR VGND sky130_ef_sc_hd__decap_12
XFILLER_0_109_777 VGND VGND VPWR VPWR sky130_fd_sc_hd__decap_6
XFILLER_0_19_591 VGND VGND VPWR VPWR sky130_fd_sc_hd__decap_3
XFILLER_0_79_19 VGND VGND VPWR VPWR sky130_fd_sc_hd__fill_2
XFILLER_0_124_769 VPWR VGND VPWR VGND sky130_ef_sc_hd__decap_12
XFILLER_0_110_27 VGND VGND VPWR VPWR sky130_fd_sc_hd__fill_1
XFILLER_0_61_380 VGND VGND VPWR VPWR sky130_fd_sc_hd__decap_3
XFILLER_0_1_617 VPWR VGND VPWR VGND sky130_ef_sc_hd__decap_12
XFILLER_0_34_583 VGND VGND VPWR VPWR sky130_fd_sc_hd__fill_2
XFILLER_0_123_279 VGND VGND VPWR VPWR sky130_fd_sc_hd__fill_1
XFILLER_0_0_116 VPWR VGND VPWR VGND sky130_ef_sc_hd__decap_12
Xclkbuf_leaf_12_CLK clknet_3_3__leaf_CLK VGND VGND VPWR VPWR clknet_leaf_12_CLK sky130_fd_sc_hd__clkbuf_8
XFILLER_0_119_69 VPWR VGND VPWR VGND sky130_ef_sc_hd__decap_12
XFILLER_0_135_57 VPWR VGND VPWR VGND sky130_ef_sc_hd__decap_12
Xclkbuf_leaf_79_CLK clknet_3_3__leaf_CLK VGND VGND VPWR VPWR clknet_leaf_79_CLK sky130_fd_sc_hd__clkbuf_8
X_5820_ net78 _2543_ VGND VGND VPWR VPWR _2544_ sky130_fd_sc_hd__or2_1
XFILLER_0_9_717 VGND VGND VPWR VPWR sky130_fd_sc_hd__decap_8
XFILLER_0_44_88 VGND VGND VPWR VPWR sky130_fd_sc_hd__fill_1
XFILLER_0_57_664 VGND VGND VPWR VPWR sky130_fd_sc_hd__decap_8
XFILLER_0_56_141 VGND VGND VPWR VPWR sky130_fd_sc_hd__decap_3
X_5751_ _2476_ _2477_ VGND VGND VPWR VPWR _2478_ sky130_fd_sc_hd__xor2_1
X_8470_ _4185_ VGND VGND VPWR VPWR _0625_ sky130_fd_sc_hd__clkbuf_1
XFILLER_0_57_697 VPWR VGND VPWR VGND sky130_ef_sc_hd__decap_12
X_4702_ _1301_ _1474_ _1307_ VGND VGND VPWR VPWR _1475_ sky130_fd_sc_hd__a21o_1
XFILLER_0_17_517 VPWR VGND VPWR VGND sky130_ef_sc_hd__decap_12
X_7421_ _3629_ VGND VGND VPWR VPWR _0132_ sky130_fd_sc_hd__clkbuf_1
XFILLER_0_115_725 VGND VGND VPWR VPWR sky130_fd_sc_hd__decap_3
XFILLER_0_71_111 VGND VGND VPWR VPWR sky130_fd_sc_hd__fill_1
XFILLER_0_60_65 VGND VGND VPWR VPWR sky130_fd_sc_hd__fill_1
XTAP_TAPCELL_ROW_20_607 VGND VPWR sky130_fd_sc_hd__tapvpwrvgnd_1
X_5682_ net92 _2257_ _2410_ _2254_ VGND VGND VPWR VPWR _2411_ sky130_fd_sc_hd__o211a_1
XFILLER_0_114_224 VGND VGND VPWR VPWR sky130_fd_sc_hd__decap_3
XFILLER_0_4_433 VPWR VGND VPWR VGND sky130_ef_sc_hd__decap_12
XFILLER_0_25_561 VGND VGND VPWR VPWR sky130_fd_sc_hd__decap_8
X_4633_ _1294_ VGND VGND VPWR VPWR _1410_ sky130_fd_sc_hd__buf_4
X_7352_ _3592_ VGND VGND VPWR VPWR _0100_ sky130_fd_sc_hd__clkbuf_1
XTAP_TAPCELL_ROW_96_1742 VGND VPWR sky130_fd_sc_hd__tapvpwrvgnd_1
XFILLER_0_71_188 VGND VGND VPWR VPWR sky130_fd_sc_hd__decap_4
X_4564_ _1344_ VGND VGND VPWR VPWR net86 sky130_fd_sc_hd__inv_2
X_6303_ _2992_ VGND VGND VPWR VPWR _0675_ sky130_fd_sc_hd__clkbuf_1
X_7283_ rf.registers\[3\]\[3\] _3284_ _3552_ VGND VGND VPWR VPWR _3556_ sky130_fd_sc_hd__mux2_1
XFILLER_0_12_233 VPWR VGND VPWR VGND sky130_ef_sc_hd__decap_12
XFILLER_0_8_77 VGND VGND VPWR VPWR sky130_fd_sc_hd__decap_6
XFILLER_0_4_477 VPWR VGND VPWR VGND sky130_ef_sc_hd__decap_12
XFILLER_0_110_441 VGND VGND VPWR VPWR sky130_fd_sc_hd__fill_2
X_9022_ clknet_leaf_30_CLK _0110_ VGND VGND VPWR VPWR rf.registers\[8\]\[13\] sky130_fd_sc_hd__dfxtp_1
X_4495_ _1277_ _1278_ _1143_ VGND VGND VPWR VPWR _1279_ sky130_fd_sc_hd__mux2_1
XFILLER_0_12_277 VPWR VGND VPWR VGND sky130_ef_sc_hd__decap_12
X_6234_ _2234_ _2286_ _2291_ _2317_ VGND VGND VPWR VPWR _2935_ sky130_fd_sc_hd__a31o_1
XFILLER_0_40_586 VGND VGND VPWR VPWR sky130_fd_sc_hd__fill_2
XFILLER_0_0_694 VGND VGND VPWR VPWR sky130_fd_sc_hd__decap_6
X_6165_ _2800_ _2802_ _2416_ VGND VGND VPWR VPWR _2870_ sky130_fd_sc_hd__mux2_1
XFILLER_0_40_3 VPWR VGND VPWR VGND sky130_ef_sc_hd__decap_12
X_5116_ rf.registers\[4\]\[12\] rf.registers\[5\]\[12\] rf.registers\[6\]\[12\] rf.registers\[7\]\[12\]
+ _1816_ _1817_ VGND VGND VPWR VPWR _1867_ sky130_fd_sc_hd__mux4_1
X_6096_ _2802_ _2804_ _2340_ VGND VGND VPWR VPWR _2805_ sky130_fd_sc_hd__mux2_1
X_5047_ rf.registers\[4\]\[8\] rf.registers\[5\]\[8\] rf.registers\[6\]\[8\] rf.registers\[7\]\[8\]
+ _1703_ _1704_ VGND VGND VPWR VPWR _1802_ sky130_fd_sc_hd__mux4_1
XTAP_TAPCELL_ROW_123_2138 VGND VPWR sky130_fd_sc_hd__tapvpwrvgnd_1
XTAP_TAPCELL_ROW_28_718 VGND VPWR sky130_fd_sc_hd__tapvpwrvgnd_1
XTAP_TAPCELL_ROW_123_2149 VGND VPWR sky130_fd_sc_hd__tapvpwrvgnd_1
XFILLER_0_95_726 VGND VGND VPWR VPWR sky130_fd_sc_hd__fill_2
X_6998_ _2978_ rf.registers\[15\]\[30\] _3346_ VGND VGND VPWR VPWR _3404_ sky130_fd_sc_hd__mux2_1
XPHY_EDGE_ROW_40_Left_179 VGND VGND VPWR VPWR sky130_fd_sc_hd__decap_3
X_8806_ clknet_leaf_84_CLK _0918_ VGND VGND VPWR VPWR rf.registers\[16\]\[21\] sky130_fd_sc_hd__dfxtp_1
XFILLER_0_138_828 VPWR VGND VPWR VGND sky130_ef_sc_hd__decap_12
XFILLER_0_137_305 VPWR VGND VPWR VGND sky130_ef_sc_hd__decap_12
XTAP_TAPCELL_ROW_105_1882 VGND VPWR sky130_fd_sc_hd__tapvpwrvgnd_1
XTAP_TAPCELL_ROW_105_1871 VGND VPWR sky130_fd_sc_hd__tapvpwrvgnd_1
X_8737_ clknet_leaf_15_CLK _0849_ VGND VGND VPWR VPWR rf.registers\[10\]\[16\] sky130_fd_sc_hd__dfxtp_1
XFILLER_0_48_631 VGND VGND VPWR VPWR sky130_fd_sc_hd__fill_1
X_5949_ _2498_ _2659_ _2665_ _2462_ _2666_ VGND VGND VPWR VPWR _2667_ sky130_fd_sc_hd__a221o_1
XFILLER_0_36_804 VGND VGND VPWR VPWR sky130_fd_sc_hd__decap_8
XFILLER_0_137_349 VPWR VGND VPWR VGND sky130_ef_sc_hd__decap_12
XFILLER_0_63_601 VGND VGND VPWR VPWR sky130_fd_sc_hd__fill_1
XFILLER_0_36_837 VGND VGND VPWR VPWR sky130_fd_sc_hd__fill_2
XFILLER_0_106_725 VPWR VGND VPWR VGND sky130_ef_sc_hd__decap_12
X_8668_ clknet_leaf_31_CLK _0780_ VGND VGND VPWR VPWR rf.registers\[1\]\[11\] sky130_fd_sc_hd__dfxtp_1
XTAP_TAPCELL_ROW_138_2392 VGND VPWR sky130_fd_sc_hd__tapvpwrvgnd_1
XTAP_TAPCELL_ROW_138_2381 VGND VPWR sky130_fd_sc_hd__tapvpwrvgnd_1
XTAP_TAPCELL_ROW_138_2370 VGND VPWR sky130_fd_sc_hd__tapvpwrvgnd_1
X_7619_ _3734_ VGND VGND VPWR VPWR _0225_ sky130_fd_sc_hd__clkbuf_1
X_8599_ clknet_leaf_60_CLK _0711_ VGND VGND VPWR VPWR rf.registers\[11\]\[6\] sky130_fd_sc_hd__dfxtp_1
XFILLER_0_7_293 VPWR VGND VPWR VGND sky130_ef_sc_hd__decap_12
XFILLER_0_106_769 VPWR VGND VPWR VGND sky130_ef_sc_hd__decap_12
XTAP_TAPCELL_ROW_8_421 VGND VPWR sky130_fd_sc_hd__tapvpwrvgnd_1
XFILLER_0_31_575 VPWR VGND VPWR VGND sky130_ef_sc_hd__decap_12
XTAP_TAPCELL_ROW_67_1310 VGND VPWR sky130_fd_sc_hd__tapvpwrvgnd_1
XFILLER_0_105_27 VPWR VGND VPWR VGND sky130_ef_sc_hd__decap_12
XFILLER_0_86_737 VPWR VGND VPWR VGND sky130_ef_sc_hd__decap_12
XFILLER_0_85_225 VGND VGND VPWR VPWR sky130_fd_sc_hd__fill_1
XFILLER_0_129_839 VGND VGND VPWR VPWR sky130_fd_sc_hd__fill_1
XFILLER_0_85_236 VGND VGND VPWR VPWR sky130_fd_sc_hd__decap_4
XFILLER_0_39_653 VGND VGND VPWR VPWR sky130_fd_sc_hd__decap_8
Xclkbuf_leaf_1_CLK clknet_3_0__leaf_CLK VGND VGND VPWR VPWR clknet_leaf_1_CLK sky130_fd_sc_hd__clkbuf_8
XFILLER_0_94_781 VPWR VGND VPWR VGND sky130_ef_sc_hd__decap_12
XFILLER_0_27_837 VGND VGND VPWR VPWR sky130_fd_sc_hd__decap_3
XFILLER_0_38_141 VGND VGND VPWR VPWR sky130_fd_sc_hd__fill_1
XFILLER_0_121_15 VPWR VGND VPWR VGND sky130_ef_sc_hd__decap_12
XFILLER_0_66_483 VGND VGND VPWR VPWR sky130_fd_sc_hd__fill_1
XFILLER_0_124_511 VGND VGND VPWR VPWR sky130_fd_sc_hd__fill_1
XFILLER_0_53_166 VGND VGND VPWR VPWR sky130_fd_sc_hd__fill_2
XFILLER_0_34_380 VGND VGND VPWR VPWR sky130_fd_sc_hd__decap_3
XTAP_TAPCELL_ROW_78_1472 VGND VPWR sky130_fd_sc_hd__tapvpwrvgnd_1
XFILLER_0_1_447 VGND VGND VPWR VPWR sky130_fd_sc_hd__fill_1
X_4280_ _1052_ _1060_ _1065_ _1069_ _1073_ VGND VGND VPWR VPWR _1074_ sky130_fd_sc_hd__a32o_4
XTAP_TAPCELL_ROW_91_1672 VGND VPWR sky130_fd_sc_hd__tapvpwrvgnd_1
XTAP_TAPCELL_ROW_91_1661 VGND VPWR sky130_fd_sc_hd__tapvpwrvgnd_1
XFILLER_0_55_43 VGND VGND VPWR VPWR sky130_fd_sc_hd__decap_6
X_7970_ _3357_ rf.registers\[22\]\[5\] _3915_ VGND VGND VPWR VPWR _3921_ sky130_fd_sc_hd__mux2_1
XFILLER_0_55_76 VGND VGND VPWR VPWR sky130_fd_sc_hd__fill_1
X_6921_ _3353_ rf.registers\[15\]\[3\] _3347_ VGND VGND VPWR VPWR _3354_ sky130_fd_sc_hd__mux2_1
XFILLER_0_55_98 VGND VGND VPWR VPWR sky130_fd_sc_hd__decap_4
X_6852_ _3306_ VGND VGND VPWR VPWR _0910_ sky130_fd_sc_hd__clkbuf_1
X_9571_ clknet_leaf_6_CLK _0659_ VGND VGND VPWR VPWR rf.registers\[13\]\[18\] sky130_fd_sc_hd__dfxtp_1
X_5803_ _2240_ _2405_ _2409_ _2254_ VGND VGND VPWR VPWR _2528_ sky130_fd_sc_hd__a22o_1
XFILLER_0_9_503 VGND VGND VPWR VPWR sky130_fd_sc_hd__fill_1
XFILLER_0_135_809 VPWR VGND VPWR VGND sky130_ef_sc_hd__decap_12
X_8522_ _4212_ VGND VGND VPWR VPWR _0650_ sky130_fd_sc_hd__clkbuf_1
XFILLER_0_57_461 VGND VGND VPWR VPWR sky130_fd_sc_hd__fill_1
X_6783_ _3240_ VGND VGND VPWR VPWR _3263_ sky130_fd_sc_hd__clkbuf_8
XFILLER_0_18_837 VGND VGND VPWR VPWR sky130_fd_sc_hd__fill_2
X_5734_ _2269_ _2460_ VGND VGND VPWR VPWR _2461_ sky130_fd_sc_hd__or2_1
XTAP_TAPCELL_ROW_33_798 VGND VPWR sky130_fd_sc_hd__tapvpwrvgnd_1
XFILLER_0_127_393 VGND VGND VPWR VPWR sky130_fd_sc_hd__fill_2
X_8453_ _4176_ VGND VGND VPWR VPWR _0617_ sky130_fd_sc_hd__clkbuf_1
XFILLER_0_72_475 VGND VGND VPWR VPWR sky130_fd_sc_hd__fill_1
XFILLER_0_60_604 VGND VGND VPWR VPWR sky130_fd_sc_hd__fill_2
X_5665_ _1666_ _2390_ _2393_ VGND VGND VPWR VPWR _2395_ sky130_fd_sc_hd__nand3_1
X_8384_ rf.registers\[18\]\[8\] net44 _4131_ VGND VGND VPWR VPWR _4140_ sky130_fd_sc_hd__mux2_1
XFILLER_0_88_3 VPWR VGND VPWR VGND sky130_ef_sc_hd__decap_12
XFILLER_0_5_753 VPWR VGND VPWR VGND sky130_ef_sc_hd__decap_12
X_4616_ _1120_ VGND VGND VPWR VPWR _1393_ sky130_fd_sc_hd__buf_4
X_7404_ _3619_ VGND VGND VPWR VPWR _0125_ sky130_fd_sc_hd__clkbuf_1
XPHY_EDGE_ROW_111_Right_111 VGND VGND VPWR VPWR sky130_fd_sc_hd__decap_3
XFILLER_0_111_81 VPWR VGND VPWR VGND sky130_ef_sc_hd__decap_12
X_5596_ _2263_ VGND VGND VPWR VPWR _2326_ sky130_fd_sc_hd__buf_2
XFILLER_0_5_797 VPWR VGND VPWR VGND sky130_ef_sc_hd__decap_12
XFILLER_0_13_553 VGND VGND VPWR VPWR sky130_fd_sc_hd__fill_1
X_7335_ rf.registers\[3\]\[28\] _3336_ _3574_ VGND VGND VPWR VPWR _3583_ sky130_fd_sc_hd__mux2_1
X_4547_ _1328_ VGND VGND VPWR VPWR net85 sky130_fd_sc_hd__inv_2
XFILLER_0_111_783 VGND VGND VPWR VPWR sky130_fd_sc_hd__fill_1
X_4478_ rf.registers\[4\]\[10\] rf.registers\[5\]\[10\] rf.registers\[6\]\[10\] rf.registers\[7\]\[10\]
+ _1118_ _1127_ VGND VGND VPWR VPWR _1263_ sky130_fd_sc_hd__mux4_1
X_7266_ _3546_ VGND VGND VPWR VPWR _0060_ sky130_fd_sc_hd__clkbuf_1
X_6217_ _2899_ _2904_ _2905_ _2919_ _2541_ VGND VGND VPWR VPWR net133 sky130_fd_sc_hd__o32a_2
X_7197_ rf.registers\[4\]\[27\] _3334_ _3502_ VGND VGND VPWR VPWR _3510_ sky130_fd_sc_hd__mux2_1
X_9005_ clknet_leaf_0_CLK _0093_ VGND VGND VPWR VPWR rf.registers\[3\]\[28\] sky130_fd_sc_hd__dfxtp_1
X_6148_ _2853_ _2847_ _2850_ VGND VGND VPWR VPWR _2855_ sky130_fd_sc_hd__and3b_1
XTAP_TAPCELL_ROW_107_1911 VGND VPWR sky130_fd_sc_hd__tapvpwrvgnd_1
XTAP_TAPCELL_ROW_107_1900 VGND VPWR sky130_fd_sc_hd__tapvpwrvgnd_1
X_6079_ _2016_ _2768_ _2788_ VGND VGND VPWR VPWR _2789_ sky130_fd_sc_hd__o21ai_1
XTAP_TAPCELL_ROW_49_1040 VGND VPWR sky130_fd_sc_hd__tapvpwrvgnd_1
XFILLER_0_138_669 VGND VGND VPWR VPWR sky130_fd_sc_hd__decap_3
XFILLER_0_137_113 VPWR VGND VPWR VGND sky130_ef_sc_hd__decap_12
XFILLER_0_83_729 VPWR VGND VPWR VGND sky130_ef_sc_hd__decap_12
XFILLER_0_76_781 VPWR VGND VPWR VGND sky130_ef_sc_hd__decap_12
XFILLER_0_48_494 VGND VGND VPWR VPWR sky130_fd_sc_hd__fill_1
XFILLER_0_36_645 VPWR VGND VPWR VGND sky130_ef_sc_hd__decap_12
XFILLER_0_106_533 VGND VGND VPWR VPWR sky130_fd_sc_hd__fill_2
XFILLER_0_8_580 VGND VGND VPWR VPWR sky130_fd_sc_hd__fill_1
XFILLER_0_36_667 VPWR VGND VPWR VGND sky130_ef_sc_hd__decap_12
XFILLER_0_63_486 VGND VGND VPWR VPWR sky130_fd_sc_hd__fill_1
XTAP_TAPCELL_ROW_11_459 VGND VPWR sky130_fd_sc_hd__tapvpwrvgnd_1
XFILLER_0_133_385 VGND VGND VPWR VPWR sky130_fd_sc_hd__decap_6
XTAP_TAPCELL_ROW_73_1391 VGND VPWR sky130_fd_sc_hd__tapvpwrvgnd_1
XFILLER_0_116_15 VPWR VGND VPWR VGND sky130_ef_sc_hd__decap_12
XFILLER_0_58_236 VGND VGND VPWR VPWR sky130_fd_sc_hd__decap_3
XFILLER_0_117_809 VPWR VGND VPWR VGND sky130_ef_sc_hd__decap_12
XFILLER_0_58_269 VGND VGND VPWR VPWR sky130_fd_sc_hd__decap_3
XFILLER_0_66_291 VGND VGND VPWR VPWR sky130_fd_sc_hd__fill_1
XTAP_TAPCELL_ROW_30_746 VGND VPWR sky130_fd_sc_hd__tapvpwrvgnd_1
X_5450_ rf.registers\[16\]\[31\] rf.registers\[17\]\[31\] rf.registers\[18\]\[31\]
+ rf.registers\[19\]\[31\] _2109_ _2110_ VGND VGND VPWR VPWR _2182_ sky130_fd_sc_hd__mux4_1
XFILLER_0_54_486 VGND VGND VPWR VPWR sky130_fd_sc_hd__decap_6
XTAP_TAPCELL_ROW_30_757 VGND VPWR sky130_fd_sc_hd__tapvpwrvgnd_1
XFILLER_0_124_385 VGND VGND VPWR VPWR sky130_fd_sc_hd__fill_1
XFILLER_0_124_363 VGND VGND VPWR VPWR sky130_fd_sc_hd__fill_1
XTAP_TAPCELL_ROW_93_1701 VGND VPWR sky130_fd_sc_hd__tapvpwrvgnd_1
XFILLER_0_2_701 VPWR VGND VPWR VGND sky130_ef_sc_hd__decap_12
X_4401_ _1168_ VGND VGND VPWR VPWR _1190_ sky130_fd_sc_hd__clkbuf_8
XFILLER_0_10_501 VPWR VGND VPWR VGND sky130_ef_sc_hd__decap_12
XFILLER_0_22_350 VPWR VGND VPWR VGND sky130_ef_sc_hd__decap_12
X_5381_ _2112_ _2114_ _2117_ _1958_ _1940_ VGND VGND VPWR VPWR _2118_ sky130_fd_sc_hd__o221a_1
XFILLER_0_41_169 VGND VGND VPWR VPWR sky130_fd_sc_hd__fill_1
X_4332_ _1122_ VGND VGND VPWR VPWR _1123_ sky130_fd_sc_hd__buf_4
XFILLER_0_10_545 VGND VGND VPWR VPWR sky130_fd_sc_hd__decap_8
X_7120_ _3469_ VGND VGND VPWR VPWR _1015_ sky130_fd_sc_hd__clkbuf_1
X_4263_ rf.registers\[20\]\[1\] rf.registers\[21\]\[1\] rf.registers\[22\]\[1\] rf.registers\[23\]\[1\]
+ _1041_ _1043_ VGND VGND VPWR VPWR _1057_ sky130_fd_sc_hd__mux4_1
X_7051_ rf.registers\[6\]\[22\] _3324_ _3430_ VGND VGND VPWR VPWR _3433_ sky130_fd_sc_hd__mux2_1
X_6002_ _2299_ _2217_ VGND VGND VPWR VPWR _2717_ sky130_fd_sc_hd__nand2_1
XPHY_EDGE_ROW_105_Left_244 VGND VGND VPWR VPWR sky130_fd_sc_hd__decap_3
XFILLER_0_96_309 VGND VGND VPWR VPWR sky130_fd_sc_hd__decap_4
X_7953_ _3911_ VGND VGND VPWR VPWR _0382_ sky130_fd_sc_hd__clkbuf_1
XTAP_TAPCELL_ROW_38_868 VGND VPWR sky130_fd_sc_hd__tapvpwrvgnd_1
X_6904_ _3341_ VGND VGND VPWR VPWR _0927_ sky130_fd_sc_hd__clkbuf_1
XFILLER_0_49_236 VPWR VGND VPWR VGND sky130_ef_sc_hd__decap_12
XFILLER_0_49_225 VGND VGND VPWR VPWR sky130_fd_sc_hd__fill_2
XTAP_TAPCELL_ROW_18_570 VGND VPWR sky130_fd_sc_hd__tapvpwrvgnd_1
X_7884_ _3874_ VGND VGND VPWR VPWR _0350_ sky130_fd_sc_hd__clkbuf_1
XFILLER_0_119_113 VPWR VGND VPWR VGND sky130_ef_sc_hd__decap_12
X_6835_ rf.registers\[16\]\[8\] _3294_ _3278_ VGND VGND VPWR VPWR _3295_ sky130_fd_sc_hd__mux2_1
XTAP_TAPCELL_ROW_102_1830 VGND VPWR sky130_fd_sc_hd__tapvpwrvgnd_1
XFILLER_0_65_729 VPWR VGND VPWR VGND sky130_ef_sc_hd__decap_12
XFILLER_0_135_617 VPWR VGND VPWR VGND sky130_ef_sc_hd__decap_12
X_9554_ clknet_leaf_46_CLK _0642_ VGND VGND VPWR VPWR rf.registers\[13\]\[1\] sky130_fd_sc_hd__dfxtp_1
XPHY_EDGE_ROW_114_Left_253 VGND VGND VPWR VPWR sky130_fd_sc_hd__decap_3
X_6766_ _3254_ VGND VGND VPWR VPWR _0876_ sky130_fd_sc_hd__clkbuf_1
XFILLER_0_58_781 VPWR VGND VPWR VGND sky130_ef_sc_hd__decap_12
XFILLER_0_17_111 VGND VGND VPWR VPWR sky130_fd_sc_hd__fill_1
XFILLER_0_18_634 VGND VGND VPWR VPWR sky130_fd_sc_hd__fill_2
XFILLER_0_18_645 VPWR VGND VPWR VGND sky130_ef_sc_hd__decap_12
X_8505_ _4203_ VGND VGND VPWR VPWR _0642_ sky130_fd_sc_hd__clkbuf_1
X_5717_ _2330_ _2338_ _2383_ VGND VGND VPWR VPWR _2445_ sky130_fd_sc_hd__mux2_1
X_6697_ rf.registers\[10\]\[11\] _3010_ _3216_ VGND VGND VPWR VPWR _3218_ sky130_fd_sc_hd__mux2_1
X_9485_ clknet_leaf_0_CLK _0573_ VGND VGND VPWR VPWR rf.registers\[20\]\[28\] sky130_fd_sc_hd__dfxtp_1
XFILLER_0_33_615 VGND VGND VPWR VPWR sky130_fd_sc_hd__fill_1
X_8436_ _2982_ rf.registers\[14\]\[0\] _4167_ VGND VGND VPWR VPWR _4168_ sky130_fd_sc_hd__mux2_1
XFILLER_0_60_456 VGND VGND VPWR VPWR sky130_fd_sc_hd__fill_1
XFILLER_0_5_561 VPWR VGND VPWR VGND sky130_ef_sc_hd__decap_12
X_5648_ _2375_ _2377_ net92 VGND VGND VPWR VPWR _2378_ sky130_fd_sc_hd__mux2_1
XFILLER_0_33_659 VGND VGND VPWR VPWR sky130_fd_sc_hd__decap_4
XFILLER_0_130_333 VPWR VGND VPWR VGND sky130_ef_sc_hd__decap_12
XFILLER_0_115_396 VPWR VGND VPWR VGND sky130_ef_sc_hd__decap_12
X_8367_ _4130_ VGND VGND VPWR VPWR _4131_ sky130_fd_sc_hd__buf_4
XFILLER_0_13_361 VPWR VGND VPWR VGND sky130_ef_sc_hd__decap_12
X_5579_ _2062_ _2218_ VGND VGND VPWR VPWR _2310_ sky130_fd_sc_hd__nor2_1
XTAP_TAPCELL_ROW_131_2259 VGND VPWR sky130_fd_sc_hd__tapvpwrvgnd_1
XFILLER_0_130_377 VPWR VGND VPWR VGND sky130_ef_sc_hd__decap_12
X_8298_ _2985_ _3877_ VGND VGND VPWR VPWR _4094_ sky130_fd_sc_hd__nor2b_4
X_7318_ _3551_ VGND VGND VPWR VPWR _3574_ sky130_fd_sc_hd__buf_4
XFILLER_0_111_591 VGND VGND VPWR VPWR sky130_fd_sc_hd__fill_1
X_7249_ _3537_ VGND VGND VPWR VPWR _0052_ sky130_fd_sc_hd__clkbuf_1
XPHY_EDGE_ROW_123_Left_262 VGND VGND VPWR VPWR sky130_fd_sc_hd__decap_3
XTAP_TAPCELL_ROW_113_1992 VGND VPWR sky130_fd_sc_hd__tapvpwrvgnd_1
XFILLER_0_99_169 VGND VGND VPWR VPWR sky130_fd_sc_hd__fill_1
XFILLER_0_99_147 VGND VGND VPWR VPWR sky130_fd_sc_hd__fill_1
XPHY_EDGE_ROW_132_Left_271 VGND VGND VPWR VPWR sky130_fd_sc_hd__decap_3
XFILLER_0_68_589 VGND VGND VPWR VPWR sky130_fd_sc_hd__fill_1
XFILLER_0_138_477 VPWR VGND VPWR VGND sky130_ef_sc_hd__decap_12
XFILLER_0_83_559 VGND VGND VPWR VPWR sky130_fd_sc_hd__fill_1
XFILLER_0_125_105 VGND VGND VPWR VPWR sky130_fd_sc_hd__decap_6
XFILLER_0_125_149 VPWR VGND VPWR VGND sky130_ef_sc_hd__decap_12
XFILLER_0_23_136 VGND VGND VPWR VPWR sky130_fd_sc_hd__decap_4
XFILLER_0_24_659 VGND VGND VPWR VPWR sky130_fd_sc_hd__fill_1
XFILLER_0_133_193 VPWR VGND VPWR VGND sky130_ef_sc_hd__decap_12
XFILLER_0_87_19 VPWR VGND VPWR VGND sky130_ef_sc_hd__decap_12
XTAP_TAPCELL_ROW_75_1420 VGND VPWR sky130_fd_sc_hd__tapvpwrvgnd_1
XFILLER_0_32_670 VPWR VGND VPWR VGND sky130_ef_sc_hd__decap_12
XTAP_TAPCELL_ROW_75_1431 VGND VPWR sky130_fd_sc_hd__tapvpwrvgnd_1
Xinput8 A2[4] VGND VGND VPWR VPWR net8 sky130_fd_sc_hd__clkbuf_2
XFILLER_0_127_69 VPWR VGND VPWR VGND sky130_ef_sc_hd__decap_12
XFILLER_0_36_78 VGND VGND VPWR VPWR sky130_fd_sc_hd__decap_3
XFILLER_0_87_821 VPWR VGND VPWR VGND sky130_ef_sc_hd__decap_12
X_4950_ _1697_ _1702_ _1708_ _1660_ _1709_ VGND VGND VPWR VPWR _1710_ sky130_fd_sc_hd__a221o_1
XTAP_TAPCELL_ROW_35_827 VGND VPWR sky130_fd_sc_hd__tapvpwrvgnd_1
XTAP_TAPCELL_ROW_86_1593 VGND VPWR sky130_fd_sc_hd__tapvpwrvgnd_1
X_4881_ _1643_ VGND VGND VPWR VPWR net49 sky130_fd_sc_hd__inv_2
XFILLER_0_19_409 VGND VGND VPWR VPWR sky130_fd_sc_hd__decap_6
XFILLER_0_47_729 VPWR VGND VPWR VGND sky130_ef_sc_hd__decap_12
XFILLER_0_117_617 VGND VGND VPWR VPWR sky130_fd_sc_hd__fill_1
X_6620_ _3176_ VGND VGND VPWR VPWR _0808_ sky130_fd_sc_hd__clkbuf_1
X_6551_ _3139_ VGND VGND VPWR VPWR _0776_ sky130_fd_sc_hd__clkbuf_1
XFILLER_0_7_837 VGND VGND VPWR VPWR sky130_fd_sc_hd__decap_3
XFILLER_0_27_431 VGND VGND VPWR VPWR sky130_fd_sc_hd__decap_6
X_5502_ _1074_ VGND VGND VPWR VPWR _2233_ sky130_fd_sc_hd__clkbuf_4
X_6482_ _3102_ VGND VGND VPWR VPWR _0744_ sky130_fd_sc_hd__clkbuf_1
X_9270_ clknet_leaf_59_CLK _0358_ VGND VGND VPWR VPWR rf.registers\[23\]\[5\] sky130_fd_sc_hd__dfxtp_1
XFILLER_0_2_531 VGND VGND VPWR VPWR sky130_fd_sc_hd__fill_1
X_8221_ _4053_ VGND VGND VPWR VPWR _0508_ sky130_fd_sc_hd__clkbuf_1
XFILLER_0_30_607 VGND VGND VPWR VPWR sky130_fd_sc_hd__fill_2
X_5433_ rf.registers\[20\]\[30\] rf.registers\[21\]\[30\] rf.registers\[22\]\[30\]
+ rf.registers\[23\]\[30\] _2109_ _2110_ VGND VGND VPWR VPWR _2166_ sky130_fd_sc_hd__mux4_1
XFILLER_0_11_821 VPWR VGND VPWR VGND sky130_ef_sc_hd__decap_12
X_8152_ _2972_ rf.registers\[26\]\[27\] _4009_ VGND VGND VPWR VPWR _4017_ sky130_fd_sc_hd__mux2_1
X_5364_ rf.registers\[20\]\[26\] rf.registers\[21\]\[26\] rf.registers\[22\]\[26\]
+ rf.registers\[23\]\[26\] _2070_ _2071_ VGND VGND VPWR VPWR _2101_ sky130_fd_sc_hd__mux4_1
X_4315_ _1105_ _1106_ _1031_ VGND VGND VPWR VPWR _1107_ sky130_fd_sc_hd__mux2_1
X_7103_ _3460_ VGND VGND VPWR VPWR _1007_ sky130_fd_sc_hd__clkbuf_1
X_8083_ _3980_ VGND VGND VPWR VPWR _0443_ sky130_fd_sc_hd__clkbuf_1
X_5295_ rf.registers\[20\]\[22\] rf.registers\[21\]\[22\] rf.registers\[22\]\[22\]
+ rf.registers\[23\]\[22\] _1730_ _1732_ VGND VGND VPWR VPWR _2036_ sky130_fd_sc_hd__mux4_1
X_4246_ A2[0] VGND VGND VPWR VPWR _1041_ sky130_fd_sc_hd__buf_4
X_7034_ rf.registers\[6\]\[14\] _3307_ _3419_ VGND VGND VPWR VPWR _3424_ sky130_fd_sc_hd__mux2_1
XFILLER_0_93_51 VGND VGND VPWR VPWR sky130_fd_sc_hd__decap_4
X_8985_ clknet_leaf_47_CLK _0073_ VGND VGND VPWR VPWR rf.registers\[3\]\[8\] sky130_fd_sc_hd__dfxtp_1
X_7936_ _3391_ rf.registers\[23\]\[21\] _3901_ VGND VGND VPWR VPWR _3903_ sky130_fd_sc_hd__mux2_1
X_7867_ _3391_ rf.registers\[28\]\[21\] _3864_ VGND VGND VPWR VPWR _3866_ sky130_fd_sc_hd__mux2_1
XFILLER_0_38_707 VGND VGND VPWR VPWR sky130_fd_sc_hd__fill_1
XFILLER_0_38_729 VGND VGND VPWR VPWR sky130_fd_sc_hd__decap_4
X_6818_ _3283_ VGND VGND VPWR VPWR _0899_ sky130_fd_sc_hd__clkbuf_1
XFILLER_0_37_217 VGND VGND VPWR VPWR sky130_fd_sc_hd__decap_6
X_7798_ _3829_ VGND VGND VPWR VPWR _0309_ sky130_fd_sc_hd__clkbuf_1
XFILLER_0_18_442 VPWR VGND VPWR VGND sky130_ef_sc_hd__decap_12
XFILLER_0_135_469 VPWR VGND VPWR VGND sky130_ef_sc_hd__decap_12
XFILLER_0_135_447 VGND VGND VPWR VPWR sky130_fd_sc_hd__fill_1
X_6749_ _3245_ VGND VGND VPWR VPWR _0868_ sky130_fd_sc_hd__clkbuf_1
XFILLER_0_92_378 VGND VGND VPWR VPWR sky130_fd_sc_hd__fill_2
X_9537_ clknet_leaf_15_CLK _0625_ VGND VGND VPWR VPWR rf.registers\[14\]\[16\] sky130_fd_sc_hd__dfxtp_1
XFILLER_0_61_721 VGND VGND VPWR VPWR sky130_fd_sc_hd__decap_6
X_9468_ clknet_leaf_27_CLK _0556_ VGND VGND VPWR VPWR rf.registers\[20\]\[11\] sky130_fd_sc_hd__dfxtp_1
XFILLER_0_61_765 VPWR VGND VPWR VGND sky130_ef_sc_hd__decap_12
XFILLER_0_33_445 VGND VGND VPWR VPWR sky130_fd_sc_hd__decap_3
XFILLER_0_115_193 VPWR VGND VPWR VGND sky130_ef_sc_hd__decap_12
XFILLER_0_60_253 VPWR VGND VPWR VGND sky130_ef_sc_hd__decap_12
XFILLER_0_5_391 VGND VGND VPWR VPWR sky130_fd_sc_hd__fill_1
X_8419_ _4158_ VGND VGND VPWR VPWR _0601_ sky130_fd_sc_hd__clkbuf_1
XFILLER_0_130_141 VPWR VGND VPWR VGND sky130_ef_sc_hd__decap_12
X_9399_ clknet_leaf_56_CLK _0487_ VGND VGND VPWR VPWR rf.registers\[21\]\[6\] sky130_fd_sc_hd__dfxtp_1
XFILLER_0_131_697 VPWR VGND VPWR VGND sky130_ef_sc_hd__decap_12
XTAP_TAPCELL_ROW_57_1161 VGND VPWR sky130_fd_sc_hd__tapvpwrvgnd_1
XTAP_TAPCELL_ROW_57_1150 VGND VPWR sky130_fd_sc_hd__tapvpwrvgnd_1
Xclkbuf_3_1__f_CLK clknet_0_CLK VGND VGND VPWR VPWR clknet_3_1__leaf_CLK sky130_fd_sc_hd__clkbuf_16
XTAP_TAPCELL_ROW_70_1350 VGND VPWR sky130_fd_sc_hd__tapvpwrvgnd_1
XFILLER_0_69_821 VPWR VGND VPWR VGND sky130_ef_sc_hd__decap_12
XFILLER_0_84_813 VPWR VGND VPWR VGND sky130_ef_sc_hd__decap_12
XFILLER_0_29_718 VGND VGND VPWR VPWR sky130_fd_sc_hd__fill_1
XFILLER_0_29_729 VGND VGND VPWR VPWR sky130_fd_sc_hd__fill_1
XFILLER_0_113_27 VPWR VGND VPWR VGND sky130_ef_sc_hd__decap_12
XFILLER_0_28_228 VGND VGND VPWR VPWR sky130_fd_sc_hd__fill_2
XFILLER_0_83_389 VGND VGND VPWR VPWR sky130_fd_sc_hd__decap_3
XFILLER_0_36_250 VGND VGND VPWR VPWR sky130_fd_sc_hd__fill_2
XFILLER_0_98_29 VPWR VGND VPWR VGND sky130_ef_sc_hd__decap_12
XFILLER_0_3_317 VPWR VGND VPWR VGND sky130_ef_sc_hd__decap_12
XTAP_TAPCELL_ROW_40_896 VGND VPWR sky130_fd_sc_hd__tapvpwrvgnd_1
XFILLER_0_106_171 VGND VGND VPWR VPWR sky130_fd_sc_hd__fill_2
XFILLER_0_122_697 VGND VGND VPWR VPWR sky130_fd_sc_hd__decap_3
XFILLER_0_110_837 VGND VGND VPWR VPWR sky130_fd_sc_hd__fill_2
XFILLER_0_138_35 VPWR VGND VPWR VGND sky130_ef_sc_hd__decap_12
XFILLER_0_20_684 VGND VGND VPWR VPWR sky130_fd_sc_hd__fill_1
XFILLER_0_138_57 VPWR VGND VPWR VGND sky130_ef_sc_hd__decap_12
X_5080_ _1829_ _1832_ _1651_ VGND VGND VPWR VPWR _1833_ sky130_fd_sc_hd__mux2_1
XTAP_TAPCELL_ROW_88_1622 VGND VPWR sky130_fd_sc_hd__tapvpwrvgnd_1
XFILLER_0_79_629 VPWR VGND VPWR VGND sky130_ef_sc_hd__decap_12
X_8770_ clknet_leaf_12_CLK _0882_ VGND VGND VPWR VPWR rf.registers\[0\]\[17\] sky130_fd_sc_hd__dfxtp_1
X_5982_ _2554_ _2697_ _2421_ VGND VGND VPWR VPWR _2698_ sky130_fd_sc_hd__mux2_1
X_4933_ _1630_ VGND VGND VPWR VPWR _1693_ sky130_fd_sc_hd__buf_4
X_7721_ _3788_ VGND VGND VPWR VPWR _0273_ sky130_fd_sc_hd__clkbuf_1
X_4864_ _1623_ _1626_ _1621_ VGND VGND VPWR VPWR _1627_ sky130_fd_sc_hd__mux2_1
XFILLER_0_90_805 VGND VGND VPWR VPWR sky130_fd_sc_hd__decap_6
XFILLER_0_86_194 VGND VGND VPWR VPWR sky130_fd_sc_hd__fill_2
XANTENNA_13 net99 VGND VGND VPWR VPWR sky130_fd_sc_hd__diode_2
X_7652_ _3751_ VGND VGND VPWR VPWR _0241_ sky130_fd_sc_hd__clkbuf_1
XFILLER_0_7_634 VPWR VGND VPWR VGND sky130_ef_sc_hd__decap_12
X_7583_ _3380_ rf.registers\[27\]\[16\] _3708_ VGND VGND VPWR VPWR _3715_ sky130_fd_sc_hd__mux2_1
X_6603_ _2985_ _3166_ VGND VGND VPWR VPWR _3167_ sky130_fd_sc_hd__nor2b_4
XFILLER_0_6_133 VGND VGND VPWR VPWR sky130_fd_sc_hd__decap_6
X_4795_ rf.registers\[12\]\[28\] rf.registers\[13\]\[28\] rf.registers\[14\]\[28\]
+ rf.registers\[15\]\[28\] _1393_ _1394_ VGND VGND VPWR VPWR _1562_ sky130_fd_sc_hd__mux4_1
XTAP_TAPCELL_ROW_115_2018 VGND VPWR sky130_fd_sc_hd__tapvpwrvgnd_1
X_6534_ _3091_ _3129_ VGND VGND VPWR VPWR _3130_ sky130_fd_sc_hd__nor2_2
XFILLER_0_6_177 VPWR VGND VPWR VGND sky130_ef_sc_hd__decap_12
X_9322_ clknet_leaf_85_CLK _0410_ VGND VGND VPWR VPWR rf.registers\[22\]\[25\] sky130_fd_sc_hd__dfxtp_1
XTAP_TAPCELL_ROW_115_2029 VGND VPWR sky130_fd_sc_hd__tapvpwrvgnd_1
XFILLER_0_113_620 VGND VGND VPWR VPWR sky130_fd_sc_hd__fill_2
XTAP_TAPCELL_ROW_99_1784 VGND VPWR sky130_fd_sc_hd__tapvpwrvgnd_1
X_6465_ _3091_ _3092_ VGND VGND VPWR VPWR _3093_ sky130_fd_sc_hd__nor2_4
X_9253_ clknet_leaf_81_CLK _0341_ VGND VGND VPWR VPWR rf.registers\[28\]\[20\] sky130_fd_sc_hd__dfxtp_1
XFILLER_0_112_141 VPWR VGND VPWR VGND sky130_ef_sc_hd__decap_12
X_8204_ _4044_ VGND VGND VPWR VPWR _0500_ sky130_fd_sc_hd__clkbuf_1
XFILLER_0_70_3 VPWR VGND VPWR VGND sky130_ef_sc_hd__decap_12
X_5416_ rf.registers\[20\]\[29\] rf.registers\[21\]\[29\] rf.registers\[22\]\[29\]
+ rf.registers\[23\]\[29\] _1959_ _1960_ VGND VGND VPWR VPWR _2150_ sky130_fd_sc_hd__mux4_1
X_9184_ clknet_leaf_24_CLK _0272_ VGND VGND VPWR VPWR rf.registers\[30\]\[15\] sky130_fd_sc_hd__dfxtp_1
X_6396_ _3055_ VGND VGND VPWR VPWR _3056_ sky130_fd_sc_hd__buf_4
Xoutput131 net131 VGND VGND VPWR VPWR alu_result[26] sky130_fd_sc_hd__buf_1
Xoutput120 net120 VGND VGND VPWR VPWR alu_result[16] sky130_fd_sc_hd__buf_1
Xoutput142 net142 VGND VGND VPWR VPWR alu_result[7] sky130_fd_sc_hd__buf_1
X_8135_ _3386_ rf.registers\[26\]\[19\] _3998_ VGND VGND VPWR VPWR _4008_ sky130_fd_sc_hd__mux2_1
XFILLER_0_11_673 VGND VGND VPWR VPWR sky130_fd_sc_hd__decap_3
X_5347_ rf.registers\[20\]\[25\] rf.registers\[21\]\[25\] rf.registers\[22\]\[25\]
+ rf.registers\[23\]\[25\] _2077_ _2078_ VGND VGND VPWR VPWR _2085_ sky130_fd_sc_hd__mux4_1
XTAP_TAPCELL_ROW_110_1951 VGND VPWR sky130_fd_sc_hd__tapvpwrvgnd_1
X_8066_ _3971_ VGND VGND VPWR VPWR _0435_ sky130_fd_sc_hd__clkbuf_1
X_5278_ rf.registers\[28\]\[21\] rf.registers\[29\]\[21\] rf.registers\[30\]\[21\]
+ rf.registers\[31\]\[21\] _1922_ _1923_ VGND VGND VPWR VPWR _2020_ sky130_fd_sc_hd__mux4_1
X_4229_ net8 VGND VGND VPWR VPWR _1024_ sky130_fd_sc_hd__clkbuf_8
X_7017_ rf.registers\[6\]\[6\] _3290_ _3408_ VGND VGND VPWR VPWR _3415_ sky130_fd_sc_hd__mux2_1
XTAP_TAPCELL_ROW_52_1080 VGND VPWR sky130_fd_sc_hd__tapvpwrvgnd_1
X_8968_ clknet_leaf_2_CLK _0056_ VGND VGND VPWR VPWR rf.registers\[19\]\[23\] sky130_fd_sc_hd__dfxtp_1
X_7919_ _3374_ rf.registers\[23\]\[13\] _3890_ VGND VGND VPWR VPWR _3894_ sky130_fd_sc_hd__mux2_1
XFILLER_0_66_813 VPWR VGND VPWR VGND sky130_ef_sc_hd__decap_12
XFILLER_0_136_701 VPWR VGND VPWR VGND sky130_ef_sc_hd__decap_12
X_8899_ clknet_leaf_7_CLK _1011_ VGND VGND VPWR VPWR rf.registers\[5\]\[18\] sky130_fd_sc_hd__dfxtp_1
XFILLER_0_46_581 VGND VGND VPWR VPWR sky130_fd_sc_hd__fill_1
XFILLER_0_21_404 VPWR VGND VPWR VGND sky130_ef_sc_hd__decap_12
XFILLER_0_34_787 VPWR VGND VPWR VGND sky130_ef_sc_hd__decap_12
XFILLER_0_104_664 VPWR VGND VPWR VGND sky130_ef_sc_hd__decap_12
XFILLER_0_104_642 VGND VGND VPWR VPWR sky130_fd_sc_hd__fill_2
XFILLER_0_0_309 VPWR VGND VPWR VGND sky130_ef_sc_hd__decap_12
XFILLER_0_33_297 VGND VGND VPWR VPWR sky130_fd_sc_hd__fill_2
XFILLER_0_108_27 VGND VGND VPWR VPWR sky130_fd_sc_hd__fill_1
XTAP_TAPCELL_ROW_6_393 VGND VPWR sky130_fd_sc_hd__tapvpwrvgnd_1
XFILLER_0_17_69 VPWR VGND VPWR VGND sky130_ef_sc_hd__decap_12
XFILLER_0_124_15 VPWR VGND VPWR VGND sky130_ef_sc_hd__decap_12
XFILLER_0_69_673 VPWR VGND VPWR VGND sky130_ef_sc_hd__decap_12
XTAP_TAPCELL_ROW_83_1552 VGND VPWR sky130_fd_sc_hd__tapvpwrvgnd_1
XTAP_TAPCELL_ROW_83_1541 VGND VPWR sky130_fd_sc_hd__tapvpwrvgnd_1
XFILLER_0_56_312 VGND VGND VPWR VPWR sky130_fd_sc_hd__decap_6
XFILLER_0_33_57 VGND VGND VPWR VPWR sky130_fd_sc_hd__fill_2
XTAP_TAPCELL_ROW_45_977 VGND VPWR sky130_fd_sc_hd__tapvpwrvgnd_1
XFILLER_0_72_805 VGND VGND VPWR VPWR sky130_fd_sc_hd__decap_6
XFILLER_0_29_548 VGND VGND VPWR VPWR sky130_fd_sc_hd__fill_1
XFILLER_0_29_559 VGND VGND VPWR VPWR sky130_fd_sc_hd__fill_1
XFILLER_0_126_233 VPWR VGND VPWR VGND sky130_ef_sc_hd__decap_12
XFILLER_0_16_209 VPWR VGND VPWR VGND sky130_ef_sc_hd__decap_12
Xinput11 A3[2] VGND VGND VPWR VPWR net11 sky130_fd_sc_hd__clkbuf_4
XFILLER_0_126_277 VPWR VGND VPWR VGND sky130_ef_sc_hd__decap_12
X_4580_ rf.registers\[20\]\[16\] rf.registers\[21\]\[16\] rf.registers\[22\]\[16\]
+ rf.registers\[23\]\[16\] _1191_ _1192_ VGND VGND VPWR VPWR _1359_ sky130_fd_sc_hd__mux4_1
Xinput22 WD3[17] VGND VGND VPWR VPWR net22 sky130_fd_sc_hd__clkbuf_2
XFILLER_0_109_3 VPWR VGND VPWR VGND sky130_ef_sc_hd__decap_12
Xinput44 WD3[8] VGND VGND VPWR VPWR net44 sky130_fd_sc_hd__buf_2
XFILLER_0_4_637 VGND VGND VPWR VPWR sky130_fd_sc_hd__decap_6
XFILLER_0_3_125 VPWR VGND VPWR VGND sky130_ef_sc_hd__decap_12
XFILLER_0_25_765 VPWR VGND VPWR VGND sky130_ef_sc_hd__decap_12
Xinput33 WD3[27] VGND VGND VPWR VPWR net33 sky130_fd_sc_hd__clkbuf_2
XFILLER_0_3_169 VPWR VGND VPWR VGND sky130_ef_sc_hd__decap_12
XFILLER_0_0_810 VGND VGND VPWR VPWR sky130_fd_sc_hd__fill_2
X_6250_ _2939_ _2940_ _2399_ _2950_ VGND VGND VPWR VPWR net136 sky130_fd_sc_hd__o2bb2a_2
XFILLER_0_40_757 VGND VGND VPWR VPWR sky130_fd_sc_hd__fill_2
X_5201_ _1945_ _1946_ _1943_ VGND VGND VPWR VPWR _1947_ sky130_fd_sc_hd__mux2_1
X_6181_ _2194_ _2203_ _2820_ VGND VGND VPWR VPWR _2885_ sky130_fd_sc_hd__or3_2
X_5132_ _1880_ _1881_ _1693_ VGND VGND VPWR VPWR _1882_ sky130_fd_sc_hd__mux2_1
X_5063_ _1656_ VGND VGND VPWR VPWR _1817_ sky130_fd_sc_hd__clkbuf_4
XFILLER_0_74_75 VGND VGND VPWR VPWR sky130_fd_sc_hd__decap_8
X_8822_ clknet_leaf_64_CLK _0934_ VGND VGND VPWR VPWR rf.registers\[15\]\[5\] sky130_fd_sc_hd__dfxtp_1
XTAP_TAPCELL_ROW_125_2180 VGND VPWR sky130_fd_sc_hd__tapvpwrvgnd_1
XFILLER_0_94_418 VGND VGND VPWR VPWR sky130_fd_sc_hd__fill_2
XFILLER_0_48_813 VPWR VGND VPWR VGND sky130_ef_sc_hd__decap_12
X_8753_ clknet_leaf_41_CLK _0865_ VGND VGND VPWR VPWR rf.registers\[0\]\[0\] sky130_fd_sc_hd__dfxtp_1
XFILLER_0_90_41 VGND VGND VPWR VPWR sky130_fd_sc_hd__decap_3
XFILLER_0_59_172 VGND VGND VPWR VPWR sky130_fd_sc_hd__fill_1
XFILLER_0_59_161 VGND VGND VPWR VPWR sky130_fd_sc_hd__decap_6
X_5965_ _2636_ _2681_ _2383_ VGND VGND VPWR VPWR _2682_ sky130_fd_sc_hd__mux2_1
X_4916_ _1630_ _1676_ _1641_ VGND VGND VPWR VPWR _1677_ sky130_fd_sc_hd__o21a_1
XFILLER_0_118_701 VPWR VGND VPWR VGND sky130_ef_sc_hd__decap_12
X_7704_ _3779_ VGND VGND VPWR VPWR _0265_ sky130_fd_sc_hd__clkbuf_1
XFILLER_0_90_85 VGND VGND VPWR VPWR sky130_fd_sc_hd__fill_2
XFILLER_0_75_665 VGND VGND VPWR VPWR sky130_fd_sc_hd__decap_6
XFILLER_0_59_194 VGND VGND VPWR VPWR sky130_fd_sc_hd__decap_3
X_5896_ _2584_ _2615_ _2616_ VGND VGND VPWR VPWR _2617_ sky130_fd_sc_hd__a21o_1
X_8684_ clknet_leaf_86_CLK _0796_ VGND VGND VPWR VPWR rf.registers\[1\]\[27\] sky130_fd_sc_hd__dfxtp_1
XTAP_TAPCELL_ROW_23_638 VGND VPWR sky130_fd_sc_hd__tapvpwrvgnd_1
X_7635_ _3742_ VGND VGND VPWR VPWR _0233_ sky130_fd_sc_hd__clkbuf_1
X_4847_ rf.registers\[4\]\[31\] rf.registers\[5\]\[31\] rf.registers\[6\]\[31\] rf.registers\[7\]\[31\]
+ _1172_ _1173_ VGND VGND VPWR VPWR _1611_ sky130_fd_sc_hd__mux4_1
XTAP_TAPCELL_ROW_23_649 VGND VPWR sky130_fd_sc_hd__tapvpwrvgnd_1
XFILLER_0_74_197 VGND VGND VPWR VPWR sky130_fd_sc_hd__fill_1
XFILLER_0_62_326 VGND VGND VPWR VPWR sky130_fd_sc_hd__fill_1
XFILLER_0_16_743 VPWR VGND VPWR VGND sky130_ef_sc_hd__decap_12
X_9305_ clknet_leaf_36_CLK _0393_ VGND VGND VPWR VPWR rf.registers\[22\]\[8\] sky130_fd_sc_hd__dfxtp_1
X_7566_ _3363_ rf.registers\[27\]\[8\] _3697_ VGND VGND VPWR VPWR _3706_ sky130_fd_sc_hd__mux2_1
XFILLER_0_7_497 VGND VGND VPWR VPWR sky130_fd_sc_hd__decap_6
XFILLER_0_31_702 VGND VGND VPWR VPWR sky130_fd_sc_hd__decap_4
X_4778_ rf.registers\[4\]\[27\] rf.registers\[5\]\[27\] rf.registers\[6\]\[27\] rf.registers\[7\]\[27\]
+ _1320_ _1321_ VGND VGND VPWR VPWR _1546_ sky130_fd_sc_hd__mux4_1
X_7497_ _3669_ VGND VGND VPWR VPWR _0168_ sky130_fd_sc_hd__clkbuf_1
X_6517_ rf.registers\[17\]\[24\] _3037_ _3116_ VGND VGND VPWR VPWR _3121_ sky130_fd_sc_hd__mux2_1
XFILLER_0_43_573 VGND VGND VPWR VPWR sky130_fd_sc_hd__fill_1
X_9236_ clknet_leaf_38_CLK _0324_ VGND VGND VPWR VPWR rf.registers\[28\]\[3\] sky130_fd_sc_hd__dfxtp_1
X_6448_ _3083_ VGND VGND VPWR VPWR _0729_ sky130_fd_sc_hd__clkbuf_1
XFILLER_0_101_645 VPWR VGND VPWR VGND sky130_ef_sc_hd__decap_12
X_9167_ clknet_leaf_75_CLK _0255_ VGND VGND VPWR VPWR rf.registers\[2\]\[30\] sky130_fd_sc_hd__dfxtp_1
X_6379_ rf.registers\[12\]\[27\] _3043_ _3029_ VGND VGND VPWR VPWR _3044_ sky130_fd_sc_hd__mux2_1
X_8118_ _3999_ VGND VGND VPWR VPWR _0459_ sky130_fd_sc_hd__clkbuf_1
X_9098_ clknet_leaf_83_CLK _0186_ VGND VGND VPWR VPWR rf.registers\[31\]\[25\] sky130_fd_sc_hd__dfxtp_1
X_8049_ rf.registers\[7\]\[10\] _3298_ _3962_ VGND VGND VPWR VPWR _3963_ sky130_fd_sc_hd__mux2_1
XFILLER_0_98_713 VPWR VGND VPWR VGND sky130_ef_sc_hd__decap_12
XTAP_TAPCELL_ROW_3_352 VGND VPWR sky130_fd_sc_hd__tapvpwrvgnd_1
XTAP_TAPCELL_ROW_3_341 VGND VPWR sky130_fd_sc_hd__tapvpwrvgnd_1
XFILLER_0_98_757 VPWR VGND VPWR VGND sky130_ef_sc_hd__decap_12
XPHY_EDGE_ROW_125_Right_125 VGND VGND VPWR VPWR sky130_fd_sc_hd__decap_3
XFILLER_0_66_643 VGND VGND VPWR VPWR sky130_fd_sc_hd__fill_1
XTAP_TAPCELL_ROW_65_1282 VGND VPWR sky130_fd_sc_hd__tapvpwrvgnd_1
XTAP_TAPCELL_ROW_65_1271 VGND VPWR sky130_fd_sc_hd__tapvpwrvgnd_1
XFILLER_0_54_805 VGND VGND VPWR VPWR sky130_fd_sc_hd__decap_6
XTAP_TAPCELL_ROW_42_925 VGND VPWR sky130_fd_sc_hd__tapvpwrvgnd_1
XTAP_TAPCELL_ROW_42_936 VGND VPWR sky130_fd_sc_hd__tapvpwrvgnd_1
XFILLER_0_136_531 VGND VGND VPWR VPWR sky130_fd_sc_hd__fill_1
XFILLER_0_81_613 VGND VGND VPWR VPWR sky130_fd_sc_hd__decap_3
XFILLER_0_26_529 VGND VGND VPWR VPWR sky130_fd_sc_hd__decap_3
XFILLER_0_53_348 VGND VGND VPWR VPWR sky130_fd_sc_hd__fill_1
XFILLER_0_53_337 VGND VGND VPWR VPWR sky130_fd_sc_hd__fill_2
XFILLER_0_124_737 VPWR VGND VPWR VGND sky130_ef_sc_hd__decap_12
XFILLER_0_123_225 VPWR VGND VPWR VGND sky130_ef_sc_hd__decap_12
XFILLER_0_81_668 VGND VGND VPWR VPWR sky130_fd_sc_hd__decap_4
XFILLER_0_80_189 VGND VGND VPWR VPWR sky130_fd_sc_hd__fill_2
XFILLER_0_132_781 VPWR VGND VPWR VGND sky130_ef_sc_hd__decap_12
XFILLER_0_1_629 VPWR VGND VPWR VGND sky130_ef_sc_hd__decap_12
XFILLER_0_95_19 VPWR VGND VPWR VGND sky130_ef_sc_hd__decap_12
XFILLER_0_0_128 VPWR VGND VPWR VGND sky130_ef_sc_hd__decap_12
XFILLER_0_30_790 VPWR VGND VPWR VGND sky130_ef_sc_hd__decap_12
XFILLER_0_135_69 VPWR VGND VPWR VGND sky130_ef_sc_hd__decap_12
XFILLER_0_44_45 VGND VGND VPWR VPWR sky130_fd_sc_hd__fill_1
X_5750_ _2433_ _2435_ _2432_ VGND VGND VPWR VPWR _2477_ sky130_fd_sc_hd__a21o_1
X_4701_ _1472_ _1473_ _1397_ VGND VGND VPWR VPWR _1474_ sky130_fd_sc_hd__mux2_1
XFILLER_0_17_529 VPWR VGND VPWR VGND sky130_ef_sc_hd__decap_12
X_5681_ _2234_ _2249_ VGND VGND VPWR VPWR _2410_ sky130_fd_sc_hd__or2_1
X_7420_ _3353_ rf.registers\[29\]\[3\] _3625_ VGND VGND VPWR VPWR _3629_ sky130_fd_sc_hd__mux2_1
X_4632_ rf.registers\[4\]\[18\] rf.registers\[5\]\[18\] rf.registers\[6\]\[18\] rf.registers\[7\]\[18\]
+ _1403_ _1404_ VGND VGND VPWR VPWR _1409_ sky130_fd_sc_hd__mux4_1
XFILLER_0_4_401 VPWR VGND VPWR VGND sky130_ef_sc_hd__decap_12
XFILLER_0_25_551 VGND VGND VPWR VPWR sky130_fd_sc_hd__decap_8
X_7351_ rf.registers\[8\]\[3\] _3284_ _3588_ VGND VGND VPWR VPWR _3592_ sky130_fd_sc_hd__mux2_1
XTAP_TAPCELL_ROW_96_1743 VGND VPWR sky130_fd_sc_hd__tapvpwrvgnd_1
X_4563_ _1282_ _1335_ _1339_ _1343_ VGND VGND VPWR VPWR _1344_ sky130_fd_sc_hd__a2bb2o_2
XFILLER_0_52_381 VGND VGND VPWR VPWR sky130_fd_sc_hd__fill_2
XFILLER_0_4_445 VPWR VGND VPWR VGND sky130_ef_sc_hd__decap_12
XFILLER_0_13_724 VGND VGND VPWR VPWR sky130_fd_sc_hd__decap_4
X_6302_ rf.registers\[12\]\[2\] _2991_ _2987_ VGND VGND VPWR VPWR _2992_ sky130_fd_sc_hd__mux2_1
X_7282_ _3555_ VGND VGND VPWR VPWR _0067_ sky130_fd_sc_hd__clkbuf_1
X_4494_ rf.registers\[0\]\[11\] rf.registers\[1\]\[11\] rf.registers\[2\]\[11\] rf.registers\[3\]\[11\]
+ _1118_ _1127_ VGND VGND VPWR VPWR _1278_ sky130_fd_sc_hd__mux4_1
XFILLER_0_12_245 VGND VGND VPWR VPWR sky130_fd_sc_hd__decap_6
XFILLER_0_4_489 VPWR VGND VPWR VGND sky130_ef_sc_hd__decap_12
XFILLER_0_13_768 VPWR VGND VPWR VGND sky130_ef_sc_hd__decap_12
X_9021_ clknet_leaf_17_CLK _0109_ VGND VGND VPWR VPWR rf.registers\[8\]\[12\] sky130_fd_sc_hd__dfxtp_1
XFILLER_0_0_640 VGND VGND VPWR VPWR sky130_fd_sc_hd__decap_4
X_6233_ _2926_ _2927_ _2934_ _2399_ VGND VGND VPWR VPWR net134 sky130_fd_sc_hd__o2bb2a_2
XFILLER_0_40_565 VGND VGND VPWR VPWR sky130_fd_sc_hd__decap_4
XFILLER_0_12_289 VPWR VGND VPWR VGND sky130_ef_sc_hd__decap_12
XFILLER_0_0_651 VGND VGND VPWR VPWR sky130_fd_sc_hd__fill_1
XFILLER_0_0_673 VGND VGND VPWR VPWR sky130_fd_sc_hd__decap_6
X_6164_ _2837_ _2868_ _2260_ VGND VGND VPWR VPWR _2869_ sky130_fd_sc_hd__mux2_1
X_5115_ _1864_ _1865_ _1707_ VGND VGND VPWR VPWR _1866_ sky130_fd_sc_hd__mux2_1
X_6095_ _2776_ _2803_ _2383_ VGND VGND VPWR VPWR _2804_ sky130_fd_sc_hd__mux2_1
XFILLER_0_109_81 VPWR VGND VPWR VGND sky130_ef_sc_hd__decap_12
X_5046_ _1796_ _1798_ _1799_ _1800_ _1698_ _1651_ VGND VGND VPWR VPWR _1801_ sky130_fd_sc_hd__mux4_2
XFILLER_0_33_3 VPWR VGND VPWR VGND sky130_ef_sc_hd__decap_12
XTAP_TAPCELL_ROW_0_300 VGND VPWR sky130_fd_sc_hd__tapvpwrvgnd_1
XTAP_TAPCELL_ROW_28_719 VGND VPWR sky130_fd_sc_hd__tapvpwrvgnd_1
XTAP_TAPCELL_ROW_123_2139 VGND VPWR sky130_fd_sc_hd__tapvpwrvgnd_1
XFILLER_0_48_610 VGND VGND VPWR VPWR sky130_fd_sc_hd__decap_6
X_6997_ _3403_ VGND VGND VPWR VPWR _0958_ sky130_fd_sc_hd__clkbuf_1
X_8805_ clknet_leaf_83_CLK _0917_ VGND VGND VPWR VPWR rf.registers\[16\]\[20\] sky130_fd_sc_hd__dfxtp_1
XFILLER_0_137_317 VPWR VGND VPWR VGND sky130_ef_sc_hd__decap_12
XTAP_TAPCELL_ROW_105_1872 VGND VPWR sky130_fd_sc_hd__tapvpwrvgnd_1
X_8736_ clknet_leaf_22_CLK _0848_ VGND VGND VPWR VPWR rf.registers\[10\]\[15\] sky130_fd_sc_hd__dfxtp_1
X_5948_ _2384_ _2642_ _2398_ VGND VGND VPWR VPWR _2666_ sky130_fd_sc_hd__o21ai_1
XFILLER_0_63_613 VGND VGND VPWR VPWR sky130_fd_sc_hd__decap_3
X_8667_ clknet_leaf_32_CLK _0779_ VGND VGND VPWR VPWR rf.registers\[1\]\[10\] sky130_fd_sc_hd__dfxtp_1
XFILLER_0_90_421 VGND VGND VPWR VPWR sky130_fd_sc_hd__fill_1
X_5879_ _2560_ _2598_ _2600_ VGND VGND VPWR VPWR _2601_ sky130_fd_sc_hd__o21ai_1
XFILLER_0_35_337 VGND VGND VPWR VPWR sky130_fd_sc_hd__decap_4
XFILLER_0_47_175 VGND VGND VPWR VPWR sky130_fd_sc_hd__fill_1
XTAP_TAPCELL_ROW_138_2382 VGND VPWR sky130_fd_sc_hd__tapvpwrvgnd_1
XTAP_TAPCELL_ROW_138_2371 VGND VPWR sky130_fd_sc_hd__tapvpwrvgnd_1
X_7618_ rf.registers\[2\]\[0\] _3276_ _3733_ VGND VGND VPWR VPWR _3734_ sky130_fd_sc_hd__mux2_1
XFILLER_0_106_737 VPWR VGND VPWR VGND sky130_ef_sc_hd__decap_12
X_8598_ clknet_leaf_64_CLK _0710_ VGND VGND VPWR VPWR rf.registers\[11\]\[5\] sky130_fd_sc_hd__dfxtp_1
XFILLER_0_7_261 VPWR VGND VPWR VGND sky130_ef_sc_hd__decap_12
X_7549_ _3696_ VGND VGND VPWR VPWR _3697_ sky130_fd_sc_hd__clkbuf_8
XFILLER_0_121_729 VPWR VGND VPWR VGND sky130_ef_sc_hd__decap_12
XFILLER_0_114_781 VPWR VGND VPWR VGND sky130_ef_sc_hd__decap_12
X_9219_ clknet_leaf_6_CLK _0307_ VGND VGND VPWR VPWR rf.registers\[9\]\[18\] sky130_fd_sc_hd__dfxtp_1
XFILLER_0_31_587 VGND VGND VPWR VPWR sky130_fd_sc_hd__decap_3
XTAP_TAPCELL_ROW_8_422 VGND VPWR sky130_fd_sc_hd__tapvpwrvgnd_1
XTAP_TAPCELL_ROW_67_1300 VGND VPWR sky130_fd_sc_hd__tapvpwrvgnd_1
XFILLER_0_98_554 VGND VGND VPWR VPWR sky130_fd_sc_hd__decap_6
XTAP_TAPCELL_ROW_67_1311 VGND VPWR sky130_fd_sc_hd__tapvpwrvgnd_1
XFILLER_0_105_39 VPWR VGND VPWR VGND sky130_ef_sc_hd__decap_12
XFILLER_0_86_749 VGND VGND VPWR VPWR sky130_fd_sc_hd__decap_6
XFILLER_0_14_15 VPWR VGND VPWR VGND sky130_ef_sc_hd__decap_12
XTAP_TAPCELL_ROW_80_1500 VGND VPWR sky130_fd_sc_hd__tapvpwrvgnd_1
XFILLER_0_121_27 VPWR VGND VPWR VGND sky130_ef_sc_hd__decap_12
XFILLER_0_94_793 VPWR VGND VPWR VGND sky130_ef_sc_hd__decap_12
XFILLER_0_53_101 VGND VGND VPWR VPWR sky130_fd_sc_hd__fill_2
XFILLER_0_81_443 VGND VGND VPWR VPWR sky130_fd_sc_hd__decap_4
XFILLER_0_124_567 VGND VGND VPWR VPWR sky130_fd_sc_hd__fill_1
XFILLER_0_53_178 VGND VGND VPWR VPWR sky130_fd_sc_hd__fill_2
XTAP_TAPCELL_ROW_78_1473 VGND VPWR sky130_fd_sc_hd__tapvpwrvgnd_1
XFILLER_0_10_705 VPWR VGND VPWR VGND sky130_ef_sc_hd__decap_12
XFILLER_0_22_587 VGND VGND VPWR VPWR sky130_fd_sc_hd__fill_1
XTAP_TAPCELL_ROW_91_1662 VGND VPWR sky130_fd_sc_hd__tapvpwrvgnd_1
X_6920_ net39 VGND VGND VPWR VPWR _3353_ sky130_fd_sc_hd__clkbuf_2
X_6851_ rf.registers\[16\]\[13\] _3305_ _3299_ VGND VGND VPWR VPWR _3306_ sky130_fd_sc_hd__mux2_1
XFILLER_0_77_727 VGND VGND VPWR VPWR sky130_fd_sc_hd__fill_1
XFILLER_0_71_54 VGND VGND VPWR VPWR sky130_fd_sc_hd__fill_2
X_9570_ clknet_leaf_10_CLK _0658_ VGND VGND VPWR VPWR rf.registers\[13\]\[17\] sky130_fd_sc_hd__dfxtp_1
X_5802_ _2525_ _2526_ _2340_ VGND VGND VPWR VPWR _2527_ sky130_fd_sc_hd__mux2_1
X_8521_ _3005_ rf.registers\[13\]\[9\] _4205_ VGND VGND VPWR VPWR _4212_ sky130_fd_sc_hd__mux2_1
X_6782_ _3262_ VGND VGND VPWR VPWR _0884_ sky130_fd_sc_hd__clkbuf_1
XFILLER_0_9_559 VGND VGND VPWR VPWR sky130_fd_sc_hd__fill_1
XFILLER_0_18_805 VGND VGND VPWR VPWR sky130_fd_sc_hd__decap_6
XFILLER_0_134_309 VPWR VGND VPWR VGND sky130_ef_sc_hd__decap_12
X_5733_ _2296_ _2458_ _2459_ _2293_ VGND VGND VPWR VPWR _2460_ sky130_fd_sc_hd__o22a_1
XFILLER_0_17_337 VGND VGND VPWR VPWR sky130_fd_sc_hd__decap_3
XTAP_TAPCELL_ROW_33_788 VGND VPWR sky130_fd_sc_hd__tapvpwrvgnd_1
XFILLER_0_127_361 VPWR VGND VPWR VGND sky130_ef_sc_hd__decap_12
X_8452_ _3003_ rf.registers\[14\]\[8\] _4167_ VGND VGND VPWR VPWR _4176_ sky130_fd_sc_hd__mux2_1
XTAP_TAPCELL_ROW_33_799 VGND VPWR sky130_fd_sc_hd__tapvpwrvgnd_1
X_5664_ _2390_ _2393_ _1666_ VGND VGND VPWR VPWR _2394_ sky130_fd_sc_hd__a21oi_1
X_8383_ _4139_ VGND VGND VPWR VPWR _0584_ sky130_fd_sc_hd__clkbuf_1
X_4615_ _1392_ VGND VGND VPWR VPWR net89 sky130_fd_sc_hd__clkbuf_2
XFILLER_0_5_765 VPWR VGND VPWR VGND sky130_ef_sc_hd__decap_12
XTAP_TAPCELL_ROW_13_490 VGND VPWR sky130_fd_sc_hd__tapvpwrvgnd_1
X_5595_ _2260_ _2324_ VGND VGND VPWR VPWR _2325_ sky130_fd_sc_hd__nand2_1
X_7403_ rf.registers\[8\]\[28\] _3336_ _3610_ VGND VGND VPWR VPWR _3619_ sky130_fd_sc_hd__mux2_1
XFILLER_0_103_729 VPWR VGND VPWR VGND sky130_ef_sc_hd__decap_12
X_4546_ _1282_ _1317_ _1327_ VGND VGND VPWR VPWR _1328_ sky130_fd_sc_hd__o21ai_4
XFILLER_0_53_690 VPWR VGND VPWR VGND sky130_ef_sc_hd__decap_12
XFILLER_0_4_253 VPWR VGND VPWR VGND sky130_ef_sc_hd__decap_12
X_7334_ _3582_ VGND VGND VPWR VPWR _0092_ sky130_fd_sc_hd__clkbuf_1
XFILLER_0_41_841 VGND VGND VPWR VPWR sky130_fd_sc_hd__fill_1
XTAP_TAPCELL_ROW_133_2290 VGND VPWR sky130_fd_sc_hd__tapvpwrvgnd_1
XFILLER_0_111_93 VPWR VGND VPWR VGND sky130_ef_sc_hd__decap_12
XFILLER_0_13_565 VGND VGND VPWR VPWR sky130_fd_sc_hd__decap_8
X_4477_ _1144_ _1259_ _1261_ _1034_ VGND VGND VPWR VPWR _1262_ sky130_fd_sc_hd__o211a_1
X_7265_ rf.registers\[19\]\[27\] _3334_ _3538_ VGND VGND VPWR VPWR _3546_ sky130_fd_sc_hd__mux2_1
X_9004_ clknet_leaf_87_CLK _0092_ VGND VGND VPWR VPWR rf.registers\[3\]\[27\] sky130_fd_sc_hd__dfxtp_1
X_7196_ _3509_ VGND VGND VPWR VPWR _0027_ sky130_fd_sc_hd__clkbuf_1
X_6216_ _2917_ _2918_ VGND VGND VPWR VPWR _2919_ sky130_fd_sc_hd__nor2_1
X_6147_ _2847_ _2850_ _2853_ VGND VGND VPWR VPWR _2854_ sky130_fd_sc_hd__a21boi_1
XTAP_TAPCELL_ROW_107_1901 VGND VPWR sky130_fd_sc_hd__tapvpwrvgnd_1
X_6078_ _2769_ _2774_ VGND VGND VPWR VPWR _2788_ sky130_fd_sc_hd__or2_1
XTAP_TAPCELL_ROW_107_1912 VGND VPWR sky130_fd_sc_hd__tapvpwrvgnd_1
X_5029_ _1781_ _1784_ _1628_ VGND VGND VPWR VPWR _1785_ sky130_fd_sc_hd__mux2_1
XTAP_TAPCELL_ROW_49_1041 VGND VPWR sky130_fd_sc_hd__tapvpwrvgnd_1
XTAP_TAPCELL_ROW_49_1030 VGND VPWR sky130_fd_sc_hd__tapvpwrvgnd_1
XFILLER_0_137_125 VPWR VGND VPWR VGND sky130_ef_sc_hd__decap_12
XTAP_TAPCELL_ROW_62_1230 VGND VPWR sky130_fd_sc_hd__tapvpwrvgnd_1
XFILLER_0_137_169 VPWR VGND VPWR VGND sky130_ef_sc_hd__decap_12
XFILLER_0_91_741 VPWR VGND VPWR VGND sky130_ef_sc_hd__decap_12
XFILLER_0_76_793 VPWR VGND VPWR VGND sky130_ef_sc_hd__decap_12
XFILLER_0_75_281 VGND VGND VPWR VPWR sky130_fd_sc_hd__decap_3
XFILLER_0_63_432 VGND VGND VPWR VPWR sky130_fd_sc_hd__decap_4
X_8719_ clknet_leaf_67_CLK _0831_ VGND VGND VPWR VPWR rf.registers\[24\]\[30\] sky130_fd_sc_hd__dfxtp_1
XFILLER_0_36_657 VGND VGND VPWR VPWR sky130_fd_sc_hd__decap_6
XFILLER_0_91_785 VPWR VGND VPWR VGND sky130_ef_sc_hd__decap_12
XFILLER_0_63_498 VGND VGND VPWR VPWR sky130_fd_sc_hd__decap_6
XFILLER_0_35_189 VGND VGND VPWR VPWR sky130_fd_sc_hd__decap_4
XFILLER_0_50_137 VGND VGND VPWR VPWR sky130_fd_sc_hd__decap_3
XFILLER_0_31_340 VGND VGND VPWR VPWR sky130_fd_sc_hd__fill_2
XFILLER_0_31_351 VGND VGND VPWR VPWR sky130_fd_sc_hd__fill_2
XTAP_TAPCELL_ROW_73_1392 VGND VPWR sky130_fd_sc_hd__tapvpwrvgnd_1
XFILLER_0_99_841 VGND VGND VPWR VPWR sky130_fd_sc_hd__fill_1
XFILLER_0_116_27 VGND VGND VPWR VPWR sky130_fd_sc_hd__fill_1
XFILLER_0_86_502 VGND VGND VPWR VPWR sky130_fd_sc_hd__fill_2
XFILLER_0_59_727 VGND VGND VPWR VPWR sky130_fd_sc_hd__fill_1
XFILLER_0_58_248 VGND VGND VPWR VPWR sky130_fd_sc_hd__decap_4
XFILLER_0_132_15 VPWR VGND VPWR VGND sky130_ef_sc_hd__decap_12
XFILLER_0_125_821 VPWR VGND VPWR VGND sky130_ef_sc_hd__decap_12
XTAP_TAPCELL_ROW_30_747 VGND VPWR sky130_fd_sc_hd__tapvpwrvgnd_1
XFILLER_0_14_307 VGND VGND VPWR VPWR sky130_fd_sc_hd__fill_1
XTAP_TAPCELL_ROW_93_1702 VGND VPWR sky130_fd_sc_hd__tapvpwrvgnd_1
X_4400_ _1185_ _1188_ _1168_ VGND VGND VPWR VPWR _1189_ sky130_fd_sc_hd__mux2_1
XFILLER_0_81_295 VGND VGND VPWR VPWR sky130_fd_sc_hd__fill_2
XFILLER_0_2_713 VPWR VGND VPWR VGND sky130_ef_sc_hd__decap_12
XFILLER_0_23_841 VGND VGND VPWR VPWR sky130_fd_sc_hd__fill_1
XFILLER_0_2_757 VPWR VGND VPWR VGND sky130_ef_sc_hd__decap_12
XFILLER_0_1_223 VGND VGND VPWR VPWR sky130_fd_sc_hd__fill_1
XFILLER_0_22_362 VGND VGND VPWR VPWR sky130_fd_sc_hd__fill_2
X_5380_ _2115_ _2116_ _2074_ VGND VGND VPWR VPWR _2117_ sky130_fd_sc_hd__mux2_1
X_4331_ _1121_ VGND VGND VPWR VPWR _1122_ sky130_fd_sc_hd__buf_4
XFILLER_0_10_513 VPWR VGND VPWR VGND sky130_ef_sc_hd__decap_12
XFILLER_0_22_373 VGND VGND VPWR VPWR sky130_fd_sc_hd__decap_4
X_4262_ _1056_ VGND VGND VPWR VPWR net81 sky130_fd_sc_hd__buf_4
X_7050_ _3432_ VGND VGND VPWR VPWR _0982_ sky130_fd_sc_hd__clkbuf_1
X_6001_ _1115_ _2462_ VGND VGND VPWR VPWR _2716_ sky130_fd_sc_hd__nand2_2
XFILLER_0_5_57 VPWR VGND VPWR VGND sky130_ef_sc_hd__decap_12
X_7952_ _2976_ rf.registers\[23\]\[29\] _3901_ VGND VGND VPWR VPWR _3911_ sky130_fd_sc_hd__mux2_1
XTAP_TAPCELL_ROW_38_869 VGND VPWR sky130_fd_sc_hd__tapvpwrvgnd_1
X_6903_ rf.registers\[16\]\[30\] _3340_ _3277_ VGND VGND VPWR VPWR _3341_ sky130_fd_sc_hd__mux2_1
XFILLER_0_106_71 VGND VGND VPWR VPWR sky130_fd_sc_hd__fill_1
XFILLER_0_49_248 VGND VGND VPWR VPWR sky130_fd_sc_hd__fill_1
XTAP_TAPCELL_ROW_18_571 VGND VPWR sky130_fd_sc_hd__tapvpwrvgnd_1
X_7883_ _2976_ rf.registers\[28\]\[29\] _3864_ VGND VGND VPWR VPWR _3874_ sky130_fd_sc_hd__mux2_1
XFILLER_0_119_125 VPWR VGND VPWR VGND sky130_ef_sc_hd__decap_12
X_6834_ net44 VGND VGND VPWR VPWR _3294_ sky130_fd_sc_hd__buf_2
XTAP_TAPCELL_ROW_102_1831 VGND VPWR sky130_fd_sc_hd__tapvpwrvgnd_1
X_9553_ clknet_leaf_40_CLK _0641_ VGND VGND VPWR VPWR rf.registers\[13\]\[0\] sky130_fd_sc_hd__dfxtp_1
XFILLER_0_119_169 VPWR VGND VPWR VGND sky130_ef_sc_hd__decap_12
XFILLER_0_92_549 VGND VGND VPWR VPWR sky130_fd_sc_hd__fill_2
X_6765_ rf.registers\[0\]\[11\] _3010_ _3252_ VGND VGND VPWR VPWR _3254_ sky130_fd_sc_hd__mux2_1
XFILLER_0_58_793 VPWR VGND VPWR VGND sky130_ef_sc_hd__decap_12
XFILLER_0_45_410 VGND VGND VPWR VPWR sky130_fd_sc_hd__fill_1
XFILLER_0_135_629 VPWR VGND VPWR VGND sky130_ef_sc_hd__decap_12
X_8504_ _2989_ rf.registers\[13\]\[1\] _2968_ VGND VGND VPWR VPWR _4203_ sky130_fd_sc_hd__mux2_1
XFILLER_0_73_741 VPWR VGND VPWR VGND sky130_ef_sc_hd__decap_12
XFILLER_0_18_657 VGND VGND VPWR VPWR sky130_fd_sc_hd__fill_2
XFILLER_0_18_668 VPWR VGND VPWR VGND sky130_ef_sc_hd__decap_12
X_9484_ clknet_leaf_87_CLK _0572_ VGND VGND VPWR VPWR rf.registers\[20\]\[27\] sky130_fd_sc_hd__dfxtp_1
X_5716_ _2331_ _2363_ _2304_ VGND VGND VPWR VPWR _2444_ sky130_fd_sc_hd__mux2_1
XFILLER_0_45_432 VGND VGND VPWR VPWR sky130_fd_sc_hd__decap_4
XTAP_TAPCELL_ROW_135_2330 VGND VPWR sky130_fd_sc_hd__tapvpwrvgnd_1
XFILLER_0_134_139 VGND VGND VPWR VPWR sky130_fd_sc_hd__fill_1
X_6696_ _3217_ VGND VGND VPWR VPWR _0843_ sky130_fd_sc_hd__clkbuf_1
XFILLER_0_73_785 VPWR VGND VPWR VGND sky130_ef_sc_hd__decap_12
X_8435_ _4166_ VGND VGND VPWR VPWR _4167_ sky130_fd_sc_hd__clkbuf_8
XFILLER_0_60_402 VGND VGND VPWR VPWR sky130_fd_sc_hd__fill_2
XFILLER_0_17_167 VGND VGND VPWR VPWR sky130_fd_sc_hd__fill_1
XFILLER_0_130_301 VGND VGND VPWR VPWR sky130_fd_sc_hd__decap_6
XFILLER_0_5_573 VPWR VGND VPWR VGND sky130_ef_sc_hd__decap_12
X_5647_ _2229_ _2149_ _2219_ _2376_ VGND VGND VPWR VPWR _2377_ sky130_fd_sc_hd__o31a_1
X_8366_ _3092_ _3203_ VGND VGND VPWR VPWR _4130_ sky130_fd_sc_hd__nor2_4
XFILLER_0_60_468 VGND VGND VPWR VPWR sky130_fd_sc_hd__decap_3
X_5578_ _2046_ _2207_ VGND VGND VPWR VPWR _2309_ sky130_fd_sc_hd__nor2_1
XFILLER_0_130_345 VPWR VGND VPWR VGND sky130_ef_sc_hd__decap_12
X_4529_ rf.registers\[16\]\[13\] rf.registers\[17\]\[13\] rf.registers\[18\]\[13\]
+ rf.registers\[19\]\[13\] _1126_ _1129_ VGND VGND VPWR VPWR _1311_ sky130_fd_sc_hd__mux4_1
X_7317_ _3573_ VGND VGND VPWR VPWR _0084_ sky130_fd_sc_hd__clkbuf_1
XFILLER_0_13_373 VPWR VGND VPWR VGND sky130_ef_sc_hd__decap_12
XFILLER_0_41_693 VGND VGND VPWR VPWR sky130_fd_sc_hd__decap_8
X_8297_ _4093_ VGND VGND VPWR VPWR _0544_ sky130_fd_sc_hd__clkbuf_1
XFILLER_0_130_389 VPWR VGND VPWR VGND sky130_ef_sc_hd__decap_12
X_7248_ rf.registers\[19\]\[19\] _3317_ _3527_ VGND VGND VPWR VPWR _3537_ sky130_fd_sc_hd__mux2_1
XTAP_TAPCELL_ROW_113_1993 VGND VPWR sky130_fd_sc_hd__tapvpwrvgnd_1
X_7179_ _3500_ VGND VGND VPWR VPWR _0019_ sky130_fd_sc_hd__clkbuf_1
XFILLER_0_96_811 VGND VGND VPWR VPWR sky130_fd_sc_hd__fill_1
XFILLER_0_138_489 VPWR VGND VPWR VGND sky130_ef_sc_hd__decap_12
XFILLER_0_107_821 VPWR VGND VPWR VGND sky130_ef_sc_hd__decap_12
XFILLER_0_63_240 VGND VGND VPWR VPWR sky130_fd_sc_hd__decap_4
XFILLER_0_102_29 VPWR VGND VPWR VGND sky130_ef_sc_hd__decap_12
XFILLER_0_51_413 VGND VGND VPWR VPWR sky130_fd_sc_hd__decap_8
XFILLER_0_122_813 VPWR VGND VPWR VGND sky130_ef_sc_hd__decap_12
XFILLER_0_121_301 VGND VGND VPWR VPWR sky130_fd_sc_hd__fill_1
XFILLER_0_133_161 VGND VGND VPWR VPWR sky130_fd_sc_hd__decap_6
XTAP_TAPCELL_ROW_75_1432 VGND VPWR sky130_fd_sc_hd__tapvpwrvgnd_1
XTAP_TAPCELL_ROW_75_1421 VGND VPWR sky130_fd_sc_hd__tapvpwrvgnd_1
XFILLER_0_32_682 VGND VGND VPWR VPWR sky130_fd_sc_hd__decap_3
Xinput9 A3[0] VGND VGND VPWR VPWR net9 sky130_fd_sc_hd__clkbuf_4
XFILLER_0_87_833 VGND VGND VPWR VPWR sky130_fd_sc_hd__decap_6
XTAP_TAPCELL_ROW_86_1583 VGND VPWR sky130_fd_sc_hd__tapvpwrvgnd_1
XFILLER_0_59_535 VPWR VGND VPWR VGND sky130_ef_sc_hd__decap_12
XTAP_TAPCELL_ROW_35_828 VGND VPWR sky130_fd_sc_hd__tapvpwrvgnd_1
X_4880_ _1616_ _1629_ _1642_ VGND VGND VPWR VPWR _1643_ sky130_fd_sc_hd__o21ai_4
XTAP_TAPCELL_ROW_86_1594 VGND VPWR sky130_fd_sc_hd__tapvpwrvgnd_1
XFILLER_0_86_343 VGND VGND VPWR VPWR sky130_fd_sc_hd__decap_4
XFILLER_0_74_505 VGND VGND VPWR VPWR sky130_fd_sc_hd__fill_1
XTAP_TAPCELL_ROW_15_530 VGND VPWR sky130_fd_sc_hd__tapvpwrvgnd_1
X_6550_ rf.registers\[1\]\[7\] _3001_ _3131_ VGND VGND VPWR VPWR _3139_ sky130_fd_sc_hd__mux2_1
XFILLER_0_55_741 VPWR VGND VPWR VGND sky130_ef_sc_hd__decap_12
XFILLER_0_116_139 VGND VGND VPWR VPWR sky130_fd_sc_hd__fill_1
XFILLER_0_82_582 VGND VGND VPWR VPWR sky130_fd_sc_hd__decap_3
XFILLER_0_55_785 VPWR VGND VPWR VGND sky130_ef_sc_hd__decap_12
X_5501_ net81 _2228_ _2231_ VGND VGND VPWR VPWR _2232_ sky130_fd_sc_hd__o21bai_1
XFILLER_0_125_673 VPWR VGND VPWR VGND sky130_ef_sc_hd__decap_12
XTAP_TAPCELL_ROW_117_2060 VGND VPWR sky130_fd_sc_hd__tapvpwrvgnd_1
X_6481_ rf.registers\[17\]\[7\] _3001_ _3094_ VGND VGND VPWR VPWR _3102_ sky130_fd_sc_hd__mux2_1
XFILLER_0_70_755 VGND VGND VPWR VPWR sky130_fd_sc_hd__fill_1
XFILLER_0_112_334 VGND VGND VPWR VPWR sky130_fd_sc_hd__decap_4
XFILLER_0_112_312 VGND VGND VPWR VPWR sky130_fd_sc_hd__fill_1
X_5432_ _2165_ VGND VGND VPWR VPWR net70 sky130_fd_sc_hd__inv_2
X_8220_ _3043_ rf.registers\[21\]\[27\] _4045_ VGND VGND VPWR VPWR _4053_ sky130_fd_sc_hd__mux2_1
XFILLER_0_11_833 VGND VGND VPWR VPWR sky130_fd_sc_hd__fill_1
X_8151_ _4016_ VGND VGND VPWR VPWR _0475_ sky130_fd_sc_hd__clkbuf_1
XFILLER_0_23_671 VGND VGND VPWR VPWR sky130_fd_sc_hd__fill_1
XFILLER_0_23_693 VGND VGND VPWR VPWR sky130_fd_sc_hd__decap_4
X_5363_ _2100_ VGND VGND VPWR VPWR net66 sky130_fd_sc_hd__inv_2
X_4314_ rf.registers\[0\]\[3\] rf.registers\[1\]\[3\] rf.registers\[2\]\[3\] rf.registers\[3\]\[3\]
+ _1026_ _1027_ VGND VGND VPWR VPWR _1106_ sky130_fd_sc_hd__mux4_1
XFILLER_0_100_529 VGND VGND VPWR VPWR sky130_fd_sc_hd__decap_3
X_7102_ rf.registers\[5\]\[14\] _3307_ _3455_ VGND VGND VPWR VPWR _3460_ sky130_fd_sc_hd__mux2_1
XFILLER_0_10_321 VPWR VGND VPWR VGND sky130_ef_sc_hd__decap_12
XFILLER_0_2_587 VGND VGND VPWR VPWR sky130_fd_sc_hd__fill_1
XFILLER_0_10_365 VPWR VGND VPWR VGND sky130_ef_sc_hd__decap_12
X_8082_ rf.registers\[7\]\[26\] _3332_ _3973_ VGND VGND VPWR VPWR _3980_ sky130_fd_sc_hd__mux2_1
X_5294_ rf.registers\[16\]\[22\] rf.registers\[17\]\[22\] rf.registers\[18\]\[22\]
+ rf.registers\[19\]\[22\] _1730_ _1732_ VGND VGND VPWR VPWR _2035_ sky130_fd_sc_hd__mux4_1
X_4245_ _1034_ _1039_ VGND VGND VPWR VPWR _1040_ sky130_fd_sc_hd__nand2_1
X_7033_ _3423_ VGND VGND VPWR VPWR _0974_ sky130_fd_sc_hd__clkbuf_1
XFILLER_0_117_81 VPWR VGND VPWR VGND sky130_ef_sc_hd__decap_12
X_8984_ clknet_leaf_50_CLK _0072_ VGND VGND VPWR VPWR rf.registers\[3\]\[7\] sky130_fd_sc_hd__dfxtp_1
XFILLER_0_78_811 VGND VGND VPWR VPWR sky130_fd_sc_hd__fill_1
X_7935_ _3902_ VGND VGND VPWR VPWR _0373_ sky130_fd_sc_hd__clkbuf_1
XFILLER_0_65_505 VGND VGND VPWR VPWR sky130_fd_sc_hd__fill_2
X_7866_ _3865_ VGND VGND VPWR VPWR _0341_ sky130_fd_sc_hd__clkbuf_1
X_6817_ rf.registers\[16\]\[2\] _3282_ _3278_ VGND VGND VPWR VPWR _3283_ sky130_fd_sc_hd__mux2_1
XFILLER_0_65_538 VGND VGND VPWR VPWR sky130_fd_sc_hd__fill_1
XFILLER_0_65_516 VGND VGND VPWR VPWR sky130_fd_sc_hd__decap_6
XFILLER_0_18_410 VGND VGND VPWR VPWR sky130_fd_sc_hd__decap_6
X_9536_ clknet_leaf_22_CLK _0624_ VGND VGND VPWR VPWR rf.registers\[14\]\[15\] sky130_fd_sc_hd__dfxtp_1
XFILLER_0_18_454 VGND VGND VPWR VPWR sky130_fd_sc_hd__fill_2
X_7797_ rf.registers\[9\]\[20\] _3319_ _3828_ VGND VGND VPWR VPWR _3829_ sky130_fd_sc_hd__mux2_1
X_6748_ rf.registers\[0\]\[3\] _2993_ _3241_ VGND VGND VPWR VPWR _3245_ sky130_fd_sc_hd__mux2_1
XFILLER_0_18_465 VGND VGND VPWR VPWR sky130_fd_sc_hd__decap_8
XFILLER_0_122_109 VPWR VGND VPWR VGND sky130_ef_sc_hd__decap_12
X_6679_ _3208_ VGND VGND VPWR VPWR _0835_ sky130_fd_sc_hd__clkbuf_1
X_9467_ clknet_leaf_36_CLK _0555_ VGND VGND VPWR VPWR rf.registers\[20\]\[10\] sky130_fd_sc_hd__dfxtp_1
XFILLER_0_104_813 VPWR VGND VPWR VGND sky130_ef_sc_hd__decap_12
XFILLER_0_115_161 VGND VGND VPWR VPWR sky130_fd_sc_hd__decap_6
X_9398_ clknet_leaf_58_CLK _0486_ VGND VGND VPWR VPWR rf.registers\[21\]\[5\] sky130_fd_sc_hd__dfxtp_1
XFILLER_0_61_777 VGND VGND VPWR VPWR sky130_fd_sc_hd__decap_6
XFILLER_0_60_265 VGND VGND VPWR VPWR sky130_fd_sc_hd__fill_2
X_8418_ rf.registers\[18\]\[24\] net30 _4153_ VGND VGND VPWR VPWR _4158_ sky130_fd_sc_hd__mux2_1
X_8349_ _4121_ VGND VGND VPWR VPWR _0568_ sky130_fd_sc_hd__clkbuf_1
XFILLER_0_130_153 VPWR VGND VPWR VGND sky130_ef_sc_hd__decap_12
XFILLER_0_103_389 VGND VGND VPWR VPWR sky130_fd_sc_hd__decap_3
XTAP_TAPCELL_ROW_57_1162 VGND VPWR sky130_fd_sc_hd__tapvpwrvgnd_1
XTAP_TAPCELL_ROW_57_1151 VGND VPWR sky130_fd_sc_hd__tapvpwrvgnd_1
XFILLER_0_13_181 VPWR VGND VPWR VGND sky130_ef_sc_hd__decap_12
XFILLER_0_41_490 VGND VGND VPWR VPWR sky130_fd_sc_hd__decap_8
XFILLER_0_130_197 VPWR VGND VPWR VGND sky130_ef_sc_hd__decap_12
XTAP_TAPCELL_ROW_70_1351 VGND VPWR sky130_fd_sc_hd__tapvpwrvgnd_1
XFILLER_0_69_833 VGND VGND VPWR VPWR sky130_fd_sc_hd__decap_6
XFILLER_0_68_365 VGND VGND VPWR VPWR sky130_fd_sc_hd__fill_2
XFILLER_0_84_825 VPWR VGND VPWR VGND sky130_ef_sc_hd__decap_12
XFILLER_0_83_302 VGND VGND VPWR VPWR sky130_fd_sc_hd__fill_2
XFILLER_0_56_527 VGND VGND VPWR VPWR sky130_fd_sc_hd__fill_2
XFILLER_0_22_15 VPWR VGND VPWR VGND sky130_ef_sc_hd__decap_12
XFILLER_0_113_39 VPWR VGND VPWR VGND sky130_ef_sc_hd__decap_12
XFILLER_0_107_673 VPWR VGND VPWR VGND sky130_ef_sc_hd__decap_12
XFILLER_0_52_755 VGND VGND VPWR VPWR sky130_fd_sc_hd__fill_1
XFILLER_0_51_210 VGND VGND VPWR VPWR sky130_fd_sc_hd__decap_3
XTAP_TAPCELL_ROW_40_897 VGND VPWR sky130_fd_sc_hd__tapvpwrvgnd_1
XFILLER_0_134_481 VGND VGND VPWR VPWR sky130_fd_sc_hd__decap_4
XFILLER_0_3_329 VGND VGND VPWR VPWR sky130_fd_sc_hd__decap_6
XFILLER_0_110_805 VGND VGND VPWR VPWR sky130_fd_sc_hd__decap_6
XFILLER_0_106_194 VGND VGND VPWR VPWR sky130_fd_sc_hd__fill_2
XFILLER_0_20_652 VPWR VGND VPWR VGND sky130_ef_sc_hd__decap_12
XFILLER_0_138_47 VGND VGND VPWR VPWR sky130_fd_sc_hd__decap_8
XFILLER_0_138_69 VPWR VGND VPWR VGND sky130_ef_sc_hd__decap_12
XPHY_EDGE_ROW_10_Right_10 VGND VGND VPWR VPWR sky130_fd_sc_hd__decap_3
XTAP_TAPCELL_ROW_88_1623 VGND VPWR sky130_fd_sc_hd__tapvpwrvgnd_1
XFILLER_0_87_641 VGND VGND VPWR VPWR sky130_fd_sc_hd__fill_1
X_5981_ _2627_ _2696_ _2416_ VGND VGND VPWR VPWR _2697_ sky130_fd_sc_hd__mux2_1
X_4932_ _1688_ _1691_ _1651_ VGND VGND VPWR VPWR _1692_ sky130_fd_sc_hd__mux2_1
X_7720_ _3380_ rf.registers\[30\]\[16\] _3781_ VGND VGND VPWR VPWR _3788_ sky130_fd_sc_hd__mux2_1
X_7651_ rf.registers\[2\]\[16\] _3311_ _3744_ VGND VGND VPWR VPWR _3751_ sky130_fd_sc_hd__mux2_1
X_4863_ rf.registers\[24\]\[0\] rf.registers\[25\]\[0\] rf.registers\[26\]\[0\] rf.registers\[27\]\[0\]
+ _1624_ _1625_ VGND VGND VPWR VPWR _1626_ sky130_fd_sc_hd__mux4_1
X_6602_ net11 net12 net13 VGND VGND VPWR VPWR _3166_ sky130_fd_sc_hd__and3b_2
XFILLER_0_7_613 VGND VGND VPWR VPWR sky130_fd_sc_hd__decap_3
XANTENNA_14 net119 VGND VGND VPWR VPWR sky130_fd_sc_hd__diode_2
X_7582_ _3714_ VGND VGND VPWR VPWR _0208_ sky130_fd_sc_hd__clkbuf_1
XFILLER_0_62_519 VPWR VGND VPWR VGND sky130_ef_sc_hd__decap_12
XFILLER_0_7_646 VPWR VGND VPWR VGND sky130_ef_sc_hd__decap_12
X_4794_ rf.registers\[8\]\[28\] rf.registers\[9\]\[28\] rf.registers\[10\]\[28\] rf.registers\[11\]\[28\]
+ _1393_ _1394_ VGND VGND VPWR VPWR _1561_ sky130_fd_sc_hd__mux4_1
XFILLER_0_28_763 VPWR VGND VPWR VGND sky130_ef_sc_hd__decap_12
XTAP_TAPCELL_ROW_115_2019 VGND VPWR sky130_fd_sc_hd__tapvpwrvgnd_1
X_6533_ net13 net12 net11 VGND VGND VPWR VPWR _3129_ sky130_fd_sc_hd__or3_4
XFILLER_0_55_582 VPWR VGND VPWR VGND sky130_ef_sc_hd__decap_12
X_9321_ clknet_leaf_84_CLK _0409_ VGND VGND VPWR VPWR rf.registers\[22\]\[24\] sky130_fd_sc_hd__dfxtp_1
XTAP_TAPCELL_ROW_99_1785 VGND VPWR sky130_fd_sc_hd__tapvpwrvgnd_1
X_9252_ clknet_leaf_22_CLK _0340_ VGND VGND VPWR VPWR rf.registers\[28\]\[19\] sky130_fd_sc_hd__dfxtp_1
X_6464_ net12 net11 net13 VGND VGND VPWR VPWR _3092_ sky130_fd_sc_hd__or3b_4
XFILLER_0_6_189 VGND VGND VPWR VPWR sky130_fd_sc_hd__decap_6
Xoutput110 net110 VGND VGND VPWR VPWR RD2[7] sky130_fd_sc_hd__buf_1
X_8203_ _3386_ rf.registers\[21\]\[19\] _4034_ VGND VGND VPWR VPWR _4044_ sky130_fd_sc_hd__mux2_1
XFILLER_0_3_841 VGND VGND VPWR VPWR sky130_fd_sc_hd__fill_1
X_5415_ _2149_ VGND VGND VPWR VPWR net69 sky130_fd_sc_hd__inv_2
XFILLER_0_113_676 VPWR VGND VPWR VGND sky130_ef_sc_hd__decap_12
X_9183_ clknet_leaf_25_CLK _0271_ VGND VGND VPWR VPWR rf.registers\[30\]\[14\] sky130_fd_sc_hd__dfxtp_1
XFILLER_0_112_153 VGND VGND VPWR VPWR sky130_fd_sc_hd__fill_1
X_6395_ _3053_ _3054_ VGND VGND VPWR VPWR _3055_ sky130_fd_sc_hd__nor2_2
Xoutput132 net132 VGND VGND VPWR VPWR alu_result[27] sky130_fd_sc_hd__buf_1
Xoutput121 net121 VGND VGND VPWR VPWR alu_result[17] sky130_fd_sc_hd__buf_1
Xoutput143 net143 VGND VGND VPWR VPWR alu_result[8] sky130_fd_sc_hd__buf_1
XFILLER_0_100_359 VGND VGND VPWR VPWR sky130_fd_sc_hd__fill_2
X_8134_ _4007_ VGND VGND VPWR VPWR _0467_ sky130_fd_sc_hd__clkbuf_1
X_5346_ _2084_ VGND VGND VPWR VPWR net65 sky130_fd_sc_hd__inv_2
X_8065_ rf.registers\[7\]\[18\] _3315_ _3962_ VGND VGND VPWR VPWR _3971_ sky130_fd_sc_hd__mux2_1
X_5277_ _2017_ _2018_ _1943_ VGND VGND VPWR VPWR _2019_ sky130_fd_sc_hd__mux2_1
XFILLER_0_10_195 VGND VGND VPWR VPWR sky130_fd_sc_hd__fill_1
XTAP_TAPCELL_ROW_110_1952 VGND VPWR sky130_fd_sc_hd__tapvpwrvgnd_1
X_7016_ _3414_ VGND VGND VPWR VPWR _0966_ sky130_fd_sc_hd__clkbuf_1
XTAP_TAPCELL_ROW_52_1081 VGND VPWR sky130_fd_sc_hd__tapvpwrvgnd_1
XPHY_EDGE_ROW_106_Right_106 VGND VGND VPWR VPWR sky130_fd_sc_hd__decap_3
XFILLER_0_97_405 VGND VGND VPWR VPWR sky130_fd_sc_hd__fill_2
XFILLER_0_97_449 VGND VGND VPWR VPWR sky130_fd_sc_hd__decap_8
X_8967_ clknet_leaf_0_CLK _0055_ VGND VGND VPWR VPWR rf.registers\[19\]\[22\] sky130_fd_sc_hd__dfxtp_1
X_7918_ _3893_ VGND VGND VPWR VPWR _0365_ sky130_fd_sc_hd__clkbuf_1
X_8898_ clknet_leaf_12_CLK _1010_ VGND VGND VPWR VPWR rf.registers\[5\]\[17\] sky130_fd_sc_hd__dfxtp_1
XFILLER_0_66_825 VPWR VGND VPWR VGND sky130_ef_sc_hd__decap_12
XFILLER_0_136_713 VPWR VGND VPWR VGND sky130_ef_sc_hd__decap_12
X_7849_ _3856_ VGND VGND VPWR VPWR _0333_ sky130_fd_sc_hd__clkbuf_1
XFILLER_0_93_655 VPWR VGND VPWR VGND sky130_ef_sc_hd__decap_12
XFILLER_0_136_757 VPWR VGND VPWR VGND sky130_ef_sc_hd__decap_12
XFILLER_0_135_223 VGND VGND VPWR VPWR sky130_fd_sc_hd__fill_1
XFILLER_0_108_448 VGND VGND VPWR VPWR sky130_fd_sc_hd__decap_4
XFILLER_0_81_839 VGND VGND VPWR VPWR sky130_fd_sc_hd__fill_1
XFILLER_0_19_785 VPWR VGND VPWR VGND sky130_ef_sc_hd__decap_12
XFILLER_0_80_338 VGND VGND VPWR VPWR sky130_fd_sc_hd__fill_1
XFILLER_0_73_390 VGND VGND VPWR VPWR sky130_fd_sc_hd__fill_2
X_9519_ clknet_leaf_73_CLK _0607_ VGND VGND VPWR VPWR rf.registers\[18\]\[30\] sky130_fd_sc_hd__dfxtp_1
XFILLER_0_123_429 VGND VGND VPWR VPWR sky130_fd_sc_hd__fill_2
XFILLER_0_61_552 VGND VGND VPWR VPWR sky130_fd_sc_hd__decap_8
XFILLER_0_21_416 VGND VGND VPWR VPWR sky130_fd_sc_hd__fill_1
XFILLER_0_34_799 VPWR VGND VPWR VGND sky130_ef_sc_hd__decap_12
XFILLER_0_104_676 VPWR VGND VPWR VGND sky130_ef_sc_hd__decap_12
XFILLER_0_103_164 VGND VGND VPWR VPWR sky130_fd_sc_hd__decap_4
XFILLER_0_21_449 VGND VGND VPWR VPWR sky130_fd_sc_hd__fill_1
XTAP_TAPCELL_ROW_6_394 VGND VPWR sky130_fd_sc_hd__tapvpwrvgnd_1
XTAP_TAPCELL_ROW_6_383 VGND VPWR sky130_fd_sc_hd__tapvpwrvgnd_1
XFILLER_0_17_15 VPWR VGND VPWR VGND sky130_ef_sc_hd__decap_12
XFILLER_0_124_27 VGND VGND VPWR VPWR sky130_fd_sc_hd__fill_1
XFILLER_0_69_652 VPWR VGND VPWR VGND sky130_ef_sc_hd__decap_12
XTAP_TAPCELL_ROW_83_1542 VGND VPWR sky130_fd_sc_hd__tapvpwrvgnd_1
XFILLER_0_69_685 VPWR VGND VPWR VGND sky130_ef_sc_hd__decap_12
XTAP_TAPCELL_ROW_45_978 VGND VPWR sky130_fd_sc_hd__tapvpwrvgnd_1
XTAP_TAPCELL_ROW_25_680 VGND VPWR sky130_fd_sc_hd__tapvpwrvgnd_1
Xinput12 A3[3] VGND VGND VPWR VPWR net12 sky130_fd_sc_hd__clkbuf_4
XFILLER_0_126_245 VGND VGND VPWR VPWR sky130_fd_sc_hd__decap_6
XFILLER_0_25_722 VGND VGND VPWR VPWR sky130_fd_sc_hd__decap_6
XFILLER_0_126_289 VPWR VGND VPWR VGND sky130_ef_sc_hd__decap_12
Xinput45 WD3[9] VGND VGND VPWR VPWR net45 sky130_fd_sc_hd__buf_2
Xinput23 WD3[18] VGND VGND VPWR VPWR net23 sky130_fd_sc_hd__buf_1
XFILLER_0_25_777 VGND VGND VPWR VPWR sky130_fd_sc_hd__decap_6
Xinput34 WD3[28] VGND VGND VPWR VPWR net34 sky130_fd_sc_hd__buf_1
XFILLER_0_3_137 VPWR VGND VPWR VGND sky130_ef_sc_hd__decap_12
XFILLER_0_24_287 VGND VGND VPWR VPWR sky130_fd_sc_hd__fill_2
XFILLER_0_40_736 VGND VGND VPWR VPWR sky130_fd_sc_hd__fill_1
X_5200_ rf.registers\[24\]\[17\] rf.registers\[25\]\[17\] rf.registers\[26\]\[17\]
+ rf.registers\[27\]\[17\] _1919_ _1920_ VGND VGND VPWR VPWR _1946_ sky130_fd_sc_hd__mux4_1
X_6180_ net98 net99 _2873_ net100 VGND VGND VPWR VPWR _2884_ sky130_fd_sc_hd__o31a_1
X_5131_ rf.registers\[12\]\[13\] rf.registers\[13\]\[13\] rf.registers\[14\]\[13\]
+ rf.registers\[15\]\[13\] _1734_ _1797_ VGND VGND VPWR VPWR _1881_ sky130_fd_sc_hd__mux4_1
XFILLER_0_20_493 VPWR VGND VPWR VGND sky130_ef_sc_hd__decap_12
X_5062_ _1655_ VGND VGND VPWR VPWR _1816_ sky130_fd_sc_hd__buf_4
XFILLER_0_35_7 VPWR VGND VPWR VGND sky130_ef_sc_hd__decap_12
XTAP_TAPCELL_ROW_125_2170 VGND VPWR sky130_fd_sc_hd__tapvpwrvgnd_1
X_8821_ clknet_leaf_54_CLK _0933_ VGND VGND VPWR VPWR rf.registers\[15\]\[4\] sky130_fd_sc_hd__dfxtp_1
XTAP_TAPCELL_ROW_125_2181 VGND VPWR sky130_fd_sc_hd__tapvpwrvgnd_1
X_8752_ clknet_leaf_77_CLK _0864_ VGND VGND VPWR VPWR rf.registers\[10\]\[31\] sky130_fd_sc_hd__dfxtp_1
X_7703_ _3363_ rf.registers\[30\]\[8\] _3770_ VGND VGND VPWR VPWR _3779_ sky130_fd_sc_hd__mux2_1
XFILLER_0_90_53 VGND VGND VPWR VPWR sky130_fd_sc_hd__decap_3
XFILLER_0_48_825 VGND VGND VPWR VPWR sky130_fd_sc_hd__decap_8
X_5964_ _2210_ _2221_ VGND VGND VPWR VPWR _2681_ sky130_fd_sc_hd__nand2_1
XFILLER_0_118_713 VPWR VGND VPWR VGND sky130_ef_sc_hd__decap_12
X_4915_ rf.registers\[0\]\[2\] rf.registers\[1\]\[2\] rf.registers\[2\]\[2\] rf.registers\[3\]\[2\]
+ _1624_ _1625_ VGND VGND VPWR VPWR _1676_ sky130_fd_sc_hd__mux4_1
XFILLER_0_75_633 VGND VGND VPWR VPWR sky130_fd_sc_hd__decap_4
X_5895_ _2577_ _2590_ _2589_ VGND VGND VPWR VPWR _2616_ sky130_fd_sc_hd__a21o_1
X_8683_ clknet_leaf_69_CLK _0795_ VGND VGND VPWR VPWR rf.registers\[1\]\[26\] sky130_fd_sc_hd__dfxtp_1
XTAP_TAPCELL_ROW_23_639 VGND VPWR sky130_fd_sc_hd__tapvpwrvgnd_1
XFILLER_0_118_757 VPWR VGND VPWR VGND sky130_ef_sc_hd__decap_12
XFILLER_0_117_223 VGND VGND VPWR VPWR sky130_fd_sc_hd__fill_1
X_7634_ rf.registers\[2\]\[8\] _3294_ _3733_ VGND VGND VPWR VPWR _3742_ sky130_fd_sc_hd__mux2_1
XFILLER_0_90_614 VGND VGND VPWR VPWR sky130_fd_sc_hd__fill_2
XFILLER_0_63_839 VGND VGND VPWR VPWR sky130_fd_sc_hd__fill_1
X_4846_ _1197_ _1609_ VGND VGND VPWR VPWR _1610_ sky130_fd_sc_hd__nor2_1
X_7565_ _3705_ VGND VGND VPWR VPWR _0200_ sky130_fd_sc_hd__clkbuf_1
XFILLER_0_133_727 VGND VGND VPWR VPWR sky130_fd_sc_hd__fill_1
X_9304_ clknet_leaf_53_CLK _0392_ VGND VGND VPWR VPWR rf.registers\[22\]\[7\] sky130_fd_sc_hd__dfxtp_1
X_6516_ _3120_ VGND VGND VPWR VPWR _0760_ sky130_fd_sc_hd__clkbuf_1
XFILLER_0_16_755 VGND VGND VPWR VPWR sky130_fd_sc_hd__fill_1
X_4777_ _1541_ _1544_ _1190_ VGND VGND VPWR VPWR _1545_ sky130_fd_sc_hd__mux2_1
XFILLER_0_43_541 VPWR VGND VPWR VGND sky130_ef_sc_hd__decap_12
X_7496_ _3361_ rf.registers\[31\]\[7\] _3661_ VGND VGND VPWR VPWR _3669_ sky130_fd_sc_hd__mux2_1
XFILLER_0_31_736 VPWR VGND VPWR VGND sky130_ef_sc_hd__decap_12
X_9235_ clknet_leaf_43_CLK _0323_ VGND VGND VPWR VPWR rf.registers\[28\]\[2\] sky130_fd_sc_hd__dfxtp_1
XFILLER_0_3_671 VGND VGND VPWR VPWR sky130_fd_sc_hd__fill_1
X_6447_ rf.registers\[11\]\[24\] _3037_ _3078_ VGND VGND VPWR VPWR _3083_ sky130_fd_sc_hd__mux2_1
XFILLER_0_101_657 VPWR VGND VPWR VGND sky130_ef_sc_hd__decap_12
XTAP_TAPCELL_ROW_54_1110 VGND VPWR sky130_fd_sc_hd__tapvpwrvgnd_1
X_6378_ net33 VGND VGND VPWR VPWR _3043_ sky130_fd_sc_hd__clkbuf_2
X_9166_ clknet_leaf_91_CLK _0254_ VGND VGND VPWR VPWR rf.registers\[2\]\[29\] sky130_fd_sc_hd__dfxtp_1
X_8117_ _3367_ rf.registers\[26\]\[10\] _3998_ VGND VGND VPWR VPWR _3999_ sky130_fd_sc_hd__mux2_1
X_5329_ _2066_ _2067_ _1955_ VGND VGND VPWR VPWR _2068_ sky130_fd_sc_hd__mux2_1
X_9097_ clknet_leaf_83_CLK _0185_ VGND VGND VPWR VPWR rf.registers\[31\]\[24\] sky130_fd_sc_hd__dfxtp_1
X_8048_ _3950_ VGND VGND VPWR VPWR _3962_ sky130_fd_sc_hd__buf_4
XFILLER_0_98_725 VPWR VGND VPWR VGND sky130_ef_sc_hd__decap_12
XTAP_TAPCELL_ROW_3_342 VGND VPWR sky130_fd_sc_hd__tapvpwrvgnd_1
XFILLER_0_98_769 VPWR VGND VPWR VGND sky130_ef_sc_hd__decap_12
XFILLER_0_38_313 VGND VGND VPWR VPWR sky130_fd_sc_hd__fill_1
XTAP_TAPCELL_ROW_65_1272 VGND VPWR sky130_fd_sc_hd__tapvpwrvgnd_1
XTAP_TAPCELL_ROW_42_926 VGND VPWR sky130_fd_sc_hd__tapvpwrvgnd_1
XTAP_TAPCELL_ROW_42_937 VGND VPWR sky130_fd_sc_hd__tapvpwrvgnd_1
XFILLER_0_66_699 VGND VGND VPWR VPWR sky130_fd_sc_hd__fill_1
XFILLER_0_53_327 VGND VGND VPWR VPWR sky130_fd_sc_hd__decap_6
XFILLER_0_136_587 VGND VGND VPWR VPWR sky130_fd_sc_hd__fill_1
XFILLER_0_124_749 VGND VGND VPWR VPWR sky130_fd_sc_hd__decap_6
XFILLER_0_123_237 VPWR VGND VPWR VGND sky130_ef_sc_hd__decap_12
XFILLER_0_110_29 VPWR VGND VPWR VGND sky130_ef_sc_hd__decap_12
XFILLER_0_104_440 VGND VGND VPWR VPWR sky130_fd_sc_hd__decap_4
XFILLER_0_132_793 VPWR VGND VPWR VGND sky130_ef_sc_hd__decap_12
XFILLER_0_131_281 VPWR VGND VPWR VGND sky130_ef_sc_hd__decap_12
XFILLER_0_84_441 VPWR VGND VPWR VGND sky130_ef_sc_hd__decap_12
XFILLER_0_56_132 VGND VGND VPWR VPWR sky130_fd_sc_hd__decap_4
XFILLER_0_29_335 VGND VGND VPWR VPWR sky130_fd_sc_hd__fill_1
XFILLER_0_29_379 VGND VGND VPWR VPWR sky130_fd_sc_hd__decap_4
X_5680_ _2232_ _2246_ _2234_ VGND VGND VPWR VPWR _2409_ sky130_fd_sc_hd__mux2_1
X_4700_ rf.registers\[0\]\[22\] rf.registers\[1\]\[22\] rf.registers\[2\]\[22\] rf.registers\[3\]\[22\]
+ _1382_ _1383_ VGND VGND VPWR VPWR _1473_ sky130_fd_sc_hd__mux4_1
XFILLER_0_121_3 VPWR VGND VPWR VGND sky130_ef_sc_hd__decap_12
XFILLER_0_71_113 VPWR VGND VPWR VGND sky130_ef_sc_hd__decap_12
X_4631_ _1293_ _1407_ VGND VGND VPWR VPWR _1408_ sky130_fd_sc_hd__nand2_1
XFILLER_0_45_839 VGND VGND VPWR VPWR sky130_fd_sc_hd__fill_1
XFILLER_0_4_413 VGND VGND VPWR VPWR sky130_fd_sc_hd__decap_6
XFILLER_0_25_541 VGND VGND VPWR VPWR sky130_fd_sc_hd__fill_1
X_7350_ _3591_ VGND VGND VPWR VPWR _0099_ sky130_fd_sc_hd__clkbuf_1
XTAP_TAPCELL_ROW_96_1744 VGND VPWR sky130_fd_sc_hd__tapvpwrvgnd_1
XTAP_TAPCELL_ROW_96_1733 VGND VPWR sky130_fd_sc_hd__tapvpwrvgnd_1
X_4562_ _1197_ _1342_ _1203_ VGND VGND VPWR VPWR _1343_ sky130_fd_sc_hd__a21oi_1
XFILLER_0_80_680 VPWR VGND VPWR VGND sky130_ef_sc_hd__decap_12
XFILLER_0_4_457 VPWR VGND VPWR VGND sky130_ef_sc_hd__decap_12
X_6301_ net36 VGND VGND VPWR VPWR _2991_ sky130_fd_sc_hd__buf_2
X_7281_ rf.registers\[3\]\[2\] _3282_ _3552_ VGND VGND VPWR VPWR _3555_ sky130_fd_sc_hd__mux2_1
X_4493_ rf.registers\[4\]\[11\] rf.registers\[5\]\[11\] rf.registers\[6\]\[11\] rf.registers\[7\]\[11\]
+ _1118_ _1127_ VGND VGND VPWR VPWR _1277_ sky130_fd_sc_hd__mux4_1
XFILLER_0_100_73 VGND VGND VPWR VPWR sky130_fd_sc_hd__fill_2
X_9020_ clknet_leaf_30_CLK _0108_ VGND VGND VPWR VPWR rf.registers\[8\]\[11\] sky130_fd_sc_hd__dfxtp_1
X_6232_ _2932_ _2933_ VGND VGND VPWR VPWR _2934_ sky130_fd_sc_hd__xnor2_1
XFILLER_0_20_290 VGND VGND VPWR VPWR sky130_fd_sc_hd__fill_2
X_6163_ _2277_ _2274_ VGND VGND VPWR VPWR _2868_ sky130_fd_sc_hd__nor2_1
XTAP_TAPCELL_ROW_127_2210 VGND VPWR sky130_fd_sc_hd__tapvpwrvgnd_1
X_5114_ rf.registers\[8\]\[12\] rf.registers\[9\]\[12\] rf.registers\[10\]\[12\] rf.registers\[11\]\[12\]
+ _1699_ _1700_ VGND VGND VPWR VPWR _1865_ sky130_fd_sc_hd__mux4_1
X_6094_ net81 _2309_ _2306_ VGND VGND VPWR VPWR _2803_ sky130_fd_sc_hd__o21ai_1
XFILLER_0_109_93 VGND VGND VPWR VPWR sky130_fd_sc_hd__decap_8
X_5045_ rf.registers\[24\]\[8\] rf.registers\[25\]\[8\] rf.registers\[26\]\[8\] rf.registers\[27\]\[8\]
+ _1795_ _1736_ VGND VGND VPWR VPWR _1800_ sky130_fd_sc_hd__mux4_1
XTAP_TAPCELL_ROW_0_301 VGND VPWR sky130_fd_sc_hd__tapvpwrvgnd_1
XFILLER_0_26_3 VPWR VGND VPWR VGND sky130_ef_sc_hd__decap_12
XFILLER_0_95_706 VPWR VGND VPWR VGND sky130_ef_sc_hd__decap_12
X_8804_ clknet_leaf_20_CLK _0916_ VGND VGND VPWR VPWR rf.registers\[16\]\[19\] sky130_fd_sc_hd__dfxtp_1
XFILLER_0_79_279 VGND VGND VPWR VPWR sky130_fd_sc_hd__fill_1
XFILLER_0_67_419 VGND VGND VPWR VPWR sky130_fd_sc_hd__fill_1
X_6996_ _2976_ rf.registers\[15\]\[29\] _3389_ VGND VGND VPWR VPWR _3403_ sky130_fd_sc_hd__mux2_1
XFILLER_0_125_81 VPWR VGND VPWR VGND sky130_ef_sc_hd__decap_12
XTAP_TAPCELL_ROW_105_1873 VGND VPWR sky130_fd_sc_hd__tapvpwrvgnd_1
X_8735_ clknet_leaf_17_CLK _0847_ VGND VGND VPWR VPWR rf.registers\[10\]\[14\] sky130_fd_sc_hd__dfxtp_1
X_5947_ _2504_ _2664_ _2421_ VGND VGND VPWR VPWR _2665_ sky130_fd_sc_hd__mux2_1
XFILLER_0_137_329 VGND VGND VPWR VPWR sky130_fd_sc_hd__decap_6
X_8666_ clknet_leaf_35_CLK _0778_ VGND VGND VPWR VPWR rf.registers\[1\]\[9\] sky130_fd_sc_hd__dfxtp_1
X_7617_ _3732_ VGND VGND VPWR VPWR _3733_ sky130_fd_sc_hd__buf_4
XFILLER_0_63_625 VGND VGND VPWR VPWR sky130_fd_sc_hd__decap_3
XFILLER_0_48_699 VGND VGND VPWR VPWR sky130_fd_sc_hd__fill_1
X_5878_ _2385_ _2572_ _2599_ _2398_ VGND VGND VPWR VPWR _2600_ sky130_fd_sc_hd__o211a_1
XTAP_TAPCELL_ROW_138_2383 VGND VPWR sky130_fd_sc_hd__tapvpwrvgnd_1
XTAP_TAPCELL_ROW_138_2372 VGND VPWR sky130_fd_sc_hd__tapvpwrvgnd_1
XFILLER_0_106_749 VGND VGND VPWR VPWR sky130_fd_sc_hd__decap_6
X_8597_ clknet_leaf_50_CLK _0709_ VGND VGND VPWR VPWR rf.registers\[11\]\[4\] sky130_fd_sc_hd__dfxtp_1
X_4829_ _1291_ _1593_ VGND VGND VPWR VPWR _1594_ sky130_fd_sc_hd__nor2_1
XFILLER_0_51_809 VPWR VGND VPWR VGND sky130_ef_sc_hd__decap_12
XFILLER_0_7_273 VGND VGND VPWR VPWR sky130_fd_sc_hd__decap_6
XFILLER_0_90_477 VGND VGND VPWR VPWR sky130_fd_sc_hd__fill_2
X_7548_ _3345_ _3166_ VGND VGND VPWR VPWR _3696_ sky130_fd_sc_hd__nand2_4
X_7479_ _3659_ VGND VGND VPWR VPWR _0160_ sky130_fd_sc_hd__clkbuf_1
XFILLER_0_114_793 VPWR VGND VPWR VGND sky130_ef_sc_hd__decap_12
X_9218_ clknet_leaf_12_CLK _0306_ VGND VGND VPWR VPWR rf.registers\[9\]\[17\] sky130_fd_sc_hd__dfxtp_1
XTAP_TAPCELL_ROW_8_423 VGND VPWR sky130_fd_sc_hd__tapvpwrvgnd_1
XFILLER_0_31_599 VGND VGND VPWR VPWR sky130_fd_sc_hd__fill_1
X_9149_ clknet_leaf_18_CLK _0237_ VGND VGND VPWR VPWR rf.registers\[2\]\[12\] sky130_fd_sc_hd__dfxtp_1
XFILLER_0_98_533 VGND VGND VPWR VPWR sky130_fd_sc_hd__fill_2
XTAP_TAPCELL_ROW_67_1301 VGND VPWR sky130_fd_sc_hd__tapvpwrvgnd_1
XTAP_TAPCELL_ROW_67_1312 VGND VPWR sky130_fd_sc_hd__tapvpwrvgnd_1
XFILLER_0_14_27 VGND VGND VPWR VPWR sky130_fd_sc_hd__fill_1
XTAP_TAPCELL_ROW_80_1501 VGND VPWR sky130_fd_sc_hd__tapvpwrvgnd_1
XFILLER_0_137_841 VGND VGND VPWR VPWR sky130_fd_sc_hd__fill_1
XFILLER_0_26_305 VGND VGND VPWR VPWR sky130_fd_sc_hd__decap_3
XFILLER_0_27_806 VPWR VGND VPWR VGND sky130_ef_sc_hd__decap_12
XFILLER_0_38_132 VGND VGND VPWR VPWR sky130_fd_sc_hd__decap_8
XFILLER_0_39_666 VGND VGND VPWR VPWR sky130_fd_sc_hd__decap_3
XFILLER_0_121_39 VPWR VGND VPWR VGND sky130_ef_sc_hd__decap_12
XFILLER_0_54_658 VPWR VGND VPWR VGND sky130_ef_sc_hd__decap_12
XFILLER_0_30_15 VPWR VGND VPWR VGND sky130_ef_sc_hd__decap_12
XTAP_TAPCELL_ROW_78_1463 VGND VPWR sky130_fd_sc_hd__tapvpwrvgnd_1
XFILLER_0_1_405 VPWR VGND VPWR VGND sky130_ef_sc_hd__decap_12
XFILLER_0_22_533 VPWR VGND VPWR VGND sky130_ef_sc_hd__decap_12
XTAP_TAPCELL_ROW_78_1474 VGND VPWR sky130_fd_sc_hd__tapvpwrvgnd_1
XFILLER_0_10_717 VGND VGND VPWR VPWR sky130_fd_sc_hd__fill_1
XFILLER_0_1_449 VPWR VGND VPWR VGND sky130_ef_sc_hd__decap_12
XFILLER_0_22_566 VGND VGND VPWR VPWR sky130_fd_sc_hd__decap_4
XFILLER_0_39_57 VGND VGND VPWR VPWR sky130_fd_sc_hd__fill_2
XTAP_TAPCELL_ROW_91_1663 VGND VPWR sky130_fd_sc_hd__tapvpwrvgnd_1
X_6850_ net18 VGND VGND VPWR VPWR _3305_ sky130_fd_sc_hd__clkbuf_2
X_6781_ rf.registers\[0\]\[19\] _3026_ _3252_ VGND VGND VPWR VPWR _3262_ sky130_fd_sc_hd__mux2_1
XFILLER_0_71_44 VGND VGND VPWR VPWR sky130_fd_sc_hd__fill_1
XFILLER_0_9_505 VPWR VGND VPWR VGND sky130_ef_sc_hd__decap_12
XPHY_EDGE_ROW_8_Right_8 VGND VGND VPWR VPWR sky130_fd_sc_hd__decap_3
X_5801_ _2300_ _2222_ _2259_ VGND VGND VPWR VPWR _2526_ sky130_fd_sc_hd__mux2_1
X_8520_ _4211_ VGND VGND VPWR VPWR _0649_ sky130_fd_sc_hd__clkbuf_1
XFILLER_0_71_88 VGND VGND VPWR VPWR sky130_fd_sc_hd__fill_1
XFILLER_0_9_549 VGND VGND VPWR VPWR sky130_fd_sc_hd__fill_2
X_5732_ _2236_ _1115_ VGND VGND VPWR VPWR _2459_ sky130_fd_sc_hd__nand2_4
XFILLER_0_85_783 VGND VGND VPWR VPWR sky130_fd_sc_hd__fill_1
XFILLER_0_17_305 VPWR VGND VPWR VGND sky130_ef_sc_hd__decap_12
XTAP_TAPCELL_ROW_33_789 VGND VPWR sky130_fd_sc_hd__tapvpwrvgnd_1
XFILLER_0_127_373 VPWR VGND VPWR VGND sky130_ef_sc_hd__decap_12
X_8451_ _4175_ VGND VGND VPWR VPWR _0616_ sky130_fd_sc_hd__clkbuf_1
XFILLER_0_33_809 VPWR VGND VPWR VGND sky130_ef_sc_hd__decap_12
X_5663_ _1055_ _2392_ _1075_ VGND VGND VPWR VPWR _2393_ sky130_fd_sc_hd__a21o_1
X_8382_ rf.registers\[18\]\[7\] net43 _4131_ VGND VGND VPWR VPWR _4139_ sky130_fd_sc_hd__mux2_1
X_4614_ _1117_ _1380_ _1387_ _1391_ VGND VGND VPWR VPWR _1392_ sky130_fd_sc_hd__o22a_1
XFILLER_0_60_617 VGND VGND VPWR VPWR sky130_fd_sc_hd__decap_4
XFILLER_0_4_221 VPWR VGND VPWR VGND sky130_ef_sc_hd__decap_12
XTAP_TAPCELL_ROW_13_491 VGND VPWR sky130_fd_sc_hd__tapvpwrvgnd_1
X_7402_ _3618_ VGND VGND VPWR VPWR _0124_ sky130_fd_sc_hd__clkbuf_1
X_5594_ net81 net60 _2270_ _2321_ VGND VGND VPWR VPWR _2324_ sky130_fd_sc_hd__o211a_1
XFILLER_0_44_168 VGND VGND VPWR VPWR sky130_fd_sc_hd__decap_6
X_4545_ _1319_ _1323_ _1326_ _1190_ _1203_ VGND VGND VPWR VPWR _1327_ sky130_fd_sc_hd__a221o_1
XFILLER_0_5_777 VGND VGND VPWR VPWR sky130_fd_sc_hd__decap_6
XFILLER_0_4_265 VPWR VGND VPWR VGND sky130_ef_sc_hd__decap_12
X_7333_ rf.registers\[3\]\[27\] _3334_ _3574_ VGND VGND VPWR VPWR _3582_ sky130_fd_sc_hd__mux2_1
XFILLER_0_52_190 VGND VGND VPWR VPWR sky130_fd_sc_hd__decap_6
XFILLER_0_40_363 VGND VGND VPWR VPWR sky130_fd_sc_hd__fill_1
XTAP_TAPCELL_ROW_133_2291 VGND VPWR sky130_fd_sc_hd__tapvpwrvgnd_1
XFILLER_0_111_741 VPWR VGND VPWR VGND sky130_ef_sc_hd__decap_12
X_4476_ _1133_ _1260_ VGND VGND VPWR VPWR _1261_ sky130_fd_sc_hd__or2_1
XFILLER_0_96_41 VPWR VGND VPWR VGND sky130_ef_sc_hd__decap_12
X_7264_ _3545_ VGND VGND VPWR VPWR _0059_ sky130_fd_sc_hd__clkbuf_1
X_9003_ clknet_leaf_68_CLK _0091_ VGND VGND VPWR VPWR rf.registers\[3\]\[26\] sky130_fd_sc_hd__dfxtp_1
XFILLER_0_111_785 VPWR VGND VPWR VGND sky130_ef_sc_hd__decap_12
X_7195_ rf.registers\[4\]\[26\] _3332_ _3502_ VGND VGND VPWR VPWR _3509_ sky130_fd_sc_hd__mux2_1
X_6215_ _2916_ _2909_ VGND VGND VPWR VPWR _2918_ sky130_fd_sc_hd__and2b_1
XPHY_EDGE_ROW_39_Right_39 VGND VGND VPWR VPWR sky130_fd_sc_hd__decap_3
XFILLER_0_0_493 VGND VGND VPWR VPWR sky130_fd_sc_hd__decap_8
X_6146_ net65 _2852_ VGND VGND VPWR VPWR _2853_ sky130_fd_sc_hd__xnor2_1
XTAP_TAPCELL_ROW_107_1902 VGND VPWR sky130_fd_sc_hd__tapvpwrvgnd_1
X_6077_ _2032_ _2786_ VGND VGND VPWR VPWR _2787_ sky130_fd_sc_hd__xnor2_1
X_5028_ _1782_ _1783_ _1635_ VGND VGND VPWR VPWR _1784_ sky130_fd_sc_hd__mux2_1
XTAP_TAPCELL_ROW_49_1042 VGND VPWR sky130_fd_sc_hd__tapvpwrvgnd_1
XTAP_TAPCELL_ROW_49_1031 VGND VPWR sky130_fd_sc_hd__tapvpwrvgnd_1
XFILLER_0_137_137 VPWR VGND VPWR VGND sky130_ef_sc_hd__decap_12
XFILLER_0_83_709 VPWR VGND VPWR VGND sky130_ef_sc_hd__decap_12
XTAP_TAPCELL_ROW_62_1231 VGND VPWR sky130_fd_sc_hd__tapvpwrvgnd_1
X_6979_ net28 VGND VGND VPWR VPWR _3393_ sky130_fd_sc_hd__clkbuf_2
XPHY_EDGE_ROW_48_Right_48 VGND VGND VPWR VPWR sky130_fd_sc_hd__decap_3
XFILLER_0_48_441 VGND VGND VPWR VPWR sky130_fd_sc_hd__fill_1
XFILLER_0_119_841 VGND VGND VPWR VPWR sky130_fd_sc_hd__fill_1
XFILLER_0_48_474 VGND VGND VPWR VPWR sky130_fd_sc_hd__fill_2
X_8718_ clknet_leaf_92_CLK _0830_ VGND VGND VPWR VPWR rf.registers\[24\]\[29\] sky130_fd_sc_hd__dfxtp_1
XFILLER_0_134_811 VGND VGND VPWR VPWR sky130_fd_sc_hd__fill_1
XFILLER_0_91_753 VPWR VGND VPWR VGND sky130_ef_sc_hd__decap_12
XFILLER_0_35_135 VGND VGND VPWR VPWR sky130_fd_sc_hd__fill_2
X_8649_ clknet_leaf_71_CLK _0761_ VGND VGND VPWR VPWR rf.registers\[17\]\[24\] sky130_fd_sc_hd__dfxtp_1
XFILLER_0_91_797 VPWR VGND VPWR VGND sky130_ef_sc_hd__decap_12
XFILLER_0_90_285 VGND VGND VPWR VPWR sky130_fd_sc_hd__fill_2
XPHY_EDGE_ROW_57_Right_57 VGND VGND VPWR VPWR sky130_fd_sc_hd__decap_3
XTAP_TAPCELL_ROW_73_1393 VGND VPWR sky130_fd_sc_hd__tapvpwrvgnd_1
XFILLER_0_25_15 VPWR VGND VPWR VGND sky130_ef_sc_hd__decap_12
XPHY_EDGE_ROW_66_Right_66 VGND VGND VPWR VPWR sky130_fd_sc_hd__decap_3
XFILLER_0_132_27 VGND VGND VPWR VPWR sky130_fd_sc_hd__fill_1
XFILLER_0_73_219 VGND VGND VPWR VPWR sky130_fd_sc_hd__decap_4
XFILLER_0_67_783 VGND VGND VPWR VPWR sky130_fd_sc_hd__fill_1
XFILLER_0_137_671 VGND VGND VPWR VPWR sky130_fd_sc_hd__fill_1
XFILLER_0_125_833 VGND VGND VPWR VPWR sky130_fd_sc_hd__decap_6
XFILLER_0_15_809 VPWR VGND VPWR VGND sky130_ef_sc_hd__decap_12
XFILLER_0_27_669 VGND VGND VPWR VPWR sky130_fd_sc_hd__decap_3
XFILLER_0_124_321 VPWR VGND VPWR VGND sky130_ef_sc_hd__decap_12
XFILLER_0_26_157 VGND VGND VPWR VPWR sky130_fd_sc_hd__fill_2
XTAP_TAPCELL_ROW_30_748 VGND VPWR sky130_fd_sc_hd__tapvpwrvgnd_1
XFILLER_0_42_628 VGND VGND VPWR VPWR sky130_fd_sc_hd__fill_1
XFILLER_0_124_365 VPWR VGND VPWR VGND sky130_ef_sc_hd__decap_12
XTAP_TAPCELL_ROW_10_450 VGND VPWR sky130_fd_sc_hd__tapvpwrvgnd_1
XPHY_EDGE_ROW_75_Right_75 VGND VGND VPWR VPWR sky130_fd_sc_hd__decap_3
XFILLER_0_2_725 VPWR VGND VPWR VGND sky130_ef_sc_hd__decap_12
X_4330_ _1036_ VGND VGND VPWR VPWR _1121_ sky130_fd_sc_hd__clkbuf_4
XFILLER_0_10_525 VGND VGND VPWR VPWR sky130_fd_sc_hd__decap_6
XFILLER_0_2_769 VPWR VGND VPWR VGND sky130_ef_sc_hd__decap_12
XFILLER_0_1_279 VGND VGND VPWR VPWR sky130_fd_sc_hd__fill_1
X_4261_ _1055_ VGND VGND VPWR VPWR _1056_ sky130_fd_sc_hd__buf_2
XFILLER_0_5_69 VPWR VGND VPWR VGND sky130_ef_sc_hd__decap_12
X_6000_ _2713_ _2714_ VGND VGND VPWR VPWR _2715_ sky130_fd_sc_hd__or2_1
XPHY_EDGE_ROW_84_Right_84 VGND VGND VPWR VPWR sky130_fd_sc_hd__decap_3
XFILLER_0_82_32 VGND VGND VPWR VPWR sky130_fd_sc_hd__decap_3
XPHY_EDGE_ROW_19_Left_158 VGND VGND VPWR VPWR sky130_fd_sc_hd__decap_3
X_7951_ _3910_ VGND VGND VPWR VPWR _0381_ sky130_fd_sc_hd__clkbuf_1
X_7882_ _3873_ VGND VGND VPWR VPWR _0349_ sky130_fd_sc_hd__clkbuf_1
X_6902_ net37 VGND VGND VPWR VPWR _3340_ sky130_fd_sc_hd__clkbuf_2
X_6833_ _3293_ VGND VGND VPWR VPWR _0904_ sky130_fd_sc_hd__clkbuf_1
XTAP_TAPCELL_ROW_102_1832 VGND VPWR sky130_fd_sc_hd__tapvpwrvgnd_1
XFILLER_0_65_709 VGND VGND VPWR VPWR sky130_fd_sc_hd__fill_2
XFILLER_0_15_81 VPWR VGND VPWR VGND sky130_ef_sc_hd__decap_12
XTAP_TAPCELL_ROW_18_572 VGND VPWR sky130_fd_sc_hd__tapvpwrvgnd_1
XFILLER_0_119_137 VPWR VGND VPWR VGND sky130_ef_sc_hd__decap_12
X_6764_ _3253_ VGND VGND VPWR VPWR _0875_ sky130_fd_sc_hd__clkbuf_1
X_9552_ clknet_leaf_77_CLK _0640_ VGND VGND VPWR VPWR rf.registers\[14\]\[31\] sky130_fd_sc_hd__dfxtp_1
XFILLER_0_9_335 VGND VGND VPWR VPWR sky130_fd_sc_hd__fill_1
XFILLER_0_17_113 VPWR VGND VPWR VGND sky130_ef_sc_hd__decap_12
X_8503_ _4202_ VGND VGND VPWR VPWR _0641_ sky130_fd_sc_hd__clkbuf_1
XFILLER_0_116_811 VGND VGND VPWR VPWR sky130_fd_sc_hd__fill_1
X_6695_ rf.registers\[10\]\[10\] _3007_ _3216_ VGND VGND VPWR VPWR _3217_ sky130_fd_sc_hd__mux2_1
XFILLER_0_73_753 VPWR VGND VPWR VGND sky130_ef_sc_hd__decap_12
X_9483_ clknet_leaf_70_CLK _0571_ VGND VGND VPWR VPWR rf.registers\[20\]\[26\] sky130_fd_sc_hd__dfxtp_1
X_5715_ _2439_ _2442_ _2296_ VGND VGND VPWR VPWR _2443_ sky130_fd_sc_hd__mux2_2
XTAP_TAPCELL_ROW_135_2331 VGND VPWR sky130_fd_sc_hd__tapvpwrvgnd_1
XTAP_TAPCELL_ROW_135_2320 VGND VPWR sky130_fd_sc_hd__tapvpwrvgnd_1
XFILLER_0_127_181 VPWR VGND VPWR VGND sky130_ef_sc_hd__decap_12
XFILLER_0_93_3 VPWR VGND VPWR VGND sky130_ef_sc_hd__decap_12
XFILLER_0_73_797 VPWR VGND VPWR VGND sky130_ef_sc_hd__decap_12
XFILLER_0_72_274 VPWR VGND VPWR VGND sky130_ef_sc_hd__decap_12
X_8434_ _2964_ _3768_ VGND VGND VPWR VPWR _4166_ sky130_fd_sc_hd__nand2_2
XFILLER_0_5_541 VPWR VGND VPWR VGND sky130_ef_sc_hd__decap_12
XFILLER_0_33_617 VGND VGND VPWR VPWR sky130_fd_sc_hd__decap_8
X_5646_ _2229_ _2271_ VGND VGND VPWR VPWR _2376_ sky130_fd_sc_hd__nand2_1
XFILLER_0_45_466 VGND VGND VPWR VPWR sky130_fd_sc_hd__fill_1
XPHY_EDGE_ROW_93_Right_93 VGND VGND VPWR VPWR sky130_fd_sc_hd__decap_3
XPHY_EDGE_ROW_28_Left_167 VGND VGND VPWR VPWR sky130_fd_sc_hd__decap_3
X_8365_ _4129_ VGND VGND VPWR VPWR _0576_ sky130_fd_sc_hd__clkbuf_1
XFILLER_0_5_585 VPWR VGND VPWR VGND sky130_ef_sc_hd__decap_12
X_5577_ _2306_ _2307_ VGND VGND VPWR VPWR _2308_ sky130_fd_sc_hd__nand2_1
XFILLER_0_130_357 VGND VGND VPWR VPWR sky130_fd_sc_hd__decap_6
X_4528_ rf.registers\[20\]\[13\] rf.registers\[21\]\[13\] rf.registers\[22\]\[13\]
+ rf.registers\[23\]\[13\] _1126_ _1129_ VGND VGND VPWR VPWR _1310_ sky130_fd_sc_hd__mux4_1
X_7316_ rf.registers\[3\]\[19\] _3317_ _3563_ VGND VGND VPWR VPWR _3573_ sky130_fd_sc_hd__mux2_1
XFILLER_0_13_385 VGND VGND VPWR VPWR sky130_fd_sc_hd__decap_6
XFILLER_0_41_683 VGND VGND VPWR VPWR sky130_fd_sc_hd__decap_6
X_8296_ _3051_ rf.registers\[25\]\[31\] _4058_ VGND VGND VPWR VPWR _4093_ sky130_fd_sc_hd__mux2_1
X_4459_ _1143_ _1244_ VGND VGND VPWR VPWR _1245_ sky130_fd_sc_hd__or2_1
X_7247_ _3536_ VGND VGND VPWR VPWR _0051_ sky130_fd_sc_hd__clkbuf_1
XTAP_TAPCELL_ROW_113_1994 VGND VPWR sky130_fd_sc_hd__tapvpwrvgnd_1
X_7178_ rf.registers\[4\]\[18\] _3315_ _3491_ VGND VGND VPWR VPWR _3500_ sky130_fd_sc_hd__mux2_1
XFILLER_0_99_116 VGND VGND VPWR VPWR sky130_fd_sc_hd__fill_1
X_6129_ _2828_ _2830_ _2836_ VGND VGND VPWR VPWR net128 sky130_fd_sc_hd__a21bo_1
XPHY_EDGE_ROW_37_Left_176 VGND VGND VPWR VPWR sky130_fd_sc_hd__decap_3
XFILLER_0_95_377 VPWR VGND VPWR VGND sky130_ef_sc_hd__decap_12
XFILLER_0_49_783 VGND VGND VPWR VPWR sky130_fd_sc_hd__fill_1
XFILLER_0_107_833 VGND VGND VPWR VPWR sky130_fd_sc_hd__decap_6
XFILLER_0_51_403 VGND VGND VPWR VPWR sky130_fd_sc_hd__decap_4
XPHY_EDGE_ROW_46_Left_185 VGND VGND VPWR VPWR sky130_fd_sc_hd__decap_3
XFILLER_0_106_365 VGND VGND VPWR VPWR sky130_fd_sc_hd__decap_6
XFILLER_0_106_343 VGND VGND VPWR VPWR sky130_fd_sc_hd__fill_1
XFILLER_0_51_447 VGND VGND VPWR VPWR sky130_fd_sc_hd__fill_1
XFILLER_0_122_825 VPWR VGND VPWR VGND sky130_ef_sc_hd__decap_12
XFILLER_0_23_149 VGND VGND VPWR VPWR sky130_fd_sc_hd__fill_1
XFILLER_0_121_335 VGND VGND VPWR VPWR sky130_fd_sc_hd__fill_1
XTAP_TAPCELL_ROW_75_1422 VGND VPWR sky130_fd_sc_hd__tapvpwrvgnd_1
XPHY_EDGE_ROW_55_Left_194 VGND VGND VPWR VPWR sky130_fd_sc_hd__decap_3
XFILLER_0_59_547 VGND VGND VPWR VPWR sky130_fd_sc_hd__decap_3
XTAP_TAPCELL_ROW_35_818 VGND VPWR sky130_fd_sc_hd__tapvpwrvgnd_1
XTAP_TAPCELL_ROW_35_829 VGND VPWR sky130_fd_sc_hd__tapvpwrvgnd_1
XTAP_TAPCELL_ROW_86_1595 VGND VPWR sky130_fd_sc_hd__tapvpwrvgnd_1
XTAP_TAPCELL_ROW_86_1584 VGND VPWR sky130_fd_sc_hd__tapvpwrvgnd_1
XTAP_TAPCELL_ROW_15_520 VGND VPWR sky130_fd_sc_hd__tapvpwrvgnd_1
XTAP_TAPCELL_ROW_15_531 VGND VPWR sky130_fd_sc_hd__tapvpwrvgnd_1
XFILLER_0_46_219 VGND VGND VPWR VPWR sky130_fd_sc_hd__fill_2
XFILLER_0_67_591 VPWR VGND VPWR VGND sky130_ef_sc_hd__decap_12
XFILLER_0_55_753 VPWR VGND VPWR VGND sky130_ef_sc_hd__decap_12
XFILLER_0_70_701 VPWR VGND VPWR VGND sky130_ef_sc_hd__decap_12
XFILLER_0_55_797 VPWR VGND VPWR VGND sky130_ef_sc_hd__decap_12
XFILLER_0_15_606 VGND VGND VPWR VPWR sky130_fd_sc_hd__fill_1
XFILLER_0_15_617 VPWR VGND VPWR VGND sky130_ef_sc_hd__decap_12
X_5500_ _2229_ _2230_ VGND VGND VPWR VPWR _2231_ sky130_fd_sc_hd__nor2_1
XFILLER_0_125_652 VPWR VGND VPWR VGND sky130_ef_sc_hd__decap_12
XTAP_TAPCELL_ROW_117_2050 VGND VPWR sky130_fd_sc_hd__tapvpwrvgnd_1
X_6480_ _3101_ VGND VGND VPWR VPWR _0743_ sky130_fd_sc_hd__clkbuf_1
XFILLER_0_125_685 VPWR VGND VPWR VGND sky130_ef_sc_hd__decap_12
XTAP_TAPCELL_ROW_117_2061 VGND VPWR sky130_fd_sc_hd__tapvpwrvgnd_1
XFILLER_0_2_533 VPWR VGND VPWR VGND sky130_ef_sc_hd__decap_12
XFILLER_0_23_661 VGND VGND VPWR VPWR sky130_fd_sc_hd__fill_1
X_5431_ _1964_ _2156_ _2160_ _2164_ VGND VGND VPWR VPWR _2165_ sky130_fd_sc_hd__o2bb2a_4
XFILLER_0_124_195 VGND VGND VPWR VPWR sky130_fd_sc_hd__fill_1
Xclkbuf_leaf_60_CLK clknet_3_6__leaf_CLK VGND VGND VPWR VPWR clknet_leaf_60_CLK sky130_fd_sc_hd__clkbuf_8
X_8150_ _2970_ rf.registers\[26\]\[26\] _4009_ VGND VGND VPWR VPWR _4016_ sky130_fd_sc_hd__mux2_1
X_5362_ _1964_ _2091_ _2099_ VGND VGND VPWR VPWR _2100_ sky130_fd_sc_hd__a21oi_4
XTAP_TAPCELL_ROW_130_2250 VGND VPWR sky130_fd_sc_hd__tapvpwrvgnd_1
X_4313_ rf.registers\[4\]\[3\] rf.registers\[5\]\[3\] rf.registers\[6\]\[3\] rf.registers\[7\]\[3\]
+ _1035_ _1027_ VGND VGND VPWR VPWR _1105_ sky130_fd_sc_hd__mux4_1
X_7101_ _3459_ VGND VGND VPWR VPWR _1006_ sky130_fd_sc_hd__clkbuf_1
XFILLER_0_10_333 VPWR VGND VPWR VGND sky130_ef_sc_hd__decap_12
X_8081_ _3979_ VGND VGND VPWR VPWR _0442_ sky130_fd_sc_hd__clkbuf_1
X_7032_ rf.registers\[6\]\[13\] _3305_ _3419_ VGND VGND VPWR VPWR _3423_ sky130_fd_sc_hd__mux2_1
XFILLER_0_10_377 VPWR VGND VPWR VGND sky130_ef_sc_hd__decap_12
X_5293_ rf.registers\[28\]\[22\] rf.registers\[29\]\[22\] rf.registers\[30\]\[22\]
+ rf.registers\[31\]\[22\] _1730_ _1732_ VGND VGND VPWR VPWR _2034_ sky130_fd_sc_hd__mux4_1
X_4244_ _1037_ _1038_ _1031_ VGND VGND VPWR VPWR _1039_ sky130_fd_sc_hd__mux2_1
XFILLER_0_77_98 VGND VGND VPWR VPWR sky130_fd_sc_hd__decap_4
X_8983_ clknet_leaf_57_CLK _0071_ VGND VGND VPWR VPWR rf.registers\[3\]\[6\] sky130_fd_sc_hd__dfxtp_1
XFILLER_0_117_93 VPWR VGND VPWR VGND sky130_ef_sc_hd__decap_12
X_7934_ _3388_ rf.registers\[23\]\[20\] _3901_ VGND VGND VPWR VPWR _3902_ sky130_fd_sc_hd__mux2_1
X_7865_ _3388_ rf.registers\[28\]\[20\] _3864_ VGND VGND VPWR VPWR _3865_ sky130_fd_sc_hd__mux2_1
X_6816_ net36 VGND VGND VPWR VPWR _3282_ sky130_fd_sc_hd__buf_2
X_7796_ _3805_ VGND VGND VPWR VPWR _3828_ sky130_fd_sc_hd__clkbuf_8
XFILLER_0_135_405 VPWR VGND VPWR VGND sky130_ef_sc_hd__decap_12
XFILLER_0_133_81 VPWR VGND VPWR VGND sky130_ef_sc_hd__decap_12
X_6747_ _3244_ VGND VGND VPWR VPWR _0867_ sky130_fd_sc_hd__clkbuf_1
X_9535_ clknet_leaf_17_CLK _0623_ VGND VGND VPWR VPWR rf.registers\[14\]\[14\] sky130_fd_sc_hd__dfxtp_1
XFILLER_0_135_449 VGND VGND VPWR VPWR sky130_fd_sc_hd__decap_4
XFILLER_0_73_561 VGND VGND VPWR VPWR sky130_fd_sc_hd__decap_4
XFILLER_0_18_477 VPWR VGND VPWR VGND sky130_ef_sc_hd__decap_12
XFILLER_0_45_241 VGND VGND VPWR VPWR sky130_fd_sc_hd__fill_1
X_6678_ rf.registers\[10\]\[2\] _2991_ _3205_ VGND VGND VPWR VPWR _3208_ sky130_fd_sc_hd__mux2_1
X_9466_ clknet_leaf_33_CLK _0554_ VGND VGND VPWR VPWR rf.registers\[20\]\[9\] sky130_fd_sc_hd__dfxtp_1
XFILLER_0_60_211 VGND VGND VPWR VPWR sky130_fd_sc_hd__decap_3
XFILLER_0_131_633 VPWR VGND VPWR VGND sky130_ef_sc_hd__decap_12
XFILLER_0_104_825 VPWR VGND VPWR VGND sky130_ef_sc_hd__decap_12
X_9397_ clknet_leaf_54_CLK _0485_ VGND VGND VPWR VPWR rf.registers\[21\]\[4\] sky130_fd_sc_hd__dfxtp_1
XFILLER_0_60_244 VGND VGND VPWR VPWR sky130_fd_sc_hd__decap_8
X_5629_ _2240_ _2349_ _2357_ _2358_ VGND VGND VPWR VPWR _2359_ sky130_fd_sc_hd__a211o_1
X_8417_ _4157_ VGND VGND VPWR VPWR _0600_ sky130_fd_sc_hd__clkbuf_1
XFILLER_0_130_121 VPWR VGND VPWR VGND sky130_ef_sc_hd__decap_12
XFILLER_0_103_346 VPWR VGND VPWR VGND sky130_ef_sc_hd__decap_12
Xclkbuf_leaf_51_CLK clknet_3_6__leaf_CLK VGND VGND VPWR VPWR clknet_leaf_51_CLK sky130_fd_sc_hd__clkbuf_8
XFILLER_0_60_288 VPWR VGND VPWR VGND sky130_ef_sc_hd__decap_12
XFILLER_0_5_393 VPWR VGND VPWR VGND sky130_ef_sc_hd__decap_12
X_8348_ rf.registers\[20\]\[23\] net29 _4117_ VGND VGND VPWR VPWR _4121_ sky130_fd_sc_hd__mux2_1
XFILLER_0_130_165 VPWR VGND VPWR VGND sky130_ef_sc_hd__decap_12
XTAP_TAPCELL_ROW_57_1152 VGND VPWR sky130_fd_sc_hd__tapvpwrvgnd_1
XFILLER_0_13_193 VPWR VGND VPWR VGND sky130_ef_sc_hd__decap_12
XFILLER_0_111_390 VGND VGND VPWR VPWR sky130_fd_sc_hd__fill_2
X_8279_ _4084_ VGND VGND VPWR VPWR _0535_ sky130_fd_sc_hd__clkbuf_1
XTAP_TAPCELL_ROW_70_1352 VGND VPWR sky130_fd_sc_hd__tapvpwrvgnd_1
XFILLER_0_96_642 VGND VGND VPWR VPWR sky130_fd_sc_hd__fill_2
XFILLER_0_138_221 VGND VGND VPWR VPWR sky130_fd_sc_hd__decap_3
XFILLER_0_84_837 VGND VGND VPWR VPWR sky130_fd_sc_hd__fill_2
XFILLER_0_22_27 VGND VGND VPWR VPWR sky130_fd_sc_hd__fill_1
XFILLER_0_37_742 VPWR VGND VPWR VGND sky130_ef_sc_hd__decap_12
XFILLER_0_83_369 VPWR VGND VPWR VGND sky130_ef_sc_hd__decap_12
XFILLER_0_52_701 VPWR VGND VPWR VGND sky130_ef_sc_hd__decap_12
XFILLER_0_36_263 VGND VGND VPWR VPWR sky130_fd_sc_hd__fill_1
XFILLER_0_51_222 VGND VGND VPWR VPWR sky130_fd_sc_hd__fill_2
XFILLER_0_107_685 VPWR VGND VPWR VGND sky130_ef_sc_hd__decap_12
XTAP_TAPCELL_ROW_40_898 VGND VPWR sky130_fd_sc_hd__tapvpwrvgnd_1
Xclkbuf_leaf_42_CLK clknet_3_7__leaf_CLK VGND VGND VPWR VPWR clknet_leaf_42_CLK sky130_fd_sc_hd__clkbuf_8
XPHY_EDGE_ROW_63_Left_202 VGND VGND VPWR VPWR sky130_fd_sc_hd__decap_3
XFILLER_0_20_664 VGND VGND VPWR VPWR sky130_fd_sc_hd__decap_8
XTAP_TAPCELL_ROW_88_1624 VGND VPWR sky130_fd_sc_hd__tapvpwrvgnd_1
XTAP_TAPCELL_ROW_88_1613 VGND VPWR sky130_fd_sc_hd__tapvpwrvgnd_1
XFILLER_0_2_15 VPWR VGND VPWR VGND sky130_ef_sc_hd__decap_12
X_5980_ _2661_ _2695_ _2259_ VGND VGND VPWR VPWR _2696_ sky130_fd_sc_hd__mux2_1
X_4931_ _1689_ _1690_ _1663_ VGND VGND VPWR VPWR _1691_ sky130_fd_sc_hd__mux2_1
XFILLER_0_86_130 VGND VGND VPWR VPWR sky130_fd_sc_hd__fill_1
XPHY_EDGE_ROW_72_Left_211 VGND VGND VPWR VPWR sky130_fd_sc_hd__decap_3
X_4862_ net2 VGND VGND VPWR VPWR _1625_ sky130_fd_sc_hd__clkbuf_4
X_7650_ _3750_ VGND VGND VPWR VPWR _0240_ sky130_fd_sc_hd__clkbuf_1
X_6601_ _3165_ VGND VGND VPWR VPWR _0800_ sky130_fd_sc_hd__clkbuf_1
XFILLER_0_28_753 VGND VGND VPWR VPWR sky130_fd_sc_hd__decap_3
X_7581_ _3378_ rf.registers\[27\]\[15\] _3708_ VGND VGND VPWR VPWR _3714_ sky130_fd_sc_hd__mux2_1
X_9320_ clknet_leaf_2_CLK _0408_ VGND VGND VPWR VPWR rf.registers\[22\]\[23\] sky130_fd_sc_hd__dfxtp_1
XFILLER_0_7_658 VPWR VGND VPWR VGND sky130_ef_sc_hd__decap_12
XANTENNA_15 net121 VGND VGND VPWR VPWR sky130_fd_sc_hd__diode_2
XFILLER_0_28_775 VGND VGND VPWR VPWR sky130_fd_sc_hd__fill_2
XFILLER_0_28_786 VPWR VGND VPWR VGND sky130_ef_sc_hd__decap_12
X_4793_ _1556_ _1559_ _1190_ VGND VGND VPWR VPWR _1560_ sky130_fd_sc_hd__mux2_1
XFILLER_0_132_419 VGND VGND VPWR VPWR sky130_fd_sc_hd__fill_1
X_6532_ _3128_ VGND VGND VPWR VPWR _0768_ sky130_fd_sc_hd__clkbuf_1
XFILLER_0_55_594 VGND VGND VPWR VPWR sky130_fd_sc_hd__decap_8
XTAP_TAPCELL_ROW_99_1786 VGND VPWR sky130_fd_sc_hd__tapvpwrvgnd_1
X_6463_ net10 _2965_ VGND VGND VPWR VPWR _3091_ sky130_fd_sc_hd__or2_2
X_9251_ clknet_leaf_4_CLK _0339_ VGND VGND VPWR VPWR rf.registers\[28\]\[18\] sky130_fd_sc_hd__dfxtp_1
XFILLER_0_15_447 VGND VGND VPWR VPWR sky130_fd_sc_hd__fill_1
X_9182_ clknet_leaf_27_CLK _0270_ VGND VGND VPWR VPWR rf.registers\[30\]\[13\] sky130_fd_sc_hd__dfxtp_1
XFILLER_0_112_121 VPWR VGND VPWR VGND sky130_ef_sc_hd__decap_12
Xoutput100 net100 VGND VGND VPWR VPWR RD2[27] sky130_fd_sc_hd__buf_1
X_8202_ _4043_ VGND VGND VPWR VPWR _0499_ sky130_fd_sc_hd__clkbuf_1
X_5414_ _1964_ _2140_ _2144_ _2148_ VGND VGND VPWR VPWR _2149_ sky130_fd_sc_hd__o2bb2a_4
Xoutput111 net111 VGND VGND VPWR VPWR RD2[8] sky130_fd_sc_hd__buf_1
XFILLER_0_113_688 VPWR VGND VPWR VGND sky130_ef_sc_hd__decap_12
Xclkbuf_leaf_33_CLK clknet_3_4__leaf_CLK VGND VGND VPWR VPWR clknet_leaf_33_CLK sky130_fd_sc_hd__clkbuf_8
XFILLER_0_101_839 VGND VGND VPWR VPWR sky130_fd_sc_hd__fill_1
XPHY_EDGE_ROW_81_Left_220 VGND VGND VPWR VPWR sky130_fd_sc_hd__decap_3
X_6394_ net10 net9 net46 VGND VGND VPWR VPWR _3054_ sky130_fd_sc_hd__nand3_4
X_8133_ _3384_ rf.registers\[26\]\[18\] _3998_ VGND VGND VPWR VPWR _4007_ sky130_fd_sc_hd__mux2_1
Xoutput133 net133 VGND VGND VPWR VPWR alu_result[28] sky130_fd_sc_hd__buf_1
Xoutput122 net122 VGND VGND VPWR VPWR alu_result[18] sky130_fd_sc_hd__buf_1
XFILLER_0_2_363 VGND VGND VPWR VPWR sky130_fd_sc_hd__fill_1
XFILLER_0_42_299 VGND VGND VPWR VPWR sky130_fd_sc_hd__fill_1
XFILLER_0_100_327 VGND VGND VPWR VPWR sky130_fd_sc_hd__fill_2
XFILLER_0_56_3 VPWR VGND VPWR VGND sky130_ef_sc_hd__decap_12
XFILLER_0_11_653 VPWR VGND VPWR VGND sky130_ef_sc_hd__decap_12
XFILLER_0_10_141 VPWR VGND VPWR VGND sky130_ef_sc_hd__decap_12
Xoutput144 net144 VGND VGND VPWR VPWR alu_result[9] sky130_fd_sc_hd__buf_1
X_5345_ _1964_ _2069_ _2076_ _2083_ VGND VGND VPWR VPWR _2084_ sky130_fd_sc_hd__o2bb2a_2
X_8064_ _3970_ VGND VGND VPWR VPWR _0434_ sky130_fd_sc_hd__clkbuf_1
X_5276_ rf.registers\[16\]\[21\] rf.registers\[17\]\[21\] rf.registers\[18\]\[21\]
+ rf.registers\[19\]\[21\] _1919_ _1920_ VGND VGND VPWR VPWR _2018_ sky130_fd_sc_hd__mux4_1
XTAP_TAPCELL_ROW_110_1953 VGND VPWR sky130_fd_sc_hd__tapvpwrvgnd_1
X_7015_ rf.registers\[6\]\[5\] _3288_ _3408_ VGND VGND VPWR VPWR _3414_ sky130_fd_sc_hd__mux2_1
XTAP_TAPCELL_ROW_52_1082 VGND VPWR sky130_fd_sc_hd__tapvpwrvgnd_1
XFILLER_0_69_108 VGND VGND VPWR VPWR sky130_fd_sc_hd__fill_1
X_8966_ clknet_leaf_84_CLK _0054_ VGND VGND VPWR VPWR rf.registers\[19\]\[21\] sky130_fd_sc_hd__dfxtp_1
X_7917_ _3372_ rf.registers\[23\]\[12\] _3890_ VGND VGND VPWR VPWR _3893_ sky130_fd_sc_hd__mux2_1
XFILLER_0_93_612 VGND VGND VPWR VPWR sky130_fd_sc_hd__decap_4
X_8897_ clknet_leaf_13_CLK _1009_ VGND VGND VPWR VPWR rf.registers\[5\]\[16\] sky130_fd_sc_hd__dfxtp_1
XFILLER_0_78_697 VGND VGND VPWR VPWR sky130_fd_sc_hd__decap_3
XFILLER_0_77_152 VGND VGND VPWR VPWR sky130_fd_sc_hd__decap_3
XFILLER_0_66_837 VGND VGND VPWR VPWR sky130_fd_sc_hd__fill_2
XFILLER_0_136_725 VPWR VGND VPWR VGND sky130_ef_sc_hd__decap_12
X_7848_ _3372_ rf.registers\[28\]\[12\] _3853_ VGND VGND VPWR VPWR _3856_ sky130_fd_sc_hd__mux2_1
X_7779_ _3819_ VGND VGND VPWR VPWR _0300_ sky130_fd_sc_hd__clkbuf_1
XFILLER_0_93_667 VGND VGND VPWR VPWR sky130_fd_sc_hd__decap_4
XFILLER_0_18_241 VGND VGND VPWR VPWR sky130_fd_sc_hd__fill_2
XFILLER_0_34_701 VPWR VGND VPWR VGND sky130_ef_sc_hd__decap_12
XFILLER_0_136_769 VPWR VGND VPWR VGND sky130_ef_sc_hd__decap_12
XFILLER_0_19_797 VPWR VGND VPWR VGND sky130_ef_sc_hd__decap_12
X_9518_ clknet_leaf_93_CLK _0606_ VGND VGND VPWR VPWR rf.registers\[18\]\[29\] sky130_fd_sc_hd__dfxtp_1
XFILLER_0_135_279 VGND VGND VPWR VPWR sky130_fd_sc_hd__fill_1
XFILLER_0_33_222 VGND VGND VPWR VPWR sky130_fd_sc_hd__fill_2
X_9449_ clknet_leaf_84_CLK _0537_ VGND VGND VPWR VPWR rf.registers\[25\]\[24\] sky130_fd_sc_hd__dfxtp_1
Xclkbuf_leaf_24_CLK clknet_3_5__leaf_CLK VGND VGND VPWR VPWR clknet_leaf_24_CLK sky130_fd_sc_hd__clkbuf_8
XFILLER_0_104_688 VPWR VGND VPWR VGND sky130_ef_sc_hd__decap_12
XFILLER_0_108_29 VPWR VGND VPWR VGND sky130_ef_sc_hd__decap_12
XTAP_TAPCELL_ROW_6_395 VGND VPWR sky130_fd_sc_hd__tapvpwrvgnd_1
XTAP_TAPCELL_ROW_6_384 VGND VPWR sky130_fd_sc_hd__tapvpwrvgnd_1
XFILLER_0_17_27 VPWR VGND VPWR VGND sky130_ef_sc_hd__decap_12
XFILLER_0_69_664 VGND VGND VPWR VPWR sky130_fd_sc_hd__decap_8
XFILLER_0_33_15 VPWR VGND VPWR VGND sky130_ef_sc_hd__decap_12
XTAP_TAPCELL_ROW_83_1543 VGND VPWR sky130_fd_sc_hd__tapvpwrvgnd_1
XFILLER_0_69_697 VPWR VGND VPWR VGND sky130_ef_sc_hd__decap_12
XTAP_TAPCELL_ROW_45_968 VGND VPWR sky130_fd_sc_hd__tapvpwrvgnd_1
XTAP_TAPCELL_ROW_45_979 VGND VPWR sky130_fd_sc_hd__tapvpwrvgnd_1
XFILLER_0_83_111 VGND VGND VPWR VPWR sky130_fd_sc_hd__fill_1
XFILLER_0_56_325 VGND VGND VPWR VPWR sky130_fd_sc_hd__fill_2
XTAP_TAPCELL_ROW_25_670 VGND VPWR sky130_fd_sc_hd__tapvpwrvgnd_1
XFILLER_0_83_166 VGND VGND VPWR VPWR sky130_fd_sc_hd__fill_2
XTAP_TAPCELL_ROW_25_681 VGND VPWR sky130_fd_sc_hd__tapvpwrvgnd_1
XFILLER_0_37_561 VGND VGND VPWR VPWR sky130_fd_sc_hd__decap_4
Xinput13 A3[4] VGND VGND VPWR VPWR net13 sky130_fd_sc_hd__buf_2
XFILLER_0_114_419 VGND VGND VPWR VPWR sky130_fd_sc_hd__fill_1
Xinput24 WD3[19] VGND VGND VPWR VPWR net24 sky130_fd_sc_hd__dlymetal6s2s_1
XFILLER_0_3_105 VGND VGND VPWR VPWR sky130_fd_sc_hd__decap_6
Xinput46 WE3 VGND VGND VPWR VPWR net46 sky130_fd_sc_hd__buf_4
Xinput35 WD3[29] VGND VGND VPWR VPWR net35 sky130_fd_sc_hd__buf_1
XFILLER_0_3_149 VPWR VGND VPWR VGND sky130_ef_sc_hd__decap_12
Xclkbuf_leaf_15_CLK clknet_3_1__leaf_CLK VGND VGND VPWR VPWR clknet_leaf_15_CLK sky130_fd_sc_hd__clkbuf_8
X_5130_ rf.registers\[8\]\[13\] rf.registers\[9\]\[13\] rf.registers\[10\]\[13\] rf.registers\[11\]\[13\]
+ _1734_ _1797_ VGND VGND VPWR VPWR _1880_ sky130_fd_sc_hd__mux4_1
X_5061_ _1811_ _1812_ _1813_ _1814_ _1741_ _1742_ VGND VGND VPWR VPWR _1815_ sky130_fd_sc_hd__mux4_2
X_8820_ clknet_leaf_40_CLK _0932_ VGND VGND VPWR VPWR rf.registers\[15\]\[3\] sky130_fd_sc_hd__dfxtp_1
XTAP_TAPCELL_ROW_125_2182 VGND VPWR sky130_fd_sc_hd__tapvpwrvgnd_1
XTAP_TAPCELL_ROW_125_2171 VGND VPWR sky130_fd_sc_hd__tapvpwrvgnd_1
X_8751_ clknet_leaf_61_CLK _0863_ VGND VGND VPWR VPWR rf.registers\[10\]\[30\] sky130_fd_sc_hd__dfxtp_1
XFILLER_0_59_130 VGND VGND VPWR VPWR sky130_fd_sc_hd__fill_2
X_5963_ _2676_ _2679_ VGND VGND VPWR VPWR _2680_ sky130_fd_sc_hd__xnor2_2
X_4914_ _1621_ _1674_ VGND VGND VPWR VPWR _1675_ sky130_fd_sc_hd__or2_1
X_7702_ _3778_ VGND VGND VPWR VPWR _0264_ sky130_fd_sc_hd__clkbuf_1
XFILLER_0_48_837 VGND VGND VPWR VPWR sky130_fd_sc_hd__fill_2
X_5894_ _2591_ VGND VGND VPWR VPWR _2615_ sky130_fd_sc_hd__inv_2
X_8682_ clknet_leaf_70_CLK _0794_ VGND VGND VPWR VPWR rf.registers\[1\]\[25\] sky130_fd_sc_hd__dfxtp_1
XFILLER_0_118_725 VPWR VGND VPWR VGND sky130_ef_sc_hd__decap_12
XFILLER_0_114_83 VGND VGND VPWR VPWR sky130_fd_sc_hd__fill_1
X_7633_ _3741_ VGND VGND VPWR VPWR _0232_ sky130_fd_sc_hd__clkbuf_1
X_4845_ _1607_ _1608_ _1134_ VGND VGND VPWR VPWR _1609_ sky130_fd_sc_hd__mux2_1
XFILLER_0_35_509 VGND VGND VPWR VPWR sky130_fd_sc_hd__fill_1
XFILLER_0_118_769 VPWR VGND VPWR VGND sky130_ef_sc_hd__decap_12
X_7564_ _3361_ rf.registers\[27\]\[7\] _3697_ VGND VGND VPWR VPWR _3705_ sky130_fd_sc_hd__mux2_1
X_4776_ _1542_ _1543_ _1312_ VGND VGND VPWR VPWR _1544_ sky130_fd_sc_hd__mux2_1
XFILLER_0_28_572 VPWR VGND VPWR VGND sky130_ef_sc_hd__decap_12
X_9303_ clknet_leaf_57_CLK _0391_ VGND VGND VPWR VPWR rf.registers\[22\]\[6\] sky130_fd_sc_hd__dfxtp_1
XFILLER_0_55_391 VGND VGND VPWR VPWR sky130_fd_sc_hd__fill_1
X_6515_ rf.registers\[17\]\[23\] _3035_ _3116_ VGND VGND VPWR VPWR _3120_ sky130_fd_sc_hd__mux2_1
XFILLER_0_43_553 VGND VGND VPWR VPWR sky130_fd_sc_hd__decap_6
X_7495_ _3668_ VGND VGND VPWR VPWR _0167_ sky130_fd_sc_hd__clkbuf_1
XFILLER_0_31_715 VPWR VGND VPWR VGND sky130_ef_sc_hd__decap_12
X_9234_ clknet_leaf_42_CLK _0322_ VGND VGND VPWR VPWR rf.registers\[28\]\[1\] sky130_fd_sc_hd__dfxtp_1
X_6446_ _3082_ VGND VGND VPWR VPWR _0728_ sky130_fd_sc_hd__clkbuf_1
XFILLER_0_31_748 VGND VGND VPWR VPWR sky130_fd_sc_hd__decap_4
XTAP_TAPCELL_ROW_54_1111 VGND VPWR sky130_fd_sc_hd__tapvpwrvgnd_1
X_6377_ _3042_ VGND VGND VPWR VPWR _0699_ sky130_fd_sc_hd__clkbuf_1
X_9165_ clknet_leaf_90_CLK _0253_ VGND VGND VPWR VPWR rf.registers\[2\]\[28\] sky130_fd_sc_hd__dfxtp_1
XFILLER_0_101_669 VGND VGND VPWR VPWR sky130_fd_sc_hd__decap_3
X_8116_ _3986_ VGND VGND VPWR VPWR _3998_ sky130_fd_sc_hd__clkbuf_8
X_9096_ clknet_leaf_3_CLK _0184_ VGND VGND VPWR VPWR rf.registers\[31\]\[23\] sky130_fd_sc_hd__dfxtp_1
XFILLER_0_11_461 VPWR VGND VPWR VGND sky130_ef_sc_hd__decap_12
X_5328_ rf.registers\[24\]\[24\] rf.registers\[25\]\[24\] rf.registers\[26\]\[24\]
+ rf.registers\[27\]\[24\] _1999_ _2000_ VGND VGND VPWR VPWR _2067_ sky130_fd_sc_hd__mux4_1
X_8047_ _3961_ VGND VGND VPWR VPWR _0426_ sky130_fd_sc_hd__clkbuf_1
X_5259_ rf.registers\[28\]\[20\] rf.registers\[29\]\[20\] rf.registers\[30\]\[20\]
+ rf.registers\[31\]\[20\] _1999_ _2000_ VGND VGND VPWR VPWR _2002_ sky130_fd_sc_hd__mux4_1
XTAP_TAPCELL_ROW_3_343 VGND VPWR sky130_fd_sc_hd__tapvpwrvgnd_1
XFILLER_0_98_737 VPWR VGND VPWR VGND sky130_ef_sc_hd__decap_12
X_8949_ clknet_leaf_47_CLK _0037_ VGND VGND VPWR VPWR rf.registers\[19\]\[4\] sky130_fd_sc_hd__dfxtp_1
XFILLER_0_66_645 VPWR VGND VPWR VGND sky130_ef_sc_hd__decap_12
XTAP_TAPCELL_ROW_65_1273 VGND VPWR sky130_fd_sc_hd__tapvpwrvgnd_1
XTAP_TAPCELL_ROW_42_927 VGND VPWR sky130_fd_sc_hd__tapvpwrvgnd_1
XFILLER_0_136_533 VPWR VGND VPWR VGND sky130_ef_sc_hd__decap_12
XFILLER_0_93_442 VGND VGND VPWR VPWR sky130_fd_sc_hd__decap_6
XFILLER_0_19_561 VPWR VGND VPWR VGND sky130_ef_sc_hd__decap_12
XFILLER_0_26_509 VPWR VGND VPWR VGND sky130_ef_sc_hd__decap_12
XFILLER_0_108_257 VGND VGND VPWR VPWR sky130_fd_sc_hd__fill_1
XFILLER_0_81_648 VGND VGND VPWR VPWR sky130_fd_sc_hd__fill_1
XFILLER_0_123_205 VPWR VGND VPWR VGND sky130_ef_sc_hd__decap_12
XFILLER_0_80_136 VGND VGND VPWR VPWR sky130_fd_sc_hd__decap_4
XFILLER_0_123_249 VPWR VGND VPWR VGND sky130_ef_sc_hd__decap_12
XFILLER_0_116_290 VGND VGND VPWR VPWR sky130_fd_sc_hd__fill_1
XFILLER_0_61_372 VGND VGND VPWR VPWR sky130_fd_sc_hd__decap_8
XFILLER_0_34_575 VGND VGND VPWR VPWR sky130_fd_sc_hd__fill_1
XFILLER_0_1_609 VGND VGND VPWR VPWR sky130_fd_sc_hd__decap_6
XFILLER_0_131_293 VPWR VGND VPWR VGND sky130_ef_sc_hd__decap_12
XFILLER_0_28_15 VPWR VGND VPWR VGND sky130_ef_sc_hd__decap_12
Xclkbuf_leaf_4_CLK clknet_3_1__leaf_CLK VGND VGND VPWR VPWR clknet_leaf_4_CLK sky130_fd_sc_hd__clkbuf_8
XFILLER_0_69_461 VGND VGND VPWR VPWR sky130_fd_sc_hd__decap_6
XFILLER_0_56_100 VGND VGND VPWR VPWR sky130_fd_sc_hd__fill_1
XFILLER_0_84_453 VGND VGND VPWR VPWR sky130_fd_sc_hd__decap_6
XFILLER_0_29_358 VGND VGND VPWR VPWR sky130_fd_sc_hd__decap_4
XFILLER_0_84_475 VGND VGND VPWR VPWR sky130_fd_sc_hd__fill_1
XFILLER_0_71_125 VGND VGND VPWR VPWR sky130_fd_sc_hd__decap_4
X_4630_ _1405_ _1406_ _1381_ VGND VGND VPWR VPWR _1407_ sky130_fd_sc_hd__mux2_1
XFILLER_0_114_3 VPWR VGND VPWR VGND sky130_ef_sc_hd__decap_12
X_6300_ _2990_ VGND VGND VPWR VPWR _0674_ sky130_fd_sc_hd__clkbuf_1
XTAP_TAPCELL_ROW_96_1745 VGND VPWR sky130_fd_sc_hd__tapvpwrvgnd_1
XTAP_TAPCELL_ROW_96_1734 VGND VPWR sky130_fd_sc_hd__tapvpwrvgnd_1
X_4561_ _1340_ _1341_ _1312_ VGND VGND VPWR VPWR _1342_ sky130_fd_sc_hd__mux2_1
XFILLER_0_71_169 VGND VGND VPWR VPWR sky130_fd_sc_hd__decap_6
X_7280_ _3554_ VGND VGND VPWR VPWR _0066_ sky130_fd_sc_hd__clkbuf_1
X_4492_ _1144_ _1273_ _1275_ _1034_ VGND VGND VPWR VPWR _1276_ sky130_fd_sc_hd__o211a_1
XFILLER_0_80_692 VGND VGND VPWR VPWR sky130_fd_sc_hd__decap_8
XFILLER_0_69_33 VGND VGND VPWR VPWR sky130_fd_sc_hd__fill_1
XFILLER_0_4_469 VGND VGND VPWR VPWR sky130_fd_sc_hd__decap_6
XFILLER_0_25_597 VPWR VGND VPWR VGND sky130_ef_sc_hd__decap_12
XFILLER_0_40_545 VGND VGND VPWR VPWR sky130_fd_sc_hd__decap_6
XFILLER_0_123_783 VGND VGND VPWR VPWR sky130_fd_sc_hd__fill_1
XFILLER_0_100_41 VPWR VGND VPWR VGND sky130_ef_sc_hd__decap_12
X_6231_ _2907_ _2918_ VGND VGND VPWR VPWR _2933_ sky130_fd_sc_hd__nor2_1
XFILLER_0_100_85 VGND VGND VPWR VPWR sky130_fd_sc_hd__fill_2
X_6162_ _2417_ _2571_ _2606_ _2780_ _2398_ VGND VGND VPWR VPWR _2867_ sky130_fd_sc_hd__o221a_1
X_5113_ rf.registers\[12\]\[12\] rf.registers\[13\]\[12\] rf.registers\[14\]\[12\]
+ rf.registers\[15\]\[12\] _1699_ _1700_ VGND VGND VPWR VPWR _1864_ sky130_fd_sc_hd__mux4_1
XTAP_TAPCELL_ROW_127_2211 VGND VPWR sky130_fd_sc_hd__tapvpwrvgnd_1
XTAP_TAPCELL_ROW_127_2200 VGND VPWR sky130_fd_sc_hd__tapvpwrvgnd_1
X_6093_ _2717_ _2748_ _2259_ VGND VGND VPWR VPWR _2802_ sky130_fd_sc_hd__mux2_1
X_5044_ rf.registers\[28\]\[8\] rf.registers\[29\]\[8\] rf.registers\[30\]\[8\] rf.registers\[31\]\[8\]
+ _1795_ _1736_ VGND VGND VPWR VPWR _1799_ sky130_fd_sc_hd__mux4_1
XFILLER_0_79_225 VGND VGND VPWR VPWR sky130_fd_sc_hd__decap_6
XTAP_TAPCELL_ROW_0_302 VGND VPWR sky130_fd_sc_hd__tapvpwrvgnd_1
X_8803_ clknet_leaf_5_CLK _0915_ VGND VGND VPWR VPWR rf.registers\[16\]\[18\] sky130_fd_sc_hd__dfxtp_1
XFILLER_0_138_809 VGND VGND VPWR VPWR sky130_fd_sc_hd__decap_3
XFILLER_0_95_729 VPWR VGND VPWR VGND sky130_ef_sc_hd__decap_12
XFILLER_0_95_718 VGND VGND VPWR VPWR sky130_fd_sc_hd__decap_8
XFILLER_0_88_781 VPWR VGND VPWR VGND sky130_ef_sc_hd__decap_12
XFILLER_0_48_601 VGND VGND VPWR VPWR sky130_fd_sc_hd__fill_2
X_6995_ _3402_ VGND VGND VPWR VPWR _0957_ sky130_fd_sc_hd__clkbuf_1
XFILLER_0_125_93 VPWR VGND VPWR VGND sky130_ef_sc_hd__decap_12
XTAP_TAPCELL_ROW_105_1874 VGND VPWR sky130_fd_sc_hd__tapvpwrvgnd_1
X_8734_ clknet_leaf_29_CLK _0846_ VGND VGND VPWR VPWR rf.registers\[10\]\[13\] sky130_fd_sc_hd__dfxtp_1
XFILLER_0_48_645 VPWR VGND VPWR VGND sky130_ef_sc_hd__decap_12
X_5946_ _2663_ VGND VGND VPWR VPWR _2664_ sky130_fd_sc_hd__inv_2
XFILLER_0_118_533 VGND VGND VPWR VPWR sky130_fd_sc_hd__fill_1
X_8665_ clknet_leaf_46_CLK _0777_ VGND VGND VPWR VPWR rf.registers\[1\]\[8\] sky130_fd_sc_hd__dfxtp_1
X_5877_ _2373_ _2568_ _2570_ _2341_ VGND VGND VPWR VPWR _2599_ sky130_fd_sc_hd__o22a_1
X_7616_ _3129_ _3203_ VGND VGND VPWR VPWR _3732_ sky130_fd_sc_hd__nor2_2
XFILLER_0_63_648 VPWR VGND VPWR VGND sky130_ef_sc_hd__decap_12
X_4828_ _1591_ _1592_ _1145_ VGND VGND VPWR VPWR _1593_ sky130_fd_sc_hd__mux2_1
XFILLER_0_8_753 VGND VGND VPWR VPWR sky130_fd_sc_hd__decap_3
XTAP_TAPCELL_ROW_138_2384 VGND VPWR sky130_fd_sc_hd__tapvpwrvgnd_1
XTAP_TAPCELL_ROW_138_2373 VGND VPWR sky130_fd_sc_hd__tapvpwrvgnd_1
X_8596_ clknet_leaf_35_CLK _0708_ VGND VGND VPWR VPWR rf.registers\[11\]\[3\] sky130_fd_sc_hd__dfxtp_1
XFILLER_0_62_158 VGND VGND VPWR VPWR sky130_fd_sc_hd__fill_1
XFILLER_0_16_531 VGND VGND VPWR VPWR sky130_fd_sc_hd__fill_1
XFILLER_0_133_558 VGND VGND VPWR VPWR sky130_fd_sc_hd__fill_2
XFILLER_0_121_709 VPWR VGND VPWR VGND sky130_ef_sc_hd__decap_12
X_7547_ _3695_ VGND VGND VPWR VPWR _0192_ sky130_fd_sc_hd__clkbuf_1
X_4759_ _1526_ _1527_ _1144_ VGND VGND VPWR VPWR _1528_ sky130_fd_sc_hd__mux2_1
X_7478_ _2980_ rf.registers\[29\]\[31\] _3624_ VGND VGND VPWR VPWR _3659_ sky130_fd_sc_hd__mux2_1
XFILLER_0_31_523 VPWR VGND VPWR VGND sky130_ef_sc_hd__decap_12
X_6429_ _3073_ VGND VGND VPWR VPWR _0720_ sky130_fd_sc_hd__clkbuf_1
X_9217_ clknet_leaf_14_CLK _0305_ VGND VGND VPWR VPWR rf.registers\[9\]\[16\] sky130_fd_sc_hd__dfxtp_1
XTAP_TAPCELL_ROW_8_424 VGND VPWR sky130_fd_sc_hd__tapvpwrvgnd_1
XTAP_TAPCELL_ROW_8_413 VGND VPWR sky130_fd_sc_hd__tapvpwrvgnd_1
X_9148_ clknet_leaf_31_CLK _0236_ VGND VGND VPWR VPWR rf.registers\[2\]\[11\] sky130_fd_sc_hd__dfxtp_1
X_9079_ clknet_leaf_31_CLK _0167_ VGND VGND VPWR VPWR rf.registers\[31\]\[6\] sky130_fd_sc_hd__dfxtp_1
XTAP_TAPCELL_ROW_67_1302 VGND VPWR sky130_fd_sc_hd__tapvpwrvgnd_1
XTAP_TAPCELL_ROW_27_710 VGND VPWR sky130_fd_sc_hd__tapvpwrvgnd_1
XFILLER_0_129_809 VPWR VGND VPWR VGND sky130_ef_sc_hd__decap_12
XTAP_TAPCELL_ROW_80_1502 VGND VPWR sky130_fd_sc_hd__tapvpwrvgnd_1
XFILLER_0_27_818 VPWR VGND VPWR VGND sky130_ef_sc_hd__decap_12
XFILLER_0_81_401 VPWR VGND VPWR VGND sky130_ef_sc_hd__decap_12
XFILLER_0_66_475 VGND VGND VPWR VPWR sky130_fd_sc_hd__fill_1
XFILLER_0_26_328 VGND VGND VPWR VPWR sky130_fd_sc_hd__decap_6
XFILLER_0_39_689 VGND VGND VPWR VPWR sky130_fd_sc_hd__decap_4
XFILLER_0_136_363 VGND VGND VPWR VPWR sky130_fd_sc_hd__fill_1
Xclkbuf_3_7__f_CLK clknet_0_CLK VGND VGND VPWR VPWR clknet_3_7__leaf_CLK sky130_fd_sc_hd__clkbuf_16
XFILLER_0_30_27 VGND VGND VPWR VPWR sky130_fd_sc_hd__fill_1
XFILLER_0_34_361 VGND VGND VPWR VPWR sky130_fd_sc_hd__decap_3
XTAP_TAPCELL_ROW_78_1464 VGND VPWR sky130_fd_sc_hd__tapvpwrvgnd_1
XFILLER_0_1_417 VPWR VGND VPWR VGND sky130_ef_sc_hd__decap_12
XFILLER_0_22_545 VPWR VGND VPWR VGND sky130_ef_sc_hd__decap_12
XFILLER_0_105_783 VGND VGND VPWR VPWR sky130_fd_sc_hd__fill_1
XTAP_TAPCELL_ROW_78_1475 VGND VPWR sky130_fd_sc_hd__tapvpwrvgnd_1
XFILLER_0_22_589 VGND VGND VPWR VPWR sky130_fd_sc_hd__decap_3
XTAP_TAPCELL_ROW_91_1664 VGND VPWR sky130_fd_sc_hd__tapvpwrvgnd_1
XTAP_TAPCELL_ROW_122_2130 VGND VPWR sky130_fd_sc_hd__tapvpwrvgnd_1
XFILLER_0_77_729 VPWR VGND VPWR VGND sky130_ef_sc_hd__decap_12
X_6780_ _3261_ VGND VGND VPWR VPWR _0883_ sky130_fd_sc_hd__clkbuf_1
XFILLER_0_9_517 VPWR VGND VPWR VGND sky130_ef_sc_hd__decap_12
X_5800_ _2303_ _2308_ _2304_ VGND VGND VPWR VPWR _2525_ sky130_fd_sc_hd__mux2_1
X_5731_ net103 _2282_ _2457_ VGND VGND VPWR VPWR _2458_ sky130_fd_sc_hd__a21oi_1
XFILLER_0_17_317 VPWR VGND VPWR VGND sky130_ef_sc_hd__decap_12
XFILLER_0_115_503 VGND VGND VPWR VPWR sky130_fd_sc_hd__fill_1
XFILLER_0_95_7 VPWR VGND VPWR VGND sky130_ef_sc_hd__decap_12
X_8450_ _3001_ rf.registers\[14\]\[7\] _4167_ VGND VGND VPWR VPWR _4175_ sky130_fd_sc_hd__mux2_1
X_5662_ net47 _2391_ VGND VGND VPWR VPWR _2392_ sky130_fd_sc_hd__nand2_2
XFILLER_0_127_385 VGND VGND VPWR VPWR sky130_fd_sc_hd__decap_4
XFILLER_0_115_547 VGND VGND VPWR VPWR sky130_fd_sc_hd__fill_1
XTAP_TAPCELL_ROW_100_1793 VGND VPWR sky130_fd_sc_hd__tapvpwrvgnd_1
X_8381_ _4138_ VGND VGND VPWR VPWR _0583_ sky130_fd_sc_hd__clkbuf_1
X_4613_ _1197_ _1390_ _1024_ VGND VGND VPWR VPWR _1391_ sky130_fd_sc_hd__a21o_1
XFILLER_0_60_629 VGND VGND VPWR VPWR sky130_fd_sc_hd__decap_3
XFILLER_0_53_670 VGND VGND VPWR VPWR sky130_fd_sc_hd__fill_2
X_5593_ _2268_ _2323_ VGND VGND VPWR VPWR net113 sky130_fd_sc_hd__nand2_1
XFILLER_0_4_233 VPWR VGND VPWR VGND sky130_ef_sc_hd__decap_12
XTAP_TAPCELL_ROW_13_492 VGND VPWR sky130_fd_sc_hd__tapvpwrvgnd_1
X_7401_ rf.registers\[8\]\[27\] _3334_ _3610_ VGND VGND VPWR VPWR _3618_ sky130_fd_sc_hd__mux2_1
XFILLER_0_103_709 VPWR VGND VPWR VGND sky130_ef_sc_hd__decap_12
X_4544_ _1324_ _1325_ _1134_ VGND VGND VPWR VPWR _1326_ sky130_fd_sc_hd__mux2_1
XFILLER_0_52_180 VGND VGND VPWR VPWR sky130_fd_sc_hd__fill_1
X_7332_ _3581_ VGND VGND VPWR VPWR _0091_ sky130_fd_sc_hd__clkbuf_1
XFILLER_0_41_821 VPWR VGND VPWR VGND sky130_ef_sc_hd__decap_12
XFILLER_0_102_219 VGND VGND VPWR VPWR sky130_fd_sc_hd__fill_1
XFILLER_0_4_277 VPWR VGND VPWR VGND sky130_ef_sc_hd__decap_12
X_7263_ rf.registers\[19\]\[26\] _3332_ _3538_ VGND VGND VPWR VPWR _3545_ sky130_fd_sc_hd__mux2_1
XTAP_TAPCELL_ROW_133_2292 VGND VPWR sky130_fd_sc_hd__tapvpwrvgnd_1
XFILLER_0_111_753 VPWR VGND VPWR VGND sky130_ef_sc_hd__decap_12
X_4475_ rf.registers\[8\]\[10\] rf.registers\[9\]\[10\] rf.registers\[10\]\[10\] rf.registers\[11\]\[10\]
+ _1042_ _1044_ VGND VGND VPWR VPWR _1260_ sky130_fd_sc_hd__mux4_1
XFILLER_0_96_53 VGND VGND VPWR VPWR sky130_fd_sc_hd__fill_2
X_9002_ clknet_leaf_71_CLK _0090_ VGND VGND VPWR VPWR rf.registers\[3\]\[25\] sky130_fd_sc_hd__dfxtp_1
X_6214_ _2909_ _2916_ VGND VGND VPWR VPWR _2917_ sky130_fd_sc_hd__and2b_1
XFILLER_0_111_797 VPWR VGND VPWR VGND sky130_ef_sc_hd__decap_12
XFILLER_0_0_461 VGND VGND VPWR VPWR sky130_fd_sc_hd__fill_2
X_7194_ _3508_ VGND VGND VPWR VPWR _0026_ sky130_fd_sc_hd__clkbuf_1
X_6145_ _1508_ _2851_ VGND VGND VPWR VPWR _2852_ sky130_fd_sc_hd__xnor2_2
XFILLER_0_99_309 VGND VGND VPWR VPWR sky130_fd_sc_hd__fill_1
X_6076_ net94 _2785_ VGND VGND VPWR VPWR _2786_ sky130_fd_sc_hd__xnor2_2
X_5027_ rf.registers\[24\]\[7\] rf.registers\[25\]\[7\] rf.registers\[26\]\[7\] rf.registers\[27\]\[7\]
+ _1631_ _1632_ VGND VGND VPWR VPWR _1783_ sky130_fd_sc_hd__mux4_1
XTAP_TAPCELL_ROW_107_1903 VGND VPWR sky130_fd_sc_hd__tapvpwrvgnd_1
XTAP_TAPCELL_ROW_49_1032 VGND VPWR sky130_fd_sc_hd__tapvpwrvgnd_1
XFILLER_0_138_617 VPWR VGND VPWR VGND sky130_ef_sc_hd__decap_12
XFILLER_0_95_559 VGND VGND VPWR VPWR sky130_fd_sc_hd__fill_1
XFILLER_0_67_228 VGND VGND VPWR VPWR sky130_fd_sc_hd__fill_1
XFILLER_0_137_105 VGND VGND VPWR VPWR sky130_fd_sc_hd__decap_6
X_6978_ _3392_ VGND VGND VPWR VPWR _0950_ sky130_fd_sc_hd__clkbuf_1
X_8717_ clknet_leaf_91_CLK _0829_ VGND VGND VPWR VPWR rf.registers\[24\]\[28\] sky130_fd_sc_hd__dfxtp_1
XFILLER_0_137_149 VPWR VGND VPWR VGND sky130_ef_sc_hd__decap_12
XTAP_TAPCELL_ROW_62_1232 VGND VPWR sky130_fd_sc_hd__tapvpwrvgnd_1
X_5929_ _1309_ _2647_ VGND VGND VPWR VPWR _2648_ sky130_fd_sc_hd__xnor2_2
XFILLER_0_91_765 VPWR VGND VPWR VGND sky130_ef_sc_hd__decap_12
XFILLER_0_63_445 VGND VGND VPWR VPWR sky130_fd_sc_hd__decap_3
X_8648_ clknet_leaf_1_CLK _0760_ VGND VGND VPWR VPWR rf.registers\[17\]\[23\] sky130_fd_sc_hd__dfxtp_1
XFILLER_0_90_253 VGND VGND VPWR VPWR sky130_fd_sc_hd__decap_3
X_8579_ clknet_leaf_7_CLK _0691_ VGND VGND VPWR VPWR rf.registers\[12\]\[18\] sky130_fd_sc_hd__dfxtp_1
XFILLER_0_16_361 VGND VGND VPWR VPWR sky130_fd_sc_hd__decap_3
XFILLER_0_32_810 VGND VGND VPWR VPWR sky130_fd_sc_hd__fill_2
XFILLER_0_8_3 VPWR VGND VPWR VGND sky130_ef_sc_hd__decap_12
XTAP_TAPCELL_ROW_73_1394 VGND VPWR sky130_fd_sc_hd__tapvpwrvgnd_1
XFILLER_0_99_821 VPWR VGND VPWR VGND sky130_ef_sc_hd__decap_12
XFILLER_0_116_29 VPWR VGND VPWR VGND sky130_ef_sc_hd__decap_12
XFILLER_0_25_27 VPWR VGND VPWR VGND sky130_ef_sc_hd__decap_12
XFILLER_0_59_729 VPWR VGND VPWR VGND sky130_ef_sc_hd__decap_12
XFILLER_0_58_206 VGND VGND VPWR VPWR sky130_fd_sc_hd__fill_2
XFILLER_0_54_412 VGND VGND VPWR VPWR sky130_fd_sc_hd__fill_1
XFILLER_0_27_615 VGND VGND VPWR VPWR sky130_fd_sc_hd__fill_1
XFILLER_0_41_15 VPWR VGND VPWR VGND sky130_ef_sc_hd__decap_12
XFILLER_0_109_374 VGND VGND VPWR VPWR sky130_fd_sc_hd__fill_2
XFILLER_0_66_283 VGND VGND VPWR VPWR sky130_fd_sc_hd__decap_8
XFILLER_0_26_136 VGND VGND VPWR VPWR sky130_fd_sc_hd__fill_1
XFILLER_0_27_648 VGND VGND VPWR VPWR sky130_fd_sc_hd__decap_3
XFILLER_0_124_333 VPWR VGND VPWR VGND sky130_ef_sc_hd__decap_12
XFILLER_0_14_309 VPWR VGND VPWR VGND sky130_ef_sc_hd__decap_12
XTAP_TAPCELL_ROW_30_749 VGND VPWR sky130_fd_sc_hd__tapvpwrvgnd_1
XTAP_TAPCELL_ROW_10_451 VGND VPWR sky130_fd_sc_hd__tapvpwrvgnd_1
XFILLER_0_23_821 VPWR VGND VPWR VGND sky130_ef_sc_hd__decap_12
XFILLER_0_35_670 VGND VGND VPWR VPWR sky130_fd_sc_hd__fill_2
XFILLER_0_35_681 VGND VGND VPWR VPWR sky130_fd_sc_hd__decap_3
XFILLER_0_124_377 VGND VGND VPWR VPWR sky130_fd_sc_hd__decap_8
XFILLER_0_2_737 VPWR VGND VPWR VGND sky130_ef_sc_hd__decap_12
XFILLER_0_1_225 VPWR VGND VPWR VGND sky130_ef_sc_hd__decap_12
XFILLER_0_22_331 VGND VGND VPWR VPWR sky130_fd_sc_hd__decap_3
XFILLER_0_5_15 VPWR VGND VPWR VGND sky130_ef_sc_hd__decap_12
X_4260_ _1054_ VGND VGND VPWR VPWR _1055_ sky130_fd_sc_hd__inv_2
X_7950_ _2974_ rf.registers\[23\]\[28\] _3901_ VGND VGND VPWR VPWR _3910_ sky130_fd_sc_hd__mux2_1
XFILLER_0_82_55 VGND VGND VPWR VPWR sky130_fd_sc_hd__fill_1
X_6901_ _3339_ VGND VGND VPWR VPWR _0926_ sky130_fd_sc_hd__clkbuf_1
X_7881_ _2974_ rf.registers\[28\]\[28\] _3864_ VGND VGND VPWR VPWR _3873_ sky130_fd_sc_hd__mux2_1
X_6832_ rf.registers\[16\]\[7\] _3292_ _3278_ VGND VGND VPWR VPWR _3293_ sky130_fd_sc_hd__mux2_1
XFILLER_0_119_105 VGND VGND VPWR VPWR sky130_fd_sc_hd__decap_6
XFILLER_0_15_93 VPWR VGND VPWR VGND sky130_ef_sc_hd__decap_12
XTAP_TAPCELL_ROW_18_573 VGND VPWR sky130_fd_sc_hd__tapvpwrvgnd_1
XFILLER_0_135_609 VGND VGND VPWR VPWR sky130_fd_sc_hd__decap_6
XFILLER_0_119_149 VPWR VGND VPWR VGND sky130_ef_sc_hd__decap_12
XTAP_TAPCELL_ROW_102_1833 VGND VPWR sky130_fd_sc_hd__tapvpwrvgnd_1
X_6763_ rf.registers\[0\]\[10\] _3007_ _3252_ VGND VGND VPWR VPWR _3253_ sky130_fd_sc_hd__mux2_1
X_9551_ clknet_leaf_61_CLK _0639_ VGND VGND VPWR VPWR rf.registers\[14\]\[30\] sky130_fd_sc_hd__dfxtp_1
XFILLER_0_18_604 VPWR VGND VPWR VGND sky130_ef_sc_hd__decap_12
XFILLER_0_18_626 VGND VGND VPWR VPWR sky130_fd_sc_hd__decap_8
XFILLER_0_45_401 VGND VGND VPWR VPWR sky130_fd_sc_hd__fill_1
X_8502_ _2982_ rf.registers\[13\]\[0\] _2968_ VGND VGND VPWR VPWR _4202_ sky130_fd_sc_hd__mux2_1
X_6694_ _3204_ VGND VGND VPWR VPWR _3216_ sky130_fd_sc_hd__buf_4
XFILLER_0_17_125 VPWR VGND VPWR VGND sky130_ef_sc_hd__decap_12
X_5714_ _2440_ _2441_ _2416_ VGND VGND VPWR VPWR _2442_ sky130_fd_sc_hd__mux2_1
X_9482_ clknet_leaf_85_CLK _0570_ VGND VGND VPWR VPWR rf.registers\[20\]\[25\] sky130_fd_sc_hd__dfxtp_1
XTAP_TAPCELL_ROW_135_2332 VGND VPWR sky130_fd_sc_hd__tapvpwrvgnd_1
XTAP_TAPCELL_ROW_135_2321 VGND VPWR sky130_fd_sc_hd__tapvpwrvgnd_1
XFILLER_0_127_193 VPWR VGND VPWR VGND sky130_ef_sc_hd__decap_12
XFILLER_0_122_83 VGND VGND VPWR VPWR sky130_fd_sc_hd__fill_1
XFILLER_0_73_765 VPWR VGND VPWR VGND sky130_ef_sc_hd__decap_12
X_8433_ _4165_ VGND VGND VPWR VPWR _0608_ sky130_fd_sc_hd__clkbuf_1
XFILLER_0_17_169 VPWR VGND VPWR VGND sky130_ef_sc_hd__decap_12
X_5645_ _2209_ _2100_ _2208_ _2374_ VGND VGND VPWR VPWR _2375_ sky130_fd_sc_hd__o31a_1
XFILLER_0_86_3 VPWR VGND VPWR VGND sky130_ef_sc_hd__decap_12
XFILLER_0_72_286 VGND VGND VPWR VPWR sky130_fd_sc_hd__decap_3
XFILLER_0_60_415 VGND VGND VPWR VPWR sky130_fd_sc_hd__fill_2
XFILLER_0_5_553 VGND VGND VPWR VPWR sky130_fd_sc_hd__decap_6
XFILLER_0_26_681 VGND VGND VPWR VPWR sky130_fd_sc_hd__decap_3
XFILLER_0_31_92 VGND VGND VPWR VPWR sky130_fd_sc_hd__fill_2
X_8364_ rf.registers\[20\]\[31\] net38 _4094_ VGND VGND VPWR VPWR _4129_ sky130_fd_sc_hd__mux2_1
XFILLER_0_5_597 VPWR VGND VPWR VGND sky130_ef_sc_hd__decap_12
X_5576_ _2016_ _2219_ _2220_ VGND VGND VPWR VPWR _2307_ sky130_fd_sc_hd__o21ai_1
X_4527_ _1309_ VGND VGND VPWR VPWR net84 sky130_fd_sc_hd__inv_2
X_7315_ _3572_ VGND VGND VPWR VPWR _0083_ sky130_fd_sc_hd__clkbuf_1
XFILLER_0_41_673 VGND VGND VPWR VPWR sky130_fd_sc_hd__decap_4
X_8295_ _4092_ VGND VGND VPWR VPWR _0543_ sky130_fd_sc_hd__clkbuf_1
X_4458_ rf.registers\[12\]\[9\] rf.registers\[13\]\[9\] rf.registers\[14\]\[9\] rf.registers\[15\]\[9\]
+ _1042_ _1044_ VGND VGND VPWR VPWR _1244_ sky130_fd_sc_hd__mux4_1
X_7246_ rf.registers\[19\]\[18\] _3315_ _3527_ VGND VGND VPWR VPWR _3536_ sky130_fd_sc_hd__mux2_1
XFILLER_0_40_194 VGND VGND VPWR VPWR sky130_fd_sc_hd__fill_2
XTAP_TAPCELL_ROW_113_1995 VGND VPWR sky130_fd_sc_hd__tapvpwrvgnd_1
X_7177_ _3499_ VGND VGND VPWR VPWR _0018_ sky130_fd_sc_hd__clkbuf_1
X_4389_ _1171_ _1175_ _1178_ _1156_ _1024_ VGND VGND VPWR VPWR _1179_ sky130_fd_sc_hd__a221o_1
X_6128_ _2358_ _2551_ _2834_ _2463_ _2835_ VGND VGND VPWR VPWR _2836_ sky130_fd_sc_hd__o221a_1
X_6059_ _2742_ _2759_ VGND VGND VPWR VPWR _2770_ sky130_fd_sc_hd__or2b_1
XFILLER_0_96_813 VPWR VGND VPWR VGND sky130_ef_sc_hd__decap_12
XFILLER_0_95_334 VGND VGND VPWR VPWR sky130_fd_sc_hd__fill_2
XFILLER_0_68_526 VGND VGND VPWR VPWR sky130_fd_sc_hd__decap_6
XTAP_TAPCELL_ROW_37_860 VGND VPWR sky130_fd_sc_hd__tapvpwrvgnd_1
XFILLER_0_138_447 VGND VGND VPWR VPWR sky130_fd_sc_hd__fill_1
XFILLER_0_95_389 VGND VGND VPWR VPWR sky130_fd_sc_hd__decap_3
XFILLER_0_76_581 VGND VGND VPWR VPWR sky130_fd_sc_hd__decap_6
XFILLER_0_134_631 VPWR VGND VPWR VGND sky130_ef_sc_hd__decap_12
XPHY_EDGE_ROW_101_Left_240 VGND VGND VPWR VPWR sky130_fd_sc_hd__decap_3
XFILLER_0_63_253 VGND VGND VPWR VPWR sky130_fd_sc_hd__decap_4
XFILLER_0_17_670 VGND VGND VPWR VPWR sky130_fd_sc_hd__fill_2
XFILLER_0_122_837 VGND VGND VPWR VPWR sky130_fd_sc_hd__fill_2
XFILLER_0_32_640 VGND VGND VPWR VPWR sky130_fd_sc_hd__decap_4
XTAP_TAPCELL_ROW_75_1423 VGND VPWR sky130_fd_sc_hd__tapvpwrvgnd_1
XFILLER_0_20_813 VPWR VGND VPWR VGND sky130_ef_sc_hd__decap_12
XFILLER_0_32_695 VGND VGND VPWR VPWR sky130_fd_sc_hd__decap_4
XFILLER_0_36_15 VPWR VGND VPWR VGND sky130_ef_sc_hd__decap_12
XFILLER_0_99_673 VPWR VGND VPWR VGND sky130_ef_sc_hd__decap_12
XTAP_TAPCELL_ROW_35_819 VGND VPWR sky130_fd_sc_hd__tapvpwrvgnd_1
XFILLER_0_129_425 VGND VGND VPWR VPWR sky130_fd_sc_hd__decap_3
XTAP_TAPCELL_ROW_86_1596 VGND VPWR sky130_fd_sc_hd__tapvpwrvgnd_1
XTAP_TAPCELL_ROW_86_1585 VGND VPWR sky130_fd_sc_hd__tapvpwrvgnd_1
XFILLER_0_59_559 VGND VGND VPWR VPWR sky130_fd_sc_hd__fill_1
XFILLER_0_129_447 VGND VGND VPWR VPWR sky130_fd_sc_hd__fill_1
XFILLER_0_55_721 VGND VGND VPWR VPWR sky130_fd_sc_hd__decap_6
XTAP_TAPCELL_ROW_15_521 VGND VPWR sky130_fd_sc_hd__tapvpwrvgnd_1
XTAP_TAPCELL_ROW_15_532 VGND VPWR sky130_fd_sc_hd__tapvpwrvgnd_1
XFILLER_0_82_562 VGND VGND VPWR VPWR sky130_fd_sc_hd__fill_2
XFILLER_0_70_713 VPWR VGND VPWR VGND sky130_ef_sc_hd__decap_12
XFILLER_0_55_765 VPWR VGND VPWR VGND sky130_ef_sc_hd__decap_12
XFILLER_0_54_253 VGND VGND VPWR VPWR sky130_fd_sc_hd__fill_1
XFILLER_0_125_664 VGND VGND VPWR VPWR sky130_fd_sc_hd__decap_8
XFILLER_0_124_141 VPWR VGND VPWR VGND sky130_ef_sc_hd__decap_12
XTAP_TAPCELL_ROW_117_2051 VGND VPWR sky130_fd_sc_hd__tapvpwrvgnd_1
XFILLER_0_15_629 VGND VGND VPWR VPWR sky130_fd_sc_hd__decap_4
X_5430_ _1950_ _2163_ _1940_ VGND VGND VPWR VPWR _2164_ sky130_fd_sc_hd__o21ai_1
XFILLER_0_125_697 VPWR VGND VPWR VGND sky130_ef_sc_hd__decap_12
XTAP_TAPCELL_ROW_117_2062 VGND VPWR sky130_fd_sc_hd__tapvpwrvgnd_1
XFILLER_0_70_757 VPWR VGND VPWR VGND sky130_ef_sc_hd__decap_12
XFILLER_0_2_501 VPWR VGND VPWR VGND sky130_ef_sc_hd__decap_12
XFILLER_0_14_139 VGND VGND VPWR VPWR sky130_fd_sc_hd__fill_1
XFILLER_0_10_301 VGND VGND VPWR VPWR sky130_fd_sc_hd__decap_6
XFILLER_0_2_545 VPWR VGND VPWR VGND sky130_ef_sc_hd__decap_12
XFILLER_0_23_673 VGND VGND VPWR VPWR sky130_fd_sc_hd__fill_2
X_5361_ _2093_ _2095_ _2098_ _1948_ _1728_ VGND VGND VPWR VPWR _2099_ sky130_fd_sc_hd__o221a_1
XTAP_TAPCELL_ROW_130_2251 VGND VPWR sky130_fd_sc_hd__tapvpwrvgnd_1
X_4312_ _1061_ _1103_ VGND VGND VPWR VPWR _1104_ sky130_fd_sc_hd__nand2_1
X_7100_ rf.registers\[5\]\[13\] _3305_ _3455_ VGND VGND VPWR VPWR _3459_ sky130_fd_sc_hd__mux2_1
XFILLER_0_77_55 VGND VGND VPWR VPWR sky130_fd_sc_hd__fill_1
XFILLER_0_2_589 VPWR VGND VPWR VGND sky130_ef_sc_hd__decap_12
X_8080_ rf.registers\[7\]\[25\] _3330_ _3973_ VGND VGND VPWR VPWR _3979_ sky130_fd_sc_hd__mux2_1
X_5292_ rf.registers\[24\]\[22\] rf.registers\[25\]\[22\] rf.registers\[26\]\[22\]
+ rf.registers\[27\]\[22\] _1730_ _1732_ VGND VGND VPWR VPWR _2033_ sky130_fd_sc_hd__mux4_1
X_4243_ rf.registers\[24\]\[0\] rf.registers\[25\]\[0\] rf.registers\[26\]\[0\] rf.registers\[27\]\[0\]
+ _1035_ _1036_ VGND VGND VPWR VPWR _1038_ sky130_fd_sc_hd__mux4_1
X_7031_ _3422_ VGND VGND VPWR VPWR _0973_ sky130_fd_sc_hd__clkbuf_1
XFILLER_0_10_345 VPWR VGND VPWR VGND sky130_ef_sc_hd__decap_12
XFILLER_0_10_389 VPWR VGND VPWR VGND sky130_ef_sc_hd__decap_12
X_8982_ clknet_leaf_51_CLK _0070_ VGND VGND VPWR VPWR rf.registers\[3\]\[5\] sky130_fd_sc_hd__dfxtp_1
XFILLER_0_78_813 VPWR VGND VPWR VGND sky130_ef_sc_hd__decap_12
X_7933_ _3878_ VGND VGND VPWR VPWR _3901_ sky130_fd_sc_hd__clkbuf_8
X_7864_ _3841_ VGND VGND VPWR VPWR _3864_ sky130_fd_sc_hd__buf_4
X_6815_ _3281_ VGND VGND VPWR VPWR _0898_ sky130_fd_sc_hd__clkbuf_1
X_7795_ _3827_ VGND VGND VPWR VPWR _0308_ sky130_fd_sc_hd__clkbuf_1
XFILLER_0_9_111 VGND VGND VPWR VPWR sky130_fd_sc_hd__fill_1
XFILLER_0_135_417 VPWR VGND VPWR VGND sky130_ef_sc_hd__decap_12
XFILLER_0_133_93 VPWR VGND VPWR VGND sky130_ef_sc_hd__decap_12
X_6746_ rf.registers\[0\]\[2\] _2991_ _3241_ VGND VGND VPWR VPWR _3244_ sky130_fd_sc_hd__mux2_1
X_9534_ clknet_leaf_29_CLK _0622_ VGND VGND VPWR VPWR rf.registers\[14\]\[13\] sky130_fd_sc_hd__dfxtp_1
XFILLER_0_46_721 VGND VGND VPWR VPWR sky130_fd_sc_hd__decap_8
X_6677_ _3207_ VGND VGND VPWR VPWR _0834_ sky130_fd_sc_hd__clkbuf_1
X_9465_ clknet_leaf_36_CLK _0553_ VGND VGND VPWR VPWR rf.registers\[20\]\[8\] sky130_fd_sc_hd__dfxtp_1
XFILLER_0_18_489 VPWR VGND VPWR VGND sky130_ef_sc_hd__decap_12
XFILLER_0_131_612 VGND VGND VPWR VPWR sky130_fd_sc_hd__decap_4
X_9396_ clknet_leaf_38_CLK _0484_ VGND VGND VPWR VPWR rf.registers\[21\]\[3\] sky130_fd_sc_hd__dfxtp_1
XFILLER_0_116_686 VPWR VGND VPWR VGND sky130_ef_sc_hd__decap_12
XFILLER_0_104_837 VGND VGND VPWR VPWR sky130_fd_sc_hd__fill_2
X_5628_ _2266_ VGND VGND VPWR VPWR _2358_ sky130_fd_sc_hd__buf_4
XFILLER_0_5_361 VPWR VGND VPWR VGND sky130_ef_sc_hd__decap_12
X_8416_ rf.registers\[18\]\[23\] net29 _4153_ VGND VGND VPWR VPWR _4157_ sky130_fd_sc_hd__mux2_1
XFILLER_0_131_645 VPWR VGND VPWR VGND sky130_ef_sc_hd__decap_12
XFILLER_0_130_133 VGND VGND VPWR VPWR sky130_fd_sc_hd__decap_6
XFILLER_0_13_161 VGND VGND VPWR VPWR sky130_fd_sc_hd__decap_6
X_5559_ _2179_ _2206_ VGND VGND VPWR VPWR _2290_ sky130_fd_sc_hd__or2_1
XFILLER_0_41_470 VGND VGND VPWR VPWR sky130_fd_sc_hd__decap_4
X_8347_ _4120_ VGND VGND VPWR VPWR _0567_ sky130_fd_sc_hd__clkbuf_1
XFILLER_0_130_177 VPWR VGND VPWR VGND sky130_ef_sc_hd__decap_12
XTAP_TAPCELL_ROW_57_1153 VGND VPWR sky130_fd_sc_hd__tapvpwrvgnd_1
X_8278_ _3033_ rf.registers\[25\]\[22\] _4081_ VGND VGND VPWR VPWR _4084_ sky130_fd_sc_hd__mux2_1
X_7229_ _3515_ VGND VGND VPWR VPWR _3527_ sky130_fd_sc_hd__clkbuf_8
XTAP_TAPCELL_ROW_70_1353 VGND VPWR sky130_fd_sc_hd__tapvpwrvgnd_1
XFILLER_0_84_805 VGND VGND VPWR VPWR sky130_fd_sc_hd__decap_6
XFILLER_0_68_378 VGND VGND VPWR VPWR sky130_fd_sc_hd__decap_4
XFILLER_0_138_277 VGND VGND VPWR VPWR sky130_fd_sc_hd__decap_3
XFILLER_0_37_754 VPWR VGND VPWR VGND sky130_ef_sc_hd__decap_12
XFILLER_0_64_573 VGND VGND VPWR VPWR sky130_fd_sc_hd__fill_2
XFILLER_0_52_713 VPWR VGND VPWR VGND sky130_ef_sc_hd__decap_12
XFILLER_0_134_472 VGND VGND VPWR VPWR sky130_fd_sc_hd__decap_4
XFILLER_0_134_461 VGND VGND VPWR VPWR sky130_fd_sc_hd__fill_2
XFILLER_0_107_697 VPWR VGND VPWR VGND sky130_ef_sc_hd__decap_12
XFILLER_0_52_757 VPWR VGND VPWR VGND sky130_ef_sc_hd__decap_12
XTAP_TAPCELL_ROW_40_899 VGND VPWR sky130_fd_sc_hd__tapvpwrvgnd_1
XFILLER_0_121_111 VGND VGND VPWR VPWR sky130_fd_sc_hd__fill_1
Xclkbuf_0_CLK CLK VGND VGND VPWR VPWR clknet_0_CLK sky130_fd_sc_hd__clkbuf_16
XFILLER_0_20_643 VGND VGND VPWR VPWR sky130_fd_sc_hd__fill_1
XFILLER_0_138_27 VGND VGND VPWR VPWR sky130_fd_sc_hd__fill_1
XTAP_TAPCELL_ROW_88_1625 VGND VPWR sky130_fd_sc_hd__tapvpwrvgnd_1
XTAP_TAPCELL_ROW_88_1614 VGND VPWR sky130_fd_sc_hd__tapvpwrvgnd_1
XFILLER_0_63_13 VPWR VGND VPWR VGND sky130_ef_sc_hd__decap_12
XFILLER_0_2_27 VGND VGND VPWR VPWR sky130_fd_sc_hd__fill_1
XFILLER_0_63_57 VGND VGND VPWR VPWR sky130_fd_sc_hd__decap_3
X_4930_ rf.registers\[24\]\[3\] rf.registers\[25\]\[3\] rf.registers\[26\]\[3\] rf.registers\[27\]\[3\]
+ _1684_ _1685_ VGND VGND VPWR VPWR _1690_ sky130_fd_sc_hd__mux4_1
X_4861_ net1 VGND VGND VPWR VPWR _1624_ sky130_fd_sc_hd__buf_4
XFILLER_0_74_304 VGND VGND VPWR VPWR sky130_fd_sc_hd__decap_4
XFILLER_0_47_518 VGND VGND VPWR VPWR sky130_fd_sc_hd__fill_1
X_6600_ rf.registers\[1\]\[31\] _3051_ _3130_ VGND VGND VPWR VPWR _3165_ sky130_fd_sc_hd__mux2_1
XFILLER_0_28_732 VGND VGND VPWR VPWR sky130_fd_sc_hd__fill_1
XPHY_EDGE_ROW_120_Right_120 VGND VGND VPWR VPWR sky130_fd_sc_hd__decap_3
X_7580_ _3713_ VGND VGND VPWR VPWR _0207_ sky130_fd_sc_hd__clkbuf_1
XANTENNA_16 net122 VGND VGND VPWR VPWR sky130_fd_sc_hd__diode_2
X_4792_ _1557_ _1558_ _1298_ VGND VGND VPWR VPWR _1559_ sky130_fd_sc_hd__mux2_1
XFILLER_0_82_381 VPWR VGND VPWR VGND sky130_ef_sc_hd__decap_12
X_6531_ rf.registers\[17\]\[31\] _3051_ _3093_ VGND VGND VPWR VPWR _3128_ sky130_fd_sc_hd__mux2_1
XFILLER_0_27_264 VPWR VGND VPWR VGND sky130_ef_sc_hd__decap_12
XFILLER_0_28_798 VPWR VGND VPWR VGND sky130_ef_sc_hd__decap_12
XTAP_TAPCELL_ROW_99_1787 VGND VPWR sky130_fd_sc_hd__tapvpwrvgnd_1
X_6462_ _3090_ VGND VGND VPWR VPWR _0736_ sky130_fd_sc_hd__clkbuf_1
X_9250_ clknet_leaf_9_CLK _0338_ VGND VGND VPWR VPWR rf.registers\[28\]\[17\] sky130_fd_sc_hd__dfxtp_1
XFILLER_0_12_83 VGND VGND VPWR VPWR sky130_fd_sc_hd__fill_1
XFILLER_0_3_821 VPWR VGND VPWR VGND sky130_ef_sc_hd__decap_12
XFILLER_0_113_656 VGND VGND VPWR VPWR sky130_fd_sc_hd__fill_1
XFILLER_0_112_133 VGND VGND VPWR VPWR sky130_fd_sc_hd__decap_6
X_9181_ clknet_leaf_25_CLK _0269_ VGND VGND VPWR VPWR rf.registers\[30\]\[12\] sky130_fd_sc_hd__dfxtp_1
Xoutput101 net101 VGND VGND VPWR VPWR RD2[28] sky130_fd_sc_hd__buf_1
X_8201_ _3384_ rf.registers\[21\]\[18\] _4034_ VGND VGND VPWR VPWR _4043_ sky130_fd_sc_hd__mux2_1
X_6393_ net13 net11 net12 VGND VGND VPWR VPWR _3053_ sky130_fd_sc_hd__or3b_4
X_5413_ _1950_ _2147_ _1940_ VGND VGND VPWR VPWR _2148_ sky130_fd_sc_hd__o21ai_1
Xoutput112 net112 VGND VGND VPWR VPWR RD2[9] sky130_fd_sc_hd__buf_1
X_8132_ _4006_ VGND VGND VPWR VPWR _0466_ sky130_fd_sc_hd__clkbuf_1
XFILLER_0_11_643 VGND VGND VPWR VPWR sky130_fd_sc_hd__decap_4
XFILLER_0_11_632 VGND VGND VPWR VPWR sky130_fd_sc_hd__decap_6
Xoutput134 net134 VGND VGND VPWR VPWR alu_result[29] sky130_fd_sc_hd__buf_1
Xoutput123 net123 VGND VGND VPWR VPWR alu_result[19] sky130_fd_sc_hd__buf_1
X_5344_ _1950_ _2082_ _1940_ VGND VGND VPWR VPWR _2083_ sky130_fd_sc_hd__o21ai_1
XFILLER_0_11_665 VGND VGND VPWR VPWR sky130_fd_sc_hd__decap_6
XFILLER_0_10_153 VPWR VGND VPWR VGND sky130_ef_sc_hd__decap_12
X_8063_ rf.registers\[7\]\[17\] _3313_ _3962_ VGND VGND VPWR VPWR _3970_ sky130_fd_sc_hd__mux2_1
X_5275_ rf.registers\[20\]\[21\] rf.registers\[21\]\[21\] rf.registers\[22\]\[21\]
+ rf.registers\[23\]\[21\] _1919_ _1920_ VGND VGND VPWR VPWR _2017_ sky130_fd_sc_hd__mux4_1
XTAP_TAPCELL_ROW_110_1954 VGND VPWR sky130_fd_sc_hd__tapvpwrvgnd_1
XTAP_TAPCELL_ROW_110_1943 VGND VPWR sky130_fd_sc_hd__tapvpwrvgnd_1
X_7014_ _3413_ VGND VGND VPWR VPWR _0965_ sky130_fd_sc_hd__clkbuf_1
XFILLER_0_49_3 VPWR VGND VPWR VGND sky130_ef_sc_hd__decap_12
XFILLER_0_10_197 VPWR VGND VPWR VGND sky130_ef_sc_hd__decap_12
XTAP_TAPCELL_ROW_52_1083 VGND VPWR sky130_fd_sc_hd__tapvpwrvgnd_1
X_8965_ clknet_leaf_82_CLK _0053_ VGND VGND VPWR VPWR rf.registers\[19\]\[20\] sky130_fd_sc_hd__dfxtp_1
X_7916_ _3892_ VGND VGND VPWR VPWR _0364_ sky130_fd_sc_hd__clkbuf_1
X_8896_ clknet_leaf_16_CLK _1008_ VGND VGND VPWR VPWR rf.registers\[5\]\[15\] sky130_fd_sc_hd__dfxtp_1
XFILLER_0_66_805 VGND VGND VPWR VPWR sky130_fd_sc_hd__decap_6
X_7847_ _3855_ VGND VGND VPWR VPWR _0332_ sky130_fd_sc_hd__clkbuf_1
XFILLER_0_77_164 VGND VGND VPWR VPWR sky130_fd_sc_hd__decap_4
XFILLER_0_92_112 VGND VGND VPWR VPWR sky130_fd_sc_hd__decap_4
XFILLER_0_65_337 VGND VGND VPWR VPWR sky130_fd_sc_hd__fill_2
XFILLER_0_19_721 VGND VGND VPWR VPWR sky130_fd_sc_hd__decap_6
XFILLER_0_136_737 VPWR VGND VPWR VGND sky130_ef_sc_hd__decap_12
XFILLER_0_135_225 VPWR VGND VPWR VGND sky130_ef_sc_hd__decap_12
X_7778_ rf.registers\[9\]\[11\] _3301_ _3817_ VGND VGND VPWR VPWR _3819_ sky130_fd_sc_hd__mux2_1
XFILLER_0_18_253 VGND VGND VPWR VPWR sky130_fd_sc_hd__decap_8
XFILLER_0_46_551 VGND VGND VPWR VPWR sky130_fd_sc_hd__decap_6
XFILLER_0_80_329 VGND VGND VPWR VPWR sky130_fd_sc_hd__decap_3
X_6729_ _3234_ VGND VGND VPWR VPWR _0859_ sky130_fd_sc_hd__clkbuf_1
X_9517_ clknet_leaf_93_CLK _0605_ VGND VGND VPWR VPWR rf.registers\[18\]\[28\] sky130_fd_sc_hd__dfxtp_1
XFILLER_0_34_713 VPWR VGND VPWR VGND sky130_ef_sc_hd__decap_12
X_9448_ clknet_leaf_2_CLK _0536_ VGND VGND VPWR VPWR rf.registers\[25\]\[23\] sky130_fd_sc_hd__dfxtp_1
XFILLER_0_6_670 VPWR VGND VPWR VGND sky130_ef_sc_hd__decap_12
XFILLER_0_34_779 VGND VGND VPWR VPWR sky130_fd_sc_hd__fill_1
XFILLER_0_104_645 VGND VGND VPWR VPWR sky130_fd_sc_hd__fill_1
XFILLER_0_104_634 VGND VGND VPWR VPWR sky130_fd_sc_hd__decap_8
X_9379_ clknet_leaf_4_CLK _0467_ VGND VGND VPWR VPWR rf.registers\[26\]\[18\] sky130_fd_sc_hd__dfxtp_1
XTAP_TAPCELL_ROW_6_385 VGND VPWR sky130_fd_sc_hd__tapvpwrvgnd_1
XTAP_TAPCELL_ROW_6_396 VGND VPWR sky130_fd_sc_hd__tapvpwrvgnd_1
XFILLER_0_17_39 VPWR VGND VPWR VGND sky130_ef_sc_hd__decap_12
XFILLER_0_124_29 VPWR VGND VPWR VGND sky130_ef_sc_hd__decap_12
XTAP_TAPCELL_ROW_83_1544 VGND VPWR sky130_fd_sc_hd__tapvpwrvgnd_1
XFILLER_0_56_304 VGND VGND VPWR VPWR sky130_fd_sc_hd__fill_1
XFILLER_0_33_27 VPWR VGND VPWR VGND sky130_ef_sc_hd__decap_12
XTAP_TAPCELL_ROW_45_969 VGND VPWR sky130_fd_sc_hd__tapvpwrvgnd_1
XTAP_TAPCELL_ROW_25_671 VGND VPWR sky130_fd_sc_hd__tapvpwrvgnd_1
XTAP_TAPCELL_ROW_25_682 VGND VPWR sky130_fd_sc_hd__tapvpwrvgnd_1
XFILLER_0_25_713 VGND VGND VPWR VPWR sky130_fd_sc_hd__decap_6
Xinput14 WD3[0] VGND VGND VPWR VPWR net14 sky130_fd_sc_hd__buf_2
Xinput25 WD3[1] VGND VGND VPWR VPWR net25 sky130_fd_sc_hd__buf_2
Xinput36 WD3[2] VGND VGND VPWR VPWR net36 sky130_fd_sc_hd__buf_2
XTAP_TAPCELL_ROW_114_2010 VGND VPWR sky130_fd_sc_hd__tapvpwrvgnd_1
Xinput47 alu_opcode[0] VGND VGND VPWR VPWR net47 sky130_fd_sc_hd__clkbuf_4
XFILLER_0_52_598 VPWR VGND VPWR VGND sky130_ef_sc_hd__decap_12
XFILLER_0_0_802 VGND VGND VPWR VPWR sky130_fd_sc_hd__decap_8
XFILLER_0_0_813 VGND VGND VPWR VPWR sky130_fd_sc_hd__fill_1
XFILLER_0_110_648 VGND VGND VPWR VPWR sky130_fd_sc_hd__fill_1
X_5060_ rf.registers\[20\]\[9\] rf.registers\[21\]\[9\] rf.registers\[22\]\[9\] rf.registers\[23\]\[9\]
+ _1749_ _1750_ VGND VGND VPWR VPWR _1814_ sky130_fd_sc_hd__mux4_1
XTAP_TAPCELL_ROW_125_2172 VGND VPWR sky130_fd_sc_hd__tapvpwrvgnd_1
X_8750_ clknet_leaf_88_CLK _0862_ VGND VGND VPWR VPWR rf.registers\[10\]\[29\] sky130_fd_sc_hd__dfxtp_1
X_5962_ _2655_ _2670_ _2678_ VGND VGND VPWR VPWR _2679_ sky130_fd_sc_hd__a21bo_1
X_4913_ rf.registers\[4\]\[2\] rf.registers\[5\]\[2\] rf.registers\[6\]\[2\] rf.registers\[7\]\[2\]
+ _1624_ _1625_ VGND VGND VPWR VPWR _1674_ sky130_fd_sc_hd__mux4_1
X_7701_ _3361_ rf.registers\[30\]\[7\] _3770_ VGND VGND VPWR VPWR _3778_ sky130_fd_sc_hd__mux2_1
XFILLER_0_48_805 VGND VGND VPWR VPWR sky130_fd_sc_hd__decap_6
XFILLER_0_74_112 VGND VGND VPWR VPWR sky130_fd_sc_hd__fill_1
X_5893_ _2612_ _2613_ VGND VGND VPWR VPWR _2614_ sky130_fd_sc_hd__nor2_1
X_8681_ clknet_leaf_68_CLK _0793_ VGND VGND VPWR VPWR rf.registers\[1\]\[24\] sky130_fd_sc_hd__dfxtp_1
XFILLER_0_47_337 VGND VGND VPWR VPWR sky130_fd_sc_hd__decap_4
XFILLER_0_118_737 VPWR VGND VPWR VGND sky130_ef_sc_hd__decap_12
XFILLER_0_117_225 VPWR VGND VPWR VGND sky130_ef_sc_hd__decap_12
X_7632_ rf.registers\[2\]\[7\] _3292_ _3733_ VGND VGND VPWR VPWR _3741_ sky130_fd_sc_hd__mux2_1
XFILLER_0_74_134 VGND VGND VPWR VPWR sky130_fd_sc_hd__decap_6
XFILLER_0_62_307 VGND VGND VPWR VPWR sky130_fd_sc_hd__fill_1
X_4844_ rf.registers\[12\]\[31\] rf.registers\[13\]\[31\] rf.registers\[14\]\[31\]
+ rf.registers\[15\]\[31\] _1191_ _1192_ VGND VGND VPWR VPWR _1608_ sky130_fd_sc_hd__mux4_1
XFILLER_0_99_31 VPWR VGND VPWR VGND sky130_ef_sc_hd__decap_12
X_7563_ _3704_ VGND VGND VPWR VPWR _0199_ sky130_fd_sc_hd__clkbuf_1
X_4775_ rf.registers\[24\]\[27\] rf.registers\[25\]\[27\] rf.registers\[26\]\[27\]
+ rf.registers\[27\]\[27\] _1120_ _1123_ VGND VGND VPWR VPWR _1543_ sky130_fd_sc_hd__mux4_1
XFILLER_0_28_584 VGND VGND VPWR VPWR sky130_fd_sc_hd__decap_4
XFILLER_0_28_595 VGND VGND VPWR VPWR sky130_fd_sc_hd__fill_1
XFILLER_0_133_729 VPWR VGND VPWR VGND sky130_ef_sc_hd__decap_12
XFILLER_0_126_781 VPWR VGND VPWR VGND sky130_ef_sc_hd__decap_12
X_9302_ clknet_leaf_59_CLK _0390_ VGND VGND VPWR VPWR rf.registers\[22\]\[5\] sky130_fd_sc_hd__dfxtp_1
XFILLER_0_71_841 VGND VGND VPWR VPWR sky130_fd_sc_hd__fill_1
XFILLER_0_15_223 VGND VGND VPWR VPWR sky130_fd_sc_hd__fill_1
XFILLER_0_16_757 VGND VGND VPWR VPWR sky130_fd_sc_hd__decap_4
X_6514_ _3119_ VGND VGND VPWR VPWR _0759_ sky130_fd_sc_hd__clkbuf_1
X_9233_ clknet_leaf_39_CLK _0321_ VGND VGND VPWR VPWR rf.registers\[28\]\[0\] sky130_fd_sc_hd__dfxtp_1
X_7494_ _3359_ rf.registers\[31\]\[6\] _3661_ VGND VGND VPWR VPWR _3668_ sky130_fd_sc_hd__mux2_1
XFILLER_0_70_362 VGND VGND VPWR VPWR sky130_fd_sc_hd__fill_2
XFILLER_0_31_727 VGND VGND VPWR VPWR sky130_fd_sc_hd__fill_1
XFILLER_0_130_83 VGND VGND VPWR VPWR sky130_fd_sc_hd__fill_1
X_6445_ rf.registers\[11\]\[23\] _3035_ _3078_ VGND VGND VPWR VPWR _3082_ sky130_fd_sc_hd__mux2_1
XFILLER_0_3_673 VPWR VGND VPWR VGND sky130_ef_sc_hd__decap_12
X_6376_ rf.registers\[12\]\[26\] _3041_ _3029_ VGND VGND VPWR VPWR _3042_ sky130_fd_sc_hd__mux2_1
X_9164_ clknet_leaf_89_CLK _0252_ VGND VGND VPWR VPWR rf.registers\[2\]\[27\] sky130_fd_sc_hd__dfxtp_1
XFILLER_0_30_248 VGND VGND VPWR VPWR sky130_fd_sc_hd__decap_4
X_8115_ _3997_ VGND VGND VPWR VPWR _0458_ sky130_fd_sc_hd__clkbuf_1
XTAP_TAPCELL_ROW_54_1112 VGND VPWR sky130_fd_sc_hd__tapvpwrvgnd_1
XFILLER_0_11_473 VPWR VGND VPWR VGND sky130_ef_sc_hd__decap_12
X_5327_ rf.registers\[28\]\[24\] rf.registers\[29\]\[24\] rf.registers\[30\]\[24\]
+ rf.registers\[31\]\[24\] _1999_ _2000_ VGND VGND VPWR VPWR _2066_ sky130_fd_sc_hd__mux4_1
X_9095_ clknet_leaf_94_CLK _0183_ VGND VGND VPWR VPWR rf.registers\[31\]\[22\] sky130_fd_sc_hd__dfxtp_1
X_8046_ rf.registers\[7\]\[9\] _3296_ _3951_ VGND VGND VPWR VPWR _3961_ sky130_fd_sc_hd__mux2_1
X_5258_ rf.registers\[24\]\[20\] rf.registers\[25\]\[20\] rf.registers\[26\]\[20\]
+ rf.registers\[27\]\[20\] _1999_ _2000_ VGND VGND VPWR VPWR _2001_ sky130_fd_sc_hd__mux4_1
X_5189_ rf.registers\[0\]\[16\] rf.registers\[1\]\[16\] rf.registers\[2\]\[16\] rf.registers\[3\]\[16\]
+ _1730_ _1732_ VGND VGND VPWR VPWR _1936_ sky130_fd_sc_hd__mux4_1
XTAP_TAPCELL_ROW_3_344 VGND VPWR sky130_fd_sc_hd__tapvpwrvgnd_1
XFILLER_0_98_749 VGND VGND VPWR VPWR sky130_fd_sc_hd__decap_6
XFILLER_0_3_81 VPWR VGND VPWR VGND sky130_ef_sc_hd__decap_12
X_8948_ clknet_leaf_38_CLK _0036_ VGND VGND VPWR VPWR rf.registers\[19\]\[3\] sky130_fd_sc_hd__dfxtp_1
XTAP_TAPCELL_ROW_65_1274 VGND VPWR sky130_fd_sc_hd__tapvpwrvgnd_1
X_8879_ clknet_leaf_74_CLK _0991_ VGND VGND VPWR VPWR rf.registers\[6\]\[30\] sky130_fd_sc_hd__dfxtp_1
XTAP_TAPCELL_ROW_42_928 VGND VPWR sky130_fd_sc_hd__tapvpwrvgnd_1
XFILLER_0_136_501 VPWR VGND VPWR VGND sky130_ef_sc_hd__decap_12
XFILLER_0_109_726 VGND VGND VPWR VPWR sky130_fd_sc_hd__fill_2
XFILLER_0_66_657 VPWR VGND VPWR VGND sky130_ef_sc_hd__decap_12
XFILLER_0_136_545 VPWR VGND VPWR VGND sky130_ef_sc_hd__decap_12
XFILLER_0_65_167 VGND VGND VPWR VPWR sky130_fd_sc_hd__fill_1
XFILLER_0_19_573 VGND VGND VPWR VPWR sky130_fd_sc_hd__decap_6
XTAP_TAPCELL_ROW_22_630 VGND VPWR sky130_fd_sc_hd__tapvpwrvgnd_1
XFILLER_0_136_589 VPWR VGND VPWR VGND sky130_ef_sc_hd__decap_12
XFILLER_0_123_217 VGND VGND VPWR VPWR sky130_fd_sc_hd__decap_6
XFILLER_0_80_126 VGND VGND VPWR VPWR sky130_fd_sc_hd__fill_1
XFILLER_0_104_431 VGND VGND VPWR VPWR sky130_fd_sc_hd__fill_2
XFILLER_0_61_362 VGND VGND VPWR VPWR sky130_fd_sc_hd__fill_1
XFILLER_0_104_453 VPWR VGND VPWR VGND sky130_ef_sc_hd__decap_12
XFILLER_0_131_261 VPWR VGND VPWR VGND sky130_ef_sc_hd__decap_12
XFILLER_0_28_27 VGND VGND VPWR VPWR sky130_fd_sc_hd__fill_1
XFILLER_0_89_727 VGND VGND VPWR VPWR sky130_fd_sc_hd__fill_1
XFILLER_0_44_15 VPWR VGND VPWR VGND sky130_ef_sc_hd__decap_12
XFILLER_0_57_613 VGND VGND VPWR VPWR sky130_fd_sc_hd__decap_3
XFILLER_0_29_304 VGND VGND VPWR VPWR sky130_fd_sc_hd__decap_3
XFILLER_0_84_421 VGND VGND VPWR VPWR sky130_fd_sc_hd__decap_4
XFILLER_0_8_209 VPWR VGND VPWR VGND sky130_ef_sc_hd__decap_12
XFILLER_0_127_545 VGND VGND VPWR VPWR sky130_fd_sc_hd__fill_1
XFILLER_0_60_69 VGND VGND VPWR VPWR sky130_fd_sc_hd__decap_6
XFILLER_0_56_189 VGND VGND VPWR VPWR sky130_fd_sc_hd__fill_2
XFILLER_0_115_729 VPWR VGND VPWR VGND sky130_ef_sc_hd__decap_12
X_4560_ rf.registers\[0\]\[14\] rf.registers\[1\]\[14\] rf.registers\[2\]\[14\] rf.registers\[3\]\[14\]
+ _1320_ _1321_ VGND VGND VPWR VPWR _1341_ sky130_fd_sc_hd__mux4_1
XFILLER_0_53_841 VGND VGND VPWR VPWR sky130_fd_sc_hd__fill_1
XFILLER_0_108_781 VPWR VGND VPWR VGND sky130_ef_sc_hd__decap_12
XTAP_TAPCELL_ROW_96_1735 VGND VPWR sky130_fd_sc_hd__tapvpwrvgnd_1
XFILLER_0_8_15 VPWR VGND VPWR VGND sky130_ef_sc_hd__decap_12
XFILLER_0_13_705 VGND VGND VPWR VPWR sky130_fd_sc_hd__fill_1
X_4491_ _1133_ _1274_ VGND VGND VPWR VPWR _1275_ sky130_fd_sc_hd__or2_1
XTAP_TAPCELL_ROW_96_1746 VGND VPWR sky130_fd_sc_hd__tapvpwrvgnd_1
XFILLER_0_13_749 VGND VGND VPWR VPWR sky130_fd_sc_hd__fill_1
XFILLER_0_110_412 VGND VGND VPWR VPWR sky130_fd_sc_hd__fill_1
XFILLER_0_100_53 VPWR VGND VPWR VGND sky130_ef_sc_hd__decap_12
X_6230_ _2930_ _2931_ VGND VGND VPWR VPWR _2932_ sky130_fd_sc_hd__and2_1
X_6161_ _2541_ _2861_ _2866_ VGND VGND VPWR VPWR net130 sky130_fd_sc_hd__o21ai_4
X_5112_ _1859_ _1862_ _1651_ VGND VGND VPWR VPWR _1863_ sky130_fd_sc_hd__mux2_1
XTAP_TAPCELL_ROW_127_2212 VGND VPWR sky130_fd_sc_hd__tapvpwrvgnd_1
XTAP_TAPCELL_ROW_127_2201 VGND VPWR sky130_fd_sc_hd__tapvpwrvgnd_1
XFILLER_0_85_55 VGND VGND VPWR VPWR sky130_fd_sc_hd__fill_1
X_6092_ _2799_ _2800_ _2237_ VGND VGND VPWR VPWR _2801_ sky130_fd_sc_hd__mux2_1
XFILLER_0_109_51 VGND VGND VPWR VPWR sky130_fd_sc_hd__decap_4
X_5043_ rf.registers\[16\]\[8\] rf.registers\[17\]\[8\] rf.registers\[18\]\[8\] rf.registers\[19\]\[8\]
+ _1734_ _1797_ VGND VGND VPWR VPWR _1798_ sky130_fd_sc_hd__mux4_1
XTAP_TAPCELL_ROW_0_303 VGND VPWR sky130_fd_sc_hd__tapvpwrvgnd_1
X_8802_ clknet_leaf_11_CLK _0914_ VGND VGND VPWR VPWR rf.registers\[16\]\[17\] sky130_fd_sc_hd__dfxtp_1
X_6994_ _2974_ rf.registers\[15\]\[28\] _3389_ VGND VGND VPWR VPWR _3402_ sky130_fd_sc_hd__mux2_1
XTAP_TAPCELL_ROW_105_1875 VGND VPWR sky130_fd_sc_hd__tapvpwrvgnd_1
X_8733_ clknet_leaf_18_CLK _0845_ VGND VGND VPWR VPWR rf.registers\[10\]\[12\] sky130_fd_sc_hd__dfxtp_1
XFILLER_0_88_793 VPWR VGND VPWR VGND sky130_ef_sc_hd__decap_12
X_5945_ _2660_ _2662_ _2236_ VGND VGND VPWR VPWR _2663_ sky130_fd_sc_hd__mux2_1
X_8664_ clknet_leaf_51_CLK _0776_ VGND VGND VPWR VPWR rf.registers\[1\]\[7\] sky130_fd_sc_hd__dfxtp_1
XFILLER_0_48_657 VGND VGND VPWR VPWR sky130_fd_sc_hd__fill_1
XFILLER_0_8_721 VPWR VGND VPWR VGND sky130_ef_sc_hd__decap_12
X_5876_ _2325_ _2459_ _2597_ _2386_ VGND VGND VPWR VPWR _2598_ sky130_fd_sc_hd__o22a_1
XFILLER_0_47_134 VGND VGND VPWR VPWR sky130_fd_sc_hd__fill_1
XFILLER_0_62_104 VGND VGND VPWR VPWR sky130_fd_sc_hd__fill_1
X_4827_ rf.registers\[0\]\[30\] rf.registers\[1\]\[30\] rf.registers\[2\]\[30\] rf.registers\[3\]\[30\]
+ _1198_ _1199_ VGND VGND VPWR VPWR _1592_ sky130_fd_sc_hd__mux4_1
X_7615_ _3731_ VGND VGND VPWR VPWR _0224_ sky130_fd_sc_hd__clkbuf_1
XFILLER_0_47_167 VGND VGND VPWR VPWR sky130_fd_sc_hd__fill_1
XTAP_TAPCELL_ROW_138_2374 VGND VPWR sky130_fd_sc_hd__tapvpwrvgnd_1
XTAP_TAPCELL_ROW_138_2363 VGND VPWR sky130_fd_sc_hd__tapvpwrvgnd_1
X_8595_ clknet_leaf_45_CLK _0707_ VGND VGND VPWR VPWR rf.registers\[11\]\[2\] sky130_fd_sc_hd__dfxtp_1
XTAP_TAPCELL_ROW_138_2385 VGND VPWR sky130_fd_sc_hd__tapvpwrvgnd_1
X_7546_ _2980_ rf.registers\[31\]\[31\] _3660_ VGND VGND VPWR VPWR _3695_ sky130_fd_sc_hd__mux2_1
XTAP_TAPCELL_ROW_60_1193 VGND VPWR sky130_fd_sc_hd__tapvpwrvgnd_1
X_4758_ rf.registers\[24\]\[26\] rf.registers\[25\]\[26\] rf.registers\[26\]\[26\]
+ rf.registers\[27\]\[26\] _1125_ _1128_ VGND VGND VPWR VPWR _1527_ sky130_fd_sc_hd__mux4_1
XFILLER_0_120_209 VPWR VGND VPWR VGND sky130_ef_sc_hd__decap_12
XFILLER_0_71_682 VPWR VGND VPWR VGND sky130_ef_sc_hd__decap_12
X_4689_ _1462_ VGND VGND VPWR VPWR net94 sky130_fd_sc_hd__inv_2
X_7477_ _3658_ VGND VGND VPWR VPWR _0159_ sky130_fd_sc_hd__clkbuf_1
XFILLER_0_16_587 VGND VGND VPWR VPWR sky130_fd_sc_hd__fill_1
XFILLER_0_31_535 VPWR VGND VPWR VGND sky130_ef_sc_hd__decap_12
X_6428_ rf.registers\[11\]\[15\] _3018_ _3067_ VGND VGND VPWR VPWR _3073_ sky130_fd_sc_hd__mux2_1
X_9216_ clknet_leaf_18_CLK _0304_ VGND VGND VPWR VPWR rf.registers\[9\]\[15\] sky130_fd_sc_hd__dfxtp_1
X_9147_ clknet_leaf_32_CLK _0235_ VGND VGND VPWR VPWR rf.registers\[2\]\[10\] sky130_fd_sc_hd__dfxtp_1
XTAP_TAPCELL_ROW_8_425 VGND VPWR sky130_fd_sc_hd__tapvpwrvgnd_1
XTAP_TAPCELL_ROW_8_414 VGND VPWR sky130_fd_sc_hd__tapvpwrvgnd_1
XFILLER_0_12_782 VPWR VGND VPWR VGND sky130_ef_sc_hd__decap_12
X_6359_ _3030_ VGND VGND VPWR VPWR _0693_ sky130_fd_sc_hd__clkbuf_1
XFILLER_0_11_281 VPWR VGND VPWR VGND sky130_ef_sc_hd__decap_12
X_9078_ clknet_leaf_31_CLK _0166_ VGND VGND VPWR VPWR rf.registers\[31\]\[5\] sky130_fd_sc_hd__dfxtp_1
X_8029_ _3952_ VGND VGND VPWR VPWR _0417_ sky130_fd_sc_hd__clkbuf_1
XTAP_TAPCELL_ROW_67_1303 VGND VPWR sky130_fd_sc_hd__tapvpwrvgnd_1
XTAP_TAPCELL_ROW_27_700 VGND VPWR sky130_fd_sc_hd__tapvpwrvgnd_1
XTAP_TAPCELL_ROW_27_711 VGND VPWR sky130_fd_sc_hd__tapvpwrvgnd_1
XFILLER_0_128_309 VPWR VGND VPWR VGND sky130_ef_sc_hd__decap_12
XTAP_TAPCELL_ROW_80_1503 VGND VPWR sky130_fd_sc_hd__tapvpwrvgnd_1
XFILLER_0_78_281 VPWR VGND VPWR VGND sky130_ef_sc_hd__decap_12
XFILLER_0_14_29 VPWR VGND VPWR VGND sky130_ef_sc_hd__decap_12
XFILLER_0_38_112 VGND VGND VPWR VPWR sky130_fd_sc_hd__fill_1
XFILLER_0_137_821 VPWR VGND VPWR VGND sky130_ef_sc_hd__decap_12
XFILLER_0_38_145 VGND VGND VPWR VPWR sky130_fd_sc_hd__fill_1
XFILLER_0_109_556 VGND VGND VPWR VPWR sky130_fd_sc_hd__decap_4
XFILLER_0_81_413 VGND VGND VPWR VPWR sky130_fd_sc_hd__decap_6
XFILLER_0_124_504 VGND VGND VPWR VPWR sky130_fd_sc_hd__fill_1
XFILLER_0_93_284 VGND VGND VPWR VPWR sky130_fd_sc_hd__fill_1
XFILLER_0_35_841 VGND VGND VPWR VPWR sky130_fd_sc_hd__fill_1
XFILLER_0_50_811 VGND VGND VPWR VPWR sky130_fd_sc_hd__fill_1
XFILLER_0_50_833 VGND VGND VPWR VPWR sky130_fd_sc_hd__fill_1
XTAP_TAPCELL_ROW_78_1476 VGND VPWR sky130_fd_sc_hd__tapvpwrvgnd_1
XTAP_TAPCELL_ROW_78_1465 VGND VPWR sky130_fd_sc_hd__tapvpwrvgnd_1
XFILLER_0_1_429 VPWR VGND VPWR VGND sky130_ef_sc_hd__decap_12
XTAP_TAPCELL_ROW_91_1665 VGND VPWR sky130_fd_sc_hd__tapvpwrvgnd_1
XFILLER_0_89_502 VGND VGND VPWR VPWR sky130_fd_sc_hd__fill_2
XTAP_TAPCELL_ROW_122_2131 VGND VPWR sky130_fd_sc_hd__tapvpwrvgnd_1
XFILLER_0_76_218 VGND VGND VPWR VPWR sky130_fd_sc_hd__fill_1
XFILLER_0_85_741 VPWR VGND VPWR VGND sky130_ef_sc_hd__decap_12
X_5730_ net103 _2313_ VGND VGND VPWR VPWR _2457_ sky130_fd_sc_hd__nor2_1
XFILLER_0_9_529 VPWR VGND VPWR VGND sky130_ef_sc_hd__decap_12
XFILLER_0_85_785 VPWR VGND VPWR VGND sky130_ef_sc_hd__decap_12
XFILLER_0_17_329 VGND VGND VPWR VPWR sky130_fd_sc_hd__decap_6
X_5661_ net48 VGND VGND VPWR VPWR _2391_ sky130_fd_sc_hd__clkinv_4
X_7400_ _3617_ VGND VGND VPWR VPWR _0123_ sky130_fd_sc_hd__clkbuf_1
XTAP_TAPCELL_ROW_100_1794 VGND VPWR sky130_fd_sc_hd__tapvpwrvgnd_1
X_8380_ rf.registers\[18\]\[6\] net42 _4131_ VGND VGND VPWR VPWR _4138_ sky130_fd_sc_hd__mux2_1
X_4612_ _1388_ _1389_ _1145_ VGND VGND VPWR VPWR _1390_ sky130_fd_sc_hd__mux2_1
X_5592_ _2269_ _2316_ _2252_ _2320_ _2322_ VGND VGND VPWR VPWR _2323_ sky130_fd_sc_hd__o221a_1
XTAP_TAPCELL_ROW_13_493 VGND VPWR sky130_fd_sc_hd__tapvpwrvgnd_1
X_4543_ rf.registers\[12\]\[13\] rf.registers\[13\]\[13\] rf.registers\[14\]\[13\]
+ rf.registers\[15\]\[13\] _1120_ _1123_ VGND VGND VPWR VPWR _1325_ sky130_fd_sc_hd__mux4_1
XFILLER_0_4_245 VGND VGND VPWR VPWR sky130_fd_sc_hd__decap_6
X_7331_ rf.registers\[3\]\[26\] _3332_ _3574_ VGND VGND VPWR VPWR _3581_ sky130_fd_sc_hd__mux2_1
XFILLER_0_41_833 VGND VGND VPWR VPWR sky130_fd_sc_hd__decap_6
XFILLER_0_111_721 VGND VGND VPWR VPWR sky130_fd_sc_hd__decap_6
XFILLER_0_4_289 VPWR VGND VPWR VGND sky130_ef_sc_hd__decap_12
XFILLER_0_20_83 VGND VGND VPWR VPWR sky130_fd_sc_hd__fill_1
X_7262_ _3544_ VGND VGND VPWR VPWR _0058_ sky130_fd_sc_hd__clkbuf_1
XTAP_TAPCELL_ROW_133_2293 VGND VPWR sky130_fd_sc_hd__tapvpwrvgnd_1
XFILLER_0_111_765 VPWR VGND VPWR VGND sky130_ef_sc_hd__decap_12
X_4474_ rf.registers\[12\]\[10\] rf.registers\[13\]\[10\] rf.registers\[14\]\[10\]
+ rf.registers\[15\]\[10\] _1146_ _1148_ VGND VGND VPWR VPWR _1259_ sky130_fd_sc_hd__mux4_1
X_6213_ _2912_ _2913_ _2915_ VGND VGND VPWR VPWR _2916_ sky130_fd_sc_hd__nor3_1
X_9001_ clknet_leaf_73_CLK _0089_ VGND VGND VPWR VPWR rf.registers\[3\]\[24\] sky130_fd_sc_hd__dfxtp_1
X_7193_ rf.registers\[4\]\[25\] _3330_ _3502_ VGND VGND VPWR VPWR _3508_ sky130_fd_sc_hd__mux2_1
X_6144_ _2203_ _2820_ _2479_ VGND VGND VPWR VPWR _2851_ sky130_fd_sc_hd__o21a_1
X_6075_ _1445_ _2200_ _2646_ _2709_ VGND VGND VPWR VPWR _2785_ sky130_fd_sc_hd__a31o_1
X_5026_ rf.registers\[28\]\[7\] rf.registers\[29\]\[7\] rf.registers\[30\]\[7\] rf.registers\[31\]\[7\]
+ _1655_ _1656_ VGND VGND VPWR VPWR _1782_ sky130_fd_sc_hd__mux4_1
XTAP_TAPCELL_ROW_107_1904 VGND VPWR sky130_fd_sc_hd__tapvpwrvgnd_1
XTAP_TAPCELL_ROW_49_1033 VGND VPWR sky130_fd_sc_hd__tapvpwrvgnd_1
X_6977_ _3391_ rf.registers\[15\]\[21\] _3389_ VGND VGND VPWR VPWR _3392_ sky130_fd_sc_hd__mux2_1
XFILLER_0_48_421 VGND VGND VPWR VPWR sky130_fd_sc_hd__fill_1
XFILLER_0_138_629 VPWR VGND VPWR VGND sky130_ef_sc_hd__decap_12
XFILLER_0_119_821 VPWR VGND VPWR VGND sky130_ef_sc_hd__decap_12
X_5928_ _2389_ _2646_ VGND VGND VPWR VPWR _2647_ sky130_fd_sc_hd__nor2_1
X_8716_ clknet_leaf_86_CLK _0828_ VGND VGND VPWR VPWR rf.registers\[24\]\[27\] sky130_fd_sc_hd__dfxtp_1
XTAP_TAPCELL_ROW_62_1233 VGND VPWR sky130_fd_sc_hd__tapvpwrvgnd_1
XFILLER_0_36_605 VPWR VGND VPWR VGND sky130_ef_sc_hd__decap_12
XFILLER_0_134_813 VPWR VGND VPWR VGND sky130_ef_sc_hd__decap_12
X_5859_ _2534_ _2544_ _2545_ VGND VGND VPWR VPWR _2582_ sky130_fd_sc_hd__a21oi_1
XFILLER_0_17_830 VGND VGND VPWR VPWR sky130_fd_sc_hd__decap_4
XFILLER_0_17_841 VGND VGND VPWR VPWR sky130_fd_sc_hd__fill_1
XFILLER_0_36_638 VGND VGND VPWR VPWR sky130_fd_sc_hd__decap_6
X_8647_ clknet_leaf_0_CLK _0759_ VGND VGND VPWR VPWR rf.registers\[17\]\[22\] sky130_fd_sc_hd__dfxtp_1
XFILLER_0_118_386 VGND VGND VPWR VPWR sky130_fd_sc_hd__fill_2
XFILLER_0_91_777 VGND VGND VPWR VPWR sky130_fd_sc_hd__decap_6
X_8578_ clknet_leaf_79_CLK _0690_ VGND VGND VPWR VPWR rf.registers\[12\]\[17\] sky130_fd_sc_hd__dfxtp_1
XTAP_TAPCELL_ROW_32_780 VGND VPWR sky130_fd_sc_hd__tapvpwrvgnd_1
XFILLER_0_32_833 VGND VGND VPWR VPWR sky130_fd_sc_hd__fill_1
X_7529_ _3686_ VGND VGND VPWR VPWR _0183_ sky130_fd_sc_hd__clkbuf_1
XFILLER_0_44_671 VGND VGND VPWR VPWR sky130_fd_sc_hd__decap_8
XFILLER_0_121_529 VGND VGND VPWR VPWR sky130_fd_sc_hd__fill_2
XFILLER_0_114_592 VGND VGND VPWR VPWR sky130_fd_sc_hd__fill_2
XTAP_TAPCELL_ROW_73_1395 VGND VPWR sky130_fd_sc_hd__tapvpwrvgnd_1
XFILLER_0_99_833 VGND VGND VPWR VPWR sky130_fd_sc_hd__decap_6
XFILLER_0_98_365 VGND VGND VPWR VPWR sky130_fd_sc_hd__decap_3
XFILLER_0_86_516 VGND VGND VPWR VPWR sky130_fd_sc_hd__decap_4
XFILLER_0_25_39 VGND VGND VPWR VPWR sky130_fd_sc_hd__decap_8
XFILLER_0_67_741 VPWR VGND VPWR VGND sky130_ef_sc_hd__decap_12
XFILLER_0_39_421 VGND VGND VPWR VPWR sky130_fd_sc_hd__fill_2
XFILLER_0_132_29 VPWR VGND VPWR VGND sky130_ef_sc_hd__decap_12
XFILLER_0_128_139 VGND VGND VPWR VPWR sky130_fd_sc_hd__fill_1
XFILLER_0_67_785 VPWR VGND VPWR VGND sky130_ef_sc_hd__decap_12
XFILLER_0_66_262 VGND VGND VPWR VPWR sky130_fd_sc_hd__decap_4
XFILLER_0_66_251 VGND VGND VPWR VPWR sky130_fd_sc_hd__fill_1
XFILLER_0_41_27 VPWR VGND VPWR VGND sky130_ef_sc_hd__decap_12
XFILLER_0_137_673 VPWR VGND VPWR VGND sky130_ef_sc_hd__decap_12
XFILLER_0_82_755 VGND VGND VPWR VPWR sky130_fd_sc_hd__fill_1
XFILLER_0_124_301 VGND VGND VPWR VPWR sky130_fd_sc_hd__decap_6
XFILLER_0_124_345 VPWR VGND VPWR VGND sky130_ef_sc_hd__decap_12
XFILLER_0_81_287 VGND VGND VPWR VPWR sky130_fd_sc_hd__decap_8
XTAP_TAPCELL_ROW_10_452 VGND VPWR sky130_fd_sc_hd__tapvpwrvgnd_1
XFILLER_0_23_833 VGND VGND VPWR VPWR sky130_fd_sc_hd__decap_6
XFILLER_0_50_641 VGND VGND VPWR VPWR sky130_fd_sc_hd__decap_3
XFILLER_0_2_749 VGND VGND VPWR VPWR sky130_fd_sc_hd__decap_6
XFILLER_0_50_685 VPWR VGND VPWR VGND sky130_ef_sc_hd__decap_12
XFILLER_0_1_237 VPWR VGND VPWR VGND sky130_ef_sc_hd__decap_12
XFILLER_0_5_27 VPWR VGND VPWR VGND sky130_ef_sc_hd__decap_12
XFILLER_0_89_332 VGND VGND VPWR VPWR sky130_fd_sc_hd__decap_4
X_7880_ _3872_ VGND VGND VPWR VPWR _0348_ sky130_fd_sc_hd__clkbuf_1
X_6900_ rf.registers\[16\]\[29\] _3338_ _3320_ VGND VGND VPWR VPWR _3339_ sky130_fd_sc_hd__mux2_1
XFILLER_0_106_41 VPWR VGND VPWR VGND sky130_ef_sc_hd__decap_12
X_6831_ net43 VGND VGND VPWR VPWR _3292_ sky130_fd_sc_hd__clkbuf_2
XFILLER_0_106_85 VGND VGND VPWR VPWR sky130_fd_sc_hd__fill_1
XTAP_TAPCELL_ROW_102_1823 VGND VPWR sky130_fd_sc_hd__tapvpwrvgnd_1
XTAP_TAPCELL_ROW_18_563 VGND VPWR sky130_fd_sc_hd__tapvpwrvgnd_1
XTAP_TAPCELL_ROW_18_574 VGND VPWR sky130_fd_sc_hd__tapvpwrvgnd_1
X_9550_ clknet_leaf_90_CLK _0638_ VGND VGND VPWR VPWR rf.registers\[14\]\[29\] sky130_fd_sc_hd__dfxtp_1
XTAP_TAPCELL_ROW_102_1834 VGND VPWR sky130_fd_sc_hd__tapvpwrvgnd_1
X_6762_ _3240_ VGND VGND VPWR VPWR _3252_ sky130_fd_sc_hd__buf_4
X_8501_ _4201_ VGND VGND VPWR VPWR _0640_ sky130_fd_sc_hd__clkbuf_1
XFILLER_0_9_337 VPWR VGND VPWR VGND sky130_ef_sc_hd__decap_12
XFILLER_0_18_616 VGND VGND VPWR VPWR sky130_fd_sc_hd__decap_3
XFILLER_0_134_109 VPWR VGND VPWR VGND sky130_ef_sc_hd__decap_12
XFILLER_0_116_813 VPWR VGND VPWR VGND sky130_ef_sc_hd__decap_12
X_6693_ _3215_ VGND VGND VPWR VPWR _0842_ sky130_fd_sc_hd__clkbuf_1
XFILLER_0_17_137 VPWR VGND VPWR VGND sky130_ef_sc_hd__decap_12
X_5713_ _2377_ _2382_ _2332_ VGND VGND VPWR VPWR _2441_ sky130_fd_sc_hd__mux2_1
X_9481_ clknet_leaf_72_CLK _0569_ VGND VGND VPWR VPWR rf.registers\[20\]\[24\] sky130_fd_sc_hd__dfxtp_1
XTAP_TAPCELL_ROW_135_2322 VGND VPWR sky130_fd_sc_hd__tapvpwrvgnd_1
XFILLER_0_127_161 VGND VGND VPWR VPWR sky130_fd_sc_hd__decap_6
XFILLER_0_73_777 VGND VGND VPWR VPWR sky130_fd_sc_hd__decap_6
X_8432_ rf.registers\[18\]\[31\] net38 _4130_ VGND VGND VPWR VPWR _4165_ sky130_fd_sc_hd__mux2_1
X_5644_ _2243_ _2273_ VGND VGND VPWR VPWR _2374_ sky130_fd_sc_hd__nand2_1
XFILLER_0_14_811 VGND VGND VPWR VPWR sky130_fd_sc_hd__fill_1
XFILLER_0_26_693 VGND VGND VPWR VPWR sky130_fd_sc_hd__decap_6
X_8363_ _4128_ VGND VGND VPWR VPWR _0575_ sky130_fd_sc_hd__clkbuf_1
X_7314_ rf.registers\[3\]\[18\] _3315_ _3563_ VGND VGND VPWR VPWR _3572_ sky130_fd_sc_hd__mux2_1
X_5575_ _2032_ _2219_ _2243_ VGND VGND VPWR VPWR _2306_ sky130_fd_sc_hd__o21ai_1
X_4526_ _1282_ _1292_ _1300_ _1308_ VGND VGND VPWR VPWR _1309_ sky130_fd_sc_hd__a2bb2o_4
X_8294_ _3049_ rf.registers\[25\]\[30\] _4058_ VGND VGND VPWR VPWR _4092_ sky130_fd_sc_hd__mux2_1
X_4457_ rf.registers\[8\]\[9\] rf.registers\[9\]\[9\] rf.registers\[10\]\[9\] rf.registers\[11\]\[9\]
+ _1146_ _1148_ VGND VGND VPWR VPWR _1243_ sky130_fd_sc_hd__mux4_1
X_7245_ _3535_ VGND VGND VPWR VPWR _0050_ sky130_fd_sc_hd__clkbuf_1
X_7176_ rf.registers\[4\]\[17\] _3313_ _3491_ VGND VGND VPWR VPWR _3499_ sky130_fd_sc_hd__mux2_1
XFILLER_0_0_281 VPWR VGND VPWR VGND sky130_ef_sc_hd__decap_12
XTAP_TAPCELL_ROW_113_1996 VGND VPWR sky130_fd_sc_hd__tapvpwrvgnd_1
X_4388_ _1176_ _1177_ _1154_ VGND VGND VPWR VPWR _1178_ sky130_fd_sc_hd__mux2_1
X_6127_ _2697_ _2716_ _2781_ _2554_ VGND VGND VPWR VPWR _2835_ sky130_fd_sc_hd__o22a_1
X_6058_ _2016_ _2768_ VGND VGND VPWR VPWR _2769_ sky130_fd_sc_hd__xnor2_1
XPHY_EDGE_ROW_134_Right_134 VGND VGND VPWR VPWR sky130_fd_sc_hd__decap_3
X_5009_ rf.registers\[12\]\[6\] rf.registers\[13\]\[6\] rf.registers\[14\]\[6\] rf.registers\[15\]\[6\]
+ _1735_ _1737_ VGND VGND VPWR VPWR _1766_ sky130_fd_sc_hd__mux4_1
XFILLER_0_96_825 VPWR VGND VPWR VGND sky130_ef_sc_hd__decap_12
XTAP_TAPCELL_ROW_37_850 VGND VPWR sky130_fd_sc_hd__tapvpwrvgnd_1
XTAP_TAPCELL_ROW_37_861 VGND VPWR sky130_fd_sc_hd__tapvpwrvgnd_1
XFILLER_0_95_357 VGND VGND VPWR VPWR sky130_fd_sc_hd__fill_1
XFILLER_0_49_741 VPWR VGND VPWR VGND sky130_ef_sc_hd__decap_12
XFILLER_0_119_640 VGND VGND VPWR VPWR sky130_fd_sc_hd__decap_4
XFILLER_0_49_785 VPWR VGND VPWR VGND sky130_ef_sc_hd__decap_12
XFILLER_0_48_262 VPWR VGND VPWR VGND sky130_ef_sc_hd__decap_12
XFILLER_0_119_673 VPWR VGND VPWR VGND sky130_ef_sc_hd__decap_12
XFILLER_0_64_755 VGND VGND VPWR VPWR sky130_fd_sc_hd__fill_1
XFILLER_0_134_643 VGND VGND VPWR VPWR sky130_fd_sc_hd__fill_1
XFILLER_0_122_805 VGND VGND VPWR VPWR sky130_fd_sc_hd__decap_6
XFILLER_0_106_356 VGND VGND VPWR VPWR sky130_fd_sc_hd__decap_3
XFILLER_0_63_287 VGND VGND VPWR VPWR sky130_fd_sc_hd__fill_1
XFILLER_0_121_315 VPWR VGND VPWR VGND sky130_ef_sc_hd__decap_12
XFILLER_0_121_337 VPWR VGND VPWR VGND sky130_ef_sc_hd__decap_12
XTAP_TAPCELL_ROW_75_1424 VGND VPWR sky130_fd_sc_hd__tapvpwrvgnd_1
XFILLER_0_20_825 VPWR VGND VPWR VGND sky130_ef_sc_hd__decap_12
XFILLER_0_36_27 VGND VGND VPWR VPWR sky130_fd_sc_hd__fill_1
XPHY_EDGE_ROW_101_Right_101 VGND VGND VPWR VPWR sky130_fd_sc_hd__decap_3
XFILLER_0_99_685 VPWR VGND VPWR VGND sky130_ef_sc_hd__decap_12
XFILLER_0_52_15 VPWR VGND VPWR VGND sky130_ef_sc_hd__decap_12
XTAP_TAPCELL_ROW_86_1597 VGND VPWR sky130_fd_sc_hd__tapvpwrvgnd_1
XTAP_TAPCELL_ROW_86_1586 VGND VPWR sky130_fd_sc_hd__tapvpwrvgnd_1
XTAP_TAPCELL_ROW_15_522 VGND VPWR sky130_fd_sc_hd__tapvpwrvgnd_1
XFILLER_0_116_109 VPWR VGND VPWR VGND sky130_ef_sc_hd__decap_12
XFILLER_0_54_210 VGND VGND VPWR VPWR sky130_fd_sc_hd__fill_1
XFILLER_0_6_307 VGND VGND VPWR VPWR sky130_fd_sc_hd__fill_1
XFILLER_0_55_777 VGND VGND VPWR VPWR sky130_fd_sc_hd__decap_6
XFILLER_0_27_446 VGND VGND VPWR VPWR sky130_fd_sc_hd__fill_2
XFILLER_0_70_725 VPWR VGND VPWR VGND sky130_ef_sc_hd__decap_12
XFILLER_0_124_153 VPWR VGND VPWR VGND sky130_ef_sc_hd__decap_12
XTAP_TAPCELL_ROW_117_2052 VGND VPWR sky130_fd_sc_hd__tapvpwrvgnd_1
XFILLER_0_70_769 VPWR VGND VPWR VGND sky130_ef_sc_hd__decap_12
XFILLER_0_2_513 VPWR VGND VPWR VGND sky130_ef_sc_hd__decap_12
XFILLER_0_23_641 VGND VGND VPWR VPWR sky130_fd_sc_hd__fill_1
XFILLER_0_124_197 VPWR VGND VPWR VGND sky130_ef_sc_hd__decap_12
XFILLER_0_2_557 VPWR VGND VPWR VGND sky130_ef_sc_hd__decap_12
X_5360_ _2096_ _2097_ _1943_ VGND VGND VPWR VPWR _2098_ sky130_fd_sc_hd__mux2_1
XTAP_TAPCELL_ROW_130_2252 VGND VPWR sky130_fd_sc_hd__tapvpwrvgnd_1
X_4311_ _1101_ _1102_ _1031_ VGND VGND VPWR VPWR _1103_ sky130_fd_sc_hd__mux2_1
X_5291_ _2032_ VGND VGND VPWR VPWR net62 sky130_fd_sc_hd__inv_2
X_4242_ rf.registers\[28\]\[0\] rf.registers\[29\]\[0\] rf.registers\[30\]\[0\] rf.registers\[31\]\[0\]
+ _1035_ _1036_ VGND VGND VPWR VPWR _1037_ sky130_fd_sc_hd__mux4_1
X_7030_ rf.registers\[6\]\[12\] _3303_ _3419_ VGND VGND VPWR VPWR _3422_ sky130_fd_sc_hd__mux2_1
XFILLER_0_10_357 VGND VGND VPWR VPWR sky130_fd_sc_hd__decap_6
X_8981_ clknet_leaf_48_CLK _0069_ VGND VGND VPWR VPWR rf.registers\[3\]\[4\] sky130_fd_sc_hd__dfxtp_1
XFILLER_0_93_55 VGND VGND VPWR VPWR sky130_fd_sc_hd__fill_1
XFILLER_0_117_51 VGND VGND VPWR VPWR sky130_fd_sc_hd__decap_4
X_7932_ _3900_ VGND VGND VPWR VPWR _0372_ sky130_fd_sc_hd__clkbuf_1
XFILLER_0_78_825 VPWR VGND VPWR VGND sky130_ef_sc_hd__decap_12
XFILLER_0_26_71 VGND VGND VPWR VPWR sky130_fd_sc_hd__fill_1
X_7863_ _3863_ VGND VGND VPWR VPWR _0340_ sky130_fd_sc_hd__clkbuf_1
X_6814_ rf.registers\[16\]\[1\] _3280_ _3278_ VGND VGND VPWR VPWR _3281_ sky130_fd_sc_hd__mux2_1
XFILLER_0_93_839 VGND VGND VPWR VPWR sky130_fd_sc_hd__fill_1
X_7794_ rf.registers\[9\]\[19\] _3317_ _3817_ VGND VGND VPWR VPWR _3827_ sky130_fd_sc_hd__mux2_1
X_6745_ _3243_ VGND VGND VPWR VPWR _0866_ sky130_fd_sc_hd__clkbuf_1
X_9533_ clknet_leaf_23_CLK _0621_ VGND VGND VPWR VPWR rf.registers\[14\]\[12\] sky130_fd_sc_hd__dfxtp_1
XFILLER_0_9_167 VGND VGND VPWR VPWR sky130_fd_sc_hd__fill_1
XFILLER_0_46_744 VPWR VGND VPWR VGND sky130_ef_sc_hd__decap_12
XFILLER_0_135_429 VPWR VGND VPWR VGND sky130_ef_sc_hd__decap_12
X_9464_ clknet_leaf_52_CLK _0552_ VGND VGND VPWR VPWR rf.registers\[20\]\[7\] sky130_fd_sc_hd__dfxtp_1
X_6676_ rf.registers\[10\]\[1\] _2989_ _3205_ VGND VGND VPWR VPWR _3207_ sky130_fd_sc_hd__mux2_1
XFILLER_0_104_805 VGND VGND VPWR VPWR sky130_fd_sc_hd__decap_6
X_8415_ _4156_ VGND VGND VPWR VPWR _0599_ sky130_fd_sc_hd__clkbuf_1
X_9395_ clknet_leaf_43_CLK _0483_ VGND VGND VPWR VPWR rf.registers\[21\]\[2\] sky130_fd_sc_hd__dfxtp_1
XFILLER_0_116_698 VGND VGND VPWR VPWR sky130_fd_sc_hd__fill_2
XFILLER_0_5_373 VPWR VGND VPWR VGND sky130_ef_sc_hd__decap_12
X_5627_ _2260_ _2352_ _2356_ _2254_ VGND VGND VPWR VPWR _2357_ sky130_fd_sc_hd__o211a_1
XFILLER_0_33_449 VGND VGND VPWR VPWR sky130_fd_sc_hd__decap_4
XFILLER_0_131_657 VPWR VGND VPWR VGND sky130_ef_sc_hd__decap_12
X_5558_ _2211_ _2288_ VGND VGND VPWR VPWR _2289_ sky130_fd_sc_hd__or2_1
X_8346_ rf.registers\[20\]\[22\] net28 _4117_ VGND VGND VPWR VPWR _4120_ sky130_fd_sc_hd__mux2_1
X_4509_ _1287_ _1290_ _1291_ VGND VGND VPWR VPWR _1292_ sky130_fd_sc_hd__mux2_1
XTAP_TAPCELL_ROW_57_1154 VGND VPWR sky130_fd_sc_hd__tapvpwrvgnd_1
X_8277_ _4083_ VGND VGND VPWR VPWR _0534_ sky130_fd_sc_hd__clkbuf_1
XFILLER_0_130_189 VGND VGND VPWR VPWR sky130_fd_sc_hd__decap_6
X_7228_ _3526_ VGND VGND VPWR VPWR _0042_ sky130_fd_sc_hd__clkbuf_1
X_5489_ _2212_ VGND VGND VPWR VPWR _2220_ sky130_fd_sc_hd__buf_2
X_7159_ rf.registers\[4\]\[9\] _3296_ _3480_ VGND VGND VPWR VPWR _3490_ sky130_fd_sc_hd__mux2_1
XTAP_TAPCELL_ROW_70_1354 VGND VPWR sky130_fd_sc_hd__tapvpwrvgnd_1
XTAP_TAPCELL_ROW_70_1343 VGND VPWR sky130_fd_sc_hd__tapvpwrvgnd_1
XFILLER_0_138_201 VPWR VGND VPWR VGND sky130_ef_sc_hd__decap_12
XFILLER_0_96_699 VGND VGND VPWR VPWR sky130_fd_sc_hd__fill_1
XFILLER_0_56_519 VGND VGND VPWR VPWR sky130_fd_sc_hd__decap_4
XFILLER_0_22_29 VPWR VGND VPWR VGND sky130_ef_sc_hd__decap_12
XFILLER_0_37_722 VGND VGND VPWR VPWR sky130_fd_sc_hd__decap_6
XFILLER_0_37_766 VGND VGND VPWR VPWR sky130_fd_sc_hd__decap_4
XFILLER_0_52_725 VPWR VGND VPWR VGND sky130_ef_sc_hd__decap_12
XFILLER_0_37_788 VPWR VGND VPWR VGND sky130_ef_sc_hd__decap_12
XFILLER_0_52_769 VPWR VGND VPWR VGND sky130_ef_sc_hd__decap_12
XFILLER_0_106_197 VGND VGND VPWR VPWR sky130_fd_sc_hd__decap_6
XFILLER_0_121_167 VGND VGND VPWR VPWR sky130_fd_sc_hd__fill_1
XTAP_TAPCELL_ROW_88_1615 VGND VPWR sky130_fd_sc_hd__tapvpwrvgnd_1
XTAP_TAPCELL_ROW_88_1626 VGND VPWR sky130_fd_sc_hd__tapvpwrvgnd_1
XFILLER_0_63_25 VPWR VGND VPWR VGND sky130_ef_sc_hd__decap_12
XFILLER_0_59_346 VGND VGND VPWR VPWR sky130_fd_sc_hd__decap_4
X_4860_ rf.registers\[28\]\[0\] rf.registers\[29\]\[0\] rf.registers\[30\]\[0\] rf.registers\[31\]\[0\]
+ _1617_ _1618_ VGND VGND VPWR VPWR _1623_ sky130_fd_sc_hd__mux4_1
XFILLER_0_129_223 VGND VGND VPWR VPWR sky130_fd_sc_hd__fill_1
XFILLER_0_75_839 VGND VGND VPWR VPWR sky130_fd_sc_hd__fill_1
XFILLER_0_137_3 VPWR VGND VPWR VGND sky130_ef_sc_hd__decap_12
XFILLER_0_28_711 VGND VGND VPWR VPWR sky130_fd_sc_hd__decap_4
XFILLER_0_103_31 VPWR VGND VPWR VGND sky130_ef_sc_hd__decap_12
XFILLER_0_55_552 VGND VGND VPWR VPWR sky130_fd_sc_hd__decap_8
XANTENNA_17 net130 VGND VGND VPWR VPWR sky130_fd_sc_hd__diode_2
X_4791_ rf.registers\[24\]\[28\] rf.registers\[25\]\[28\] rf.registers\[26\]\[28\]
+ rf.registers\[27\]\[28\] _1302_ _1303_ VGND VGND VPWR VPWR _1558_ sky130_fd_sc_hd__mux4_1
X_6530_ _3127_ VGND VGND VPWR VPWR _0767_ sky130_fd_sc_hd__clkbuf_1
XFILLER_0_82_360 VGND VGND VPWR VPWR sky130_fd_sc_hd__fill_1
XFILLER_0_15_405 VPWR VGND VPWR VGND sky130_ef_sc_hd__decap_12
XFILLER_0_27_276 VGND VGND VPWR VPWR sky130_fd_sc_hd__decap_4
XFILLER_0_42_213 VGND VGND VPWR VPWR sky130_fd_sc_hd__fill_2
XFILLER_0_43_736 VGND VGND VPWR VPWR sky130_fd_sc_hd__fill_2
XTAP_TAPCELL_ROW_99_1788 VGND VPWR sky130_fd_sc_hd__tapvpwrvgnd_1
XFILLER_0_82_393 VGND VGND VPWR VPWR sky130_fd_sc_hd__decap_3
XFILLER_0_70_533 VGND VGND VPWR VPWR sky130_fd_sc_hd__fill_1
X_6461_ rf.registers\[11\]\[31\] _3051_ _3055_ VGND VGND VPWR VPWR _3090_ sky130_fd_sc_hd__mux2_1
XFILLER_0_15_449 VPWR VGND VPWR VGND sky130_ef_sc_hd__decap_12
X_9180_ clknet_leaf_26_CLK _0268_ VGND VGND VPWR VPWR rf.registers\[30\]\[11\] sky130_fd_sc_hd__dfxtp_1
XFILLER_0_88_55 VGND VGND VPWR VPWR sky130_fd_sc_hd__fill_2
X_8200_ _4042_ VGND VGND VPWR VPWR _0498_ sky130_fd_sc_hd__clkbuf_1
X_6392_ _3052_ VGND VGND VPWR VPWR _0704_ sky130_fd_sc_hd__clkbuf_1
XFILLER_0_3_833 VGND VGND VPWR VPWR sky130_fd_sc_hd__decap_6
XFILLER_0_2_321 VPWR VGND VPWR VGND sky130_ef_sc_hd__decap_12
X_5412_ _2145_ _2146_ _2081_ VGND VGND VPWR VPWR _2147_ sky130_fd_sc_hd__mux2_1
Xoutput102 net102 VGND VGND VPWR VPWR RD2[29] sky130_fd_sc_hd__buf_1
X_8131_ _3382_ rf.registers\[26\]\[17\] _3998_ VGND VGND VPWR VPWR _4006_ sky130_fd_sc_hd__mux2_1
Xoutput124 net124 VGND VGND VPWR VPWR alu_result[1] sky130_fd_sc_hd__buf_1
Xoutput113 net113 VGND VGND VPWR VPWR alu_result[0] sky130_fd_sc_hd__buf_1
XFILLER_0_2_365 VPWR VGND VPWR VGND sky130_ef_sc_hd__decap_12
X_5343_ _2079_ _2080_ _2081_ VGND VGND VPWR VPWR _2082_ sky130_fd_sc_hd__mux2_1
XPHY_EDGE_ROW_120_Left_259 VGND VGND VPWR VPWR sky130_fd_sc_hd__decap_3
XFILLER_0_10_121 VPWR VGND VPWR VGND sky130_ef_sc_hd__decap_12
Xoutput135 net135 VGND VGND VPWR VPWR alu_result[2] sky130_fd_sc_hd__buf_1
X_8062_ _3969_ VGND VGND VPWR VPWR _0433_ sky130_fd_sc_hd__clkbuf_1
XFILLER_0_11_688 VGND VGND VPWR VPWR sky130_fd_sc_hd__decap_6
XFILLER_0_10_165 VPWR VGND VPWR VGND sky130_ef_sc_hd__decap_12
X_5274_ _2016_ VGND VGND VPWR VPWR net61 sky130_fd_sc_hd__inv_2
XTAP_TAPCELL_ROW_110_1955 VGND VPWR sky130_fd_sc_hd__tapvpwrvgnd_1
XTAP_TAPCELL_ROW_110_1944 VGND VPWR sky130_fd_sc_hd__tapvpwrvgnd_1
X_7013_ rf.registers\[6\]\[4\] _3286_ _3408_ VGND VGND VPWR VPWR _3413_ sky130_fd_sc_hd__mux2_1
XTAP_TAPCELL_ROW_52_1084 VGND VPWR sky130_fd_sc_hd__tapvpwrvgnd_1
XTAP_TAPCELL_ROW_52_1073 VGND VPWR sky130_fd_sc_hd__tapvpwrvgnd_1
XFILLER_0_128_83 VGND VGND VPWR VPWR sky130_fd_sc_hd__fill_1
X_8964_ clknet_leaf_20_CLK _0052_ VGND VGND VPWR VPWR rf.registers\[19\]\[19\] sky130_fd_sc_hd__dfxtp_1
X_7915_ _3370_ rf.registers\[23\]\[11\] _3890_ VGND VGND VPWR VPWR _3892_ sky130_fd_sc_hd__mux2_1
X_8895_ clknet_leaf_14_CLK _1007_ VGND VGND VPWR VPWR rf.registers\[5\]\[14\] sky130_fd_sc_hd__dfxtp_1
X_7846_ _3370_ rf.registers\[28\]\[11\] _3853_ VGND VGND VPWR VPWR _3855_ sky130_fd_sc_hd__mux2_1
XFILLER_0_78_677 VPWR VGND VPWR VGND sky130_ef_sc_hd__decap_12
XFILLER_0_136_749 VGND VGND VPWR VPWR sky130_fd_sc_hd__decap_6
X_7777_ _3818_ VGND VGND VPWR VPWR _0299_ sky130_fd_sc_hd__clkbuf_1
XFILLER_0_92_157 VGND VGND VPWR VPWR sky130_fd_sc_hd__fill_2
X_4989_ _1663_ VGND VGND VPWR VPWR _1747_ sky130_fd_sc_hd__buf_4
XFILLER_0_81_809 VPWR VGND VPWR VGND sky130_ef_sc_hd__decap_12
XFILLER_0_135_237 VPWR VGND VPWR VGND sky130_ef_sc_hd__decap_12
X_9516_ clknet_leaf_88_CLK _0604_ VGND VGND VPWR VPWR rf.registers\[18\]\[27\] sky130_fd_sc_hd__dfxtp_1
X_6728_ rf.registers\[10\]\[26\] _3041_ _3227_ VGND VGND VPWR VPWR _3234_ sky130_fd_sc_hd__mux2_1
XFILLER_0_34_725 VPWR VGND VPWR VGND sky130_ef_sc_hd__decap_12
X_6659_ rf.registers\[24\]\[26\] _3041_ _3190_ VGND VGND VPWR VPWR _3197_ sky130_fd_sc_hd__mux2_1
X_9447_ clknet_leaf_0_CLK _0535_ VGND VGND VPWR VPWR rf.registers\[25\]\[22\] sky130_fd_sc_hd__dfxtp_1
X_9378_ clknet_leaf_11_CLK _0466_ VGND VGND VPWR VPWR rf.registers\[26\]\[17\] sky130_fd_sc_hd__dfxtp_1
XFILLER_0_6_682 VGND VGND VPWR VPWR sky130_fd_sc_hd__decap_6
XFILLER_0_5_181 VPWR VGND VPWR VGND sky130_ef_sc_hd__decap_12
X_8329_ rf.registers\[20\]\[14\] net19 _4106_ VGND VGND VPWR VPWR _4111_ sky130_fd_sc_hd__mux2_1
XTAP_TAPCELL_ROW_6_386 VGND VPWR sky130_fd_sc_hd__tapvpwrvgnd_1
XFILLER_0_88_408 VGND VGND VPWR VPWR sky130_fd_sc_hd__decap_4
XTAP_TAPCELL_ROW_6_397 VGND VPWR sky130_fd_sc_hd__tapvpwrvgnd_1
XFILLER_0_88_419 VGND VGND VPWR VPWR sky130_fd_sc_hd__fill_1
XFILLER_0_69_633 VGND VGND VPWR VPWR sky130_fd_sc_hd__decap_3
XTAP_TAPCELL_ROW_83_1545 VGND VPWR sky130_fd_sc_hd__tapvpwrvgnd_1
XFILLER_0_33_39 VGND VGND VPWR VPWR sky130_fd_sc_hd__decap_8
XFILLER_0_83_113 VGND VGND VPWR VPWR sky130_fd_sc_hd__decap_3
XFILLER_0_57_839 VGND VGND VPWR VPWR sky130_fd_sc_hd__fill_1
XFILLER_0_127_727 VGND VGND VPWR VPWR sky130_fd_sc_hd__fill_1
XTAP_TAPCELL_ROW_25_672 VGND VPWR sky130_fd_sc_hd__tapvpwrvgnd_1
XFILLER_0_37_552 VGND VGND VPWR VPWR sky130_fd_sc_hd__fill_1
XFILLER_0_123_9 VPWR VGND VPWR VGND sky130_ef_sc_hd__decap_12
XFILLER_0_107_473 VGND VGND VPWR VPWR sky130_fd_sc_hd__fill_1
Xinput15 WD3[10] VGND VGND VPWR VPWR net15 sky130_fd_sc_hd__buf_2
Xinput26 WD3[20] VGND VGND VPWR VPWR net26 sky130_fd_sc_hd__clkbuf_2
XFILLER_0_52_533 VGND VGND VPWR VPWR sky130_fd_sc_hd__fill_1
XFILLER_0_52_522 VGND VGND VPWR VPWR sky130_fd_sc_hd__fill_1
Xinput37 WD3[30] VGND VGND VPWR VPWR net37 sky130_fd_sc_hd__clkbuf_4
XFILLER_0_24_235 VGND VGND VPWR VPWR sky130_fd_sc_hd__fill_1
XTAP_TAPCELL_ROW_114_2011 VGND VPWR sky130_fd_sc_hd__tapvpwrvgnd_1
XFILLER_0_52_555 VPWR VGND VPWR VGND sky130_ef_sc_hd__decap_12
XFILLER_0_12_419 VGND VGND VPWR VPWR sky130_fd_sc_hd__fill_1
Xinput48 alu_opcode[1] VGND VGND VPWR VPWR net48 sky130_fd_sc_hd__buf_2
XFILLER_0_32_290 VGND VGND VPWR VPWR sky130_fd_sc_hd__fill_2
XTAP_TAPCELL_ROW_125_2173 VGND VPWR sky130_fd_sc_hd__tapvpwrvgnd_1
X_5961_ _1888_ _2669_ _2677_ VGND VGND VPWR VPWR _2678_ sky130_fd_sc_hd__a21o_1
X_4912_ _1669_ _1672_ _1628_ VGND VGND VPWR VPWR _1673_ sky130_fd_sc_hd__mux2_1
X_7700_ _3777_ VGND VGND VPWR VPWR _0263_ sky130_fd_sc_hd__clkbuf_1
X_8680_ clknet_leaf_8_CLK _0792_ VGND VGND VPWR VPWR rf.registers\[1\]\[23\] sky130_fd_sc_hd__dfxtp_1
XFILLER_0_114_41 VPWR VGND VPWR VGND sky130_ef_sc_hd__decap_12
X_7631_ _3740_ VGND VGND VPWR VPWR _0231_ sky130_fd_sc_hd__clkbuf_1
X_5892_ _1842_ _2611_ VGND VGND VPWR VPWR _2613_ sky130_fd_sc_hd__and2_1
XFILLER_0_118_749 VGND VGND VPWR VPWR sky130_fd_sc_hd__decap_6
XFILLER_0_114_85 VPWR VGND VPWR VGND sky130_ef_sc_hd__decap_12
XFILLER_0_74_157 VGND VGND VPWR VPWR sky130_fd_sc_hd__decap_4
XFILLER_0_63_809 VPWR VGND VPWR VGND sky130_ef_sc_hd__decap_12
X_4843_ rf.registers\[8\]\[31\] rf.registers\[9\]\[31\] rf.registers\[10\]\[31\] rf.registers\[11\]\[31\]
+ _1126_ _1129_ VGND VGND VPWR VPWR _1607_ sky130_fd_sc_hd__mux4_1
XFILLER_0_23_61 VGND VGND VPWR VPWR sky130_fd_sc_hd__fill_1
XFILLER_0_117_237 VPWR VGND VPWR VGND sky130_ef_sc_hd__decap_12
X_7562_ _3359_ rf.registers\[27\]\[6\] _3697_ VGND VGND VPWR VPWR _3704_ sky130_fd_sc_hd__mux2_1
X_4774_ rf.registers\[28\]\[27\] rf.registers\[29\]\[27\] rf.registers\[30\]\[27\]
+ rf.registers\[31\]\[27\] _1120_ _1123_ VGND VGND VPWR VPWR _1542_ sky130_fd_sc_hd__mux4_1
XFILLER_0_99_65 VGND VGND VPWR VPWR sky130_fd_sc_hd__fill_2
XFILLER_0_99_43 VPWR VGND VPWR VGND sky130_ef_sc_hd__decap_12
X_9301_ clknet_leaf_54_CLK _0389_ VGND VGND VPWR VPWR rf.registers\[22\]\[4\] sky130_fd_sc_hd__dfxtp_1
X_7493_ _3667_ VGND VGND VPWR VPWR _0166_ sky130_fd_sc_hd__clkbuf_1
X_6513_ rf.registers\[17\]\[22\] _3033_ _3116_ VGND VGND VPWR VPWR _3119_ sky130_fd_sc_hd__mux2_1
XFILLER_0_126_793 VPWR VGND VPWR VGND sky130_ef_sc_hd__decap_12
XFILLER_0_125_281 VPWR VGND VPWR VGND sky130_ef_sc_hd__decap_12
X_6444_ _3081_ VGND VGND VPWR VPWR _0727_ sky130_fd_sc_hd__clkbuf_1
X_9232_ clknet_leaf_77_CLK _0320_ VGND VGND VPWR VPWR rf.registers\[9\]\[31\] sky130_fd_sc_hd__dfxtp_1
XFILLER_0_3_641 VPWR VGND VPWR VGND sky130_ef_sc_hd__decap_12
XFILLER_0_15_279 VGND VGND VPWR VPWR sky130_fd_sc_hd__fill_1
XFILLER_0_24_780 VPWR VGND VPWR VGND sky130_ef_sc_hd__decap_12
XFILLER_0_61_3 VPWR VGND VPWR VGND sky130_ef_sc_hd__decap_12
XFILLER_0_11_441 VGND VGND VPWR VPWR sky130_fd_sc_hd__decap_6
XFILLER_0_3_685 VPWR VGND VPWR VGND sky130_ef_sc_hd__decap_12
X_6375_ net32 VGND VGND VPWR VPWR _3041_ sky130_fd_sc_hd__buf_2
XFILLER_0_23_290 VGND VGND VPWR VPWR sky130_fd_sc_hd__fill_1
X_9163_ clknet_leaf_69_CLK _0251_ VGND VGND VPWR VPWR rf.registers\[2\]\[26\] sky130_fd_sc_hd__dfxtp_1
X_8114_ _3365_ rf.registers\[26\]\[9\] _3987_ VGND VGND VPWR VPWR _3997_ sky130_fd_sc_hd__mux2_1
XTAP_TAPCELL_ROW_54_1113 VGND VPWR sky130_fd_sc_hd__tapvpwrvgnd_1
X_9094_ clknet_leaf_81_CLK _0182_ VGND VGND VPWR VPWR rf.registers\[31\]\[21\] sky130_fd_sc_hd__dfxtp_1
XFILLER_0_11_485 VPWR VGND VPWR VGND sky130_ef_sc_hd__decap_12
XFILLER_0_2_195 VGND VGND VPWR VPWR sky130_fd_sc_hd__fill_1
X_5326_ _2063_ _2064_ _1955_ VGND VGND VPWR VPWR _2065_ sky130_fd_sc_hd__mux2_1
X_8045_ _3960_ VGND VGND VPWR VPWR _0425_ sky130_fd_sc_hd__clkbuf_1
X_5257_ _1930_ VGND VGND VPWR VPWR _2000_ sky130_fd_sc_hd__clkbuf_4
X_5188_ rf.registers\[4\]\[16\] rf.registers\[5\]\[16\] rf.registers\[6\]\[16\] rf.registers\[7\]\[16\]
+ _1730_ _1732_ VGND VGND VPWR VPWR _1935_ sky130_fd_sc_hd__mux4_1
XTAP_TAPCELL_ROW_3_345 VGND VPWR sky130_fd_sc_hd__tapvpwrvgnd_1
X_8947_ clknet_leaf_44_CLK _0035_ VGND VGND VPWR VPWR rf.registers\[19\]\[2\] sky130_fd_sc_hd__dfxtp_1
XFILLER_0_78_430 VGND VGND VPWR VPWR sky130_fd_sc_hd__fill_1
XFILLER_0_3_93 VPWR VGND VPWR VGND sky130_ef_sc_hd__decap_12
XFILLER_0_78_474 VGND VGND VPWR VPWR sky130_fd_sc_hd__fill_2
X_8878_ clknet_leaf_90_CLK _0990_ VGND VGND VPWR VPWR rf.registers\[6\]\[29\] sky130_fd_sc_hd__dfxtp_1
XFILLER_0_39_839 VGND VGND VPWR VPWR sky130_fd_sc_hd__fill_1
XTAP_TAPCELL_ROW_42_929 VGND VPWR sky130_fd_sc_hd__tapvpwrvgnd_1
XFILLER_0_136_513 VPWR VGND VPWR VGND sky130_ef_sc_hd__decap_12
X_7829_ _3353_ rf.registers\[28\]\[3\] _3842_ VGND VGND VPWR VPWR _3846_ sky130_fd_sc_hd__mux2_1
XFILLER_0_66_669 VPWR VGND VPWR VGND sky130_ef_sc_hd__decap_12
XTAP_TAPCELL_ROW_65_1275 VGND VPWR sky130_fd_sc_hd__tapvpwrvgnd_1
XFILLER_0_65_157 VGND VGND VPWR VPWR sky130_fd_sc_hd__fill_2
XFILLER_0_19_541 VPWR VGND VPWR VGND sky130_ef_sc_hd__decap_12
XFILLER_0_136_557 VPWR VGND VPWR VGND sky130_ef_sc_hd__decap_12
XFILLER_0_81_617 VGND VGND VPWR VPWR sky130_fd_sc_hd__fill_1
XTAP_TAPCELL_ROW_22_631 VGND VPWR sky130_fd_sc_hd__tapvpwrvgnd_1
XFILLER_0_46_360 VGND VGND VPWR VPWR sky130_fd_sc_hd__decap_4
XFILLER_0_104_421 VGND VGND VPWR VPWR sky130_fd_sc_hd__fill_1
XFILLER_0_73_190 VGND VGND VPWR VPWR sky130_fd_sc_hd__decap_8
XFILLER_0_131_273 VGND VGND VPWR VPWR sky130_fd_sc_hd__decap_6
XFILLER_0_119_19 VPWR VGND VPWR VGND sky130_ef_sc_hd__decap_12
XFILLER_0_100_671 VPWR VGND VPWR VGND sky130_ef_sc_hd__decap_12
XFILLER_0_44_27 VGND VGND VPWR VPWR sky130_fd_sc_hd__fill_1
XFILLER_0_97_783 VGND VGND VPWR VPWR sky130_fd_sc_hd__fill_1
XFILLER_0_96_271 VGND VGND VPWR VPWR sky130_fd_sc_hd__fill_2
XFILLER_0_84_400 VGND VGND VPWR VPWR sky130_fd_sc_hd__decap_8
XFILLER_0_69_485 VGND VGND VPWR VPWR sky130_fd_sc_hd__decap_4
XFILLER_0_72_606 VGND VGND VPWR VPWR sky130_fd_sc_hd__fill_1
XFILLER_0_60_15 VPWR VGND VPWR VGND sky130_ef_sc_hd__decap_12
XFILLER_0_45_809 VPWR VGND VPWR VGND sky130_ef_sc_hd__decap_12
XFILLER_0_37_393 VGND VGND VPWR VPWR sky130_fd_sc_hd__fill_2
XFILLER_0_108_793 VPWR VGND VPWR VGND sky130_ef_sc_hd__decap_12
XTAP_TAPCELL_ROW_96_1736 VGND VPWR sky130_fd_sc_hd__tapvpwrvgnd_1
XFILLER_0_52_352 VGND VGND VPWR VPWR sky130_fd_sc_hd__decap_3
XFILLER_0_8_27 VGND VGND VPWR VPWR sky130_fd_sc_hd__fill_1
XFILLER_0_25_577 VPWR VGND VPWR VGND sky130_ef_sc_hd__decap_12
XFILLER_0_123_741 VPWR VGND VPWR VGND sky130_ef_sc_hd__decap_12
XTAP_TAPCELL_ROW_96_1747 VGND VPWR sky130_fd_sc_hd__tapvpwrvgnd_1
X_4490_ rf.registers\[8\]\[11\] rf.registers\[9\]\[11\] rf.registers\[10\]\[11\] rf.registers\[11\]\[11\]
+ _1118_ _1127_ VGND VGND VPWR VPWR _1274_ sky130_fd_sc_hd__mux4_1
XFILLER_0_40_514 VGND VGND VPWR VPWR sky130_fd_sc_hd__fill_2
XFILLER_0_123_785 VPWR VGND VPWR VGND sky130_ef_sc_hd__decap_12
XFILLER_0_122_251 VGND VGND VPWR VPWR sky130_fd_sc_hd__fill_1
XFILLER_0_100_65 VGND VGND VPWR VPWR sky130_fd_sc_hd__decap_8
XFILLER_0_0_655 VPWR VGND VPWR VGND sky130_ef_sc_hd__decap_12
XFILLER_0_21_783 VGND VGND VPWR VPWR sky130_fd_sc_hd__fill_1
X_6160_ _2385_ _2571_ _2598_ _2780_ _2865_ VGND VGND VPWR VPWR _2866_ sky130_fd_sc_hd__o221a_1
X_5111_ _1860_ _1861_ _1707_ VGND VGND VPWR VPWR _1862_ sky130_fd_sc_hd__mux2_1
XTAP_TAPCELL_ROW_127_2202 VGND VPWR sky130_fd_sc_hd__tapvpwrvgnd_1
X_6091_ _2636_ _2681_ _2259_ VGND VGND VPWR VPWR _2800_ sky130_fd_sc_hd__mux2_1
X_5042_ _1656_ VGND VGND VPWR VPWR _1797_ sky130_fd_sc_hd__clkbuf_4
XFILLER_0_79_216 VGND VGND VPWR VPWR sky130_fd_sc_hd__decap_8
XFILLER_0_18_83 VGND VGND VPWR VPWR sky130_fd_sc_hd__fill_1
X_8801_ clknet_leaf_19_CLK _0913_ VGND VGND VPWR VPWR rf.registers\[16\]\[16\] sky130_fd_sc_hd__dfxtp_1
XTAP_TAPCELL_ROW_0_304 VGND VPWR sky130_fd_sc_hd__tapvpwrvgnd_1
XFILLER_0_125_51 VGND VGND VPWR VPWR sky130_fd_sc_hd__decap_4
X_6993_ _3401_ VGND VGND VPWR VPWR _0956_ sky130_fd_sc_hd__clkbuf_1
X_8732_ clknet_leaf_30_CLK _0844_ VGND VGND VPWR VPWR rf.registers\[10\]\[11\] sky130_fd_sc_hd__dfxtp_1
X_5944_ _2626_ _2661_ _2233_ VGND VGND VPWR VPWR _2662_ sky130_fd_sc_hd__mux2_1
XFILLER_0_47_113 VGND VGND VPWR VPWR sky130_fd_sc_hd__fill_2
XTAP_TAPCELL_ROW_105_1876 VGND VPWR sky130_fd_sc_hd__tapvpwrvgnd_1
X_8663_ clknet_leaf_57_CLK _0775_ VGND VGND VPWR VPWR rf.registers\[1\]\[6\] sky130_fd_sc_hd__dfxtp_1
X_5875_ _2594_ _2596_ _2340_ VGND VGND VPWR VPWR _2597_ sky130_fd_sc_hd__mux2_1
X_8594_ clknet_leaf_45_CLK _0706_ VGND VGND VPWR VPWR rf.registers\[11\]\[1\] sky130_fd_sc_hd__dfxtp_1
XFILLER_0_63_617 VGND VGND VPWR VPWR sky130_fd_sc_hd__decap_8
X_4826_ rf.registers\[4\]\[30\] rf.registers\[5\]\[30\] rf.registers\[6\]\[30\] rf.registers\[7\]\[30\]
+ _1198_ _1199_ VGND VGND VPWR VPWR _1591_ sky130_fd_sc_hd__mux4_1
X_7614_ _2980_ rf.registers\[27\]\[31\] _3696_ VGND VGND VPWR VPWR _3731_ sky130_fd_sc_hd__mux2_1
XFILLER_0_8_733 VPWR VGND VPWR VGND sky130_ef_sc_hd__decap_12
XTAP_TAPCELL_ROW_138_2375 VGND VPWR sky130_fd_sc_hd__tapvpwrvgnd_1
XTAP_TAPCELL_ROW_138_2364 VGND VPWR sky130_fd_sc_hd__tapvpwrvgnd_1
X_7545_ _3694_ VGND VGND VPWR VPWR _0191_ sky130_fd_sc_hd__clkbuf_1
XFILLER_0_16_533 VPWR VGND VPWR VGND sky130_ef_sc_hd__decap_12
XTAP_TAPCELL_ROW_138_2386 VGND VPWR sky130_fd_sc_hd__tapvpwrvgnd_1
XTAP_TAPCELL_ROW_60_1194 VGND VPWR sky130_fd_sc_hd__tapvpwrvgnd_1
X_4757_ rf.registers\[28\]\[26\] rf.registers\[29\]\[26\] rf.registers\[30\]\[26\]
+ rf.registers\[31\]\[26\] _1125_ _1128_ VGND VGND VPWR VPWR _1526_ sky130_fd_sc_hd__mux4_1
XFILLER_0_71_694 VPWR VGND VPWR VGND sky130_ef_sc_hd__decap_12
X_4688_ _1203_ _1449_ _1453_ _1457_ _1461_ VGND VGND VPWR VPWR _1462_ sky130_fd_sc_hd__a32o_2
X_7476_ _2978_ rf.registers\[29\]\[30\] _3624_ VGND VGND VPWR VPWR _3658_ sky130_fd_sc_hd__mux2_1
X_6427_ _3072_ VGND VGND VPWR VPWR _0719_ sky130_fd_sc_hd__clkbuf_1
X_9215_ clknet_leaf_28_CLK _0303_ VGND VGND VPWR VPWR rf.registers\[9\]\[14\] sky130_fd_sc_hd__dfxtp_1
XFILLER_0_31_547 VPWR VGND VPWR VGND sky130_ef_sc_hd__decap_12
X_9146_ clknet_leaf_34_CLK _0234_ VGND VGND VPWR VPWR rf.registers\[2\]\[9\] sky130_fd_sc_hd__dfxtp_1
XFILLER_0_101_446 VGND VGND VPWR VPWR sky130_fd_sc_hd__fill_2
X_6358_ rf.registers\[12\]\[20\] _3028_ _3029_ VGND VGND VPWR VPWR _3030_ sky130_fd_sc_hd__mux2_1
XTAP_TAPCELL_ROW_8_426 VGND VPWR sky130_fd_sc_hd__tapvpwrvgnd_1
XTAP_TAPCELL_ROW_8_415 VGND VPWR sky130_fd_sc_hd__tapvpwrvgnd_1
XFILLER_0_11_293 VPWR VGND VPWR VGND sky130_ef_sc_hd__decap_12
XFILLER_0_12_794 VPWR VGND VPWR VGND sky130_ef_sc_hd__decap_12
X_5309_ _2047_ _2048_ _1747_ VGND VGND VPWR VPWR _2049_ sky130_fd_sc_hd__mux2_1
X_9077_ clknet_leaf_54_CLK _0165_ VGND VGND VPWR VPWR rf.registers\[31\]\[4\] sky130_fd_sc_hd__dfxtp_1
X_6289_ _2981_ VGND VGND VPWR VPWR _0672_ sky130_fd_sc_hd__clkbuf_1
X_8028_ rf.registers\[7\]\[0\] _3276_ _3951_ VGND VGND VPWR VPWR _3952_ sky130_fd_sc_hd__mux2_1
XTAP_TAPCELL_ROW_67_1304 VGND VPWR sky130_fd_sc_hd__tapvpwrvgnd_1
XTAP_TAPCELL_ROW_27_701 VGND VPWR sky130_fd_sc_hd__tapvpwrvgnd_1
XTAP_TAPCELL_ROW_27_712 VGND VPWR sky130_fd_sc_hd__tapvpwrvgnd_1
XFILLER_0_39_603 VPWR VGND VPWR VGND sky130_ef_sc_hd__decap_12
XFILLER_0_79_783 VGND VGND VPWR VPWR sky130_fd_sc_hd__fill_1
XFILLER_0_109_502 VGND VGND VPWR VPWR sky130_fd_sc_hd__fill_2
XTAP_TAPCELL_ROW_80_1504 VGND VPWR sky130_fd_sc_hd__tapvpwrvgnd_1
XFILLER_0_78_293 VPWR VGND VPWR VGND sky130_ef_sc_hd__decap_12
XFILLER_0_137_833 VGND VGND VPWR VPWR sky130_fd_sc_hd__decap_6
XFILLER_0_136_321 VPWR VGND VPWR VGND sky130_ef_sc_hd__decap_12
XFILLER_0_66_477 VGND VGND VPWR VPWR sky130_fd_sc_hd__decap_6
XFILLER_0_54_617 VGND VGND VPWR VPWR sky130_fd_sc_hd__fill_2
XFILLER_0_136_365 VPWR VGND VPWR VGND sky130_ef_sc_hd__decap_12
XFILLER_0_81_447 VGND VGND VPWR VPWR sky130_fd_sc_hd__fill_1
XFILLER_0_53_116 VGND VGND VPWR VPWR sky130_fd_sc_hd__decap_4
XFILLER_0_19_393 VGND VGND VPWR VPWR sky130_fd_sc_hd__fill_1
XFILLER_0_30_29 VPWR VGND VPWR VGND sky130_ef_sc_hd__decap_12
XFILLER_0_46_190 VGND VGND VPWR VPWR sky130_fd_sc_hd__decap_6
XFILLER_0_105_741 VPWR VGND VPWR VGND sky130_ef_sc_hd__decap_12
XFILLER_0_105_785 VPWR VGND VPWR VGND sky130_ef_sc_hd__decap_12
XTAP_TAPCELL_ROW_78_1477 VGND VPWR sky130_fd_sc_hd__tapvpwrvgnd_1
XTAP_TAPCELL_ROW_78_1466 VGND VPWR sky130_fd_sc_hd__tapvpwrvgnd_1
XFILLER_0_120_755 VGND VGND VPWR VPWR sky130_fd_sc_hd__fill_1
XTAP_TAPCELL_ROW_91_1666 VGND VPWR sky130_fd_sc_hd__tapvpwrvgnd_1
XTAP_TAPCELL_ROW_122_2132 VGND VPWR sky130_fd_sc_hd__tapvpwrvgnd_1
XFILLER_0_77_709 VPWR VGND VPWR VGND sky130_ef_sc_hd__decap_12
XFILLER_0_128_811 VGND VGND VPWR VPWR sky130_fd_sc_hd__fill_1
XFILLER_0_85_753 VPWR VGND VPWR VGND sky130_ef_sc_hd__decap_12
XFILLER_0_29_113 VGND VGND VPWR VPWR sky130_fd_sc_hd__fill_2
XFILLER_0_85_797 VPWR VGND VPWR VGND sky130_ef_sc_hd__decap_12
XFILLER_0_45_617 VGND VGND VPWR VPWR sky130_fd_sc_hd__fill_1
XFILLER_0_45_628 VGND VGND VPWR VPWR sky130_fd_sc_hd__fill_2
X_5660_ _2211_ _1074_ _2389_ VGND VGND VPWR VPWR _2390_ sky130_fd_sc_hd__or3_1
XFILLER_0_72_436 VGND VGND VPWR VPWR sky130_fd_sc_hd__fill_1
X_4611_ rf.registers\[0\]\[17\] rf.registers\[1\]\[17\] rf.registers\[2\]\[17\] rf.registers\[3\]\[17\]
+ _1283_ _1284_ VGND VGND VPWR VPWR _1389_ sky130_fd_sc_hd__mux4_1
XTAP_TAPCELL_ROW_100_1795 VGND VPWR sky130_fd_sc_hd__tapvpwrvgnd_1
XFILLER_0_72_469 VGND VGND VPWR VPWR sky130_fd_sc_hd__decap_6
XTAP_TAPCELL_ROW_13_494 VGND VPWR sky130_fd_sc_hd__tapvpwrvgnd_1
X_5591_ _2251_ _2321_ _2263_ VGND VGND VPWR VPWR _2322_ sky130_fd_sc_hd__a21o_1
XFILLER_0_111_53 VGND VGND VPWR VPWR sky130_fd_sc_hd__decap_3
X_4542_ rf.registers\[8\]\[13\] rf.registers\[9\]\[13\] rf.registers\[10\]\[13\] rf.registers\[11\]\[13\]
+ _1120_ _1123_ VGND VGND VPWR VPWR _1324_ sky130_fd_sc_hd__mux4_1
XFILLER_0_13_503 VGND VGND VPWR VPWR sky130_fd_sc_hd__fill_1
X_7330_ _3580_ VGND VGND VPWR VPWR _0090_ sky130_fd_sc_hd__clkbuf_1
Xclkbuf_leaf_90_CLK clknet_3_0__leaf_CLK VGND VGND VPWR VPWR clknet_leaf_90_CLK sky130_fd_sc_hd__clkbuf_8
X_4473_ _1254_ _1257_ _1061_ VGND VGND VPWR VPWR _1258_ sky130_fd_sc_hd__mux2_1
X_7261_ rf.registers\[19\]\[25\] _3330_ _3538_ VGND VGND VPWR VPWR _3544_ sky130_fd_sc_hd__mux2_1
XTAP_TAPCELL_ROW_133_2294 VGND VPWR sky130_fd_sc_hd__tapvpwrvgnd_1
X_9000_ clknet_leaf_8_CLK _0088_ VGND VGND VPWR VPWR rf.registers\[3\]\[23\] sky130_fd_sc_hd__dfxtp_1
X_6212_ _2883_ _2889_ _2914_ VGND VGND VPWR VPWR _2915_ sky130_fd_sc_hd__o21a_1
XPHY_EDGE_ROW_115_Right_115 VGND VGND VPWR VPWR sky130_fd_sc_hd__decap_3
XFILLER_0_111_777 VGND VGND VPWR VPWR sky130_fd_sc_hd__decap_6
XFILLER_0_21_591 VPWR VGND VPWR VGND sky130_ef_sc_hd__decap_12
X_7192_ _3507_ VGND VGND VPWR VPWR _0025_ sky130_fd_sc_hd__clkbuf_1
XFILLER_0_0_474 VGND VGND VPWR VPWR sky130_fd_sc_hd__fill_2
X_6143_ _2773_ _2848_ _2849_ VGND VGND VPWR VPWR _2850_ sky130_fd_sc_hd__o21ba_1
X_6074_ _2391_ _2775_ _2783_ _2784_ VGND VGND VPWR VPWR net125 sky130_fd_sc_hd__o2bb2a_1
X_5025_ _1779_ _1780_ _1635_ VGND VGND VPWR VPWR _1781_ sky130_fd_sc_hd__mux2_1
XTAP_TAPCELL_ROW_107_1905 VGND VPWR sky130_fd_sc_hd__tapvpwrvgnd_1
XFILLER_0_24_3 VPWR VGND VPWR VGND sky130_ef_sc_hd__decap_12
XFILLER_0_136_83 VGND VGND VPWR VPWR sky130_fd_sc_hd__fill_1
XTAP_TAPCELL_ROW_49_1034 VGND VPWR sky130_fd_sc_hd__tapvpwrvgnd_1
X_6976_ net27 VGND VGND VPWR VPWR _3391_ sky130_fd_sc_hd__clkbuf_2
X_5927_ _2645_ VGND VGND VPWR VPWR _2646_ sky130_fd_sc_hd__buf_2
XFILLER_0_0_50 VGND VGND VPWR VPWR sky130_fd_sc_hd__decap_6
XFILLER_0_0_61 VGND VGND VPWR VPWR sky130_fd_sc_hd__fill_2
X_8715_ clknet_leaf_70_CLK _0827_ VGND VGND VPWR VPWR rf.registers\[24\]\[26\] sky130_fd_sc_hd__dfxtp_1
XFILLER_0_119_833 VGND VGND VPWR VPWR sky130_fd_sc_hd__decap_6
XFILLER_0_91_701 VPWR VGND VPWR VGND sky130_ef_sc_hd__decap_12
XFILLER_0_75_263 VGND VGND VPWR VPWR sky130_fd_sc_hd__decap_4
XTAP_TAPCELL_ROW_62_1234 VGND VPWR sky130_fd_sc_hd__tapvpwrvgnd_1
XTAP_TAPCELL_ROW_62_1223 VGND VPWR sky130_fd_sc_hd__tapvpwrvgnd_1
XFILLER_0_0_83 VGND VGND VPWR VPWR sky130_fd_sc_hd__fill_1
XFILLER_0_36_617 VPWR VGND VPWR VGND sky130_ef_sc_hd__decap_12
X_8646_ clknet_leaf_80_CLK _0758_ VGND VGND VPWR VPWR rf.registers\[17\]\[21\] sky130_fd_sc_hd__dfxtp_1
X_5858_ _2477_ _2538_ _2545_ _2580_ VGND VGND VPWR VPWR _2581_ sky130_fd_sc_hd__a211oi_1
XFILLER_0_35_116 VGND VGND VPWR VPWR sky130_fd_sc_hd__fill_1
XFILLER_0_134_825 VPWR VGND VPWR VGND sky130_ef_sc_hd__decap_12
X_8577_ clknet_leaf_15_CLK _0689_ VGND VGND VPWR VPWR rf.registers\[12\]\[16\] sky130_fd_sc_hd__dfxtp_1
X_5789_ _2459_ VGND VGND VPWR VPWR _2514_ sky130_fd_sc_hd__inv_2
XFILLER_0_8_585 VGND VGND VPWR VPWR sky130_fd_sc_hd__decap_3
XPHY_EDGE_ROW_17_Right_17 VGND VGND VPWR VPWR sky130_fd_sc_hd__decap_3
X_4809_ rf.registers\[8\]\[29\] rf.registers\[9\]\[29\] rf.registers\[10\]\[29\] rf.registers\[11\]\[29\]
+ _1382_ _1383_ VGND VGND VPWR VPWR _1575_ sky130_fd_sc_hd__mux4_1
XTAP_TAPCELL_ROW_32_781 VGND VPWR sky130_fd_sc_hd__tapvpwrvgnd_1
XFILLER_0_133_335 VGND VGND VPWR VPWR sky130_fd_sc_hd__fill_1
Xclkbuf_leaf_81_CLK clknet_3_0__leaf_CLK VGND VGND VPWR VPWR clknet_leaf_81_CLK sky130_fd_sc_hd__clkbuf_8
X_7528_ _3393_ rf.registers\[31\]\[22\] _3683_ VGND VGND VPWR VPWR _3686_ sky130_fd_sc_hd__mux2_1
XFILLER_0_43_160 VGND VGND VPWR VPWR sky130_fd_sc_hd__decap_8
X_7459_ _3649_ VGND VGND VPWR VPWR _0150_ sky130_fd_sc_hd__clkbuf_1
XFILLER_0_9_81 VPWR VGND VPWR VGND sky130_ef_sc_hd__decap_12
XFILLER_0_102_755 VGND VGND VPWR VPWR sky130_fd_sc_hd__fill_1
XFILLER_0_31_388 VGND VGND VPWR VPWR sky130_fd_sc_hd__decap_4
X_9129_ clknet_leaf_84_CLK _0217_ VGND VGND VPWR VPWR rf.registers\[27\]\[24\] sky130_fd_sc_hd__dfxtp_1
XTAP_TAPCELL_ROW_73_1396 VGND VPWR sky130_fd_sc_hd__tapvpwrvgnd_1
XPHY_EDGE_ROW_26_Right_26 VGND VGND VPWR VPWR sky130_fd_sc_hd__decap_3
XFILLER_0_59_709 VPWR VGND VPWR VGND sky130_ef_sc_hd__decap_12
XFILLER_0_67_753 VPWR VGND VPWR VGND sky130_ef_sc_hd__decap_12
XFILLER_0_137_641 VPWR VGND VPWR VGND sky130_ef_sc_hd__decap_12
XFILLER_0_82_701 VPWR VGND VPWR VGND sky130_ef_sc_hd__decap_12
XFILLER_0_27_617 VGND VGND VPWR VPWR sky130_fd_sc_hd__decap_4
XFILLER_0_41_39 VGND VGND VPWR VPWR sky130_fd_sc_hd__decap_4
XFILLER_0_67_797 VPWR VGND VPWR VGND sky130_ef_sc_hd__decap_12
XFILLER_0_27_639 VGND VGND VPWR VPWR sky130_fd_sc_hd__decap_6
XPHY_EDGE_ROW_35_Right_35 VGND VGND VPWR VPWR sky130_fd_sc_hd__decap_3
XFILLER_0_39_488 VGND VGND VPWR VPWR sky130_fd_sc_hd__decap_3
XFILLER_0_137_685 VPWR VGND VPWR VGND sky130_ef_sc_hd__decap_12
XFILLER_0_136_195 VGND VGND VPWR VPWR sky130_fd_sc_hd__fill_1
XFILLER_0_124_357 VGND VGND VPWR VPWR sky130_fd_sc_hd__decap_6
XFILLER_0_35_661 VGND VGND VPWR VPWR sky130_fd_sc_hd__decap_6
Xclkbuf_leaf_72_CLK clknet_3_2__leaf_CLK VGND VGND VPWR VPWR clknet_leaf_72_CLK sky130_fd_sc_hd__clkbuf_8
XFILLER_0_62_491 VGND VGND VPWR VPWR sky130_fd_sc_hd__decap_3
XTAP_TAPCELL_ROW_10_453 VGND VPWR sky130_fd_sc_hd__tapvpwrvgnd_1
XFILLER_0_1_205 VPWR VGND VPWR VGND sky130_ef_sc_hd__decap_12
XFILLER_0_120_530 VGND VGND VPWR VPWR sky130_fd_sc_hd__fill_2
XFILLER_0_1_249 VPWR VGND VPWR VGND sky130_ef_sc_hd__decap_12
XFILLER_0_50_697 VGND VGND VPWR VPWR sky130_fd_sc_hd__decap_3
XFILLER_0_5_39 VPWR VGND VPWR VGND sky130_ef_sc_hd__decap_12
XPHY_EDGE_ROW_44_Right_44 VGND VGND VPWR VPWR sky130_fd_sc_hd__decap_3
XFILLER_0_106_53 VPWR VGND VPWR VGND sky130_ef_sc_hd__decap_12
X_6830_ _3291_ VGND VGND VPWR VPWR _0903_ sky130_fd_sc_hd__clkbuf_1
X_6761_ _3251_ VGND VGND VPWR VPWR _0874_ sky130_fd_sc_hd__clkbuf_1
XFILLER_0_9_305 VPWR VGND VPWR VGND sky130_ef_sc_hd__decap_12
XTAP_TAPCELL_ROW_18_564 VGND VPWR sky130_fd_sc_hd__tapvpwrvgnd_1
XTAP_TAPCELL_ROW_18_575 VGND VPWR sky130_fd_sc_hd__tapvpwrvgnd_1
XTAP_TAPCELL_ROW_102_1835 VGND VPWR sky130_fd_sc_hd__tapvpwrvgnd_1
XTAP_TAPCELL_ROW_102_1824 VGND VPWR sky130_fd_sc_hd__tapvpwrvgnd_1
X_8500_ _3051_ rf.registers\[14\]\[31\] _4166_ VGND VGND VPWR VPWR _4201_ sky130_fd_sc_hd__mux2_1
XPHY_EDGE_ROW_53_Right_53 VGND VGND VPWR VPWR sky130_fd_sc_hd__decap_3
XFILLER_0_9_349 VPWR VGND VPWR VGND sky130_ef_sc_hd__decap_12
X_5712_ _2304_ _2379_ VGND VGND VPWR VPWR _2440_ sky130_fd_sc_hd__or2_1
XFILLER_0_122_41 VPWR VGND VPWR VGND sky130_ef_sc_hd__decap_12
X_6692_ rf.registers\[10\]\[9\] _3005_ _3205_ VGND VGND VPWR VPWR _3215_ sky130_fd_sc_hd__mux2_1
X_9480_ clknet_leaf_2_CLK _0568_ VGND VGND VPWR VPWR rf.registers\[20\]\[23\] sky130_fd_sc_hd__dfxtp_1
XFILLER_0_17_105 VGND VGND VPWR VPWR sky130_fd_sc_hd__decap_6
XFILLER_0_45_436 VGND VGND VPWR VPWR sky130_fd_sc_hd__fill_1
XTAP_TAPCELL_ROW_135_2323 VGND VPWR sky130_fd_sc_hd__tapvpwrvgnd_1
XFILLER_0_116_825 VPWR VGND VPWR VGND sky130_ef_sc_hd__decap_12
XFILLER_0_17_149 VPWR VGND VPWR VGND sky130_ef_sc_hd__decap_12
X_5643_ _2367_ _2372_ _1096_ VGND VGND VPWR VPWR _2373_ sky130_fd_sc_hd__mux2_1
X_8431_ _4164_ VGND VGND VPWR VPWR _0607_ sky130_fd_sc_hd__clkbuf_1
XFILLER_0_122_85 VPWR VGND VPWR VGND sky130_ef_sc_hd__decap_12
XFILLER_0_115_335 VGND VGND VPWR VPWR sky130_fd_sc_hd__fill_1
X_5574_ _2300_ _2303_ _2304_ VGND VGND VPWR VPWR _2305_ sky130_fd_sc_hd__mux2_1
X_8362_ rf.registers\[20\]\[30\] net37 _4094_ VGND VGND VPWR VPWR _4128_ sky130_fd_sc_hd__mux2_1
XFILLER_0_131_839 VGND VGND VPWR VPWR sky130_fd_sc_hd__fill_1
X_4525_ _1301_ _1306_ _1307_ VGND VGND VPWR VPWR _1308_ sky130_fd_sc_hd__a21oi_1
X_7313_ _3571_ VGND VGND VPWR VPWR _0082_ sky130_fd_sc_hd__clkbuf_1
XFILLER_0_53_491 VGND VGND VPWR VPWR sky130_fd_sc_hd__fill_1
XFILLER_0_41_620 VPWR VGND VPWR VGND sky130_ef_sc_hd__decap_12
X_8293_ _4091_ VGND VGND VPWR VPWR _0542_ sky130_fd_sc_hd__clkbuf_1
XFILLER_0_40_141 VGND VGND VPWR VPWR sky130_fd_sc_hd__decap_4
X_4456_ _1238_ _1241_ _1061_ VGND VGND VPWR VPWR _1242_ sky130_fd_sc_hd__mux2_1
X_7244_ rf.registers\[19\]\[17\] _3313_ _3527_ VGND VGND VPWR VPWR _3535_ sky130_fd_sc_hd__mux2_1
XPHY_EDGE_ROW_62_Right_62 VGND VGND VPWR VPWR sky130_fd_sc_hd__decap_3
X_7175_ _3498_ VGND VGND VPWR VPWR _0017_ sky130_fd_sc_hd__clkbuf_1
X_4387_ rf.registers\[0\]\[5\] rf.registers\[1\]\[5\] rf.registers\[2\]\[5\] rf.registers\[3\]\[5\]
+ _1139_ _1140_ VGND VGND VPWR VPWR _1177_ sky130_fd_sc_hd__mux4_1
XFILLER_0_1_783 VGND VGND VPWR VPWR sky130_fd_sc_hd__fill_1
XTAP_TAPCELL_ROW_113_1997 VGND VPWR sky130_fd_sc_hd__tapvpwrvgnd_1
XFILLER_0_0_293 VGND VGND VPWR VPWR sky130_fd_sc_hd__decap_8
X_6126_ _2764_ _2833_ _2340_ VGND VGND VPWR VPWR _2834_ sky130_fd_sc_hd__mux2_1
X_6057_ _1445_ _2757_ VGND VGND VPWR VPWR _2768_ sky130_fd_sc_hd__xnor2_2
X_5008_ _1760_ _1763_ _1764_ VGND VGND VPWR VPWR _1765_ sky130_fd_sc_hd__mux2_1
XFILLER_0_96_837 VGND VGND VPWR VPWR sky130_fd_sc_hd__fill_2
XTAP_TAPCELL_ROW_37_851 VGND VPWR sky130_fd_sc_hd__tapvpwrvgnd_1
XFILLER_0_138_405 VPWR VGND VPWR VGND sky130_ef_sc_hd__decap_12
XPHY_EDGE_ROW_71_Right_71 VGND VGND VPWR VPWR sky130_fd_sc_hd__decap_3
XFILLER_0_49_753 VPWR VGND VPWR VGND sky130_ef_sc_hd__decap_12
XTAP_TAPCELL_ROW_37_862 VGND VPWR sky130_fd_sc_hd__tapvpwrvgnd_1
XFILLER_0_138_449 VPWR VGND VPWR VGND sky130_ef_sc_hd__decap_12
XFILLER_0_138_427 VPWR VGND VPWR VGND sky130_ef_sc_hd__decap_12
X_6959_ _3379_ VGND VGND VPWR VPWR _0944_ sky130_fd_sc_hd__clkbuf_1
XFILLER_0_64_701 VPWR VGND VPWR VGND sky130_ef_sc_hd__decap_12
XFILLER_0_49_797 VPWR VGND VPWR VGND sky130_ef_sc_hd__decap_12
XFILLER_0_48_274 VGND VGND VPWR VPWR sky130_fd_sc_hd__decap_6
XFILLER_0_119_685 VPWR VGND VPWR VGND sky130_ef_sc_hd__decap_12
X_8629_ clknet_leaf_48_CLK _0741_ VGND VGND VPWR VPWR rf.registers\[17\]\[4\] sky130_fd_sc_hd__dfxtp_1
XFILLER_0_91_564 VGND VGND VPWR VPWR sky130_fd_sc_hd__fill_1
XFILLER_0_17_650 VGND VGND VPWR VPWR sky130_fd_sc_hd__decap_8
XFILLER_0_118_195 VGND VGND VPWR VPWR sky130_fd_sc_hd__fill_1
XFILLER_0_106_335 VGND VGND VPWR VPWR sky130_fd_sc_hd__decap_8
XFILLER_0_63_266 VPWR VGND VPWR VGND sky130_ef_sc_hd__decap_12
XFILLER_0_134_699 VGND VGND VPWR VPWR sky130_fd_sc_hd__fill_1
Xclkbuf_leaf_54_CLK clknet_3_6__leaf_CLK VGND VGND VPWR VPWR clknet_leaf_54_CLK sky130_fd_sc_hd__clkbuf_8
XFILLER_0_121_349 VPWR VGND VPWR VGND sky130_ef_sc_hd__decap_12
XFILLER_0_121_327 VGND VGND VPWR VPWR sky130_fd_sc_hd__decap_8
XPHY_EDGE_ROW_80_Right_80 VGND VGND VPWR VPWR sky130_fd_sc_hd__decap_3
XTAP_TAPCELL_ROW_75_1425 VGND VPWR sky130_fd_sc_hd__tapvpwrvgnd_1
XPHY_EDGE_ROW_15_Left_154 VGND VGND VPWR VPWR sky130_fd_sc_hd__decap_3
XFILLER_0_20_837 VGND VGND VPWR VPWR sky130_fd_sc_hd__fill_2
XFILLER_0_127_19 VPWR VGND VPWR VGND sky130_ef_sc_hd__decap_12
XPHY_EDGE_ROW_24_Left_163 VGND VGND VPWR VPWR sky130_fd_sc_hd__decap_3
XFILLER_0_99_697 VPWR VGND VPWR VGND sky130_ef_sc_hd__decap_12
XFILLER_0_129_405 VPWR VGND VPWR VGND sky130_ef_sc_hd__decap_12
XFILLER_0_86_358 VGND VGND VPWR VPWR sky130_fd_sc_hd__decap_6
XTAP_TAPCELL_ROW_86_1587 VGND VPWR sky130_fd_sc_hd__tapvpwrvgnd_1
XFILLER_0_52_27 VGND VGND VPWR VPWR sky130_fd_sc_hd__fill_1
XFILLER_0_129_449 VGND VGND VPWR VPWR sky130_fd_sc_hd__decap_4
XTAP_TAPCELL_ROW_15_523 VGND VPWR sky130_fd_sc_hd__tapvpwrvgnd_1
XFILLER_0_7_809 VPWR VGND VPWR VGND sky130_ef_sc_hd__decap_12
XFILLER_0_124_121 VPWR VGND VPWR VGND sky130_ef_sc_hd__decap_12
XFILLER_0_70_737 VPWR VGND VPWR VGND sky130_ef_sc_hd__decap_12
XFILLER_0_124_165 VPWR VGND VPWR VGND sky130_ef_sc_hd__decap_12
XTAP_TAPCELL_ROW_117_2053 VGND VPWR sky130_fd_sc_hd__tapvpwrvgnd_1
XFILLER_0_113_839 VGND VGND VPWR VPWR sky130_fd_sc_hd__fill_1
Xclkbuf_leaf_45_CLK clknet_3_7__leaf_CLK VGND VGND VPWR VPWR clknet_leaf_45_CLK sky130_fd_sc_hd__clkbuf_8
XPHY_EDGE_ROW_33_Left_172 VGND VGND VPWR VPWR sky130_fd_sc_hd__decap_3
XFILLER_0_2_525 VGND VGND VPWR VPWR sky130_fd_sc_hd__decap_6
XFILLER_0_22_141 VGND VGND VPWR VPWR sky130_fd_sc_hd__fill_2
XTAP_TAPCELL_ROW_130_2253 VGND VPWR sky130_fd_sc_hd__tapvpwrvgnd_1
X_4310_ rf.registers\[24\]\[3\] rf.registers\[25\]\[3\] rf.registers\[26\]\[3\] rf.registers\[27\]\[3\]
+ _1026_ _1027_ VGND VGND VPWR VPWR _1102_ sky130_fd_sc_hd__mux4_1
X_5290_ _1940_ _2023_ _2027_ _2031_ VGND VGND VPWR VPWR _2032_ sky130_fd_sc_hd__a2bb2o_4
XFILLER_0_50_483 VGND VGND VPWR VPWR sky130_fd_sc_hd__fill_1
XFILLER_0_11_837 VGND VGND VPWR VPWR sky130_fd_sc_hd__decap_3
XFILLER_0_2_569 VPWR VGND VPWR VGND sky130_ef_sc_hd__decap_12
X_4241_ A2[1] VGND VGND VPWR VPWR _1036_ sky130_fd_sc_hd__clkbuf_4
XFILLER_0_120_382 VGND VGND VPWR VPWR sky130_fd_sc_hd__fill_1
XFILLER_0_77_57 VPWR VGND VPWR VGND sky130_ef_sc_hd__decap_12
X_8980_ clknet_leaf_40_CLK _0068_ VGND VGND VPWR VPWR rf.registers\[3\]\[3\] sky130_fd_sc_hd__dfxtp_1
XPHY_EDGE_ROW_42_Left_181 VGND VGND VPWR VPWR sky130_fd_sc_hd__decap_3
X_7931_ _3386_ rf.registers\[23\]\[19\] _3890_ VGND VGND VPWR VPWR _3900_ sky130_fd_sc_hd__mux2_1
XFILLER_0_78_837 VGND VGND VPWR VPWR sky130_fd_sc_hd__fill_2
X_7862_ _3386_ rf.registers\[28\]\[19\] _3853_ VGND VGND VPWR VPWR _3863_ sky130_fd_sc_hd__mux2_1
XTAP_TAPCELL_ROW_34_810 VGND VPWR sky130_fd_sc_hd__tapvpwrvgnd_1
XFILLER_0_133_51 VGND VGND VPWR VPWR sky130_fd_sc_hd__decap_4
X_6813_ net25 VGND VGND VPWR VPWR _3280_ sky130_fd_sc_hd__buf_2
X_7793_ _3826_ VGND VGND VPWR VPWR _0307_ sky130_fd_sc_hd__clkbuf_1
XFILLER_0_58_561 VPWR VGND VPWR VGND sky130_ef_sc_hd__decap_12
XFILLER_0_9_113 VPWR VGND VPWR VGND sky130_ef_sc_hd__decap_12
XFILLER_0_46_701 VGND VGND VPWR VPWR sky130_fd_sc_hd__fill_1
X_6744_ rf.registers\[0\]\[1\] _2989_ _3241_ VGND VGND VPWR VPWR _3243_ sky130_fd_sc_hd__mux2_1
X_9532_ clknet_leaf_29_CLK _0620_ VGND VGND VPWR VPWR rf.registers\[14\]\[11\] sky130_fd_sc_hd__dfxtp_1
XFILLER_0_92_339 VGND VGND VPWR VPWR sky130_fd_sc_hd__decap_4
XFILLER_0_45_200 VGND VGND VPWR VPWR sky130_fd_sc_hd__decap_3
X_6675_ _3206_ VGND VGND VPWR VPWR _0833_ sky130_fd_sc_hd__clkbuf_1
X_9463_ clknet_leaf_56_CLK _0551_ VGND VGND VPWR VPWR rf.registers\[20\]\[6\] sky130_fd_sc_hd__dfxtp_1
XFILLER_0_85_391 VGND VGND VPWR VPWR sky130_fd_sc_hd__fill_1
XFILLER_0_42_82 VGND VGND VPWR VPWR sky130_fd_sc_hd__fill_2
XPHY_EDGE_ROW_51_Left_190 VGND VGND VPWR VPWR sky130_fd_sc_hd__decap_3
X_5626_ _2354_ _2355_ VGND VGND VPWR VPWR _2356_ sky130_fd_sc_hd__nand2_1
X_8414_ rf.registers\[18\]\[22\] net28 _4153_ VGND VGND VPWR VPWR _4156_ sky130_fd_sc_hd__mux2_1
X_9394_ clknet_leaf_42_CLK _0482_ VGND VGND VPWR VPWR rf.registers\[21\]\[1\] sky130_fd_sc_hd__dfxtp_1
Xclkbuf_leaf_36_CLK clknet_3_5__leaf_CLK VGND VGND VPWR VPWR clknet_leaf_36_CLK sky130_fd_sc_hd__clkbuf_8
XFILLER_0_45_299 VGND VGND VPWR VPWR sky130_fd_sc_hd__decap_6
XFILLER_0_5_385 VGND VGND VPWR VPWR sky130_fd_sc_hd__decap_6
X_5557_ _2193_ _2206_ VGND VGND VPWR VPWR _2288_ sky130_fd_sc_hd__nor2_1
X_8345_ _4119_ VGND VGND VPWR VPWR _0566_ sky130_fd_sc_hd__clkbuf_1
XFILLER_0_131_669 VGND VGND VPWR VPWR sky130_fd_sc_hd__decap_3
X_4508_ _1034_ VGND VGND VPWR VPWR _1291_ sky130_fd_sc_hd__clkbuf_8
XTAP_TAPCELL_ROW_57_1155 VGND VPWR sky130_fd_sc_hd__tapvpwrvgnd_1
X_8276_ _3031_ rf.registers\[25\]\[21\] _4081_ VGND VGND VPWR VPWR _4083_ sky130_fd_sc_hd__mux2_1
XFILLER_0_14_697 VGND VGND VPWR VPWR sky130_fd_sc_hd__decap_3
X_5488_ _2218_ VGND VGND VPWR VPWR _2219_ sky130_fd_sc_hd__buf_2
X_4439_ _1222_ _1223_ _1224_ _1225_ _1143_ _1061_ VGND VGND VPWR VPWR _1226_ sky130_fd_sc_hd__mux4_1
X_7227_ rf.registers\[19\]\[9\] _3296_ _3516_ VGND VGND VPWR VPWR _3526_ sky130_fd_sc_hd__mux2_1
XFILLER_0_111_393 VGND VGND VPWR VPWR sky130_fd_sc_hd__decap_8
X_7158_ _3489_ VGND VGND VPWR VPWR _0009_ sky130_fd_sc_hd__clkbuf_1
XTAP_TAPCELL_ROW_70_1355 VGND VPWR sky130_fd_sc_hd__tapvpwrvgnd_1
XTAP_TAPCELL_ROW_70_1344 VGND VPWR sky130_fd_sc_hd__tapvpwrvgnd_1
X_7089_ rf.registers\[5\]\[8\] _3294_ _3444_ VGND VGND VPWR VPWR _3453_ sky130_fd_sc_hd__mux2_1
X_6109_ _2798_ _2807_ _2808_ _2817_ _2541_ VGND VGND VPWR VPWR net127 sky130_fd_sc_hd__o32a_2
XFILLER_0_138_213 VGND VGND VPWR VPWR sky130_fd_sc_hd__decap_8
XFILLER_0_68_358 VGND VGND VPWR VPWR sky130_fd_sc_hd__decap_6
XFILLER_0_138_257 VPWR VGND VPWR VGND sky130_ef_sc_hd__decap_12
XFILLER_0_49_594 VGND VGND VPWR VPWR sky130_fd_sc_hd__decap_8
XFILLER_0_64_586 VGND VGND VPWR VPWR sky130_fd_sc_hd__fill_2
XFILLER_0_52_737 VPWR VGND VPWR VGND sky130_ef_sc_hd__decap_12
Xclkbuf_leaf_27_CLK clknet_3_5__leaf_CLK VGND VGND VPWR VPWR clknet_leaf_27_CLK sky130_fd_sc_hd__clkbuf_8
XFILLER_0_134_485 VGND VGND VPWR VPWR sky130_fd_sc_hd__fill_1
XFILLER_0_121_113 VPWR VGND VPWR VGND sky130_ef_sc_hd__decap_12
XFILLER_0_20_601 VGND VGND VPWR VPWR sky130_fd_sc_hd__fill_1
XFILLER_0_60_781 VPWR VGND VPWR VGND sky130_ef_sc_hd__decap_12
XFILLER_0_20_623 VPWR VGND VPWR VGND sky130_ef_sc_hd__decap_12
XTAP_TAPCELL_ROW_88_1616 VGND VPWR sky130_fd_sc_hd__tapvpwrvgnd_1
XTAP_TAPCELL_ROW_88_1627 VGND VPWR sky130_fd_sc_hd__tapvpwrvgnd_1
XFILLER_0_2_29 VPWR VGND VPWR VGND sky130_ef_sc_hd__decap_12
XFILLER_0_63_37 VGND VGND VPWR VPWR sky130_fd_sc_hd__fill_1
XFILLER_0_87_689 VPWR VGND VPWR VGND sky130_ef_sc_hd__decap_12
XFILLER_0_28_701 VGND VGND VPWR VPWR sky130_fd_sc_hd__fill_1
X_4790_ rf.registers\[28\]\[28\] rf.registers\[29\]\[28\] rf.registers\[30\]\[28\]
+ rf.registers\[31\]\[28\] _1294_ _1295_ VGND VGND VPWR VPWR _1557_ sky130_fd_sc_hd__mux4_1
XFILLER_0_129_279 VGND VGND VPWR VPWR sky130_fd_sc_hd__fill_1
XFILLER_0_103_43 VPWR VGND VPWR VGND sky130_ef_sc_hd__decap_12
XFILLER_0_7_617 VGND VGND VPWR VPWR sky130_fd_sc_hd__decap_3
XANTENNA_18 net134 VGND VGND VPWR VPWR sky130_fd_sc_hd__diode_2
XFILLER_0_27_244 VGND VGND VPWR VPWR sky130_fd_sc_hd__fill_2
XFILLER_0_28_745 VGND VGND VPWR VPWR sky130_fd_sc_hd__decap_8
XFILLER_0_12_41 VPWR VGND VPWR VGND sky130_ef_sc_hd__decap_12
XFILLER_0_15_417 VPWR VGND VPWR VGND sky130_ef_sc_hd__decap_12
XFILLER_0_43_726 VGND VGND VPWR VPWR sky130_fd_sc_hd__fill_2
XTAP_TAPCELL_ROW_99_1778 VGND VPWR sky130_fd_sc_hd__tapvpwrvgnd_1
Xclkbuf_leaf_18_CLK clknet_3_4__leaf_CLK VGND VGND VPWR VPWR clknet_leaf_18_CLK sky130_fd_sc_hd__clkbuf_8
XFILLER_0_70_545 VPWR VGND VPWR VGND sky130_ef_sc_hd__decap_12
X_6460_ _3089_ VGND VGND VPWR VPWR _0735_ sky130_fd_sc_hd__clkbuf_1
XFILLER_0_12_85 VPWR VGND VPWR VGND sky130_ef_sc_hd__decap_12
XTAP_TAPCELL_ROW_99_1789 VGND VPWR sky130_fd_sc_hd__tapvpwrvgnd_1
X_6391_ rf.registers\[12\]\[31\] _3051_ _2986_ VGND VGND VPWR VPWR _3052_ sky130_fd_sc_hd__mux2_1
X_5411_ rf.registers\[0\]\[28\] rf.registers\[1\]\[28\] rf.registers\[2\]\[28\] rf.registers\[3\]\[28\]
+ _2077_ _2078_ VGND VGND VPWR VPWR _2146_ sky130_fd_sc_hd__mux4_1
XFILLER_0_42_269 VGND VGND VPWR VPWR sky130_fd_sc_hd__decap_4
Xoutput103 net103 VGND VGND VPWR VPWR RD2[2] sky130_fd_sc_hd__buf_1
XFILLER_0_101_809 VPWR VGND VPWR VGND sky130_ef_sc_hd__decap_12
XFILLER_0_88_78 VGND VGND VPWR VPWR sky130_fd_sc_hd__fill_1
X_8130_ _4005_ VGND VGND VPWR VPWR _0465_ sky130_fd_sc_hd__clkbuf_1
Xoutput125 net125 VGND VGND VPWR VPWR alu_result[20] sky130_fd_sc_hd__buf_1
Xoutput114 net114 VGND VGND VPWR VPWR alu_result[10] sky130_fd_sc_hd__buf_1
XFILLER_0_2_333 VPWR VGND VPWR VGND sky130_ef_sc_hd__decap_12
X_5342_ _1943_ VGND VGND VPWR VPWR _2081_ sky130_fd_sc_hd__buf_4
X_8061_ rf.registers\[7\]\[16\] _3311_ _3962_ VGND VGND VPWR VPWR _3969_ sky130_fd_sc_hd__mux2_1
XFILLER_0_10_133 VGND VGND VPWR VPWR sky130_fd_sc_hd__decap_6
Xoutput136 net136 VGND VGND VPWR VPWR alu_result[30] sky130_fd_sc_hd__buf_1
XFILLER_0_2_377 VPWR VGND VPWR VGND sky130_ef_sc_hd__decap_12
X_7012_ _3412_ VGND VGND VPWR VPWR _0964_ sky130_fd_sc_hd__clkbuf_1
XFILLER_0_10_177 VPWR VGND VPWR VGND sky130_ef_sc_hd__decap_12
X_5273_ _1940_ _2005_ _2015_ VGND VGND VPWR VPWR _2016_ sky130_fd_sc_hd__o21ai_4
XTAP_TAPCELL_ROW_110_1956 VGND VPWR sky130_fd_sc_hd__tapvpwrvgnd_1
XTAP_TAPCELL_ROW_110_1945 VGND VPWR sky130_fd_sc_hd__tapvpwrvgnd_1
XTAP_TAPCELL_ROW_52_1085 VGND VPWR sky130_fd_sc_hd__tapvpwrvgnd_1
XTAP_TAPCELL_ROW_52_1074 VGND VPWR sky130_fd_sc_hd__tapvpwrvgnd_1
X_8963_ clknet_leaf_5_CLK _0051_ VGND VGND VPWR VPWR rf.registers\[19\]\[18\] sky130_fd_sc_hd__dfxtp_1
X_7914_ _3891_ VGND VGND VPWR VPWR _0363_ sky130_fd_sc_hd__clkbuf_1
X_8894_ clknet_leaf_14_CLK _1006_ VGND VGND VPWR VPWR rf.registers\[5\]\[13\] sky130_fd_sc_hd__dfxtp_1
X_7845_ _3854_ VGND VGND VPWR VPWR _0331_ sky130_fd_sc_hd__clkbuf_1
XFILLER_0_78_689 VGND VGND VPWR VPWR sky130_fd_sc_hd__decap_8
XFILLER_0_135_205 VPWR VGND VPWR VGND sky130_ef_sc_hd__decap_12
X_7776_ rf.registers\[9\]\[10\] _3298_ _3817_ VGND VGND VPWR VPWR _3818_ sky130_fd_sc_hd__mux2_1
X_4988_ rf.registers\[8\]\[5\] rf.registers\[9\]\[5\] rf.registers\[10\]\[5\] rf.registers\[11\]\[5\]
+ _1729_ _1731_ VGND VGND VPWR VPWR _1746_ sky130_fd_sc_hd__mux4_1
XFILLER_0_19_756 VGND VGND VPWR VPWR sky130_fd_sc_hd__decap_3
X_9515_ clknet_leaf_70_CLK _0603_ VGND VGND VPWR VPWR rf.registers\[18\]\[26\] sky130_fd_sc_hd__dfxtp_1
XFILLER_0_135_249 VPWR VGND VPWR VGND sky130_ef_sc_hd__decap_12
XFILLER_0_80_309 VGND VGND VPWR VPWR sky130_fd_sc_hd__fill_1
X_6727_ _3233_ VGND VGND VPWR VPWR _0858_ sky130_fd_sc_hd__clkbuf_1
XFILLER_0_61_534 VPWR VGND VPWR VGND sky130_ef_sc_hd__decap_12
X_9446_ clknet_leaf_79_CLK _0534_ VGND VGND VPWR VPWR rf.registers\[25\]\[21\] sky130_fd_sc_hd__dfxtp_1
X_6658_ _3196_ VGND VGND VPWR VPWR _0826_ sky130_fd_sc_hd__clkbuf_1
XFILLER_0_33_214 VGND VGND VPWR VPWR sky130_fd_sc_hd__decap_8
XFILLER_0_34_737 VGND VGND VPWR VPWR sky130_fd_sc_hd__decap_6
X_9377_ clknet_leaf_5_CLK _0465_ VGND VGND VPWR VPWR rf.registers\[26\]\[16\] sky130_fd_sc_hd__dfxtp_1
X_5609_ _2335_ _2338_ _2332_ VGND VGND VPWR VPWR _2339_ sky130_fd_sc_hd__mux2_1
X_8328_ _4110_ VGND VGND VPWR VPWR _0558_ sky130_fd_sc_hd__clkbuf_1
XFILLER_0_5_193 VPWR VGND VPWR VGND sky130_ef_sc_hd__decap_12
X_6589_ _3159_ VGND VGND VPWR VPWR _0794_ sky130_fd_sc_hd__clkbuf_1
XFILLER_0_112_691 VGND VGND VPWR VPWR sky130_fd_sc_hd__decap_8
X_8259_ _3014_ rf.registers\[25\]\[13\] _4070_ VGND VGND VPWR VPWR _4074_ sky130_fd_sc_hd__mux2_1
XTAP_TAPCELL_ROW_6_387 VGND VPWR sky130_fd_sc_hd__tapvpwrvgnd_1
XTAP_TAPCELL_ROW_83_1546 VGND VPWR sky130_fd_sc_hd__tapvpwrvgnd_1
XTAP_TAPCELL_ROW_25_673 VGND VPWR sky130_fd_sc_hd__tapvpwrvgnd_1
Xinput16 WD3[11] VGND VGND VPWR VPWR net16 sky130_fd_sc_hd__clkbuf_2
Xinput27 WD3[21] VGND VGND VPWR VPWR net27 sky130_fd_sc_hd__buf_2
XFILLER_0_135_783 VGND VGND VPWR VPWR sky130_fd_sc_hd__fill_1
XTAP_TAPCELL_ROW_114_2012 VGND VPWR sky130_fd_sc_hd__tapvpwrvgnd_1
XFILLER_0_52_567 VPWR VGND VPWR VGND sky130_ef_sc_hd__decap_12
Xinput38 WD3[31] VGND VGND VPWR VPWR net38 sky130_fd_sc_hd__clkbuf_4
XFILLER_0_24_269 VGND VGND VPWR VPWR sky130_fd_sc_hd__fill_2
XFILLER_0_40_707 VGND VGND VPWR VPWR sky130_fd_sc_hd__fill_2
XFILLER_0_122_477 VGND VGND VPWR VPWR sky130_fd_sc_hd__fill_2
XFILLER_0_58_15 VPWR VGND VPWR VGND sky130_ef_sc_hd__decap_12
Xclkbuf_leaf_7_CLK clknet_3_1__leaf_CLK VGND VGND VPWR VPWR clknet_leaf_7_CLK sky130_fd_sc_hd__clkbuf_8
XTAP_TAPCELL_ROW_125_2174 VGND VPWR sky130_fd_sc_hd__tapvpwrvgnd_1
XFILLER_0_87_420 VGND VGND VPWR VPWR sky130_fd_sc_hd__decap_8
X_5960_ _1872_ _2648_ _2669_ _1888_ VGND VGND VPWR VPWR _2677_ sky130_fd_sc_hd__o22a_1
X_4911_ _1670_ _1671_ _1621_ VGND VGND VPWR VPWR _1672_ sky130_fd_sc_hd__mux2_1
X_5891_ _1842_ _2611_ VGND VGND VPWR VPWR _2612_ sky130_fd_sc_hd__nor2_1
X_7630_ rf.registers\[2\]\[6\] _3290_ _3733_ VGND VGND VPWR VPWR _3740_ sky130_fd_sc_hd__mux2_1
XTAP_TAPCELL_ROW_44_960 VGND VPWR sky130_fd_sc_hd__tapvpwrvgnd_1
XFILLER_0_117_205 VPWR VGND VPWR VGND sky130_ef_sc_hd__decap_12
XFILLER_0_114_53 VPWR VGND VPWR VGND sky130_ef_sc_hd__decap_12
X_4842_ _1602_ _1605_ _1168_ VGND VGND VPWR VPWR _1606_ sky130_fd_sc_hd__mux2_1
XFILLER_0_28_531 VGND VGND VPWR VPWR sky130_fd_sc_hd__fill_1
XFILLER_0_117_249 VGND VGND VPWR VPWR sky130_fd_sc_hd__decap_4
XFILLER_0_114_97 VPWR VGND VPWR VGND sky130_ef_sc_hd__decap_12
X_7561_ _3703_ VGND VGND VPWR VPWR _0198_ sky130_fd_sc_hd__clkbuf_1
XFILLER_0_62_309 VGND VGND VPWR VPWR sky130_fd_sc_hd__decap_4
XFILLER_0_7_447 VGND VGND VPWR VPWR sky130_fd_sc_hd__fill_1
X_4773_ _1539_ _1540_ _1312_ VGND VGND VPWR VPWR _1541_ sky130_fd_sc_hd__mux2_1
XFILLER_0_133_709 VPWR VGND VPWR VGND sky130_ef_sc_hd__decap_12
X_9300_ clknet_leaf_38_CLK _0388_ VGND VGND VPWR VPWR rf.registers\[22\]\[3\] sky130_fd_sc_hd__dfxtp_1
XFILLER_0_99_55 VGND VGND VPWR VPWR sky130_fd_sc_hd__fill_1
X_7492_ _3357_ rf.registers\[31\]\[5\] _3661_ VGND VGND VPWR VPWR _3667_ sky130_fd_sc_hd__mux2_1
XFILLER_0_71_821 VPWR VGND VPWR VGND sky130_ef_sc_hd__decap_12
X_6512_ _3118_ VGND VGND VPWR VPWR _0758_ sky130_fd_sc_hd__clkbuf_1
XFILLER_0_15_225 VPWR VGND VPWR VGND sky130_ef_sc_hd__decap_12
XFILLER_0_130_41 VPWR VGND VPWR VGND sky130_ef_sc_hd__decap_12
X_6443_ rf.registers\[11\]\[22\] _3033_ _3078_ VGND VGND VPWR VPWR _3081_ sky130_fd_sc_hd__mux2_1
X_9231_ clknet_leaf_61_CLK _0319_ VGND VGND VPWR VPWR rf.registers\[9\]\[30\] sky130_fd_sc_hd__dfxtp_1
XFILLER_0_130_85 VPWR VGND VPWR VGND sky130_ef_sc_hd__decap_12
XFILLER_0_125_293 VPWR VGND VPWR VGND sky130_ef_sc_hd__decap_12
XFILLER_0_113_433 VGND VGND VPWR VPWR sky130_fd_sc_hd__decap_4
XFILLER_0_3_653 VPWR VGND VPWR VGND sky130_ef_sc_hd__decap_12
XFILLER_0_24_792 VPWR VGND VPWR VGND sky130_ef_sc_hd__decap_12
XFILLER_0_3_697 VPWR VGND VPWR VGND sky130_ef_sc_hd__decap_12
XFILLER_0_2_141 VPWR VGND VPWR VGND sky130_ef_sc_hd__decap_12
X_9162_ clknet_leaf_70_CLK _0250_ VGND VGND VPWR VPWR rf.registers\[2\]\[25\] sky130_fd_sc_hd__dfxtp_1
X_6374_ _3040_ VGND VGND VPWR VPWR _0698_ sky130_fd_sc_hd__clkbuf_1
X_8113_ _3996_ VGND VGND VPWR VPWR _0457_ sky130_fd_sc_hd__clkbuf_1
XTAP_TAPCELL_ROW_54_1114 VGND VPWR sky130_fd_sc_hd__tapvpwrvgnd_1
XTAP_TAPCELL_ROW_54_1103 VGND VPWR sky130_fd_sc_hd__tapvpwrvgnd_1
X_5325_ rf.registers\[16\]\[24\] rf.registers\[17\]\[24\] rf.registers\[18\]\[24\]
+ rf.registers\[19\]\[24\] _1999_ _2000_ VGND VGND VPWR VPWR _2064_ sky130_fd_sc_hd__mux4_1
X_9093_ clknet_leaf_81_CLK _0181_ VGND VGND VPWR VPWR rf.registers\[31\]\[20\] sky130_fd_sc_hd__dfxtp_1
X_8044_ rf.registers\[7\]\[8\] _3294_ _3951_ VGND VGND VPWR VPWR _3960_ sky130_fd_sc_hd__mux2_1
X_5256_ _1929_ VGND VGND VPWR VPWR _1999_ sky130_fd_sc_hd__buf_4
XFILLER_0_54_3 VPWR VGND VPWR VGND sky130_ef_sc_hd__decap_12
XFILLER_0_11_497 VGND VGND VPWR VPWR sky130_fd_sc_hd__decap_6
X_5187_ _1768_ _1933_ _1764_ VGND VGND VPWR VPWR _1934_ sky130_fd_sc_hd__o21a_1
XTAP_TAPCELL_ROW_3_346 VGND VPWR sky130_fd_sc_hd__tapvpwrvgnd_1
X_8946_ clknet_leaf_44_CLK _0034_ VGND VGND VPWR VPWR rf.registers\[19\]\[1\] sky130_fd_sc_hd__dfxtp_1
XFILLER_0_109_706 VPWR VGND VPWR VGND sky130_ef_sc_hd__decap_12
XFILLER_0_66_615 VPWR VGND VPWR VGND sky130_ef_sc_hd__decap_12
X_8877_ clknet_leaf_90_CLK _0989_ VGND VGND VPWR VPWR rf.registers\[6\]\[28\] sky130_fd_sc_hd__dfxtp_1
XFILLER_0_136_525 VGND VGND VPWR VPWR sky130_fd_sc_hd__decap_6
X_7828_ _3845_ VGND VGND VPWR VPWR _0323_ sky130_fd_sc_hd__clkbuf_1
XTAP_TAPCELL_ROW_65_1276 VGND VPWR sky130_fd_sc_hd__tapvpwrvgnd_1
X_7759_ rf.registers\[9\]\[2\] _3282_ _3806_ VGND VGND VPWR VPWR _3809_ sky130_fd_sc_hd__mux2_1
XFILLER_0_108_238 VGND VGND VPWR VPWR sky130_fd_sc_hd__fill_1
XFILLER_0_19_553 VGND VGND VPWR VPWR sky130_fd_sc_hd__decap_6
XTAP_TAPCELL_ROW_22_632 VGND VPWR sky130_fd_sc_hd__tapvpwrvgnd_1
XFILLER_0_136_569 VPWR VGND VPWR VGND sky130_ef_sc_hd__decap_12
XPHY_EDGE_ROW_129_Right_129 VGND VGND VPWR VPWR sky130_fd_sc_hd__decap_3
XFILLER_0_117_783 VGND VGND VPWR VPWR sky130_fd_sc_hd__fill_1
X_9429_ clknet_leaf_54_CLK _0517_ VGND VGND VPWR VPWR rf.registers\[25\]\[4\] sky130_fd_sc_hd__dfxtp_1
XFILLER_0_21_228 VGND VGND VPWR VPWR sky130_fd_sc_hd__fill_2
XFILLER_0_34_589 VGND VGND VPWR VPWR sky130_fd_sc_hd__decap_8
XFILLER_0_104_477 VGND VGND VPWR VPWR sky130_fd_sc_hd__fill_2
XFILLER_0_30_751 VGND VGND VPWR VPWR sky130_fd_sc_hd__decap_4
XFILLER_0_28_29 VPWR VGND VPWR VGND sky130_ef_sc_hd__decap_12
XFILLER_0_100_683 VPWR VGND VPWR VGND sky130_ef_sc_hd__decap_12
XFILLER_0_135_19 VPWR VGND VPWR VGND sky130_ef_sc_hd__decap_12
XFILLER_0_89_729 VPWR VGND VPWR VGND sky130_ef_sc_hd__decap_12
XFILLER_0_69_420 VPWR VGND VPWR VGND sky130_ef_sc_hd__decap_12
XFILLER_0_60_27 VGND VGND VPWR VPWR sky130_fd_sc_hd__fill_1
XFILLER_0_127_558 VGND VGND VPWR VPWR sky130_fd_sc_hd__fill_2
XTAP_TAPCELL_ROW_120_2093 VGND VPWR sky130_fd_sc_hd__tapvpwrvgnd_1
XFILLER_0_56_169 VPWR VGND VPWR VGND sky130_ef_sc_hd__decap_12
XFILLER_0_25_501 VGND VGND VPWR VPWR sky130_fd_sc_hd__decap_3
XFILLER_0_44_309 VGND VGND VPWR VPWR sky130_fd_sc_hd__decap_4
XFILLER_0_53_821 VPWR VGND VPWR VGND sky130_ef_sc_hd__decap_12
XPHY_EDGE_ROW_7_Left_146 VGND VGND VPWR VPWR sky130_fd_sc_hd__decap_3
XFILLER_0_123_753 VPWR VGND VPWR VGND sky130_ef_sc_hd__decap_12
XTAP_TAPCELL_ROW_96_1737 VGND VPWR sky130_fd_sc_hd__tapvpwrvgnd_1
XFILLER_0_13_729 VGND VGND VPWR VPWR sky130_fd_sc_hd__decap_6
XFILLER_0_25_589 VGND VGND VPWR VPWR sky130_fd_sc_hd__decap_4
XFILLER_0_123_797 VPWR VGND VPWR VGND sky130_ef_sc_hd__decap_12
XFILLER_0_0_601 VPWR VGND VPWR VGND sky130_ef_sc_hd__decap_12
XFILLER_0_0_645 VGND VGND VPWR VPWR sky130_fd_sc_hd__decap_6
X_5110_ rf.registers\[24\]\[12\] rf.registers\[25\]\[12\] rf.registers\[26\]\[12\]
+ rf.registers\[27\]\[12\] _1694_ _1695_ VGND VGND VPWR VPWR _1861_ sky130_fd_sc_hd__mux4_1
XFILLER_0_0_667 VGND VGND VPWR VPWR sky130_fd_sc_hd__decap_4
X_6090_ _2602_ _2603_ _2234_ VGND VGND VPWR VPWR _2799_ sky130_fd_sc_hd__mux2_1
XTAP_TAPCELL_ROW_127_2203 VGND VPWR sky130_fd_sc_hd__tapvpwrvgnd_1
X_5041_ rf.registers\[20\]\[8\] rf.registers\[21\]\[8\] rf.registers\[22\]\[8\] rf.registers\[23\]\[8\]
+ _1795_ _1736_ VGND VGND VPWR VPWR _1796_ sky130_fd_sc_hd__mux4_1
XFILLER_0_85_57 VGND VGND VPWR VPWR sky130_fd_sc_hd__decap_4
X_8800_ clknet_leaf_22_CLK _0912_ VGND VGND VPWR VPWR rf.registers\[16\]\[15\] sky130_fd_sc_hd__dfxtp_1
XTAP_TAPCELL_ROW_0_305 VGND VPWR sky130_fd_sc_hd__tapvpwrvgnd_1
X_8731_ clknet_leaf_33_CLK _0843_ VGND VGND VPWR VPWR rf.registers\[10\]\[10\] sky130_fd_sc_hd__dfxtp_1
X_6992_ _2972_ rf.registers\[15\]\[27\] _3389_ VGND VGND VPWR VPWR _3401_ sky130_fd_sc_hd__mux2_1
X_5943_ _2329_ _2336_ VGND VGND VPWR VPWR _2661_ sky130_fd_sc_hd__nand2_1
XTAP_TAPCELL_ROW_105_1877 VGND VPWR sky130_fd_sc_hd__tapvpwrvgnd_1
XFILLER_0_75_445 VGND VGND VPWR VPWR sky130_fd_sc_hd__decap_3
X_8662_ clknet_leaf_65_CLK _0774_ VGND VGND VPWR VPWR rf.registers\[1\]\[5\] sky130_fd_sc_hd__dfxtp_1
XFILLER_0_8_701 VGND VGND VPWR VPWR sky130_fd_sc_hd__decap_3
X_5874_ _2552_ _2595_ _2383_ VGND VGND VPWR VPWR _2596_ sky130_fd_sc_hd__mux2_1
X_8593_ clknet_leaf_40_CLK _0705_ VGND VGND VPWR VPWR rf.registers\[11\]\[0\] sky130_fd_sc_hd__dfxtp_1
XFILLER_0_8_745 VGND VGND VPWR VPWR sky130_fd_sc_hd__decap_8
XFILLER_0_16_501 VPWR VGND VPWR VGND sky130_ef_sc_hd__decap_12
X_7613_ _3730_ VGND VGND VPWR VPWR _0223_ sky130_fd_sc_hd__clkbuf_1
XFILLER_0_47_169 VGND VGND VPWR VPWR sky130_fd_sc_hd__decap_6
X_4825_ _1586_ _1589_ _1168_ VGND VGND VPWR VPWR _1590_ sky130_fd_sc_hd__mux2_1
XTAP_TAPCELL_ROW_138_2365 VGND VPWR sky130_fd_sc_hd__tapvpwrvgnd_1
X_7544_ _2978_ rf.registers\[31\]\[30\] _3660_ VGND VGND VPWR VPWR _3694_ sky130_fd_sc_hd__mux2_1
XFILLER_0_28_361 VGND VGND VPWR VPWR sky130_fd_sc_hd__decap_3
XTAP_TAPCELL_ROW_138_2387 VGND VPWR sky130_fd_sc_hd__tapvpwrvgnd_1
XTAP_TAPCELL_ROW_138_2376 VGND VPWR sky130_fd_sc_hd__tapvpwrvgnd_1
XTAP_TAPCELL_ROW_60_1195 VGND VPWR sky130_fd_sc_hd__tapvpwrvgnd_1
XFILLER_0_16_545 VPWR VGND VPWR VGND sky130_ef_sc_hd__decap_12
X_4756_ _1523_ _1524_ _1144_ VGND VGND VPWR VPWR _1525_ sky130_fd_sc_hd__mux2_1
XFILLER_0_70_150 VGND VGND VPWR VPWR sky130_fd_sc_hd__decap_4
X_4687_ _1291_ _1460_ _1024_ VGND VGND VPWR VPWR _1461_ sky130_fd_sc_hd__a21oi_1
XFILLER_0_16_589 VPWR VGND VPWR VGND sky130_ef_sc_hd__decap_12
X_7475_ _3657_ VGND VGND VPWR VPWR _0158_ sky130_fd_sc_hd__clkbuf_1
X_9214_ clknet_leaf_29_CLK _0302_ VGND VGND VPWR VPWR rf.registers\[9\]\[13\] sky130_fd_sc_hd__dfxtp_1
X_6426_ rf.registers\[11\]\[14\] _3016_ _3067_ VGND VGND VPWR VPWR _3072_ sky130_fd_sc_hd__mux2_1
XFILLER_0_3_461 VPWR VGND VPWR VGND sky130_ef_sc_hd__decap_12
XFILLER_0_31_559 VGND VGND VPWR VPWR sky130_fd_sc_hd__fill_1
X_9145_ clknet_leaf_47_CLK _0233_ VGND VGND VPWR VPWR rf.registers\[2\]\[8\] sky130_fd_sc_hd__dfxtp_1
X_6357_ _2986_ VGND VGND VPWR VPWR _3029_ sky130_fd_sc_hd__clkbuf_8
XTAP_TAPCELL_ROW_8_427 VGND VPWR sky130_fd_sc_hd__tapvpwrvgnd_1
XTAP_TAPCELL_ROW_8_416 VGND VPWR sky130_fd_sc_hd__tapvpwrvgnd_1
XFILLER_0_11_261 VPWR VGND VPWR VGND sky130_ef_sc_hd__decap_12
X_5308_ rf.registers\[16\]\[23\] rf.registers\[17\]\[23\] rf.registers\[18\]\[23\]
+ rf.registers\[19\]\[23\] _1735_ _1773_ VGND VGND VPWR VPWR _2048_ sky130_fd_sc_hd__mux4_1
X_9076_ clknet_leaf_38_CLK _0164_ VGND VGND VPWR VPWR rf.registers\[31\]\[3\] sky130_fd_sc_hd__dfxtp_1
X_6288_ _2980_ rf.registers\[13\]\[31\] _2968_ VGND VGND VPWR VPWR _2981_ sky130_fd_sc_hd__mux2_1
X_5239_ rf.registers\[20\]\[19\] rf.registers\[21\]\[19\] rf.registers\[22\]\[19\]
+ rf.registers\[23\]\[19\] _1749_ _1750_ VGND VGND VPWR VPWR _1983_ sky130_fd_sc_hd__mux4_1
X_8027_ _3950_ VGND VGND VPWR VPWR _3951_ sky130_fd_sc_hd__buf_4
XTAP_TAPCELL_ROW_67_1305 VGND VPWR sky130_fd_sc_hd__tapvpwrvgnd_1
XTAP_TAPCELL_ROW_27_702 VGND VPWR sky130_fd_sc_hd__tapvpwrvgnd_1
X_8929_ clknet_leaf_12_CLK _0017_ VGND VGND VPWR VPWR rf.registers\[4\]\[16\] sky130_fd_sc_hd__dfxtp_1
XFILLER_0_39_615 VGND VGND VPWR VPWR sky130_fd_sc_hd__fill_1
XTAP_TAPCELL_ROW_80_1505 VGND VPWR sky130_fd_sc_hd__tapvpwrvgnd_1
XFILLER_0_66_445 VGND VGND VPWR VPWR sky130_fd_sc_hd__fill_1
XFILLER_0_136_333 VPWR VGND VPWR VGND sky130_ef_sc_hd__decap_12
XFILLER_0_66_489 VPWR VGND VPWR VGND sky130_ef_sc_hd__decap_12
XFILLER_0_66_467 VGND VGND VPWR VPWR sky130_fd_sc_hd__decap_8
XFILLER_0_54_607 VGND VGND VPWR VPWR sky130_fd_sc_hd__fill_1
XFILLER_0_26_309 VGND VGND VPWR VPWR sky130_fd_sc_hd__decap_6
XFILLER_0_19_361 VGND VGND VPWR VPWR sky130_fd_sc_hd__fill_2
XFILLER_0_35_821 VPWR VGND VPWR VGND sky130_ef_sc_hd__decap_12
XFILLER_0_136_377 VPWR VGND VPWR VGND sky130_ef_sc_hd__decap_12
XFILLER_0_124_528 VGND VGND VPWR VPWR sky130_fd_sc_hd__fill_1
XFILLER_0_62_651 VPWR VGND VPWR VGND sky130_ef_sc_hd__decap_12
XFILLER_0_34_353 VGND VGND VPWR VPWR sky130_fd_sc_hd__decap_8
XFILLER_0_105_753 VPWR VGND VPWR VGND sky130_ef_sc_hd__decap_12
XFILLER_0_50_813 VPWR VGND VPWR VGND sky130_ef_sc_hd__decap_12
XFILLER_0_120_701 VPWR VGND VPWR VGND sky130_ef_sc_hd__decap_12
XFILLER_0_105_797 VPWR VGND VPWR VGND sky130_ef_sc_hd__decap_12
XTAP_TAPCELL_ROW_78_1467 VGND VPWR sky130_fd_sc_hd__tapvpwrvgnd_1
XFILLER_0_104_274 VGND VGND VPWR VPWR sky130_fd_sc_hd__decap_4
XFILLER_0_30_592 VGND VGND VPWR VPWR sky130_fd_sc_hd__fill_1
XTAP_TAPCELL_ROW_91_1667 VGND VPWR sky130_fd_sc_hd__tapvpwrvgnd_1
XTAP_TAPCELL_ROW_122_2133 VGND VPWR sky130_fd_sc_hd__tapvpwrvgnd_1
XFILLER_0_85_765 VPWR VGND VPWR VGND sky130_ef_sc_hd__decap_12
XFILLER_0_84_253 VGND VGND VPWR VPWR sky130_fd_sc_hd__fill_1
X_4610_ rf.registers\[4\]\[17\] rf.registers\[5\]\[17\] rf.registers\[6\]\[17\] rf.registers\[7\]\[17\]
+ _1191_ _1192_ VGND VGND VPWR VPWR _1388_ sky130_fd_sc_hd__mux4_1
XFILLER_0_112_3 VPWR VGND VPWR VGND sky130_ef_sc_hd__decap_12
XFILLER_0_111_21 VPWR VGND VPWR VGND sky130_ef_sc_hd__decap_12
XTAP_TAPCELL_ROW_100_1796 VGND VPWR sky130_fd_sc_hd__tapvpwrvgnd_1
XFILLER_0_25_320 VGND VGND VPWR VPWR sky130_fd_sc_hd__fill_1
X_5590_ _1055_ _1643_ VGND VGND VPWR VPWR _2321_ sky130_fd_sc_hd__nand2_1
X_4541_ _1134_ _1322_ _1135_ VGND VGND VPWR VPWR _1323_ sky130_fd_sc_hd__o21a_1
XFILLER_0_53_673 VPWR VGND VPWR VGND sky130_ef_sc_hd__decap_12
XTAP_TAPCELL_ROW_13_495 VGND VPWR sky130_fd_sc_hd__tapvpwrvgnd_1
XFILLER_0_20_41 VPWR VGND VPWR VGND sky130_ef_sc_hd__decap_12
X_4472_ _1255_ _1256_ _1031_ VGND VGND VPWR VPWR _1257_ sky130_fd_sc_hd__mux2_1
XFILLER_0_20_85 VPWR VGND VPWR VGND sky130_ef_sc_hd__decap_12
X_7260_ _3543_ VGND VGND VPWR VPWR _0057_ sky130_fd_sc_hd__clkbuf_1
XTAP_TAPCELL_ROW_133_2295 VGND VPWR sky130_fd_sc_hd__tapvpwrvgnd_1
X_6211_ net68 _2887_ VGND VGND VPWR VPWR _2914_ sky130_fd_sc_hd__or2_1
X_7191_ rf.registers\[4\]\[24\] _3328_ _3502_ VGND VGND VPWR VPWR _3507_ sky130_fd_sc_hd__mux2_1
XFILLER_0_40_389 VGND VGND VPWR VPWR sky130_fd_sc_hd__fill_1
X_6142_ _2818_ _2824_ _2845_ _2815_ _2826_ VGND VGND VPWR VPWR _2849_ sky130_fd_sc_hd__a221o_1
X_6073_ _2358_ _2460_ VGND VGND VPWR VPWR _2784_ sky130_fd_sc_hd__nor2_1
X_5024_ rf.registers\[16\]\[7\] rf.registers\[17\]\[7\] rf.registers\[18\]\[7\] rf.registers\[19\]\[7\]
+ _1655_ _1656_ VGND VGND VPWR VPWR _1780_ sky130_fd_sc_hd__mux4_1
XTAP_TAPCELL_ROW_107_1906 VGND VPWR sky130_fd_sc_hd__tapvpwrvgnd_1
XTAP_TAPCELL_ROW_49_1035 VGND VPWR sky130_fd_sc_hd__tapvpwrvgnd_1
XFILLER_0_17_3 VPWR VGND VPWR VGND sky130_ef_sc_hd__decap_12
X_6975_ _3390_ VGND VGND VPWR VPWR _0949_ sky130_fd_sc_hd__clkbuf_1
XFILLER_0_48_401 VGND VGND VPWR VPWR sky130_fd_sc_hd__fill_2
XFILLER_0_45_93 VGND VGND VPWR VPWR sky130_fd_sc_hd__fill_2
X_5926_ _2195_ _2201_ _2473_ _2531_ VGND VGND VPWR VPWR _2645_ sky130_fd_sc_hd__nor4_1
X_8714_ clknet_leaf_71_CLK _0826_ VGND VGND VPWR VPWR rf.registers\[24\]\[25\] sky130_fd_sc_hd__dfxtp_1
XFILLER_0_91_713 VPWR VGND VPWR VGND sky130_ef_sc_hd__decap_12
XTAP_TAPCELL_ROW_62_1235 VGND VPWR sky130_fd_sc_hd__tapvpwrvgnd_1
XTAP_TAPCELL_ROW_62_1224 VGND VPWR sky130_fd_sc_hd__tapvpwrvgnd_1
XFILLER_0_8_531 VGND VGND VPWR VPWR sky130_fd_sc_hd__fill_1
X_8645_ clknet_leaf_82_CLK _0757_ VGND VGND VPWR VPWR rf.registers\[17\]\[20\] sky130_fd_sc_hd__dfxtp_1
XFILLER_0_75_275 VGND VGND VPWR VPWR sky130_fd_sc_hd__decap_4
X_5857_ _2485_ _2482_ _2536_ _2544_ _2483_ VGND VGND VPWR VPWR _2580_ sky130_fd_sc_hd__a221o_1
XFILLER_0_48_489 VGND VGND VPWR VPWR sky130_fd_sc_hd__fill_2
XFILLER_0_8_553 VGND VGND VPWR VPWR sky130_fd_sc_hd__decap_3
XFILLER_0_36_629 VGND VGND VPWR VPWR sky130_fd_sc_hd__decap_6
XFILLER_0_134_837 VGND VGND VPWR VPWR sky130_fd_sc_hd__decap_4
X_8576_ clknet_leaf_17_CLK _0688_ VGND VGND VPWR VPWR rf.registers\[12\]\[15\] sky130_fd_sc_hd__dfxtp_1
X_5788_ net92 _2292_ VGND VGND VPWR VPWR _2513_ sky130_fd_sc_hd__nor2_1
X_4808_ _1570_ _1571_ _1572_ _1573_ _1381_ _1301_ VGND VGND VPWR VPWR _1574_ sky130_fd_sc_hd__mux4_1
XTAP_TAPCELL_ROW_32_782 VGND VPWR sky130_fd_sc_hd__tapvpwrvgnd_1
XFILLER_0_71_470 VPWR VGND VPWR VGND sky130_ef_sc_hd__decap_12
X_7527_ _3685_ VGND VGND VPWR VPWR _0182_ sky130_fd_sc_hd__clkbuf_1
XFILLER_0_16_353 VGND VGND VPWR VPWR sky130_fd_sc_hd__decap_8
XFILLER_0_32_813 VPWR VGND VPWR VGND sky130_ef_sc_hd__decap_12
X_4739_ rf.registers\[24\]\[25\] rf.registers\[25\]\[25\] rf.registers\[26\]\[25\]
+ rf.registers\[27\]\[25\] _1191_ _1192_ VGND VGND VPWR VPWR _1509_ sky130_fd_sc_hd__mux4_1
XFILLER_0_102_701 VPWR VGND VPWR VGND sky130_ef_sc_hd__decap_12
X_7458_ _3391_ rf.registers\[29\]\[21\] _3647_ VGND VGND VPWR VPWR _3649_ sky130_fd_sc_hd__mux2_1
XFILLER_0_9_93 VPWR VGND VPWR VGND sky130_ef_sc_hd__decap_12
XFILLER_0_101_222 VGND VGND VPWR VPWR sky130_fd_sc_hd__fill_2
X_6409_ rf.registers\[11\]\[6\] _2999_ _3056_ VGND VGND VPWR VPWR _3063_ sky130_fd_sc_hd__mux2_1
XFILLER_0_4_781 VPWR VGND VPWR VGND sky130_ef_sc_hd__decap_12
XPHY_EDGE_ROW_79_Left_218 VGND VGND VPWR VPWR sky130_fd_sc_hd__decap_3
X_7389_ rf.registers\[8\]\[21\] _3322_ _3610_ VGND VGND VPWR VPWR _3612_ sky130_fd_sc_hd__mux2_1
X_9128_ clknet_leaf_2_CLK _0216_ VGND VGND VPWR VPWR rf.registers\[27\]\[23\] sky130_fd_sc_hd__dfxtp_1
XTAP_TAPCELL_ROW_73_1397 VGND VPWR sky130_fd_sc_hd__tapvpwrvgnd_1
X_9059_ clknet_leaf_4_CLK _0147_ VGND VGND VPWR VPWR rf.registers\[29\]\[18\] sky130_fd_sc_hd__dfxtp_1
XPHY_EDGE_ROW_88_Left_227 VGND VGND VPWR VPWR sky130_fd_sc_hd__decap_3
XFILLER_0_67_721 VGND VGND VPWR VPWR sky130_fd_sc_hd__decap_6
XFILLER_0_82_713 VPWR VGND VPWR VGND sky130_ef_sc_hd__decap_12
XFILLER_0_67_765 VPWR VGND VPWR VGND sky130_ef_sc_hd__decap_12
XFILLER_0_137_653 VPWR VGND VPWR VGND sky130_ef_sc_hd__decap_12
XFILLER_0_136_141 VPWR VGND VPWR VGND sky130_ef_sc_hd__decap_12
XFILLER_0_81_223 VGND VGND VPWR VPWR sky130_fd_sc_hd__fill_1
XFILLER_0_137_697 VPWR VGND VPWR VGND sky130_ef_sc_hd__decap_12
XFILLER_0_82_757 VPWR VGND VPWR VGND sky130_ef_sc_hd__decap_12
XTAP_TAPCELL_ROW_10_443 VGND VPWR sky130_fd_sc_hd__tapvpwrvgnd_1
XFILLER_0_35_673 VGND VGND VPWR VPWR sky130_fd_sc_hd__decap_8
XFILLER_0_62_481 VGND VGND VPWR VPWR sky130_fd_sc_hd__fill_1
XTAP_TAPCELL_ROW_10_454 VGND VPWR sky130_fd_sc_hd__tapvpwrvgnd_1
XPHY_EDGE_ROW_97_Left_236 VGND VGND VPWR VPWR sky130_fd_sc_hd__decap_3
XFILLER_0_1_217 VGND VGND VPWR VPWR sky130_fd_sc_hd__decap_6
XFILLER_0_66_15 VPWR VGND VPWR VGND sky130_ef_sc_hd__decap_12
XFILLER_0_89_356 VGND VGND VPWR VPWR sky130_fd_sc_hd__fill_1
X_6760_ rf.registers\[0\]\[9\] _3005_ _3241_ VGND VGND VPWR VPWR _3251_ sky130_fd_sc_hd__mux2_1
XFILLER_0_106_65 VGND VGND VPWR VPWR sky130_fd_sc_hd__decap_6
XTAP_TAPCELL_ROW_18_565 VGND VPWR sky130_fd_sc_hd__tapvpwrvgnd_1
XTAP_TAPCELL_ROW_18_576 VGND VPWR sky130_fd_sc_hd__tapvpwrvgnd_1
XTAP_TAPCELL_ROW_102_1836 VGND VPWR sky130_fd_sc_hd__tapvpwrvgnd_1
XTAP_TAPCELL_ROW_102_1825 VGND VPWR sky130_fd_sc_hd__tapvpwrvgnd_1
XFILLER_0_57_253 VGND VGND VPWR VPWR sky130_fd_sc_hd__decap_3
XFILLER_0_9_317 VPWR VGND VPWR VGND sky130_ef_sc_hd__decap_12
X_5711_ _2437_ _2438_ _1096_ VGND VGND VPWR VPWR _2439_ sky130_fd_sc_hd__mux2_1
X_6691_ _3214_ VGND VGND VPWR VPWR _0841_ sky130_fd_sc_hd__clkbuf_1
XFILLER_0_85_595 VGND VGND VPWR VPWR sky130_fd_sc_hd__fill_2
XFILLER_0_85_573 VGND VGND VPWR VPWR sky130_fd_sc_hd__fill_1
XFILLER_0_122_53 VPWR VGND VPWR VGND sky130_ef_sc_hd__decap_12
XFILLER_0_116_837 VGND VGND VPWR VPWR sky130_fd_sc_hd__fill_2
XFILLER_0_72_256 VGND VGND VPWR VPWR sky130_fd_sc_hd__fill_2
X_5642_ _2369_ _2371_ _2332_ VGND VGND VPWR VPWR _2372_ sky130_fd_sc_hd__mux2_1
X_8430_ rf.registers\[18\]\[30\] net37 _4130_ VGND VGND VPWR VPWR _4164_ sky130_fd_sc_hd__mux2_1
XTAP_TAPCELL_ROW_135_2324 VGND VPWR sky130_fd_sc_hd__tapvpwrvgnd_1
XFILLER_0_122_97 VPWR VGND VPWR VGND sky130_ef_sc_hd__decap_12
XFILLER_0_14_813 VPWR VGND VPWR VGND sky130_ef_sc_hd__decap_12
X_8361_ _4127_ VGND VGND VPWR VPWR _0574_ sky130_fd_sc_hd__clkbuf_1
XFILLER_0_26_662 VGND VGND VPWR VPWR sky130_fd_sc_hd__fill_2
X_5573_ _1076_ VGND VGND VPWR VPWR _2304_ sky130_fd_sc_hd__clkbuf_4
X_4524_ _1024_ VGND VGND VPWR VPWR _1307_ sky130_fd_sc_hd__buf_4
X_7312_ rf.registers\[3\]\[17\] _3313_ _3563_ VGND VGND VPWR VPWR _3571_ sky130_fd_sc_hd__mux2_1
X_8292_ _3047_ rf.registers\[25\]\[29\] _4081_ VGND VGND VPWR VPWR _4091_ sky130_fd_sc_hd__mux2_1
X_4455_ _1239_ _1240_ _1031_ VGND VGND VPWR VPWR _1241_ sky130_fd_sc_hd__mux2_1
X_7243_ _3534_ VGND VGND VPWR VPWR _0049_ sky130_fd_sc_hd__clkbuf_1
XFILLER_0_40_175 VGND VGND VPWR VPWR sky130_fd_sc_hd__decap_8
XFILLER_0_40_186 VGND VGND VPWR VPWR sky130_fd_sc_hd__decap_8
X_7174_ rf.registers\[4\]\[16\] _3311_ _3491_ VGND VGND VPWR VPWR _3498_ sky130_fd_sc_hd__mux2_1
X_4386_ rf.registers\[4\]\[5\] rf.registers\[5\]\[5\] rf.registers\[6\]\[5\] rf.registers\[7\]\[5\]
+ _1139_ _1140_ VGND VGND VPWR VPWR _1176_ sky130_fd_sc_hd__mux4_1
XFILLER_0_0_250 VGND VGND VPWR VPWR sky130_fd_sc_hd__fill_2
XFILLER_0_40_197 VGND VGND VPWR VPWR sky130_fd_sc_hd__fill_2
XTAP_TAPCELL_ROW_113_1998 VGND VPWR sky130_fd_sc_hd__tapvpwrvgnd_1
X_6125_ _2260_ _2831_ _2832_ VGND VGND VPWR VPWR _2833_ sky130_fd_sc_hd__a21oi_1
X_6056_ _2358_ _2443_ _2762_ _2767_ VGND VGND VPWR VPWR net123 sky130_fd_sc_hd__o211ai_4
XFILLER_0_96_805 VGND VGND VPWR VPWR sky130_fd_sc_hd__decap_6
X_5007_ _1628_ VGND VGND VPWR VPWR _1764_ sky130_fd_sc_hd__buf_4
XTAP_TAPCELL_ROW_37_852 VGND VPWR sky130_fd_sc_hd__tapvpwrvgnd_1
XFILLER_0_138_417 VGND VGND VPWR VPWR sky130_fd_sc_hd__decap_3
XFILLER_0_95_337 VGND VGND VPWR VPWR sky130_fd_sc_hd__decap_4
XFILLER_0_95_326 VGND VGND VPWR VPWR sky130_fd_sc_hd__decap_8
XFILLER_0_138_439 VGND VGND VPWR VPWR sky130_fd_sc_hd__decap_8
X_6958_ _3378_ rf.registers\[15\]\[15\] _3368_ VGND VGND VPWR VPWR _3379_ sky130_fd_sc_hd__mux2_1
XFILLER_0_49_765 VPWR VGND VPWR VGND sky130_ef_sc_hd__decap_12
XFILLER_0_48_242 VGND VGND VPWR VPWR sky130_fd_sc_hd__fill_1
XFILLER_0_118_141 VPWR VGND VPWR VGND sky130_ef_sc_hd__decap_12
XFILLER_0_64_713 VPWR VGND VPWR VGND sky130_ef_sc_hd__decap_12
X_5909_ _2454_ _2459_ _2628_ _2296_ VGND VGND VPWR VPWR _2629_ sky130_fd_sc_hd__o22a_1
X_6889_ _3331_ VGND VGND VPWR VPWR _0922_ sky130_fd_sc_hd__clkbuf_1
X_8628_ clknet_leaf_40_CLK _0740_ VGND VGND VPWR VPWR rf.registers\[17\]\[3\] sky130_fd_sc_hd__dfxtp_1
XFILLER_0_119_697 VPWR VGND VPWR VGND sky130_ef_sc_hd__decap_12
XFILLER_0_64_757 VPWR VGND VPWR VGND sky130_ef_sc_hd__decap_12
XFILLER_0_134_645 VPWR VGND VPWR VGND sky130_ef_sc_hd__decap_12
XFILLER_0_133_111 VGND VGND VPWR VPWR sky130_fd_sc_hd__fill_1
XFILLER_0_63_278 VGND VGND VPWR VPWR sky130_fd_sc_hd__fill_2
X_8559_ clknet_leaf_61_CLK _0671_ VGND VGND VPWR VPWR rf.registers\[13\]\[30\] sky130_fd_sc_hd__dfxtp_1
XFILLER_0_17_673 VGND VGND VPWR VPWR sky130_fd_sc_hd__fill_1
XTAP_TAPCELL_ROW_75_1426 VGND VPWR sky130_fd_sc_hd__tapvpwrvgnd_1
XFILLER_0_102_586 VGND VGND VPWR VPWR sky130_fd_sc_hd__fill_2
XFILLER_0_6_3 VPWR VGND VPWR VGND sky130_ef_sc_hd__decap_12
XFILLER_0_36_29 VPWR VGND VPWR VGND sky130_ef_sc_hd__decap_12
XFILLER_0_86_304 VGND VGND VPWR VPWR sky130_fd_sc_hd__decap_4
XFILLER_0_129_417 VGND VGND VPWR VPWR sky130_fd_sc_hd__decap_8
XFILLER_0_86_326 VGND VGND VPWR VPWR sky130_fd_sc_hd__decap_8
XTAP_TAPCELL_ROW_86_1588 VGND VPWR sky130_fd_sc_hd__tapvpwrvgnd_1
XTAP_TAPCELL_ROW_15_524 VGND VPWR sky130_fd_sc_hd__tapvpwrvgnd_1
XFILLER_0_39_253 VGND VGND VPWR VPWR sky130_fd_sc_hd__decap_4
XFILLER_0_39_275 VGND VGND VPWR VPWR sky130_fd_sc_hd__decap_4
XFILLER_0_137_461 VPWR VGND VPWR VGND sky130_ef_sc_hd__decap_12
XFILLER_0_109_141 VGND VGND VPWR VPWR sky130_fd_sc_hd__fill_2
XFILLER_0_54_223 VPWR VGND VPWR VGND sky130_ef_sc_hd__decap_12
XFILLER_0_6_309 VPWR VGND VPWR VGND sky130_ef_sc_hd__decap_12
XFILLER_0_124_133 VGND VGND VPWR VPWR sky130_fd_sc_hd__decap_6
XFILLER_0_14_109 VPWR VGND VPWR VGND sky130_ef_sc_hd__decap_12
XTAP_TAPCELL_ROW_117_2054 VGND VPWR sky130_fd_sc_hd__tapvpwrvgnd_1
XFILLER_0_70_749 VGND VGND VPWR VPWR sky130_fd_sc_hd__decap_6
XFILLER_0_35_492 VGND VGND VPWR VPWR sky130_fd_sc_hd__decap_6
XFILLER_0_124_177 VPWR VGND VPWR VGND sky130_ef_sc_hd__decap_12
XTAP_TAPCELL_ROW_130_2243 VGND VPWR sky130_fd_sc_hd__tapvpwrvgnd_1
XFILLER_0_23_687 VGND VGND VPWR VPWR sky130_fd_sc_hd__fill_2
XTAP_TAPCELL_ROW_130_2254 VGND VPWR sky130_fd_sc_hd__tapvpwrvgnd_1
X_4240_ A2[0] VGND VGND VPWR VPWR _1035_ sky130_fd_sc_hd__buf_4
XFILLER_0_77_69 VGND VGND VPWR VPWR sky130_fd_sc_hd__decap_4
XFILLER_0_77_47 VGND VGND VPWR VPWR sky130_fd_sc_hd__fill_1
XFILLER_0_93_57 VGND VGND VPWR VPWR sky130_fd_sc_hd__fill_2
XFILLER_0_93_68 VGND VGND VPWR VPWR sky130_fd_sc_hd__decap_4
XFILLER_0_78_805 VGND VGND VPWR VPWR sky130_fd_sc_hd__decap_6
X_7930_ _3899_ VGND VGND VPWR VPWR _0371_ sky130_fd_sc_hd__clkbuf_1
X_7861_ _3862_ VGND VGND VPWR VPWR _0339_ sky130_fd_sc_hd__clkbuf_1
X_6812_ _3279_ VGND VGND VPWR VPWR _0897_ sky130_fd_sc_hd__clkbuf_1
XFILLER_0_77_337 VGND VGND VPWR VPWR sky130_fd_sc_hd__fill_1
X_7792_ rf.registers\[9\]\[18\] _3315_ _3817_ VGND VGND VPWR VPWR _3826_ sky130_fd_sc_hd__mux2_1
XFILLER_0_9_125 VPWR VGND VPWR VGND sky130_ef_sc_hd__decap_12
XTAP_TAPCELL_ROW_34_811 VGND VPWR sky130_fd_sc_hd__tapvpwrvgnd_1
X_6743_ _3242_ VGND VGND VPWR VPWR _0865_ sky130_fd_sc_hd__clkbuf_1
X_9531_ clknet_leaf_33_CLK _0619_ VGND VGND VPWR VPWR rf.registers\[14\]\[10\] sky130_fd_sc_hd__dfxtp_1
XFILLER_0_58_573 VGND VGND VPWR VPWR sky130_fd_sc_hd__decap_3
XFILLER_0_45_212 VPWR VGND VPWR VGND sky130_ef_sc_hd__decap_12
XFILLER_0_46_735 VGND VGND VPWR VPWR sky130_fd_sc_hd__fill_1
X_6674_ rf.registers\[10\]\[0\] _2982_ _3205_ VGND VGND VPWR VPWR _3206_ sky130_fd_sc_hd__mux2_1
X_9462_ clknet_leaf_58_CLK _0550_ VGND VGND VPWR VPWR rf.registers\[20\]\[5\] sky130_fd_sc_hd__dfxtp_1
XFILLER_0_9_169 VPWR VGND VPWR VGND sky130_ef_sc_hd__decap_12
XFILLER_0_42_72 VGND VGND VPWR VPWR sky130_fd_sc_hd__fill_1
XFILLER_0_46_757 VPWR VGND VPWR VGND sky130_ef_sc_hd__decap_12
XFILLER_0_115_111 VGND VGND VPWR VPWR sky130_fd_sc_hd__fill_1
XFILLER_0_73_565 VGND VGND VPWR VPWR sky130_fd_sc_hd__fill_1
XFILLER_0_61_727 VGND VGND VPWR VPWR sky130_fd_sc_hd__fill_1
X_5625_ _1682_ _2207_ _2243_ VGND VGND VPWR VPWR _2355_ sky130_fd_sc_hd__o21ai_1
X_8413_ _4155_ VGND VGND VPWR VPWR _0598_ sky130_fd_sc_hd__clkbuf_1
X_9393_ clknet_leaf_39_CLK _0481_ VGND VGND VPWR VPWR rf.registers\[21\]\[0\] sky130_fd_sc_hd__dfxtp_1
XFILLER_0_84_3 VPWR VGND VPWR VGND sky130_ef_sc_hd__decap_12
XFILLER_0_14_654 VGND VGND VPWR VPWR sky130_fd_sc_hd__decap_4
X_5556_ _2284_ _2286_ VGND VGND VPWR VPWR _2287_ sky130_fd_sc_hd__nand2_1
X_8344_ rf.registers\[20\]\[21\] net27 _4117_ VGND VGND VPWR VPWR _4119_ sky130_fd_sc_hd__mux2_1
X_4507_ _1288_ _1289_ _1145_ VGND VGND VPWR VPWR _1290_ sky130_fd_sc_hd__mux2_1
X_8275_ _4082_ VGND VGND VPWR VPWR _0533_ sky130_fd_sc_hd__clkbuf_1
X_5487_ _2205_ VGND VGND VPWR VPWR _2218_ sky130_fd_sc_hd__buf_2
X_4438_ rf.registers\[24\]\[8\] rf.registers\[25\]\[8\] rf.registers\[26\]\[8\] rf.registers\[27\]\[8\]
+ _1138_ _1121_ VGND VGND VPWR VPWR _1225_ sky130_fd_sc_hd__mux4_1
X_7226_ _3525_ VGND VGND VPWR VPWR _0041_ sky130_fd_sc_hd__clkbuf_1
XTAP_TAPCELL_ROW_57_1156 VGND VPWR sky130_fd_sc_hd__tapvpwrvgnd_1
XFILLER_0_6_83 VGND VGND VPWR VPWR sky130_fd_sc_hd__fill_1
X_7157_ rf.registers\[4\]\[8\] _3294_ _3480_ VGND VGND VPWR VPWR _3489_ sky130_fd_sc_hd__mux2_1
X_4369_ _1138_ VGND VGND VPWR VPWR _1159_ sky130_fd_sc_hd__clkbuf_8
XTAP_TAPCELL_ROW_70_1356 VGND VPWR sky130_fd_sc_hd__tapvpwrvgnd_1
XTAP_TAPCELL_ROW_70_1345 VGND VPWR sky130_fd_sc_hd__tapvpwrvgnd_1
X_7088_ _3452_ VGND VGND VPWR VPWR _1000_ sky130_fd_sc_hd__clkbuf_1
X_6108_ _2811_ _2816_ VGND VGND VPWR VPWR _2817_ sky130_fd_sc_hd__xnor2_1
X_6039_ _2318_ _2319_ _2404_ _2560_ VGND VGND VPWR VPWR _2752_ sky130_fd_sc_hd__o31a_1
XFILLER_0_68_304 VGND VGND VPWR VPWR sky130_fd_sc_hd__decap_4
XFILLER_0_138_225 VPWR VGND VPWR VGND sky130_ef_sc_hd__decap_12
XFILLER_0_96_679 VPWR VGND VPWR VGND sky130_ef_sc_hd__decap_12
XFILLER_0_138_269 VGND VGND VPWR VPWR sky130_fd_sc_hd__decap_8
XFILLER_0_36_234 VGND VGND VPWR VPWR sky130_fd_sc_hd__fill_1
XFILLER_0_37_779 VGND VGND VPWR VPWR sky130_fd_sc_hd__fill_2
XFILLER_0_52_749 VGND VGND VPWR VPWR sky130_fd_sc_hd__decap_6
XFILLER_0_121_125 VPWR VGND VPWR VGND sky130_ef_sc_hd__decap_12
XTAP_TAPCELL_ROW_20_593 VGND VPWR sky130_fd_sc_hd__tapvpwrvgnd_1
XFILLER_0_32_451 VGND VGND VPWR VPWR sky130_fd_sc_hd__decap_4
XFILLER_0_60_793 VPWR VGND VPWR VGND sky130_ef_sc_hd__decap_12
XFILLER_0_130_681 VPWR VGND VPWR VGND sky130_ef_sc_hd__decap_12
XFILLER_0_121_169 VPWR VGND VPWR VGND sky130_ef_sc_hd__decap_12
XFILLER_0_20_635 VGND VGND VPWR VPWR sky130_fd_sc_hd__decap_8
XFILLER_0_138_19 VGND VGND VPWR VPWR sky130_fd_sc_hd__decap_8
XFILLER_0_102_383 VGND VGND VPWR VPWR sky130_fd_sc_hd__decap_4
XTAP_TAPCELL_ROW_88_1617 VGND VPWR sky130_fd_sc_hd__tapvpwrvgnd_1
XFILLER_0_86_101 VGND VGND VPWR VPWR sky130_fd_sc_hd__fill_1
XFILLER_0_129_225 VPWR VGND VPWR VGND sky130_ef_sc_hd__decap_12
XFILLER_0_83_841 VGND VGND VPWR VPWR sky130_fd_sc_hd__fill_1
XFILLER_0_55_521 VGND VGND VPWR VPWR sky130_fd_sc_hd__fill_1
XANTENNA_19 net136 VGND VGND VPWR VPWR sky130_fd_sc_hd__diode_2
XFILLER_0_103_55 VGND VGND VPWR VPWR sky130_fd_sc_hd__fill_1
XFILLER_0_12_53 VPWR VGND VPWR VGND sky130_ef_sc_hd__decap_12
XFILLER_0_6_139 VGND VGND VPWR VPWR sky130_fd_sc_hd__fill_1
XFILLER_0_103_99 VGND VGND VPWR VPWR sky130_fd_sc_hd__fill_1
XTAP_TAPCELL_ROW_99_1779 VGND VPWR sky130_fd_sc_hd__tapvpwrvgnd_1
XFILLER_0_12_97 VPWR VGND VPWR VGND sky130_ef_sc_hd__decap_12
XFILLER_0_15_429 VPWR VGND VPWR VGND sky130_ef_sc_hd__decap_12
XFILLER_0_125_497 VGND VGND VPWR VPWR sky130_fd_sc_hd__fill_1
XFILLER_0_88_35 VGND VGND VPWR VPWR sky130_fd_sc_hd__fill_1
XFILLER_0_70_557 VGND VGND VPWR VPWR sky130_fd_sc_hd__decap_4
XFILLER_0_2_301 VGND VGND VPWR VPWR sky130_fd_sc_hd__decap_6
X_5410_ rf.registers\[4\]\[28\] rf.registers\[5\]\[28\] rf.registers\[6\]\[28\] rf.registers\[7\]\[28\]
+ _2077_ _2078_ VGND VGND VPWR VPWR _2145_ sky130_fd_sc_hd__mux4_1
X_6390_ net38 VGND VGND VPWR VPWR _3051_ sky130_fd_sc_hd__buf_2
Xoutput104 net104 VGND VGND VPWR VPWR RD2[30] sky130_fd_sc_hd__buf_1
Xoutput115 net115 VGND VGND VPWR VPWR alu_result[11] sky130_fd_sc_hd__buf_1
XFILLER_0_2_345 VPWR VGND VPWR VGND sky130_ef_sc_hd__decap_12
X_5341_ rf.registers\[0\]\[24\] rf.registers\[1\]\[24\] rf.registers\[2\]\[24\] rf.registers\[3\]\[24\]
+ _2077_ _2078_ VGND VGND VPWR VPWR _2080_ sky130_fd_sc_hd__mux4_1
XFILLER_0_100_309 VGND VGND VPWR VPWR sky130_fd_sc_hd__fill_2
X_8060_ _3968_ VGND VGND VPWR VPWR _0432_ sky130_fd_sc_hd__clkbuf_1
Xoutput137 net137 VGND VGND VPWR VPWR alu_result[31] sky130_fd_sc_hd__buf_1
Xoutput126 net126 VGND VGND VPWR VPWR alu_result[21] sky130_fd_sc_hd__buf_1
XFILLER_0_2_389 VPWR VGND VPWR VGND sky130_ef_sc_hd__decap_12
X_7011_ rf.registers\[6\]\[3\] _3284_ _3408_ VGND VGND VPWR VPWR _3412_ sky130_fd_sc_hd__mux2_1
X_5272_ _2007_ _2011_ _2014_ _1948_ _1755_ VGND VGND VPWR VPWR _2015_ sky130_fd_sc_hd__a221o_1
XTAP_TAPCELL_ROW_110_1957 VGND VPWR sky130_fd_sc_hd__tapvpwrvgnd_1
XTAP_TAPCELL_ROW_110_1946 VGND VPWR sky130_fd_sc_hd__tapvpwrvgnd_1
XFILLER_0_10_189 VGND VGND VPWR VPWR sky130_fd_sc_hd__decap_6
XFILLER_0_128_41 VPWR VGND VPWR VGND sky130_ef_sc_hd__decap_12
XTAP_TAPCELL_ROW_52_1075 VGND VPWR sky130_fd_sc_hd__tapvpwrvgnd_1
XFILLER_0_128_85 VPWR VGND VPWR VGND sky130_ef_sc_hd__decap_12
X_8962_ clknet_leaf_11_CLK _0050_ VGND VGND VPWR VPWR rf.registers\[19\]\[17\] sky130_fd_sc_hd__dfxtp_1
XTAP_TAPCELL_ROW_52_1086 VGND VPWR sky130_fd_sc_hd__tapvpwrvgnd_1
XFILLER_0_37_61 VGND VGND VPWR VPWR sky130_fd_sc_hd__fill_1
X_7913_ _3367_ rf.registers\[23\]\[10\] _3890_ VGND VGND VPWR VPWR _3891_ sky130_fd_sc_hd__mux2_1
XFILLER_0_78_613 VGND VGND VPWR VPWR sky130_fd_sc_hd__fill_1
X_8893_ clknet_leaf_18_CLK _1005_ VGND VGND VPWR VPWR rf.registers\[5\]\[12\] sky130_fd_sc_hd__dfxtp_1
X_7844_ _3367_ rf.registers\[28\]\[10\] _3853_ VGND VGND VPWR VPWR _3854_ sky130_fd_sc_hd__mux2_1
X_7775_ _3805_ VGND VGND VPWR VPWR _3817_ sky130_fd_sc_hd__buf_4
XFILLER_0_18_201 VGND VGND VPWR VPWR sky130_fd_sc_hd__fill_1
XFILLER_0_135_217 VGND VGND VPWR VPWR sky130_fd_sc_hd__decap_6
XFILLER_0_92_126 VGND VGND VPWR VPWR sky130_fd_sc_hd__decap_4
X_4987_ rf.registers\[12\]\[5\] rf.registers\[13\]\[5\] rf.registers\[14\]\[5\] rf.registers\[15\]\[5\]
+ _1729_ _1731_ VGND VGND VPWR VPWR _1745_ sky130_fd_sc_hd__mux4_1
XFILLER_0_19_768 VPWR VGND VPWR VGND sky130_ef_sc_hd__decap_12
X_9514_ clknet_leaf_85_CLK _0602_ VGND VGND VPWR VPWR rf.registers\[18\]\[25\] sky130_fd_sc_hd__dfxtp_1
X_6726_ rf.registers\[10\]\[25\] _3039_ _3227_ VGND VGND VPWR VPWR _3233_ sky130_fd_sc_hd__mux2_1
XFILLER_0_104_604 VGND VGND VPWR VPWR sky130_fd_sc_hd__decap_4
XFILLER_0_61_546 VGND VGND VPWR VPWR sky130_fd_sc_hd__decap_3
XFILLER_0_6_662 VGND VGND VPWR VPWR sky130_fd_sc_hd__fill_1
XFILLER_0_6_640 VGND VGND VPWR VPWR sky130_fd_sc_hd__decap_4
XFILLER_0_18_289 VGND VGND VPWR VPWR sky130_fd_sc_hd__decap_6
X_6657_ rf.registers\[24\]\[25\] _3039_ _3190_ VGND VGND VPWR VPWR _3196_ sky130_fd_sc_hd__mux2_1
X_9445_ clknet_leaf_82_CLK _0533_ VGND VGND VPWR VPWR rf.registers\[25\]\[20\] sky130_fd_sc_hd__dfxtp_1
XFILLER_0_116_475 VGND VGND VPWR VPWR sky130_fd_sc_hd__fill_1
X_9376_ clknet_leaf_22_CLK _0464_ VGND VGND VPWR VPWR rf.registers\[26\]\[15\] sky130_fd_sc_hd__dfxtp_1
XFILLER_0_6_695 VGND VGND VPWR VPWR sky130_fd_sc_hd__decap_4
XFILLER_0_5_161 VGND VGND VPWR VPWR sky130_fd_sc_hd__decap_6
X_6588_ rf.registers\[1\]\[25\] _3039_ _3153_ VGND VGND VPWR VPWR _3159_ sky130_fd_sc_hd__mux2_1
X_5608_ _2336_ _2337_ VGND VGND VPWR VPWR _2338_ sky130_fd_sc_hd__nand2_1
X_8327_ rf.registers\[20\]\[13\] net18 _4106_ VGND VGND VPWR VPWR _4110_ sky130_fd_sc_hd__mux2_1
X_5539_ _2206_ VGND VGND VPWR VPWR _2270_ sky130_fd_sc_hd__inv_2
X_8258_ _4073_ VGND VGND VPWR VPWR _0525_ sky130_fd_sc_hd__clkbuf_1
X_7209_ rf.registers\[19\]\[0\] _3276_ _3516_ VGND VGND VPWR VPWR _3517_ sky130_fd_sc_hd__mux2_1
XFILLER_0_111_191 VGND VGND VPWR VPWR sky130_fd_sc_hd__fill_2
X_8189_ _3372_ rf.registers\[21\]\[12\] _4034_ VGND VGND VPWR VPWR _4037_ sky130_fd_sc_hd__mux2_1
XFILLER_0_10_690 VGND VGND VPWR VPWR sky130_fd_sc_hd__decap_8
XTAP_TAPCELL_ROW_6_388 VGND VPWR sky130_fd_sc_hd__tapvpwrvgnd_1
XFILLER_0_96_421 VGND VGND VPWR VPWR sky130_fd_sc_hd__decap_6
XFILLER_0_68_112 VGND VGND VPWR VPWR sky130_fd_sc_hd__fill_1
XFILLER_0_84_605 VGND VGND VPWR VPWR sky130_fd_sc_hd__fill_2
XFILLER_0_84_616 VGND VGND VPWR VPWR sky130_fd_sc_hd__decap_6
XTAP_TAPCELL_ROW_83_1547 VGND VPWR sky130_fd_sc_hd__tapvpwrvgnd_1
XFILLER_0_127_729 VPWR VGND VPWR VGND sky130_ef_sc_hd__decap_12
XFILLER_0_65_841 VGND VGND VPWR VPWR sky130_fd_sc_hd__fill_1
XTAP_TAPCELL_ROW_25_674 VGND VPWR sky130_fd_sc_hd__tapvpwrvgnd_1
XFILLER_0_80_811 VGND VGND VPWR VPWR sky130_fd_sc_hd__fill_1
XFILLER_0_64_340 VGND VGND VPWR VPWR sky130_fd_sc_hd__fill_1
XFILLER_0_25_705 VGND VGND VPWR VPWR sky130_fd_sc_hd__fill_1
XFILLER_0_37_565 VGND VGND VPWR VPWR sky130_fd_sc_hd__fill_1
Xinput17 WD3[12] VGND VGND VPWR VPWR net17 sky130_fd_sc_hd__clkbuf_2
XFILLER_0_80_833 VGND VGND VPWR VPWR sky130_fd_sc_hd__fill_2
Xinput28 WD3[22] VGND VGND VPWR VPWR net28 sky130_fd_sc_hd__dlymetal6s2s_1
Xinput39 WD3[3] VGND VGND VPWR VPWR net39 sky130_fd_sc_hd__buf_2
XTAP_TAPCELL_ROW_114_2013 VGND VPWR sky130_fd_sc_hd__tapvpwrvgnd_1
XFILLER_0_52_579 VGND VGND VPWR VPWR sky130_fd_sc_hd__fill_2
XFILLER_0_58_27 VGND VGND VPWR VPWR sky130_fd_sc_hd__fill_1
XFILLER_0_20_421 VGND VGND VPWR VPWR sky130_fd_sc_hd__decap_8
XFILLER_0_74_15 VPWR VGND VPWR VGND sky130_ef_sc_hd__decap_12
XTAP_TAPCELL_ROW_125_2175 VGND VPWR sky130_fd_sc_hd__tapvpwrvgnd_1
XFILLER_0_99_281 VGND VGND VPWR VPWR sky130_fd_sc_hd__fill_1
X_4910_ rf.registers\[24\]\[2\] rf.registers\[25\]\[2\] rf.registers\[26\]\[2\] rf.registers\[27\]\[2\]
+ net1 net2 VGND VGND VPWR VPWR _1671_ sky130_fd_sc_hd__mux4_1
X_5890_ net82 _2610_ VGND VGND VPWR VPWR _2611_ sky130_fd_sc_hd__xor2_1
XFILLER_0_59_167 VGND VGND VPWR VPWR sky130_fd_sc_hd__fill_1
X_4841_ _1603_ _1604_ _1163_ VGND VGND VPWR VPWR _1605_ sky130_fd_sc_hd__mux2_1
XFILLER_0_23_30 VPWR VGND VPWR VGND sky130_ef_sc_hd__decap_12
XFILLER_0_47_318 VPWR VGND VPWR VGND sky130_ef_sc_hd__decap_12
XFILLER_0_114_65 VPWR VGND VPWR VGND sky130_ef_sc_hd__decap_12
XFILLER_0_28_521 VGND VGND VPWR VPWR sky130_fd_sc_hd__fill_1
XTAP_TAPCELL_ROW_44_961 VGND VPWR sky130_fd_sc_hd__tapvpwrvgnd_1
XFILLER_0_117_217 VGND VGND VPWR VPWR sky130_fd_sc_hd__decap_6
X_7560_ _3357_ rf.registers\[27\]\[5\] _3697_ VGND VGND VPWR VPWR _3703_ sky130_fd_sc_hd__mux2_1
X_4772_ rf.registers\[16\]\[27\] rf.registers\[17\]\[27\] rf.registers\[18\]\[27\]
+ rf.registers\[19\]\[27\] _1120_ _1123_ VGND VGND VPWR VPWR _1540_ sky130_fd_sc_hd__mux4_1
XFILLER_0_28_565 VGND VGND VPWR VPWR sky130_fd_sc_hd__fill_1
XFILLER_0_132_209 VPWR VGND VPWR VGND sky130_ef_sc_hd__decap_12
X_7491_ _3666_ VGND VGND VPWR VPWR _0165_ sky130_fd_sc_hd__clkbuf_1
XFILLER_0_71_833 VGND VGND VPWR VPWR sky130_fd_sc_hd__decap_6
X_6511_ rf.registers\[17\]\[21\] _3031_ _3116_ VGND VGND VPWR VPWR _3118_ sky130_fd_sc_hd__mux2_1
XFILLER_0_130_53 VPWR VGND VPWR VGND sky130_ef_sc_hd__decap_12
XFILLER_0_125_261 VPWR VGND VPWR VGND sky130_ef_sc_hd__decap_12
X_6442_ _3080_ VGND VGND VPWR VPWR _0726_ sky130_fd_sc_hd__clkbuf_1
XFILLER_0_15_237 VPWR VGND VPWR VGND sky130_ef_sc_hd__decap_12
X_9230_ clknet_leaf_89_CLK _0318_ VGND VGND VPWR VPWR rf.registers\[9\]\[29\] sky130_fd_sc_hd__dfxtp_1
XFILLER_0_130_97 VPWR VGND VPWR VGND sky130_ef_sc_hd__decap_12
XFILLER_0_113_456 VGND VGND VPWR VPWR sky130_fd_sc_hd__fill_1
XFILLER_0_70_365 VGND VGND VPWR VPWR sky130_fd_sc_hd__decap_4
X_9161_ clknet_leaf_73_CLK _0249_ VGND VGND VPWR VPWR rf.registers\[2\]\[24\] sky130_fd_sc_hd__dfxtp_1
X_8112_ _3363_ rf.registers\[26\]\[8\] _3987_ VGND VGND VPWR VPWR _3996_ sky130_fd_sc_hd__mux2_1
XFILLER_0_70_398 VGND VGND VPWR VPWR sky130_fd_sc_hd__fill_1
XFILLER_0_51_590 VPWR VGND VPWR VGND sky130_ef_sc_hd__decap_12
XFILLER_0_3_665 VGND VGND VPWR VPWR sky130_fd_sc_hd__decap_6
XFILLER_0_2_153 VPWR VGND VPWR VGND sky130_ef_sc_hd__decap_12
X_6373_ rf.registers\[12\]\[25\] _3039_ _3029_ VGND VGND VPWR VPWR _3040_ sky130_fd_sc_hd__mux2_1
XFILLER_0_100_139 VGND VGND VPWR VPWR sky130_fd_sc_hd__fill_1
X_9092_ clknet_leaf_22_CLK _0180_ VGND VGND VPWR VPWR rf.registers\[31\]\[19\] sky130_fd_sc_hd__dfxtp_1
XTAP_TAPCELL_ROW_54_1115 VGND VPWR sky130_fd_sc_hd__tapvpwrvgnd_1
XTAP_TAPCELL_ROW_54_1104 VGND VPWR sky130_fd_sc_hd__tapvpwrvgnd_1
XFILLER_0_2_197 VPWR VGND VPWR VGND sky130_ef_sc_hd__decap_12
X_5324_ rf.registers\[20\]\[24\] rf.registers\[21\]\[24\] rf.registers\[22\]\[24\]
+ rf.registers\[23\]\[24\] _1999_ _2000_ VGND VGND VPWR VPWR _2063_ sky130_fd_sc_hd__mux4_1
X_8043_ _3959_ VGND VGND VPWR VPWR _0424_ sky130_fd_sc_hd__clkbuf_1
X_5255_ _1998_ VGND VGND VPWR VPWR net59 sky130_fd_sc_hd__inv_2
XFILLER_0_48_82 VGND VGND VPWR VPWR sky130_fd_sc_hd__fill_2
X_5186_ rf.registers\[12\]\[16\] rf.registers\[13\]\[16\] rf.registers\[14\]\[16\]
+ rf.registers\[15\]\[16\] _1929_ _1930_ VGND VGND VPWR VPWR _1933_ sky130_fd_sc_hd__mux4_1
XTAP_TAPCELL_ROW_3_347 VGND VPWR sky130_fd_sc_hd__tapvpwrvgnd_1
X_8945_ clknet_leaf_39_CLK _0033_ VGND VGND VPWR VPWR rf.registers\[19\]\[0\] sky130_fd_sc_hd__dfxtp_1
XFILLER_0_78_410 VGND VGND VPWR VPWR sky130_fd_sc_hd__decap_3
XFILLER_0_78_454 VGND VGND VPWR VPWR sky130_fd_sc_hd__decap_4
X_8876_ clknet_leaf_83_CLK _0988_ VGND VGND VPWR VPWR rf.registers\[6\]\[27\] sky130_fd_sc_hd__dfxtp_1
X_7827_ _3351_ rf.registers\[28\]\[2\] _3842_ VGND VGND VPWR VPWR _3845_ sky130_fd_sc_hd__mux2_1
XFILLER_0_66_627 VPWR VGND VPWR VGND sky130_ef_sc_hd__decap_12
XFILLER_0_109_729 VPWR VGND VPWR VGND sky130_ef_sc_hd__decap_12
XFILLER_0_109_718 VGND VGND VPWR VPWR sky130_fd_sc_hd__decap_8
XTAP_TAPCELL_ROW_65_1277 VGND VPWR sky130_fd_sc_hd__tapvpwrvgnd_1
XFILLER_0_47_841 VGND VGND VPWR VPWR sky130_fd_sc_hd__fill_1
X_7758_ _3808_ VGND VGND VPWR VPWR _0290_ sky130_fd_sc_hd__clkbuf_1
XFILLER_0_62_811 VGND VGND VPWR VPWR sky130_fd_sc_hd__fill_1
XTAP_TAPCELL_ROW_22_633 VGND VPWR sky130_fd_sc_hd__tapvpwrvgnd_1
XFILLER_0_34_502 VGND VGND VPWR VPWR sky130_fd_sc_hd__decap_3
X_7689_ _3349_ rf.registers\[30\]\[1\] _3770_ VGND VGND VPWR VPWR _3772_ sky130_fd_sc_hd__mux2_1
X_6709_ rf.registers\[10\]\[17\] _3022_ _3216_ VGND VGND VPWR VPWR _3224_ sky130_fd_sc_hd__mux2_1
X_9428_ clknet_leaf_38_CLK _0516_ VGND VGND VPWR VPWR rf.registers\[25\]\[3\] sky130_fd_sc_hd__dfxtp_1
XFILLER_0_15_782 VGND VGND VPWR VPWR sky130_fd_sc_hd__fill_2
X_9359_ clknet_leaf_74_CLK _0447_ VGND VGND VPWR VPWR rf.registers\[7\]\[30\] sky130_fd_sc_hd__dfxtp_1
XFILLER_0_100_695 VGND VGND VPWR VPWR sky130_fd_sc_hd__decap_4
XFILLER_0_44_29 VPWR VGND VPWR VGND sky130_ef_sc_hd__decap_12
XFILLER_0_97_741 VPWR VGND VPWR VGND sky130_ef_sc_hd__decap_12
XFILLER_0_69_432 VPWR VGND VPWR VGND sky130_ef_sc_hd__decap_12
XFILLER_0_97_785 VPWR VGND VPWR VGND sky130_ef_sc_hd__decap_12
XTAP_TAPCELL_ROW_120_2094 VGND VPWR sky130_fd_sc_hd__tapvpwrvgnd_1
XFILLER_0_71_107 VGND VGND VPWR VPWR sky130_fd_sc_hd__decap_4
XFILLER_0_56_159 VGND VGND VPWR VPWR sky130_fd_sc_hd__fill_1
XTAP_TAPCELL_ROW_41_920 VGND VPWR sky130_fd_sc_hd__tapvpwrvgnd_1
XFILLER_0_65_671 VGND VGND VPWR VPWR sky130_fd_sc_hd__fill_1
XFILLER_0_53_833 VGND VGND VPWR VPWR sky130_fd_sc_hd__decap_6
XFILLER_0_123_721 VGND VGND VPWR VPWR sky130_fd_sc_hd__decap_6
XFILLER_0_80_630 VGND VGND VPWR VPWR sky130_fd_sc_hd__decap_6
XFILLER_0_64_192 VGND VGND VPWR VPWR sky130_fd_sc_hd__fill_1
XFILLER_0_8_29 VPWR VGND VPWR VGND sky130_ef_sc_hd__decap_12
XTAP_TAPCELL_ROW_96_1738 VGND VPWR sky130_fd_sc_hd__tapvpwrvgnd_1
XFILLER_0_69_15 VPWR VGND VPWR VGND sky130_ef_sc_hd__decap_12
XFILLER_0_123_765 VPWR VGND VPWR VGND sky130_ef_sc_hd__decap_12
XFILLER_0_122_253 VPWR VGND VPWR VGND sky130_ef_sc_hd__decap_12
XFILLER_0_0_613 VGND VGND VPWR VPWR sky130_fd_sc_hd__decap_3
XFILLER_0_21_741 VGND VGND VPWR VPWR sky130_fd_sc_hd__decap_3
XFILLER_0_21_785 VPWR VGND VPWR VGND sky130_ef_sc_hd__decap_12
Xclkbuf_3_2__f_CLK clknet_0_CLK VGND VGND VPWR VPWR clknet_3_2__leaf_CLK sky130_fd_sc_hd__clkbuf_16
XTAP_TAPCELL_ROW_127_2204 VGND VPWR sky130_fd_sc_hd__tapvpwrvgnd_1
X_5040_ _1652_ VGND VGND VPWR VPWR _1795_ sky130_fd_sc_hd__buf_4
XFILLER_0_18_41 VPWR VGND VPWR VGND sky130_ef_sc_hd__decap_12
XPHY_EDGE_ROW_108_Left_247 VGND VGND VPWR VPWR sky130_fd_sc_hd__decap_3
XFILLER_0_18_85 VPWR VGND VPWR VGND sky130_ef_sc_hd__decap_12
XTAP_TAPCELL_ROW_0_306 VGND VPWR sky130_fd_sc_hd__tapvpwrvgnd_1
X_6991_ _3400_ VGND VGND VPWR VPWR _0955_ sky130_fd_sc_hd__clkbuf_1
X_8730_ clknet_leaf_34_CLK _0842_ VGND VGND VPWR VPWR rf.registers\[10\]\[9\] sky130_fd_sc_hd__dfxtp_1
X_5942_ _2552_ _2595_ _2233_ VGND VGND VPWR VPWR _2660_ sky130_fd_sc_hd__mux2_1
XTAP_TAPCELL_ROW_105_1878 VGND VPWR sky130_fd_sc_hd__tapvpwrvgnd_1
X_8661_ clknet_leaf_48_CLK _0773_ VGND VGND VPWR VPWR rf.registers\[1\]\[4\] sky130_fd_sc_hd__dfxtp_1
XFILLER_0_29_841 VGND VGND VPWR VPWR sky130_fd_sc_hd__fill_1
X_5873_ _2243_ _2230_ _2342_ VGND VGND VPWR VPWR _2595_ sky130_fd_sc_hd__o21bai_1
X_8592_ clknet_leaf_60_CLK _0704_ VGND VGND VPWR VPWR rf.registers\[12\]\[31\] sky130_fd_sc_hd__dfxtp_1
XFILLER_0_7_223 VGND VGND VPWR VPWR sky130_fd_sc_hd__fill_1
X_7612_ _2978_ rf.registers\[27\]\[30\] _3696_ VGND VGND VPWR VPWR _3730_ sky130_fd_sc_hd__mux2_1
X_4824_ _1587_ _1588_ _1144_ VGND VGND VPWR VPWR _1589_ sky130_fd_sc_hd__mux2_1
XTAP_TAPCELL_ROW_138_2366 VGND VPWR sky130_fd_sc_hd__tapvpwrvgnd_1
XPHY_EDGE_ROW_117_Left_256 VGND VGND VPWR VPWR sky130_fd_sc_hd__decap_3
XFILLER_0_8_757 VPWR VGND VPWR VGND sky130_ef_sc_hd__decap_12
XFILLER_0_16_513 VPWR VGND VPWR VGND sky130_ef_sc_hd__decap_12
X_7543_ _3693_ VGND VGND VPWR VPWR _0190_ sky130_fd_sc_hd__clkbuf_1
X_4755_ rf.registers\[16\]\[26\] rf.registers\[17\]\[26\] rf.registers\[18\]\[26\]
+ rf.registers\[19\]\[26\] _1125_ _1128_ VGND VGND VPWR VPWR _1524_ sky130_fd_sc_hd__mux4_1
XFILLER_0_28_384 VPWR VGND VPWR VGND sky130_ef_sc_hd__decap_12
XTAP_TAPCELL_ROW_138_2388 VGND VPWR sky130_fd_sc_hd__tapvpwrvgnd_1
XTAP_TAPCELL_ROW_138_2377 VGND VPWR sky130_fd_sc_hd__tapvpwrvgnd_1
XFILLER_0_50_83 VGND VGND VPWR VPWR sky130_fd_sc_hd__fill_1
XFILLER_0_16_557 VPWR VGND VPWR VGND sky130_ef_sc_hd__decap_12
X_9213_ clknet_leaf_23_CLK _0301_ VGND VGND VPWR VPWR rf.registers\[9\]\[12\] sky130_fd_sc_hd__dfxtp_1
X_4686_ _1458_ _1459_ _1137_ VGND VGND VPWR VPWR _1460_ sky130_fd_sc_hd__mux2_1
XTAP_TAPCELL_ROW_60_1196 VGND VPWR sky130_fd_sc_hd__tapvpwrvgnd_1
X_7474_ _2976_ rf.registers\[29\]\[29\] _3647_ VGND VGND VPWR VPWR _3657_ sky130_fd_sc_hd__mux2_1
XFILLER_0_43_387 VGND VGND VPWR VPWR sky130_fd_sc_hd__fill_2
X_6425_ _3071_ VGND VGND VPWR VPWR _0718_ sky130_fd_sc_hd__clkbuf_1
XFILLER_0_70_195 VGND VGND VPWR VPWR sky130_fd_sc_hd__fill_1
XFILLER_0_101_426 VGND VGND VPWR VPWR sky130_fd_sc_hd__fill_1
X_9144_ clknet_leaf_52_CLK _0232_ VGND VGND VPWR VPWR rf.registers\[2\]\[7\] sky130_fd_sc_hd__dfxtp_1
X_6356_ net26 VGND VGND VPWR VPWR _3028_ sky130_fd_sc_hd__buf_2
XTAP_TAPCELL_ROW_8_417 VGND VPWR sky130_fd_sc_hd__tapvpwrvgnd_1
XFILLER_0_3_473 VPWR VGND VPWR VGND sky130_ef_sc_hd__decap_12
X_9075_ clknet_leaf_43_CLK _0163_ VGND VGND VPWR VPWR rf.registers\[31\]\[2\] sky130_fd_sc_hd__dfxtp_1
XFILLER_0_59_81 VGND VGND VPWR VPWR sky130_fd_sc_hd__decap_8
X_5307_ rf.registers\[20\]\[23\] rf.registers\[21\]\[23\] rf.registers\[22\]\[23\]
+ rf.registers\[23\]\[23\] _1735_ _1737_ VGND VGND VPWR VPWR _2047_ sky130_fd_sc_hd__mux4_1
XFILLER_0_11_273 VGND VGND VPWR VPWR sky130_fd_sc_hd__decap_6
X_8026_ _3054_ _3406_ VGND VGND VPWR VPWR _3950_ sky130_fd_sc_hd__nor2_2
X_6287_ net38 VGND VGND VPWR VPWR _2980_ sky130_fd_sc_hd__buf_2
XPHY_EDGE_ROW_126_Left_265 VGND VGND VPWR VPWR sky130_fd_sc_hd__decap_3
X_5238_ _1982_ VGND VGND VPWR VPWR net58 sky130_fd_sc_hd__inv_2
X_5169_ _1911_ _1913_ _1916_ _1764_ _1709_ VGND VGND VPWR VPWR _1917_ sky130_fd_sc_hd__a221o_1
XTAP_TAPCELL_ROW_67_1306 VGND VPWR sky130_fd_sc_hd__tapvpwrvgnd_1
XFILLER_0_79_741 VPWR VGND VPWR VGND sky130_ef_sc_hd__decap_12
XTAP_TAPCELL_ROW_27_703 VGND VPWR sky130_fd_sc_hd__tapvpwrvgnd_1
X_8928_ clknet_leaf_16_CLK _0016_ VGND VGND VPWR VPWR rf.registers\[4\]\[15\] sky130_fd_sc_hd__dfxtp_1
XFILLER_0_79_785 VPWR VGND VPWR VGND sky130_ef_sc_hd__decap_12
XFILLER_0_78_240 VGND VGND VPWR VPWR sky130_fd_sc_hd__fill_1
XFILLER_0_94_755 VGND VGND VPWR VPWR sky130_fd_sc_hd__fill_1
X_8859_ clknet_leaf_31_CLK _0971_ VGND VGND VPWR VPWR rf.registers\[6\]\[10\] sky130_fd_sc_hd__dfxtp_1
XTAP_TAPCELL_ROW_80_1506 VGND VPWR sky130_fd_sc_hd__tapvpwrvgnd_1
XFILLER_0_136_301 VGND VGND VPWR VPWR sky130_fd_sc_hd__decap_6
XPHY_EDGE_ROW_135_Left_274 VGND VGND VPWR VPWR sky130_fd_sc_hd__decap_3
XFILLER_0_136_345 VPWR VGND VPWR VGND sky130_ef_sc_hd__decap_12
XFILLER_0_19_384 VGND VGND VPWR VPWR sky130_fd_sc_hd__decap_8
XFILLER_0_35_833 VGND VGND VPWR VPWR sky130_fd_sc_hd__fill_1
XFILLER_0_136_389 VPWR VGND VPWR VGND sky130_ef_sc_hd__decap_12
XFILLER_0_105_721 VGND VGND VPWR VPWR sky130_fd_sc_hd__decap_6
XFILLER_0_62_663 VPWR VGND VPWR VGND sky130_ef_sc_hd__decap_12
XFILLER_0_50_825 VGND VGND VPWR VPWR sky130_fd_sc_hd__decap_8
XFILLER_0_22_505 VPWR VGND VPWR VGND sky130_ef_sc_hd__decap_12
XFILLER_0_34_365 VGND VGND VPWR VPWR sky130_fd_sc_hd__decap_6
XFILLER_0_120_713 VPWR VGND VPWR VGND sky130_ef_sc_hd__decap_12
XFILLER_0_105_765 VPWR VGND VPWR VGND sky130_ef_sc_hd__decap_12
XFILLER_0_104_253 VGND VGND VPWR VPWR sky130_fd_sc_hd__fill_2
XTAP_TAPCELL_ROW_78_1468 VGND VPWR sky130_fd_sc_hd__tapvpwrvgnd_1
XFILLER_0_132_584 VGND VGND VPWR VPWR sky130_fd_sc_hd__fill_1
XFILLER_0_120_757 VPWR VGND VPWR VGND sky130_ef_sc_hd__decap_12
XTAP_TAPCELL_ROW_91_1668 VGND VPWR sky130_fd_sc_hd__tapvpwrvgnd_1
XTAP_TAPCELL_ROW_122_2134 VGND VPWR sky130_fd_sc_hd__tapvpwrvgnd_1
XTAP_TAPCELL_ROW_122_2123 VGND VPWR sky130_fd_sc_hd__tapvpwrvgnd_1
XFILLER_0_71_27 VGND VGND VPWR VPWR sky130_fd_sc_hd__decap_3
XFILLER_0_128_813 VPWR VGND VPWR VGND sky130_ef_sc_hd__decap_12
XFILLER_0_69_284 VGND VGND VPWR VPWR sky130_fd_sc_hd__fill_2
XFILLER_0_85_777 VGND VGND VPWR VPWR sky130_fd_sc_hd__decap_6
XFILLER_0_57_457 VGND VGND VPWR VPWR sky130_fd_sc_hd__fill_1
XFILLER_0_45_608 VGND VGND VPWR VPWR sky130_fd_sc_hd__decap_8
XFILLER_0_72_416 VGND VGND VPWR VPWR sky130_fd_sc_hd__decap_4
XFILLER_0_26_811 VGND VGND VPWR VPWR sky130_fd_sc_hd__fill_1
XFILLER_0_5_727 VGND VGND VPWR VPWR sky130_fd_sc_hd__fill_1
XFILLER_0_25_343 VGND VGND VPWR VPWR sky130_fd_sc_hd__decap_3
XFILLER_0_111_33 VPWR VGND VPWR VGND sky130_ef_sc_hd__decap_12
XFILLER_0_108_581 VGND VGND VPWR VPWR sky130_fd_sc_hd__fill_2
XFILLER_0_105_3 VPWR VGND VPWR VGND sky130_ef_sc_hd__decap_12
XTAP_TAPCELL_ROW_100_1797 VGND VPWR sky130_fd_sc_hd__tapvpwrvgnd_1
X_4540_ rf.registers\[0\]\[13\] rf.registers\[1\]\[13\] rf.registers\[2\]\[13\] rf.registers\[3\]\[13\]
+ _1320_ _1321_ VGND VGND VPWR VPWR _1322_ sky130_fd_sc_hd__mux4_1
XFILLER_0_53_685 VGND VGND VPWR VPWR sky130_fd_sc_hd__fill_2
XFILLER_0_13_505 VPWR VGND VPWR VGND sky130_ef_sc_hd__decap_12
XTAP_TAPCELL_ROW_13_496 VGND VPWR sky130_fd_sc_hd__tapvpwrvgnd_1
X_4471_ rf.registers\[24\]\[10\] rf.registers\[25\]\[10\] rf.registers\[26\]\[10\]
+ rf.registers\[27\]\[10\] _1035_ _1036_ VGND VGND VPWR VPWR _1256_ sky130_fd_sc_hd__mux4_1
XFILLER_0_20_53 VPWR VGND VPWR VGND sky130_ef_sc_hd__decap_12
XTAP_TAPCELL_ROW_133_2296 VGND VPWR sky130_fd_sc_hd__tapvpwrvgnd_1
XFILLER_0_0_421 VGND VGND VPWR VPWR sky130_fd_sc_hd__decap_8
XFILLER_0_20_97 VGND VGND VPWR VPWR sky130_fd_sc_hd__decap_6
X_6210_ _2876_ _2878_ _2890_ VGND VGND VPWR VPWR _2913_ sky130_fd_sc_hd__and3b_1
XFILLER_0_40_368 VGND VGND VPWR VPWR sky130_fd_sc_hd__decap_3
X_7190_ _3506_ VGND VGND VPWR VPWR _0024_ sky130_fd_sc_hd__clkbuf_1
X_6141_ _2812_ _2845_ VGND VGND VPWR VPWR _2848_ sky130_fd_sc_hd__nand2_1
X_6072_ net106 _2462_ _2639_ _2779_ _2782_ VGND VGND VPWR VPWR _2783_ sky130_fd_sc_hd__a311o_1
X_5023_ rf.registers\[20\]\[7\] rf.registers\[21\]\[7\] rf.registers\[22\]\[7\] rf.registers\[23\]\[7\]
+ _1655_ _1656_ VGND VGND VPWR VPWR _1779_ sky130_fd_sc_hd__mux4_1
XFILLER_0_136_41 VPWR VGND VPWR VGND sky130_ef_sc_hd__decap_12
XTAP_TAPCELL_ROW_107_1907 VGND VPWR sky130_fd_sc_hd__tapvpwrvgnd_1
XFILLER_0_136_85 VPWR VGND VPWR VGND sky130_ef_sc_hd__decap_12
XFILLER_0_95_519 VGND VGND VPWR VPWR sky130_fd_sc_hd__decap_4
X_6974_ _3388_ rf.registers\[15\]\[20\] _3389_ VGND VGND VPWR VPWR _3390_ sky130_fd_sc_hd__mux2_1
XTAP_TAPCELL_ROW_49_1036 VGND VPWR sky130_fd_sc_hd__tapvpwrvgnd_1
X_5925_ _2458_ _2568_ _2571_ _2468_ _2643_ VGND VGND VPWR VPWR _2644_ sky130_fd_sc_hd__o221a_1
X_8713_ clknet_leaf_84_CLK _0825_ VGND VGND VPWR VPWR rf.registers\[24\]\[24\] sky130_fd_sc_hd__dfxtp_1
X_8644_ clknet_leaf_20_CLK _0756_ VGND VGND VPWR VPWR rf.registers\[17\]\[19\] sky130_fd_sc_hd__dfxtp_1
XFILLER_0_76_755 VGND VGND VPWR VPWR sky130_fd_sc_hd__fill_1
XTAP_TAPCELL_ROW_62_1236 VGND VPWR sky130_fd_sc_hd__tapvpwrvgnd_1
XTAP_TAPCELL_ROW_62_1225 VGND VPWR sky130_fd_sc_hd__tapvpwrvgnd_1
X_5856_ _2577_ _2578_ VGND VGND VPWR VPWR _2579_ sky130_fd_sc_hd__or2_1
XFILLER_0_134_805 VGND VGND VPWR VPWR sky130_fd_sc_hd__decap_6
XFILLER_0_91_725 VGND VGND VPWR VPWR sky130_fd_sc_hd__decap_3
XFILLER_0_75_287 VGND VGND VPWR VPWR sky130_fd_sc_hd__decap_3
XPHY_EDGE_ROW_3_Right_3 VGND VGND VPWR VPWR sky130_fd_sc_hd__decap_3
X_4807_ rf.registers\[20\]\[29\] rf.registers\[21\]\[29\] rf.registers\[22\]\[29\]
+ rf.registers\[23\]\[29\] _1410_ _1411_ VGND VGND VPWR VPWR _1573_ sky130_fd_sc_hd__mux4_1
XFILLER_0_29_671 VGND VGND VPWR VPWR sky130_fd_sc_hd__fill_1
X_8575_ clknet_leaf_28_CLK _0687_ VGND VGND VPWR VPWR rf.registers\[12\]\[14\] sky130_fd_sc_hd__dfxtp_1
XFILLER_0_8_598 VGND VGND VPWR VPWR sky130_fd_sc_hd__decap_6
X_5787_ _2512_ VGND VGND VPWR VPWR net140 sky130_fd_sc_hd__clkbuf_1
XFILLER_0_16_321 VPWR VGND VPWR VGND sky130_ef_sc_hd__decap_12
XTAP_TAPCELL_ROW_32_783 VGND VPWR sky130_fd_sc_hd__tapvpwrvgnd_1
XFILLER_0_133_337 VPWR VGND VPWR VGND sky130_ef_sc_hd__decap_12
X_7526_ _3391_ rf.registers\[31\]\[21\] _3683_ VGND VGND VPWR VPWR _3685_ sky130_fd_sc_hd__mux2_1
XFILLER_0_16_365 VGND VGND VPWR VPWR sky130_fd_sc_hd__decap_6
XFILLER_0_32_825 VGND VGND VPWR VPWR sky130_fd_sc_hd__decap_8
X_4738_ _1508_ VGND VGND VPWR VPWR net97 sky130_fd_sc_hd__inv_2
XFILLER_0_71_493 VGND VGND VPWR VPWR sky130_fd_sc_hd__decap_8
XFILLER_0_71_482 VGND VGND VPWR VPWR sky130_fd_sc_hd__fill_2
X_4669_ _1197_ _1443_ _1024_ VGND VGND VPWR VPWR _1444_ sky130_fd_sc_hd__a21oi_1
X_7457_ _3648_ VGND VGND VPWR VPWR _0149_ sky130_fd_sc_hd__clkbuf_1
XFILLER_0_16_387 VPWR VGND VPWR VGND sky130_ef_sc_hd__decap_12
XFILLER_0_102_713 VPWR VGND VPWR VGND sky130_ef_sc_hd__decap_12
X_6408_ _3062_ VGND VGND VPWR VPWR _0710_ sky130_fd_sc_hd__clkbuf_1
XFILLER_0_4_793 VPWR VGND VPWR VGND sky130_ef_sc_hd__decap_12
XFILLER_0_3_281 VPWR VGND VPWR VGND sky130_ef_sc_hd__decap_12
XFILLER_0_102_757 VPWR VGND VPWR VGND sky130_ef_sc_hd__decap_12
X_7388_ _3611_ VGND VGND VPWR VPWR _0117_ sky130_fd_sc_hd__clkbuf_1
XFILLER_0_12_582 VGND VGND VPWR VPWR sky130_fd_sc_hd__decap_6
XFILLER_0_31_379 VGND VGND VPWR VPWR sky130_fd_sc_hd__fill_2
X_9127_ clknet_leaf_0_CLK _0215_ VGND VGND VPWR VPWR rf.registers\[27\]\[22\] sky130_fd_sc_hd__dfxtp_1
X_6339_ rf.registers\[12\]\[14\] _3016_ _3008_ VGND VGND VPWR VPWR _3017_ sky130_fd_sc_hd__mux2_1
XTAP_TAPCELL_ROW_73_1398 VGND VPWR sky130_fd_sc_hd__tapvpwrvgnd_1
X_9058_ clknet_leaf_10_CLK _0146_ VGND VGND VPWR VPWR rf.registers\[29\]\[17\] sky130_fd_sc_hd__dfxtp_1
X_8009_ _3941_ VGND VGND VPWR VPWR _0408_ sky130_fd_sc_hd__clkbuf_1
XFILLER_0_128_109 VPWR VGND VPWR VGND sky130_ef_sc_hd__decap_12
XFILLER_0_67_777 VGND VGND VPWR VPWR sky130_fd_sc_hd__decap_6
XFILLER_0_137_665 VGND VGND VPWR VPWR sky130_fd_sc_hd__decap_6
XFILLER_0_82_725 VPWR VGND VPWR VGND sky130_ef_sc_hd__decap_12
XFILLER_0_136_153 VPWR VGND VPWR VGND sky130_ef_sc_hd__decap_12
XFILLER_0_82_769 VPWR VGND VPWR VGND sky130_ef_sc_hd__decap_12
XFILLER_0_136_197 VPWR VGND VPWR VGND sky130_ef_sc_hd__decap_12
XFILLER_0_81_279 VGND VGND VPWR VPWR sky130_fd_sc_hd__fill_1
XTAP_TAPCELL_ROW_10_455 VGND VPWR sky130_fd_sc_hd__tapvpwrvgnd_1
XTAP_TAPCELL_ROW_10_444 VGND VPWR sky130_fd_sc_hd__tapvpwrvgnd_1
XFILLER_0_34_195 VGND VGND VPWR VPWR sky130_fd_sc_hd__fill_1
XFILLER_0_120_587 VGND VGND VPWR VPWR sky130_fd_sc_hd__fill_1
XFILLER_0_66_27 VGND VGND VPWR VPWR sky130_fd_sc_hd__fill_1
XFILLER_0_82_15 VPWR VGND VPWR VGND sky130_ef_sc_hd__decap_12
XFILLER_0_15_53 VGND VGND VPWR VPWR sky130_fd_sc_hd__decap_3
XTAP_TAPCELL_ROW_18_566 VGND VPWR sky130_fd_sc_hd__tapvpwrvgnd_1
XTAP_TAPCELL_ROW_18_577 VGND VPWR sky130_fd_sc_hd__tapvpwrvgnd_1
XTAP_TAPCELL_ROW_102_1837 VGND VPWR sky130_fd_sc_hd__tapvpwrvgnd_1
XTAP_TAPCELL_ROW_102_1826 VGND VPWR sky130_fd_sc_hd__tapvpwrvgnd_1
XFILLER_0_97_390 VGND VGND VPWR VPWR sky130_fd_sc_hd__fill_2
XFILLER_0_58_755 VGND VGND VPWR VPWR sky130_fd_sc_hd__fill_1
XFILLER_0_9_329 VGND VGND VPWR VPWR sky130_fd_sc_hd__decap_6
X_5710_ _2371_ _2375_ _2332_ VGND VGND VPWR VPWR _2438_ sky130_fd_sc_hd__mux2_1
XFILLER_0_128_654 VPWR VGND VPWR VGND sky130_ef_sc_hd__decap_12
XFILLER_0_128_643 VGND VGND VPWR VPWR sky130_fd_sc_hd__fill_1
XFILLER_0_116_805 VGND VGND VPWR VPWR sky130_fd_sc_hd__decap_6
X_6690_ rf.registers\[10\]\[8\] _3003_ _3205_ VGND VGND VPWR VPWR _3214_ sky130_fd_sc_hd__mux2_1
XFILLER_0_128_698 VGND VGND VPWR VPWR sky130_fd_sc_hd__fill_2
XFILLER_0_122_65 VPWR VGND VPWR VGND sky130_ef_sc_hd__decap_12
X_5641_ net81 _2278_ _2370_ VGND VGND VPWR VPWR _2371_ sky130_fd_sc_hd__a21oi_1
XTAP_TAPCELL_ROW_135_2325 VGND VPWR sky130_fd_sc_hd__tapvpwrvgnd_1
XFILLER_0_115_337 VGND VGND VPWR VPWR sky130_fd_sc_hd__decap_4
XFILLER_0_14_825 VPWR VGND VPWR VGND sky130_ef_sc_hd__decap_12
X_8360_ rf.registers\[20\]\[29\] net35 _4117_ VGND VGND VPWR VPWR _4127_ sky130_fd_sc_hd__mux2_1
X_5572_ _2301_ _2302_ VGND VGND VPWR VPWR _2303_ sky130_fd_sc_hd__nand2_1
XFILLER_0_130_307 VGND VGND VPWR VPWR sky130_fd_sc_hd__fill_1
X_4523_ _1304_ _1305_ _1298_ VGND VGND VPWR VPWR _1306_ sky130_fd_sc_hd__mux2_1
X_7311_ _3570_ VGND VGND VPWR VPWR _0081_ sky130_fd_sc_hd__clkbuf_1
XFILLER_0_13_335 VGND VGND VPWR VPWR sky130_fd_sc_hd__fill_1
X_8291_ _4090_ VGND VGND VPWR VPWR _0541_ sky130_fd_sc_hd__clkbuf_1
X_7242_ rf.registers\[19\]\[16\] _3311_ _3527_ VGND VGND VPWR VPWR _3534_ sky130_fd_sc_hd__mux2_1
X_4454_ rf.registers\[24\]\[9\] rf.registers\[25\]\[9\] rf.registers\[26\]\[9\] rf.registers\[27\]\[9\]
+ _1035_ _1036_ VGND VGND VPWR VPWR _1240_ sky130_fd_sc_hd__mux4_1
XFILLER_0_1_741 VPWR VGND VPWR VGND sky130_ef_sc_hd__decap_12
X_7173_ _3497_ VGND VGND VPWR VPWR _0016_ sky130_fd_sc_hd__clkbuf_1
X_4385_ _1145_ _1174_ _1034_ VGND VGND VPWR VPWR _1175_ sky130_fd_sc_hd__o21a_1
XFILLER_0_0_273 VGND VGND VPWR VPWR sky130_fd_sc_hd__fill_1
XFILLER_0_1_785 VPWR VGND VPWR VGND sky130_ef_sc_hd__decap_12
XTAP_TAPCELL_ROW_113_1999 VGND VPWR sky130_fd_sc_hd__tapvpwrvgnd_1
XTAP_TAPCELL_ROW_113_1988 VGND VPWR sky130_fd_sc_hd__tapvpwrvgnd_1
X_6124_ _2348_ _2792_ VGND VGND VPWR VPWR _2832_ sky130_fd_sc_hd__nor2_1
X_6055_ _2628_ _2716_ _2765_ _2463_ _2766_ VGND VGND VPWR VPWR _2767_ sky130_fd_sc_hd__o221a_1
X_5006_ _1761_ _1762_ _1698_ VGND VGND VPWR VPWR _1763_ sky130_fd_sc_hd__mux2_1
XFILLER_0_56_71 VPWR VGND VPWR VGND sky130_ef_sc_hd__decap_12
XFILLER_0_68_508 VPWR VGND VPWR VGND sky130_ef_sc_hd__decap_12
X_6957_ net20 VGND VGND VPWR VPWR _3378_ sky130_fd_sc_hd__clkbuf_2
XTAP_TAPCELL_ROW_37_853 VGND VPWR sky130_fd_sc_hd__tapvpwrvgnd_1
XFILLER_0_49_777 VGND VGND VPWR VPWR sky130_fd_sc_hd__decap_6
XFILLER_0_64_725 VPWR VGND VPWR VGND sky130_ef_sc_hd__decap_12
XFILLER_0_9_841 VGND VGND VPWR VPWR sky130_fd_sc_hd__fill_1
X_5908_ _2553_ _2627_ _2340_ VGND VGND VPWR VPWR _2628_ sky130_fd_sc_hd__mux2_1
X_6888_ rf.registers\[16\]\[25\] _3330_ _3320_ VGND VGND VPWR VPWR _3331_ sky130_fd_sc_hd__mux2_1
X_8627_ clknet_leaf_44_CLK _0739_ VGND VGND VPWR VPWR rf.registers\[17\]\[2\] sky130_fd_sc_hd__dfxtp_1
XFILLER_0_118_153 VPWR VGND VPWR VGND sky130_ef_sc_hd__decap_12
XFILLER_0_64_769 VPWR VGND VPWR VGND sky130_ef_sc_hd__decap_12
X_5839_ _2241_ _2244_ _2561_ VGND VGND VPWR VPWR _2562_ sky130_fd_sc_hd__o21ai_1
XFILLER_0_134_657 VPWR VGND VPWR VGND sky130_ef_sc_hd__decap_12
XFILLER_0_118_197 VPWR VGND VPWR VGND sky130_ef_sc_hd__decap_12
X_8558_ clknet_leaf_91_CLK _0670_ VGND VGND VPWR VPWR rf.registers\[13\]\[29\] sky130_fd_sc_hd__dfxtp_1
XFILLER_0_133_167 VGND VGND VPWR VPWR sky130_fd_sc_hd__fill_1
X_7509_ _3374_ rf.registers\[31\]\[13\] _3672_ VGND VGND VPWR VPWR _3676_ sky130_fd_sc_hd__mux2_1
XFILLER_0_31_110 VGND VGND VPWR VPWR sky130_fd_sc_hd__fill_2
XTAP_TAPCELL_ROW_75_1427 VGND VPWR sky130_fd_sc_hd__tapvpwrvgnd_1
XFILLER_0_16_195 VGND VGND VPWR VPWR sky130_fd_sc_hd__fill_1
X_8489_ _4195_ VGND VGND VPWR VPWR _0634_ sky130_fd_sc_hd__clkbuf_1
XFILLER_0_32_699 VGND VGND VPWR VPWR sky130_fd_sc_hd__fill_1
XFILLER_0_87_839 VGND VGND VPWR VPWR sky130_fd_sc_hd__fill_1
XTAP_TAPCELL_ROW_86_1589 VGND VPWR sky130_fd_sc_hd__tapvpwrvgnd_1
XFILLER_0_52_29 VPWR VGND VPWR VGND sky130_ef_sc_hd__decap_12
XTAP_TAPCELL_ROW_15_525 VGND VPWR sky130_fd_sc_hd__tapvpwrvgnd_1
XFILLER_0_137_473 VPWR VGND VPWR VGND sky130_ef_sc_hd__decap_12
XFILLER_0_82_533 VGND VGND VPWR VPWR sky130_fd_sc_hd__decap_4
XFILLER_0_54_235 VGND VGND VPWR VPWR sky130_fd_sc_hd__decap_8
XFILLER_0_27_449 VGND VGND VPWR VPWR sky130_fd_sc_hd__fill_2
XFILLER_0_42_419 VGND VGND VPWR VPWR sky130_fd_sc_hd__fill_1
XTAP_TAPCELL_ROW_117_2055 VGND VPWR sky130_fd_sc_hd__tapvpwrvgnd_1
XFILLER_0_23_611 VGND VGND VPWR VPWR sky130_fd_sc_hd__fill_1
XFILLER_0_124_189 VGND VGND VPWR VPWR sky130_fd_sc_hd__decap_6
XTAP_TAPCELL_ROW_130_2244 VGND VPWR sky130_fd_sc_hd__tapvpwrvgnd_1
XFILLER_0_121_841 VGND VGND VPWR VPWR sky130_fd_sc_hd__fill_1
XFILLER_0_77_15 VPWR VGND VPWR VGND sky130_ef_sc_hd__decap_12
XTAP_TAPCELL_ROW_130_2255 VGND VPWR sky130_fd_sc_hd__tapvpwrvgnd_1
XFILLER_0_120_362 VGND VGND VPWR VPWR sky130_fd_sc_hd__fill_2
XFILLER_0_89_121 VGND VGND VPWR VPWR sky130_fd_sc_hd__fill_1
XFILLER_0_26_41 VGND VGND VPWR VPWR sky130_fd_sc_hd__decap_4
X_7860_ _3384_ rf.registers\[28\]\[18\] _3853_ VGND VGND VPWR VPWR _3862_ sky130_fd_sc_hd__mux2_1
X_6811_ rf.registers\[16\]\[0\] _3276_ _3278_ VGND VGND VPWR VPWR _3279_ sky130_fd_sc_hd__mux2_1
XFILLER_0_26_85 VGND VGND VPWR VPWR sky130_fd_sc_hd__fill_1
XFILLER_0_93_809 VPWR VGND VPWR VGND sky130_ef_sc_hd__decap_12
X_7791_ _3825_ VGND VGND VPWR VPWR _0306_ sky130_fd_sc_hd__clkbuf_1
XTAP_TAPCELL_ROW_34_812 VGND VPWR sky130_fd_sc_hd__tapvpwrvgnd_1
X_6742_ rf.registers\[0\]\[0\] _2982_ _3241_ VGND VGND VPWR VPWR _3242_ sky130_fd_sc_hd__mux2_1
X_9530_ clknet_leaf_33_CLK _0618_ VGND VGND VPWR VPWR rf.registers\[14\]\[9\] sky130_fd_sc_hd__dfxtp_1
XFILLER_0_58_585 VGND VGND VPWR VPWR sky130_fd_sc_hd__decap_3
XFILLER_0_9_137 VPWR VGND VPWR VGND sky130_ef_sc_hd__decap_12
XFILLER_0_18_416 VGND VGND VPWR VPWR sky130_fd_sc_hd__fill_1
X_9461_ clknet_leaf_47_CLK _0549_ VGND VGND VPWR VPWR rf.registers\[20\]\[4\] sky130_fd_sc_hd__dfxtp_1
XFILLER_0_85_393 VPWR VGND VPWR VGND sky130_ef_sc_hd__decap_12
XFILLER_0_73_555 VGND VGND VPWR VPWR sky130_fd_sc_hd__decap_4
X_6673_ _3204_ VGND VGND VPWR VPWR _3205_ sky130_fd_sc_hd__buf_4
XFILLER_0_6_811 VGND VGND VPWR VPWR sky130_fd_sc_hd__fill_1
XFILLER_0_46_769 VPWR VGND VPWR VGND sky130_ef_sc_hd__decap_12
X_5624_ _1076_ _2353_ VGND VGND VPWR VPWR _2354_ sky130_fd_sc_hd__nor2_1
X_8412_ rf.registers\[18\]\[21\] net27 _4153_ VGND VGND VPWR VPWR _4155_ sky130_fd_sc_hd__mux2_1
X_9392_ clknet_leaf_66_CLK _0480_ VGND VGND VPWR VPWR rf.registers\[26\]\[31\] sky130_fd_sc_hd__dfxtp_1
XFILLER_0_14_611 VPWR VGND VPWR VGND sky130_ef_sc_hd__decap_12
X_8343_ _4118_ VGND VGND VPWR VPWR _0565_ sky130_fd_sc_hd__clkbuf_1
XFILLER_0_115_167 VGND VGND VPWR VPWR sky130_fd_sc_hd__fill_1
X_5555_ _2211_ _2285_ VGND VGND VPWR VPWR _2286_ sky130_fd_sc_hd__or2_1
XFILLER_0_124_690 VGND VGND VPWR VPWR sky130_fd_sc_hd__decap_8
X_4506_ rf.registers\[24\]\[12\] rf.registers\[25\]\[12\] rf.registers\[26\]\[12\]
+ rf.registers\[27\]\[12\] _1283_ _1284_ VGND VGND VPWR VPWR _1289_ sky130_fd_sc_hd__mux4_1
XFILLER_0_77_3 VPWR VGND VPWR VGND sky130_ef_sc_hd__decap_12
X_5486_ _2209_ _2216_ VGND VGND VPWR VPWR _2217_ sky130_fd_sc_hd__nand2_1
X_8274_ _3028_ rf.registers\[25\]\[20\] _4081_ VGND VGND VPWR VPWR _4082_ sky130_fd_sc_hd__mux2_1
X_4437_ rf.registers\[28\]\[8\] rf.registers\[29\]\[8\] rf.registers\[30\]\[8\] rf.registers\[31\]\[8\]
+ _1138_ _1127_ VGND VGND VPWR VPWR _1224_ sky130_fd_sc_hd__mux4_1
X_7225_ rf.registers\[19\]\[8\] _3294_ _3516_ VGND VGND VPWR VPWR _3525_ sky130_fd_sc_hd__mux2_1
XTAP_TAPCELL_ROW_57_1157 VGND VPWR sky130_fd_sc_hd__tapvpwrvgnd_1
X_7156_ _3488_ VGND VGND VPWR VPWR _0008_ sky130_fd_sc_hd__clkbuf_1
X_4368_ _1158_ VGND VGND VPWR VPWR net107 sky130_fd_sc_hd__inv_4
XTAP_TAPCELL_ROW_70_1357 VGND VPWR sky130_fd_sc_hd__tapvpwrvgnd_1
XTAP_TAPCELL_ROW_70_1346 VGND VPWR sky130_fd_sc_hd__tapvpwrvgnd_1
X_6107_ _2813_ _2815_ VGND VGND VPWR VPWR _2816_ sky130_fd_sc_hd__nor2_1
X_4299_ rf.registers\[8\]\[2\] rf.registers\[9\]\[2\] rf.registers\[10\]\[2\] rf.registers\[11\]\[2\]
+ _1077_ _1078_ VGND VGND VPWR VPWR _1092_ sky130_fd_sc_hd__mux4_1
X_7087_ rf.registers\[5\]\[7\] _3292_ _3444_ VGND VGND VPWR VPWR _3452_ sky130_fd_sc_hd__mux2_1
X_6038_ _2386_ _2750_ _1158_ VGND VGND VPWR VPWR _2751_ sky130_fd_sc_hd__o21a_1
XFILLER_0_69_839 VGND VGND VPWR VPWR sky130_fd_sc_hd__fill_1
X_7989_ _3376_ rf.registers\[22\]\[14\] _3926_ VGND VGND VPWR VPWR _3931_ sky130_fd_sc_hd__mux2_1
XFILLER_0_138_237 VPWR VGND VPWR VGND sky130_ef_sc_hd__decap_12
XFILLER_0_64_533 VGND VGND VPWR VPWR sky130_fd_sc_hd__decap_4
XFILLER_0_134_421 VPWR VGND VPWR VGND sky130_ef_sc_hd__decap_12
XFILLER_0_24_419 VGND VGND VPWR VPWR sky130_fd_sc_hd__fill_1
XFILLER_0_122_638 VGND VGND VPWR VPWR sky130_fd_sc_hd__decap_3
XFILLER_0_121_137 VPWR VGND VPWR VGND sky130_ef_sc_hd__decap_12
XFILLER_0_103_841 VGND VGND VPWR VPWR sky130_fd_sc_hd__fill_1
XTAP_TAPCELL_ROW_20_594 VGND VPWR sky130_fd_sc_hd__tapvpwrvgnd_1
XFILLER_0_32_496 VGND VGND VPWR VPWR sky130_fd_sc_hd__fill_2
XFILLER_0_130_693 VGND VGND VPWR VPWR sky130_fd_sc_hd__decap_6
XFILLER_0_47_18 VPWR VGND VPWR VGND sky130_ef_sc_hd__decap_12
XTAP_TAPCELL_ROW_88_1618 VGND VPWR sky130_fd_sc_hd__tapvpwrvgnd_1
XFILLER_0_87_614 VGND VGND VPWR VPWR sky130_fd_sc_hd__fill_2
XFILLER_0_86_157 VGND VGND VPWR VPWR sky130_fd_sc_hd__fill_2
XFILLER_0_75_809 VPWR VGND VPWR VGND sky130_ef_sc_hd__decap_12
XFILLER_0_129_237 VPWR VGND VPWR VGND sky130_ef_sc_hd__decap_12
XFILLER_0_138_771 VPWR VGND VPWR VGND sky130_ef_sc_hd__decap_12
XFILLER_0_137_281 VPWR VGND VPWR VGND sky130_ef_sc_hd__decap_12
XFILLER_0_43_706 VPWR VGND VPWR VGND sky130_ef_sc_hd__decap_12
XFILLER_0_125_443 VGND VGND VPWR VPWR sky130_fd_sc_hd__decap_4
XFILLER_0_70_525 VGND VGND VPWR VPWR sky130_fd_sc_hd__fill_1
XFILLER_0_12_65 VPWR VGND VPWR VGND sky130_ef_sc_hd__decap_12
XFILLER_0_36_780 VPWR VGND VPWR VGND sky130_ef_sc_hd__decap_12
Xoutput105 net105 VGND VGND VPWR VPWR RD2[31] sky130_fd_sc_hd__buf_1
XFILLER_0_51_783 VGND VGND VPWR VPWR sky130_fd_sc_hd__fill_1
Xoutput116 net116 VGND VGND VPWR VPWR alu_result[12] sky130_fd_sc_hd__buf_1
XFILLER_0_2_357 VGND VGND VPWR VPWR sky130_fd_sc_hd__decap_6
X_5340_ rf.registers\[4\]\[24\] rf.registers\[5\]\[24\] rf.registers\[6\]\[24\] rf.registers\[7\]\[24\]
+ _2077_ _2078_ VGND VGND VPWR VPWR _2079_ sky130_fd_sc_hd__mux4_1
XFILLER_0_121_671 VGND VGND VPWR VPWR sky130_fd_sc_hd__fill_1
X_5271_ _2012_ _2013_ _1927_ VGND VGND VPWR VPWR _2014_ sky130_fd_sc_hd__mux2_1
XFILLER_0_11_647 VGND VGND VPWR VPWR sky130_fd_sc_hd__fill_1
Xoutput127 net127 VGND VGND VPWR VPWR alu_result[22] sky130_fd_sc_hd__buf_1
Xoutput138 net138 VGND VGND VPWR VPWR alu_result[3] sky130_fd_sc_hd__buf_1
X_7010_ _3411_ VGND VGND VPWR VPWR _0963_ sky130_fd_sc_hd__clkbuf_1
XTAP_TAPCELL_ROW_110_1947 VGND VPWR sky130_fd_sc_hd__tapvpwrvgnd_1
XFILLER_0_128_53 VPWR VGND VPWR VGND sky130_ef_sc_hd__decap_12
XTAP_TAPCELL_ROW_52_1076 VGND VPWR sky130_fd_sc_hd__tapvpwrvgnd_1
XFILLER_0_37_51 VGND VGND VPWR VPWR sky130_fd_sc_hd__decap_4
XFILLER_0_128_97 VPWR VGND VPWR VGND sky130_ef_sc_hd__decap_12
X_8961_ clknet_leaf_20_CLK _0049_ VGND VGND VPWR VPWR rf.registers\[19\]\[16\] sky130_fd_sc_hd__dfxtp_1
XTAP_TAPCELL_ROW_52_1087 VGND VPWR sky130_fd_sc_hd__tapvpwrvgnd_1
X_7912_ _3878_ VGND VGND VPWR VPWR _3890_ sky130_fd_sc_hd__clkbuf_8
XFILLER_0_37_95 VGND VGND VPWR VPWR sky130_fd_sc_hd__fill_1
X_8892_ clknet_leaf_31_CLK _1004_ VGND VGND VPWR VPWR rf.registers\[5\]\[11\] sky130_fd_sc_hd__dfxtp_1
XFILLER_0_77_113 VPWR VGND VPWR VGND sky130_ef_sc_hd__decap_12
XFILLER_0_77_102 VGND VGND VPWR VPWR sky130_fd_sc_hd__fill_1
X_7843_ _3841_ VGND VGND VPWR VPWR _3853_ sky130_fd_sc_hd__clkbuf_8
X_7774_ _3816_ VGND VGND VPWR VPWR _0298_ sky130_fd_sc_hd__clkbuf_1
XFILLER_0_92_116 VGND VGND VPWR VPWR sky130_fd_sc_hd__fill_1
X_4986_ _1651_ VGND VGND VPWR VPWR _1744_ sky130_fd_sc_hd__buf_4
XFILLER_0_65_308 VGND VGND VPWR VPWR sky130_fd_sc_hd__fill_2
XFILLER_0_18_224 VGND VGND VPWR VPWR sky130_fd_sc_hd__fill_1
XFILLER_0_19_736 VPWR VGND VPWR VGND sky130_ef_sc_hd__decap_12
X_9513_ clknet_leaf_72_CLK _0601_ VGND VGND VPWR VPWR rf.registers\[18\]\[24\] sky130_fd_sc_hd__dfxtp_1
X_6725_ _3232_ VGND VGND VPWR VPWR _0857_ sky130_fd_sc_hd__clkbuf_1
XFILLER_0_116_421 VGND VGND VPWR VPWR sky130_fd_sc_hd__fill_2
XFILLER_0_46_577 VGND VGND VPWR VPWR sky130_fd_sc_hd__decap_4
X_9444_ clknet_leaf_21_CLK _0532_ VGND VGND VPWR VPWR rf.registers\[25\]\[19\] sky130_fd_sc_hd__dfxtp_1
XFILLER_0_73_396 VGND VGND VPWR VPWR sky130_fd_sc_hd__fill_2
X_6656_ _3195_ VGND VGND VPWR VPWR _0825_ sky130_fd_sc_hd__clkbuf_1
X_9375_ clknet_leaf_28_CLK _0463_ VGND VGND VPWR VPWR rf.registers\[26\]\[14\] sky130_fd_sc_hd__dfxtp_1
X_6587_ _3158_ VGND VGND VPWR VPWR _0793_ sky130_fd_sc_hd__clkbuf_1
X_5607_ _1055_ _2225_ VGND VGND VPWR VPWR _2337_ sky130_fd_sc_hd__or2_1
X_8326_ _4109_ VGND VGND VPWR VPWR _0557_ sky130_fd_sc_hd__clkbuf_1
X_5538_ net107 _2265_ VGND VGND VPWR VPWR _2269_ sky130_fd_sc_hd__nand2_4
XFILLER_0_131_479 VGND VGND VPWR VPWR sky130_fd_sc_hd__fill_2
X_8257_ _3012_ rf.registers\[25\]\[12\] _4070_ VGND VGND VPWR VPWR _4073_ sky130_fd_sc_hd__mux2_1
XFILLER_0_100_811 VGND VGND VPWR VPWR sky130_fd_sc_hd__fill_1
X_7208_ _3515_ VGND VGND VPWR VPWR _3516_ sky130_fd_sc_hd__buf_4
X_5469_ _1415_ _1429_ _2198_ _2199_ VGND VGND VPWR VPWR _2200_ sky130_fd_sc_hd__and4_2
X_8188_ _4036_ VGND VGND VPWR VPWR _0492_ sky130_fd_sc_hd__clkbuf_1
X_7139_ _2985_ _3406_ VGND VGND VPWR VPWR _3479_ sky130_fd_sc_hd__nor2_2
XTAP_TAPCELL_ROW_6_389 VGND VPWR sky130_fd_sc_hd__tapvpwrvgnd_1
XFILLER_0_69_603 VGND VGND VPWR VPWR sky130_fd_sc_hd__fill_1
XFILLER_0_57_809 VPWR VGND VPWR VGND sky130_ef_sc_hd__decap_12
XTAP_TAPCELL_ROW_83_1548 VGND VPWR sky130_fd_sc_hd__tapvpwrvgnd_1
XTAP_TAPCELL_ROW_25_675 VGND VPWR sky130_fd_sc_hd__tapvpwrvgnd_1
XFILLER_0_119_281 VGND VGND VPWR VPWR sky130_fd_sc_hd__decap_4
XFILLER_0_135_741 VPWR VGND VPWR VGND sky130_ef_sc_hd__decap_12
Xinput18 WD3[13] VGND VGND VPWR VPWR net18 sky130_fd_sc_hd__buf_2
XFILLER_0_64_363 VGND VGND VPWR VPWR sky130_fd_sc_hd__fill_1
XFILLER_0_135_785 VPWR VGND VPWR VGND sky130_ef_sc_hd__decap_12
XFILLER_0_134_251 VGND VGND VPWR VPWR sky130_fd_sc_hd__fill_1
XTAP_TAPCELL_ROW_114_2014 VGND VPWR sky130_fd_sc_hd__tapvpwrvgnd_1
XTAP_TAPCELL_ROW_114_2003 VGND VPWR sky130_fd_sc_hd__tapvpwrvgnd_1
Xinput29 WD3[23] VGND VGND VPWR VPWR net29 sky130_fd_sc_hd__buf_1
XFILLER_0_122_446 VGND VGND VPWR VPWR sky130_fd_sc_hd__fill_1
XFILLER_0_33_783 VGND VGND VPWR VPWR sky130_fd_sc_hd__fill_1
XFILLER_0_0_817 VPWR VGND VPWR VGND sky130_ef_sc_hd__decap_12
XFILLER_0_74_27 VGND VGND VPWR VPWR sky130_fd_sc_hd__fill_1
XTAP_TAPCELL_ROW_125_2176 VGND VPWR sky130_fd_sc_hd__tapvpwrvgnd_1
XFILLER_0_59_113 VGND VGND VPWR VPWR sky130_fd_sc_hd__decap_4
XFILLER_0_90_15 VPWR VGND VPWR VGND sky130_ef_sc_hd__decap_12
XFILLER_0_59_135 VGND VGND VPWR VPWR sky130_fd_sc_hd__fill_1
X_4840_ rf.registers\[24\]\[31\] rf.registers\[25\]\[31\] rf.registers\[26\]\[31\]
+ rf.registers\[27\]\[31\] _1183_ _1181_ VGND VGND VPWR VPWR _1604_ sky130_fd_sc_hd__mux4_1
XFILLER_0_114_77 VGND VGND VPWR VPWR sky130_fd_sc_hd__decap_6
XFILLER_0_7_405 VPWR VGND VPWR VGND sky130_ef_sc_hd__decap_12
XFILLER_0_23_42 VPWR VGND VPWR VGND sky130_ef_sc_hd__decap_12
XFILLER_0_28_533 VPWR VGND VPWR VGND sky130_ef_sc_hd__decap_12
XTAP_TAPCELL_ROW_44_962 VGND VPWR sky130_fd_sc_hd__tapvpwrvgnd_1
XFILLER_0_67_190 VGND VGND VPWR VPWR sky130_fd_sc_hd__fill_2
XFILLER_0_55_330 VGND VGND VPWR VPWR sky130_fd_sc_hd__decap_3
XFILLER_0_7_449 VPWR VGND VPWR VGND sky130_ef_sc_hd__decap_12
X_4771_ rf.registers\[20\]\[27\] rf.registers\[21\]\[27\] rf.registers\[22\]\[27\]
+ rf.registers\[23\]\[27\] _1120_ _1123_ VGND VGND VPWR VPWR _1539_ sky130_fd_sc_hd__mux4_1
X_6510_ _3117_ VGND VGND VPWR VPWR _0757_ sky130_fd_sc_hd__clkbuf_1
X_7490_ _3355_ rf.registers\[31\]\[4\] _3661_ VGND VGND VPWR VPWR _3666_ sky130_fd_sc_hd__mux2_1
XFILLER_0_15_205 VPWR VGND VPWR VGND sky130_ef_sc_hd__decap_12
XFILLER_0_125_273 VGND VGND VPWR VPWR sky130_fd_sc_hd__decap_6
XFILLER_0_99_57 VGND VGND VPWR VPWR sky130_fd_sc_hd__decap_8
X_6441_ rf.registers\[11\]\[21\] _3031_ _3078_ VGND VGND VPWR VPWR _3080_ sky130_fd_sc_hd__mux2_1
XFILLER_0_15_249 VPWR VGND VPWR VGND sky130_ef_sc_hd__decap_12
XFILLER_0_130_65 VPWR VGND VPWR VGND sky130_ef_sc_hd__decap_12
X_9160_ clknet_leaf_8_CLK _0248_ VGND VGND VPWR VPWR rf.registers\[2\]\[23\] sky130_fd_sc_hd__dfxtp_1
XFILLER_0_2_121 VPWR VGND VPWR VGND sky130_ef_sc_hd__decap_12
XFILLER_0_24_761 VGND VGND VPWR VPWR sky130_fd_sc_hd__fill_1
X_6372_ net31 VGND VGND VPWR VPWR _3039_ sky130_fd_sc_hd__buf_2
X_8111_ _3995_ VGND VGND VPWR VPWR _0456_ sky130_fd_sc_hd__clkbuf_1
XFILLER_0_2_165 VPWR VGND VPWR VGND sky130_ef_sc_hd__decap_12
X_5323_ _2062_ VGND VGND VPWR VPWR net64 sky130_fd_sc_hd__inv_2
X_9091_ clknet_leaf_4_CLK _0179_ VGND VGND VPWR VPWR rf.registers\[31\]\[18\] sky130_fd_sc_hd__dfxtp_1
XTAP_TAPCELL_ROW_54_1116 VGND VPWR sky130_fd_sc_hd__tapvpwrvgnd_1
XTAP_TAPCELL_ROW_54_1105 VGND VPWR sky130_fd_sc_hd__tapvpwrvgnd_1
XFILLER_0_121_490 VPWR VGND VPWR VGND sky130_ef_sc_hd__decap_12
X_8042_ rf.registers\[7\]\[7\] _3292_ _3951_ VGND VGND VPWR VPWR _3959_ sky130_fd_sc_hd__mux2_1
X_5254_ _1728_ _1989_ _1997_ VGND VGND VPWR VPWR _1998_ sky130_fd_sc_hd__o21ai_4
X_5185_ _1927_ _1931_ VGND VGND VPWR VPWR _1932_ sky130_fd_sc_hd__or2_1
XTAP_TAPCELL_ROW_3_348 VGND VPWR sky130_fd_sc_hd__tapvpwrvgnd_1
XFILLER_0_64_71 VGND VGND VPWR VPWR sky130_fd_sc_hd__decap_4
X_8944_ clknet_leaf_75_CLK _0032_ VGND VGND VPWR VPWR rf.registers\[4\]\[31\] sky130_fd_sc_hd__dfxtp_1
X_8875_ clknet_leaf_68_CLK _0987_ VGND VGND VPWR VPWR rf.registers\[6\]\[26\] sky130_fd_sc_hd__dfxtp_1
XFILLER_0_39_809 VPWR VGND VPWR VGND sky130_ef_sc_hd__decap_12
X_7826_ _3844_ VGND VGND VPWR VPWR _0322_ sky130_fd_sc_hd__clkbuf_1
XFILLER_0_78_477 VGND VGND VPWR VPWR sky130_fd_sc_hd__decap_6
XFILLER_0_78_499 VGND VGND VPWR VPWR sky130_fd_sc_hd__decap_4
XFILLER_0_66_639 VGND VGND VPWR VPWR sky130_fd_sc_hd__decap_4
XTAP_TAPCELL_ROW_65_1278 VGND VPWR sky130_fd_sc_hd__tapvpwrvgnd_1
XFILLER_0_65_116 VGND VGND VPWR VPWR sky130_fd_sc_hd__fill_1
X_7757_ rf.registers\[9\]\[1\] _3280_ _3806_ VGND VGND VPWR VPWR _3808_ sky130_fd_sc_hd__mux2_1
X_4969_ _1727_ VGND VGND VPWR VPWR net75 sky130_fd_sc_hd__inv_2
XTAP_TAPCELL_ROW_22_623 VGND VPWR sky130_fd_sc_hd__tapvpwrvgnd_1
XTAP_TAPCELL_ROW_22_634 VGND VPWR sky130_fd_sc_hd__tapvpwrvgnd_1
X_7688_ _3771_ VGND VGND VPWR VPWR _0257_ sky130_fd_sc_hd__clkbuf_1
XFILLER_0_117_741 VPWR VGND VPWR VGND sky130_ef_sc_hd__decap_12
X_6708_ _3223_ VGND VGND VPWR VPWR _0849_ sky130_fd_sc_hd__clkbuf_1
X_9427_ clknet_leaf_42_CLK _0515_ VGND VGND VPWR VPWR rf.registers\[25\]\[2\] sky130_fd_sc_hd__dfxtp_1
XFILLER_0_117_785 VPWR VGND VPWR VGND sky130_ef_sc_hd__decap_12
X_6639_ _3186_ VGND VGND VPWR VPWR _0817_ sky130_fd_sc_hd__clkbuf_1
XFILLER_0_132_755 VGND VGND VPWR VPWR sky130_fd_sc_hd__fill_1
XFILLER_0_21_219 VGND VGND VPWR VPWR sky130_fd_sc_hd__fill_2
X_9358_ clknet_leaf_90_CLK _0446_ VGND VGND VPWR VPWR rf.registers\[7\]\[29\] sky130_fd_sc_hd__dfxtp_1
X_8309_ _4100_ VGND VGND VPWR VPWR _0549_ sky130_fd_sc_hd__clkbuf_1
X_9289_ clknet_leaf_84_CLK _0377_ VGND VGND VPWR VPWR rf.registers\[23\]\[24\] sky130_fd_sc_hd__dfxtp_1
XPHY_EDGE_ROW_110_Right_110 VGND VGND VPWR VPWR sky130_fd_sc_hd__decap_3
XFILLER_0_89_709 VPWR VGND VPWR VGND sky130_ef_sc_hd__decap_12
XFILLER_0_97_753 VPWR VGND VPWR VGND sky130_ef_sc_hd__decap_12
XFILLER_0_69_444 VGND VGND VPWR VPWR sky130_fd_sc_hd__fill_1
XFILLER_0_97_797 VPWR VGND VPWR VGND sky130_ef_sc_hd__decap_12
XFILLER_0_84_414 VGND VGND VPWR VPWR sky130_fd_sc_hd__decap_6
XFILLER_0_57_628 VPWR VGND VPWR VGND sky130_ef_sc_hd__decap_12
XFILLER_0_57_617 VGND VGND VPWR VPWR sky130_fd_sc_hd__decap_8
XFILLER_0_127_505 VGND VGND VPWR VPWR sky130_fd_sc_hd__fill_1
XFILLER_0_84_425 VGND VGND VPWR VPWR sky130_fd_sc_hd__fill_1
XFILLER_0_127_527 VGND VGND VPWR VPWR sky130_fd_sc_hd__fill_2
XTAP_TAPCELL_ROW_120_2095 VGND VPWR sky130_fd_sc_hd__tapvpwrvgnd_1
XFILLER_0_60_29 VPWR VGND VPWR VGND sky130_ef_sc_hd__decap_12
XTAP_TAPCELL_ROW_41_910 VGND VPWR sky130_fd_sc_hd__tapvpwrvgnd_1
XTAP_TAPCELL_ROW_41_921 VGND VPWR sky130_fd_sc_hd__tapvpwrvgnd_1
XFILLER_0_52_300 VGND VGND VPWR VPWR sky130_fd_sc_hd__decap_8
XFILLER_0_4_419 VGND VGND VPWR VPWR sky130_fd_sc_hd__fill_1
XFILLER_0_122_221 VPWR VGND VPWR VGND sky130_ef_sc_hd__decap_12
XFILLER_0_107_7 VPWR VGND VPWR VGND sky130_ef_sc_hd__decap_12
XTAP_TAPCELL_ROW_96_1739 VGND VPWR sky130_fd_sc_hd__tapvpwrvgnd_1
XFILLER_0_69_27 VGND VGND VPWR VPWR sky130_fd_sc_hd__decap_6
XFILLER_0_123_777 VGND VGND VPWR VPWR sky130_fd_sc_hd__decap_6
XFILLER_0_122_265 VPWR VGND VPWR VGND sky130_ef_sc_hd__decap_12
XFILLER_0_33_591 VGND VGND VPWR VPWR sky130_fd_sc_hd__fill_2
XFILLER_0_20_241 VGND VGND VPWR VPWR sky130_fd_sc_hd__fill_2
XFILLER_0_21_753 VPWR VGND VPWR VGND sky130_ef_sc_hd__decap_12
XFILLER_0_85_15 VPWR VGND VPWR VGND sky130_ef_sc_hd__decap_12
XFILLER_0_21_797 VPWR VGND VPWR VGND sky130_ef_sc_hd__decap_12
XTAP_TAPCELL_ROW_127_2205 VGND VPWR sky130_fd_sc_hd__tapvpwrvgnd_1
XFILLER_0_109_55 VGND VGND VPWR VPWR sky130_fd_sc_hd__fill_1
XFILLER_0_18_53 VPWR VGND VPWR VGND sky130_ef_sc_hd__decap_12
XTAP_TAPCELL_ROW_0_307 VGND VPWR sky130_fd_sc_hd__tapvpwrvgnd_1
XFILLER_0_18_97 VPWR VGND VPWR VGND sky130_ef_sc_hd__decap_12
X_6990_ _2970_ rf.registers\[15\]\[26\] _3389_ VGND VGND VPWR VPWR _3400_ sky130_fd_sc_hd__mux2_1
X_5941_ _2568_ VGND VGND VPWR VPWR _2659_ sky130_fd_sc_hd__inv_2
XFILLER_0_87_241 VGND VGND VPWR VPWR sky130_fd_sc_hd__fill_2
XFILLER_0_34_41 VPWR VGND VPWR VGND sky130_ef_sc_hd__decap_12
X_8660_ clknet_leaf_41_CLK _0772_ VGND VGND VPWR VPWR rf.registers\[1\]\[3\] sky130_fd_sc_hd__dfxtp_1
XTAP_TAPCELL_ROW_105_1879 VGND VPWR sky130_fd_sc_hd__tapvpwrvgnd_1
XTAP_TAPCELL_ROW_105_1868 VGND VPWR sky130_fd_sc_hd__tapvpwrvgnd_1
X_5872_ _2452_ _2500_ _2383_ VGND VGND VPWR VPWR _2594_ sky130_fd_sc_hd__mux2_1
XFILLER_0_75_458 VPWR VGND VPWR VGND sky130_ef_sc_hd__decap_12
X_8591_ clknet_leaf_62_CLK _0703_ VGND VGND VPWR VPWR rf.registers\[12\]\[30\] sky130_fd_sc_hd__dfxtp_1
X_7611_ _3729_ VGND VGND VPWR VPWR _0222_ sky130_fd_sc_hd__clkbuf_1
X_4823_ rf.registers\[24\]\[30\] rf.registers\[25\]\[30\] rf.registers\[26\]\[30\]
+ rf.registers\[27\]\[30\] _1125_ _1128_ VGND VGND VPWR VPWR _1588_ sky130_fd_sc_hd__mux4_1
XFILLER_0_8_769 VPWR VGND VPWR VGND sky130_ef_sc_hd__decap_12
XFILLER_0_16_525 VGND VGND VPWR VPWR sky130_fd_sc_hd__decap_6
X_4754_ rf.registers\[20\]\[26\] rf.registers\[21\]\[26\] rf.registers\[22\]\[26\]
+ rf.registers\[23\]\[26\] _1119_ _1122_ VGND VGND VPWR VPWR _1523_ sky130_fd_sc_hd__mux4_1
X_7542_ _2976_ rf.registers\[31\]\[29\] _3683_ VGND VGND VPWR VPWR _3693_ sky130_fd_sc_hd__mux2_1
Xclkbuf_leaf_93_CLK clknet_3_0__leaf_CLK VGND VGND VPWR VPWR clknet_leaf_93_CLK sky130_fd_sc_hd__clkbuf_8
XTAP_TAPCELL_ROW_138_2389 VGND VPWR sky130_fd_sc_hd__tapvpwrvgnd_1
XTAP_TAPCELL_ROW_138_2378 VGND VPWR sky130_fd_sc_hd__tapvpwrvgnd_1
XTAP_TAPCELL_ROW_138_2367 VGND VPWR sky130_fd_sc_hd__tapvpwrvgnd_1
XFILLER_0_7_279 VGND VGND VPWR VPWR sky130_fd_sc_hd__fill_1
XFILLER_0_28_396 VPWR VGND VPWR VGND sky130_ef_sc_hd__decap_12
X_7473_ _3656_ VGND VGND VPWR VPWR _0157_ sky130_fd_sc_hd__clkbuf_1
XFILLER_0_114_755 VGND VGND VPWR VPWR sky130_fd_sc_hd__fill_1
X_9212_ clknet_leaf_29_CLK _0300_ VGND VGND VPWR VPWR rf.registers\[9\]\[11\] sky130_fd_sc_hd__dfxtp_1
X_4685_ rf.registers\[12\]\[21\] rf.registers\[13\]\[21\] rf.registers\[14\]\[21\]
+ rf.registers\[15\]\[21\] _1147_ _1149_ VGND VGND VPWR VPWR _1459_ sky130_fd_sc_hd__mux4_1
XTAP_TAPCELL_ROW_60_1197 VGND VPWR sky130_fd_sc_hd__tapvpwrvgnd_1
XFILLER_0_16_569 VPWR VGND VPWR VGND sky130_ef_sc_hd__decap_12
XFILLER_0_113_254 VGND VGND VPWR VPWR sky130_fd_sc_hd__fill_1
X_6424_ rf.registers\[11\]\[13\] _3014_ _3067_ VGND VGND VPWR VPWR _3071_ sky130_fd_sc_hd__mux2_1
XFILLER_0_3_441 VGND VGND VPWR VPWR sky130_fd_sc_hd__decap_6
XFILLER_0_12_731 VGND VGND VPWR VPWR sky130_fd_sc_hd__decap_4
X_6355_ _3027_ VGND VGND VPWR VPWR _0692_ sky130_fd_sc_hd__clkbuf_1
X_9143_ clknet_leaf_57_CLK _0231_ VGND VGND VPWR VPWR rf.registers\[2\]\[6\] sky130_fd_sc_hd__dfxtp_1
XTAP_TAPCELL_ROW_8_418 VGND VPWR sky130_fd_sc_hd__tapvpwrvgnd_1
XFILLER_0_3_485 VPWR VGND VPWR VGND sky130_ef_sc_hd__decap_12
X_9074_ clknet_leaf_41_CLK _0162_ VGND VGND VPWR VPWR rf.registers\[31\]\[1\] sky130_fd_sc_hd__dfxtp_1
X_6286_ _2979_ VGND VGND VPWR VPWR _0671_ sky130_fd_sc_hd__clkbuf_1
X_5306_ _2046_ VGND VGND VPWR VPWR net63 sky130_fd_sc_hd__inv_2
X_5237_ _1940_ _1973_ _1977_ _1981_ VGND VGND VPWR VPWR _1982_ sky130_fd_sc_hd__a2bb2o_4
X_8025_ _3949_ VGND VGND VPWR VPWR _0416_ sky130_fd_sc_hd__clkbuf_1
X_5168_ _1914_ _1915_ _1630_ VGND VGND VPWR VPWR _1916_ sky130_fd_sc_hd__mux2_1
X_5099_ _1764_ _1850_ VGND VGND VPWR VPWR _1851_ sky130_fd_sc_hd__nand2_1
XTAP_TAPCELL_ROW_67_1307 VGND VPWR sky130_fd_sc_hd__tapvpwrvgnd_1
X_8927_ clknet_leaf_16_CLK _0015_ VGND VGND VPWR VPWR rf.registers\[4\]\[14\] sky130_fd_sc_hd__dfxtp_1
XFILLER_0_79_753 VPWR VGND VPWR VGND sky130_ef_sc_hd__decap_12
XTAP_TAPCELL_ROW_27_704 VGND VPWR sky130_fd_sc_hd__tapvpwrvgnd_1
XFILLER_0_94_701 VPWR VGND VPWR VGND sky130_ef_sc_hd__decap_12
XFILLER_0_66_403 VGND VGND VPWR VPWR sky130_fd_sc_hd__fill_1
XFILLER_0_39_617 VPWR VGND VPWR VGND sky130_ef_sc_hd__decap_12
X_8858_ clknet_leaf_55_CLK _0970_ VGND VGND VPWR VPWR rf.registers\[6\]\[9\] sky130_fd_sc_hd__dfxtp_1
XFILLER_0_93_222 VGND VGND VPWR VPWR sky130_fd_sc_hd__fill_2
XTAP_TAPCELL_ROW_80_1507 VGND VPWR sky130_fd_sc_hd__tapvpwrvgnd_1
XFILLER_0_79_797 VPWR VGND VPWR VGND sky130_ef_sc_hd__decap_12
X_8789_ clknet_leaf_48_CLK _0901_ VGND VGND VPWR VPWR rf.registers\[16\]\[4\] sky130_fd_sc_hd__dfxtp_1
X_7809_ rf.registers\[9\]\[26\] _3332_ _3828_ VGND VGND VPWR VPWR _3835_ sky130_fd_sc_hd__mux2_1
XFILLER_0_136_357 VGND VGND VPWR VPWR sky130_fd_sc_hd__decap_6
Xclkbuf_leaf_84_CLK clknet_3_2__leaf_CLK VGND VGND VPWR VPWR clknet_leaf_84_CLK sky130_fd_sc_hd__clkbuf_8
XFILLER_0_47_683 VGND VGND VPWR VPWR sky130_fd_sc_hd__fill_1
XFILLER_0_117_582 VGND VGND VPWR VPWR sky130_fd_sc_hd__fill_1
XFILLER_0_62_675 VPWR VGND VPWR VGND sky130_ef_sc_hd__decap_12
XFILLER_0_22_517 VPWR VGND VPWR VGND sky130_ef_sc_hd__decap_12
XFILLER_0_105_777 VGND VGND VPWR VPWR sky130_fd_sc_hd__decap_6
XTAP_TAPCELL_ROW_78_1469 VGND VPWR sky130_fd_sc_hd__tapvpwrvgnd_1
XFILLER_0_50_837 VGND VGND VPWR VPWR sky130_fd_sc_hd__fill_2
XFILLER_0_15_591 VGND VGND VPWR VPWR sky130_fd_sc_hd__fill_1
XFILLER_0_120_725 VPWR VGND VPWR VGND sky130_ef_sc_hd__decap_12
XFILLER_0_39_19 VPWR VGND VPWR VGND sky130_ef_sc_hd__decap_12
XFILLER_0_120_769 VPWR VGND VPWR VGND sky130_ef_sc_hd__decap_12
XTAP_TAPCELL_ROW_91_1669 VGND VPWR sky130_fd_sc_hd__tapvpwrvgnd_1
XTAP_TAPCELL_ROW_91_1658 VGND VPWR sky130_fd_sc_hd__tapvpwrvgnd_1
XTAP_TAPCELL_ROW_122_2124 VGND VPWR sky130_fd_sc_hd__tapvpwrvgnd_1
XTAP_TAPCELL_ROW_122_2135 VGND VPWR sky130_fd_sc_hd__tapvpwrvgnd_1
XFILLER_0_71_39 VGND VGND VPWR VPWR sky130_fd_sc_hd__fill_2
XFILLER_0_128_825 VPWR VGND VPWR VGND sky130_ef_sc_hd__decap_12
XFILLER_0_57_447 VGND VGND VPWR VPWR sky130_fd_sc_hd__fill_1
XFILLER_0_127_335 VGND VGND VPWR VPWR sky130_fd_sc_hd__fill_1
XFILLER_0_65_491 VPWR VGND VPWR VGND sky130_ef_sc_hd__decap_12
Xclkbuf_leaf_75_CLK clknet_3_3__leaf_CLK VGND VGND VPWR VPWR clknet_leaf_75_CLK sky130_fd_sc_hd__clkbuf_8
XFILLER_0_53_631 VGND VGND VPWR VPWR sky130_fd_sc_hd__decap_8
XFILLER_0_25_333 VGND VGND VPWR VPWR sky130_fd_sc_hd__decap_3
XFILLER_0_111_45 VGND VGND VPWR VPWR sky130_fd_sc_hd__decap_8
XTAP_TAPCELL_ROW_100_1798 VGND VPWR sky130_fd_sc_hd__tapvpwrvgnd_1
XFILLER_0_52_141 VPWR VGND VPWR VGND sky130_ef_sc_hd__decap_12
XFILLER_0_13_517 VPWR VGND VPWR VGND sky130_ef_sc_hd__decap_12
XTAP_TAPCELL_ROW_13_497 VGND VPWR sky130_fd_sc_hd__tapvpwrvgnd_1
X_4470_ rf.registers\[28\]\[10\] rf.registers\[29\]\[10\] rf.registers\[30\]\[10\]
+ rf.registers\[31\]\[10\] _1035_ _1036_ VGND VGND VPWR VPWR _1255_ sky130_fd_sc_hd__mux4_1
XFILLER_0_80_483 VGND VGND VPWR VPWR sky130_fd_sc_hd__fill_1
XFILLER_0_20_65 VPWR VGND VPWR VGND sky130_ef_sc_hd__decap_12
XFILLER_0_40_336 VGND VGND VPWR VPWR sky130_fd_sc_hd__fill_2
XTAP_TAPCELL_ROW_133_2297 VGND VPWR sky130_fd_sc_hd__tapvpwrvgnd_1
X_6140_ _2702_ _2703_ _2707_ _2846_ VGND VGND VPWR VPWR _2847_ sky130_fd_sc_hd__a31o_1
XFILLER_0_0_466 VGND VGND VPWR VPWR sky130_fd_sc_hd__decap_8
XFILLER_0_0_477 VPWR VGND VPWR VGND sky130_ef_sc_hd__decap_12
X_6071_ _2467_ _2781_ VGND VGND VPWR VPWR _2782_ sky130_fd_sc_hd__nor2_1
X_5022_ _1778_ VGND VGND VPWR VPWR net77 sky130_fd_sc_hd__inv_2
XFILLER_0_31_7 VPWR VGND VPWR VGND sky130_ef_sc_hd__decap_12
XFILLER_0_136_53 VPWR VGND VPWR VGND sky130_ef_sc_hd__decap_12
XTAP_TAPCELL_ROW_107_1908 VGND VPWR sky130_fd_sc_hd__tapvpwrvgnd_1
XFILLER_0_136_97 VPWR VGND VPWR VGND sky130_ef_sc_hd__decap_12
XFILLER_0_76_701 VPWR VGND VPWR VGND sky130_ef_sc_hd__decap_12
X_6973_ _3346_ VGND VGND VPWR VPWR _3389_ sky130_fd_sc_hd__clkbuf_8
XTAP_TAPCELL_ROW_49_1037 VGND VPWR sky130_fd_sc_hd__tapvpwrvgnd_1
XFILLER_0_75_200 VGND VGND VPWR VPWR sky130_fd_sc_hd__fill_2
X_8712_ clknet_leaf_1_CLK _0824_ VGND VGND VPWR VPWR rf.registers\[24\]\[23\] sky130_fd_sc_hd__dfxtp_1
XFILLER_0_48_414 VGND VGND VPWR VPWR sky130_fd_sc_hd__decap_6
X_5924_ _2293_ _2642_ _2263_ VGND VGND VPWR VPWR _2643_ sky130_fd_sc_hd__o21a_1
X_8643_ clknet_leaf_5_CLK _0755_ VGND VGND VPWR VPWR rf.registers\[17\]\[18\] sky130_fd_sc_hd__dfxtp_1
XTAP_TAPCELL_ROW_62_1237 VGND VPWR sky130_fd_sc_hd__tapvpwrvgnd_1
XTAP_TAPCELL_ROW_62_1226 VGND VPWR sky130_fd_sc_hd__tapvpwrvgnd_1
X_5855_ _1810_ _2576_ VGND VGND VPWR VPWR _2578_ sky130_fd_sc_hd__and2_1
XFILLER_0_8_533 VPWR VGND VPWR VGND sky130_ef_sc_hd__decap_12
X_4806_ rf.registers\[16\]\[29\] rf.registers\[17\]\[29\] rf.registers\[18\]\[29\]
+ rf.registers\[19\]\[29\] _1410_ _1411_ VGND VGND VPWR VPWR _1572_ sky130_fd_sc_hd__mux4_1
XFILLER_0_133_305 VPWR VGND VPWR VGND sky130_ef_sc_hd__decap_12
X_8574_ clknet_leaf_29_CLK _0686_ VGND VGND VPWR VPWR rf.registers\[12\]\[13\] sky130_fd_sc_hd__dfxtp_1
XFILLER_0_63_439 VGND VGND VPWR VPWR sky130_fd_sc_hd__decap_3
Xclkbuf_leaf_66_CLK clknet_3_3__leaf_CLK VGND VGND VPWR VPWR clknet_leaf_66_CLK sky130_fd_sc_hd__clkbuf_8
XFILLER_0_16_333 VGND VGND VPWR VPWR sky130_fd_sc_hd__decap_4
X_5786_ _2489_ _2506_ _2511_ VGND VGND VPWR VPWR _2512_ sky130_fd_sc_hd__or3b_1
XTAP_TAPCELL_ROW_32_773 VGND VPWR sky130_fd_sc_hd__tapvpwrvgnd_1
XTAP_TAPCELL_ROW_32_784 VGND VPWR sky130_fd_sc_hd__tapvpwrvgnd_1
XFILLER_0_133_349 VPWR VGND VPWR VGND sky130_ef_sc_hd__decap_12
XFILLER_0_9_51 VGND VGND VPWR VPWR sky130_fd_sc_hd__decap_4
X_4737_ _1203_ _1499_ _1503_ _1507_ VGND VGND VPWR VPWR _1508_ sky130_fd_sc_hd__o2bb2a_2
X_7525_ _3684_ VGND VGND VPWR VPWR _0181_ sky130_fd_sc_hd__clkbuf_1
X_7456_ _3388_ rf.registers\[29\]\[20\] _3647_ VGND VGND VPWR VPWR _3648_ sky130_fd_sc_hd__mux2_1
XFILLER_0_16_399 VPWR VGND VPWR VGND sky130_ef_sc_hd__decap_12
XFILLER_0_32_837 VGND VGND VPWR VPWR sky130_fd_sc_hd__fill_2
X_4668_ _1441_ _1442_ _1154_ VGND VGND VPWR VPWR _1443_ sky130_fd_sc_hd__mux2_1
XFILLER_0_102_725 VPWR VGND VPWR VGND sky130_ef_sc_hd__decap_12
X_6407_ rf.registers\[11\]\[5\] _2997_ _3056_ VGND VGND VPWR VPWR _3062_ sky130_fd_sc_hd__mux2_1
XFILLER_0_102_769 VPWR VGND VPWR VGND sky130_ef_sc_hd__decap_12
X_4599_ rf.registers\[28\]\[17\] rf.registers\[29\]\[17\] rf.registers\[30\]\[17\]
+ rf.registers\[31\]\[17\] _1320_ _1321_ VGND VGND VPWR VPWR _1377_ sky130_fd_sc_hd__mux4_1
X_9126_ clknet_leaf_80_CLK _0214_ VGND VGND VPWR VPWR rf.registers\[27\]\[21\] sky130_fd_sc_hd__dfxtp_1
X_7387_ rf.registers\[8\]\[20\] _3319_ _3610_ VGND VGND VPWR VPWR _3611_ sky130_fd_sc_hd__mux2_1
XFILLER_0_3_293 VPWR VGND VPWR VGND sky130_ef_sc_hd__decap_12
X_6338_ net19 VGND VGND VPWR VPWR _3016_ sky130_fd_sc_hd__clkbuf_2
X_9057_ clknet_leaf_11_CLK _0145_ VGND VGND VPWR VPWR rf.registers\[29\]\[16\] sky130_fd_sc_hd__dfxtp_1
XTAP_TAPCELL_ROW_73_1399 VGND VPWR sky130_fd_sc_hd__tapvpwrvgnd_1
XTAP_TAPCELL_ROW_73_1388 VGND VPWR sky130_fd_sc_hd__tapvpwrvgnd_1
X_6269_ _2967_ VGND VGND VPWR VPWR _2968_ sky130_fd_sc_hd__buf_6
X_8008_ _3395_ rf.registers\[22\]\[23\] _3937_ VGND VGND VPWR VPWR _3941_ sky130_fd_sc_hd__mux2_1
XFILLER_0_98_325 VPWR VGND VPWR VGND sky130_ef_sc_hd__decap_12
XFILLER_0_94_531 VGND VGND VPWR VPWR sky130_fd_sc_hd__fill_1
XFILLER_0_66_222 VGND VGND VPWR VPWR sky130_fd_sc_hd__decap_4
XFILLER_0_27_609 VGND VGND VPWR VPWR sky130_fd_sc_hd__decap_6
XFILLER_0_136_121 VPWR VGND VPWR VGND sky130_ef_sc_hd__decap_12
XFILLER_0_82_737 VPWR VGND VPWR VGND sky130_ef_sc_hd__decap_12
XFILLER_0_66_266 VGND VGND VPWR VPWR sky130_fd_sc_hd__fill_1
XFILLER_0_54_406 VGND VGND VPWR VPWR sky130_fd_sc_hd__decap_6
XFILLER_0_136_165 VPWR VGND VPWR VGND sky130_ef_sc_hd__decap_12
XFILLER_0_125_839 VGND VGND VPWR VPWR sky130_fd_sc_hd__fill_1
XFILLER_0_81_225 VGND VGND VPWR VPWR sky130_fd_sc_hd__decap_3
Xclkbuf_leaf_57_CLK clknet_3_6__leaf_CLK VGND VGND VPWR VPWR clknet_leaf_57_CLK sky130_fd_sc_hd__clkbuf_8
XFILLER_0_34_141 VGND VGND VPWR VPWR sky130_fd_sc_hd__fill_2
XFILLER_0_117_390 VGND VGND VPWR VPWR sky130_fd_sc_hd__fill_2
XFILLER_0_90_781 VPWR VGND VPWR VGND sky130_ef_sc_hd__decap_12
XTAP_TAPCELL_ROW_10_456 VGND VPWR sky130_fd_sc_hd__tapvpwrvgnd_1
XTAP_TAPCELL_ROW_10_445 VGND VPWR sky130_fd_sc_hd__tapvpwrvgnd_1
XFILLER_0_50_645 VGND VGND VPWR VPWR sky130_fd_sc_hd__decap_3
XPHY_EDGE_ROW_13_Right_13 VGND VGND VPWR VPWR sky130_fd_sc_hd__decap_3
XFILLER_0_82_27 VGND VGND VPWR VPWR sky130_fd_sc_hd__fill_1
XFILLER_0_58_701 VPWR VGND VPWR VGND sky130_ef_sc_hd__decap_12
XFILLER_0_15_21 VPWR VGND VPWR VGND sky130_ef_sc_hd__decap_12
XTAP_TAPCELL_ROW_18_567 VGND VPWR sky130_fd_sc_hd__tapvpwrvgnd_1
XTAP_TAPCELL_ROW_102_1827 VGND VPWR sky130_fd_sc_hd__tapvpwrvgnd_1
XFILLER_0_73_726 VGND VGND VPWR VPWR sky130_fd_sc_hd__fill_2
XFILLER_0_45_417 VGND VGND VPWR VPWR sky130_fd_sc_hd__decap_6
XFILLER_0_128_666 VPWR VGND VPWR VGND sky130_ef_sc_hd__decap_12
Xclkbuf_leaf_48_CLK clknet_3_6__leaf_CLK VGND VGND VPWR VPWR clknet_leaf_48_CLK sky130_fd_sc_hd__clkbuf_8
XFILLER_0_5_503 VGND VGND VPWR VPWR sky130_fd_sc_hd__fill_1
XFILLER_0_31_31 VPWR VGND VPWR VGND sky130_ef_sc_hd__decap_12
X_5640_ _2229_ _2310_ VGND VGND VPWR VPWR _2370_ sky130_fd_sc_hd__and2_1
XTAP_TAPCELL_ROW_135_2326 VGND VPWR sky130_fd_sc_hd__tapvpwrvgnd_1
XFILLER_0_122_77 VGND VGND VPWR VPWR sky130_fd_sc_hd__decap_6
XPHY_EDGE_ROW_22_Right_22 VGND VGND VPWR VPWR sky130_fd_sc_hd__decap_3
X_5571_ _1982_ _2219_ _2220_ VGND VGND VPWR VPWR _2302_ sky130_fd_sc_hd__o21ai_1
XFILLER_0_131_809 VPWR VGND VPWR VGND sky130_ef_sc_hd__decap_12
X_4522_ rf.registers\[0\]\[12\] rf.registers\[1\]\[12\] rf.registers\[2\]\[12\] rf.registers\[3\]\[12\]
+ _1302_ _1303_ VGND VGND VPWR VPWR _1305_ sky130_fd_sc_hd__mux4_1
X_7310_ rf.registers\[3\]\[16\] _3311_ _3563_ VGND VGND VPWR VPWR _3570_ sky130_fd_sc_hd__mux2_1
XFILLER_0_53_472 VGND VGND VPWR VPWR sky130_fd_sc_hd__fill_1
XFILLER_0_14_837 VGND VGND VPWR VPWR sky130_fd_sc_hd__fill_2
X_8290_ _3045_ rf.registers\[25\]\[28\] _4081_ VGND VGND VPWR VPWR _4090_ sky130_fd_sc_hd__mux2_1
X_4453_ rf.registers\[28\]\[9\] rf.registers\[29\]\[9\] rf.registers\[30\]\[9\] rf.registers\[31\]\[9\]
+ _1035_ _1036_ VGND VGND VPWR VPWR _1239_ sky130_fd_sc_hd__mux4_1
X_7241_ _3533_ VGND VGND VPWR VPWR _0048_ sky130_fd_sc_hd__clkbuf_1
XFILLER_0_79_7 VPWR VGND VPWR VGND sky130_ef_sc_hd__decap_12
XFILLER_0_41_645 VPWR VGND VPWR VGND sky130_ef_sc_hd__decap_12
XFILLER_0_1_753 VPWR VGND VPWR VGND sky130_ef_sc_hd__decap_12
X_7172_ rf.registers\[4\]\[15\] _3309_ _3491_ VGND VGND VPWR VPWR _3497_ sky130_fd_sc_hd__mux2_1
X_4384_ rf.registers\[12\]\[5\] rf.registers\[13\]\[5\] rf.registers\[14\]\[5\] rf.registers\[15\]\[5\]
+ _1172_ _1173_ VGND VGND VPWR VPWR _1174_ sky130_fd_sc_hd__mux4_1
XTAP_TAPCELL_ROW_113_1989 VGND VPWR sky130_fd_sc_hd__tapvpwrvgnd_1
XFILLER_0_1_797 VPWR VGND VPWR VGND sky130_ef_sc_hd__decap_12
X_6123_ _2241_ _2309_ _2495_ VGND VGND VPWR VPWR _2831_ sky130_fd_sc_hd__o21ba_1
X_6054_ _1158_ _2318_ _2319_ _2454_ VGND VGND VPWR VPWR _2766_ sky130_fd_sc_hd__or4_1
XPHY_EDGE_ROW_31_Right_31 VGND VGND VPWR VPWR sky130_fd_sc_hd__decap_3
X_5005_ rf.registers\[24\]\[6\] rf.registers\[25\]\[6\] rf.registers\[26\]\[6\] rf.registers\[27\]\[6\]
+ _1729_ _1731_ VGND VGND VPWR VPWR _1762_ sky130_fd_sc_hd__mux4_1
XFILLER_0_56_83 VGND VGND VPWR VPWR sky130_fd_sc_hd__fill_1
XFILLER_0_56_94 VGND VGND VPWR VPWR sky130_fd_sc_hd__decap_6
XFILLER_0_22_3 VPWR VGND VPWR VGND sky130_ef_sc_hd__decap_12
X_6956_ _3377_ VGND VGND VPWR VPWR _0943_ sky130_fd_sc_hd__clkbuf_1
XTAP_TAPCELL_ROW_37_854 VGND VPWR sky130_fd_sc_hd__tapvpwrvgnd_1
XFILLER_0_76_531 VGND VGND VPWR VPWR sky130_fd_sc_hd__fill_1
X_5907_ _2595_ _2626_ _2259_ VGND VGND VPWR VPWR _2627_ sky130_fd_sc_hd__mux2_1
XFILLER_0_118_121 VPWR VGND VPWR VGND sky130_ef_sc_hd__decap_12
XFILLER_0_64_737 VPWR VGND VPWR VGND sky130_ef_sc_hd__decap_12
X_6887_ net31 VGND VGND VPWR VPWR _3330_ sky130_fd_sc_hd__buf_2
Xclkbuf_leaf_39_CLK clknet_3_7__leaf_CLK VGND VGND VPWR VPWR clknet_leaf_39_CLK sky130_fd_sc_hd__clkbuf_8
X_8626_ clknet_leaf_44_CLK _0738_ VGND VGND VPWR VPWR rf.registers\[17\]\[1\] sky130_fd_sc_hd__dfxtp_1
XFILLER_0_118_165 VPWR VGND VPWR VGND sky130_ef_sc_hd__decap_12
XFILLER_0_63_225 VGND VGND VPWR VPWR sky130_fd_sc_hd__decap_6
XFILLER_0_8_363 VGND VGND VPWR VPWR sky130_fd_sc_hd__fill_1
XFILLER_0_36_439 VGND VGND VPWR VPWR sky130_fd_sc_hd__decap_8
X_5838_ _2241_ _2228_ VGND VGND VPWR VPWR _2561_ sky130_fd_sc_hd__nand2_1
XPHY_EDGE_ROW_40_Right_40 VGND VGND VPWR VPWR sky130_fd_sc_hd__decap_3
XFILLER_0_133_113 VPWR VGND VPWR VGND sky130_ef_sc_hd__decap_12
XFILLER_0_107_839 VGND VGND VPWR VPWR sky130_fd_sc_hd__fill_1
XFILLER_0_16_141 VPWR VGND VPWR VGND sky130_ef_sc_hd__decap_12
X_8557_ clknet_leaf_92_CLK _0669_ VGND VGND VPWR VPWR rf.registers\[13\]\[28\] sky130_fd_sc_hd__dfxtp_1
X_5769_ _2243_ _2310_ VGND VGND VPWR VPWR _2495_ sky130_fd_sc_hd__nor2_1
XFILLER_0_134_669 VPWR VGND VPWR VGND sky130_ef_sc_hd__decap_12
X_7508_ _3675_ VGND VGND VPWR VPWR _0173_ sky130_fd_sc_hd__clkbuf_1
XFILLER_0_72_781 VPWR VGND VPWR VGND sky130_ef_sc_hd__decap_12
XFILLER_0_121_308 VGND VGND VPWR VPWR sky130_fd_sc_hd__decap_4
X_8488_ _3039_ rf.registers\[14\]\[25\] _4189_ VGND VGND VPWR VPWR _4195_ sky130_fd_sc_hd__mux2_1
XFILLER_0_32_645 VPWR VGND VPWR VGND sky130_ef_sc_hd__decap_12
X_7439_ _3372_ rf.registers\[29\]\[12\] _3636_ VGND VGND VPWR VPWR _3639_ sky130_fd_sc_hd__mux2_1
XTAP_TAPCELL_ROW_75_1428 VGND VPWR sky130_fd_sc_hd__tapvpwrvgnd_1
X_9109_ clknet_leaf_54_CLK _0197_ VGND VGND VPWR VPWR rf.registers\[27\]\[4\] sky130_fd_sc_hd__dfxtp_1
XTAP_TAPCELL_ROW_15_526 VGND VPWR sky130_fd_sc_hd__tapvpwrvgnd_1
XFILLER_0_137_441 VGND VGND VPWR VPWR sky130_fd_sc_hd__decap_6
XFILLER_0_137_485 VPWR VGND VPWR VGND sky130_ef_sc_hd__decap_12
XTAP_TAPCELL_ROW_117_2056 VGND VPWR sky130_fd_sc_hd__tapvpwrvgnd_1
XFILLER_0_113_809 VPWR VGND VPWR VGND sky130_ef_sc_hd__decap_12
XFILLER_0_62_291 VGND VGND VPWR VPWR sky130_fd_sc_hd__decap_3
XFILLER_0_105_393 VGND VGND VPWR VPWR sky130_fd_sc_hd__decap_4
XFILLER_0_77_27 VPWR VGND VPWR VGND sky130_ef_sc_hd__decap_12
XTAP_TAPCELL_ROW_130_2256 VGND VPWR sky130_fd_sc_hd__tapvpwrvgnd_1
XTAP_TAPCELL_ROW_130_2245 VGND VPWR sky130_fd_sc_hd__tapvpwrvgnd_1
XFILLER_0_93_15 VPWR VGND VPWR VGND sky130_ef_sc_hd__decap_12
XFILLER_0_117_55 VGND VGND VPWR VPWR sky130_fd_sc_hd__fill_1
X_6810_ _3277_ VGND VGND VPWR VPWR _3278_ sky130_fd_sc_hd__buf_4
XPHY_EDGE_ROW_11_Left_150 VGND VGND VPWR VPWR sky130_fd_sc_hd__decap_3
X_7790_ rf.registers\[9\]\[17\] _3313_ _3817_ VGND VGND VPWR VPWR _3825_ sky130_fd_sc_hd__mux2_1
XFILLER_0_58_542 VGND VGND VPWR VPWR sky130_fd_sc_hd__decap_3
XFILLER_0_9_105 VGND VGND VPWR VPWR sky130_fd_sc_hd__decap_6
XTAP_TAPCELL_ROW_34_813 VGND VPWR sky130_fd_sc_hd__tapvpwrvgnd_1
XFILLER_0_92_309 VGND VGND VPWR VPWR sky130_fd_sc_hd__fill_2
X_6741_ _3240_ VGND VGND VPWR VPWR _3241_ sky130_fd_sc_hd__buf_4
XFILLER_0_9_149 VPWR VGND VPWR VGND sky130_ef_sc_hd__decap_12
XFILLER_0_42_41 VGND VGND VPWR VPWR sky130_fd_sc_hd__decap_8
X_9460_ clknet_leaf_38_CLK _0548_ VGND VGND VPWR VPWR rf.registers\[20\]\[3\] sky130_fd_sc_hd__dfxtp_1
X_6672_ _3053_ _3203_ VGND VGND VPWR VPWR _3204_ sky130_fd_sc_hd__nor2_2
XFILLER_0_58_597 VGND VGND VPWR VPWR sky130_fd_sc_hd__decap_3
XFILLER_0_115_113 VPWR VGND VPWR VGND sky130_ef_sc_hd__decap_12
X_8411_ _4154_ VGND VGND VPWR VPWR _0597_ sky130_fd_sc_hd__clkbuf_1
X_5623_ _1666_ _2208_ _2220_ VGND VGND VPWR VPWR _2353_ sky130_fd_sc_hd__o21a_1
X_9391_ clknet_leaf_74_CLK _0479_ VGND VGND VPWR VPWR rf.registers\[26\]\[30\] sky130_fd_sc_hd__dfxtp_1
XFILLER_0_61_729 VPWR VGND VPWR VGND sky130_ef_sc_hd__decap_12
XFILLER_0_54_781 VPWR VGND VPWR VGND sky130_ef_sc_hd__decap_12
XFILLER_0_14_623 VPWR VGND VPWR VGND sky130_ef_sc_hd__decap_12
X_8342_ rf.registers\[20\]\[20\] net26 _4117_ VGND VGND VPWR VPWR _4118_ sky130_fd_sc_hd__mux2_1
XFILLER_0_13_111 VGND VGND VPWR VPWR sky130_fd_sc_hd__fill_1
X_5554_ _2165_ _2218_ VGND VGND VPWR VPWR _2285_ sky130_fd_sc_hd__nor2_1
XFILLER_0_111_330 VGND VGND VPWR VPWR sky130_fd_sc_hd__decap_6
X_4505_ rf.registers\[28\]\[12\] rf.registers\[29\]\[12\] rf.registers\[30\]\[12\]
+ rf.registers\[31\]\[12\] _1283_ _1284_ VGND VGND VPWR VPWR _1288_ sky130_fd_sc_hd__mux4_1
X_8273_ _4058_ VGND VGND VPWR VPWR _4081_ sky130_fd_sc_hd__buf_4
XFILLER_0_14_678 VGND VGND VPWR VPWR sky130_fd_sc_hd__decap_4
XFILLER_0_14_689 VGND VGND VPWR VPWR sky130_fd_sc_hd__decap_8
X_5485_ _2215_ _2207_ VGND VGND VPWR VPWR _2216_ sky130_fd_sc_hd__or2_1
X_4436_ rf.registers\[16\]\[8\] rf.registers\[17\]\[8\] rf.registers\[18\]\[8\] rf.registers\[19\]\[8\]
+ _1118_ _1127_ VGND VGND VPWR VPWR _1223_ sky130_fd_sc_hd__mux4_1
X_7224_ _3524_ VGND VGND VPWR VPWR _0040_ sky130_fd_sc_hd__clkbuf_1
XTAP_TAPCELL_ROW_57_1158 VGND VPWR sky130_fd_sc_hd__tapvpwrvgnd_1
XFILLER_0_6_41 VPWR VGND VPWR VGND sky130_ef_sc_hd__decap_12
XFILLER_0_1_561 VPWR VGND VPWR VGND sky130_ef_sc_hd__decap_12
X_4367_ _1117_ _1136_ _1157_ VGND VGND VPWR VPWR _1158_ sky130_fd_sc_hd__o21ai_4
X_7155_ rf.registers\[4\]\[7\] _3292_ _3480_ VGND VGND VPWR VPWR _3488_ sky130_fd_sc_hd__mux2_1
XTAP_TAPCELL_ROW_70_1347 VGND VPWR sky130_fd_sc_hd__tapvpwrvgnd_1
XFILLER_0_67_82 VGND VGND VPWR VPWR sky130_fd_sc_hd__decap_3
XFILLER_0_6_85 VPWR VGND VPWR VGND sky130_ef_sc_hd__decap_12
X_6106_ _2032_ _2786_ _2814_ VGND VGND VPWR VPWR _2815_ sky130_fd_sc_hd__a21oi_1
X_4298_ rf.registers\[12\]\[2\] rf.registers\[13\]\[2\] rf.registers\[14\]\[2\] rf.registers\[15\]\[2\]
+ _1077_ _1078_ VGND VGND VPWR VPWR _1091_ sky130_fd_sc_hd__mux4_1
X_7086_ _3451_ VGND VGND VPWR VPWR _0999_ sky130_fd_sc_hd__clkbuf_1
X_6037_ _2682_ _2749_ _2237_ VGND VGND VPWR VPWR _2750_ sky130_fd_sc_hd__mux2_1
X_7988_ _3930_ VGND VGND VPWR VPWR _0398_ sky130_fd_sc_hd__clkbuf_1
XFILLER_0_138_249 VGND VGND VPWR VPWR sky130_fd_sc_hd__decap_3
X_6939_ _3365_ rf.registers\[15\]\[9\] _3347_ VGND VGND VPWR VPWR _3366_ sky130_fd_sc_hd__mux2_1
X_8609_ clknet_leaf_15_CLK _0721_ VGND VGND VPWR VPWR rf.registers\[11\]\[16\] sky130_fd_sc_hd__dfxtp_1
XFILLER_0_134_455 VGND VGND VPWR VPWR sky130_fd_sc_hd__fill_2
XFILLER_0_134_433 VPWR VGND VPWR VGND sky130_ef_sc_hd__decap_12
XFILLER_0_106_135 VGND VGND VPWR VPWR sky130_fd_sc_hd__fill_1
XFILLER_0_64_589 VPWR VGND VPWR VGND sky130_ef_sc_hd__decap_12
XFILLER_0_51_228 VPWR VGND VPWR VGND sky130_ef_sc_hd__decap_12
XFILLER_0_17_461 VPWR VGND VPWR VGND sky130_ef_sc_hd__decap_12
XFILLER_0_134_477 VGND VGND VPWR VPWR sky130_fd_sc_hd__fill_2
XFILLER_0_121_105 VGND VGND VPWR VPWR sky130_fd_sc_hd__decap_6
XFILLER_0_121_149 VPWR VGND VPWR VGND sky130_ef_sc_hd__decap_12
XTAP_TAPCELL_ROW_20_595 VGND VPWR sky130_fd_sc_hd__tapvpwrvgnd_1
XFILLER_0_99_431 VGND VGND VPWR VPWR sky130_fd_sc_hd__decap_3
XTAP_TAPCELL_ROW_88_1619 VGND VPWR sky130_fd_sc_hd__tapvpwrvgnd_1
XFILLER_0_129_205 VPWR VGND VPWR VGND sky130_ef_sc_hd__decap_12
XFILLER_0_129_249 VPWR VGND VPWR VGND sky130_ef_sc_hd__decap_12
XFILLER_0_95_670 VGND VGND VPWR VPWR sky130_fd_sc_hd__fill_2
XFILLER_0_74_309 VGND VGND VPWR VPWR sky130_fd_sc_hd__fill_2
XFILLER_0_28_715 VGND VGND VPWR VPWR sky130_fd_sc_hd__fill_1
XFILLER_0_28_726 VGND VGND VPWR VPWR sky130_fd_sc_hd__decap_6
XFILLER_0_83_821 VPWR VGND VPWR VGND sky130_ef_sc_hd__decap_12
XFILLER_0_27_225 VGND VGND VPWR VPWR sky130_fd_sc_hd__fill_1
XFILLER_0_138_783 VGND VGND VPWR VPWR sky130_fd_sc_hd__fill_1
XFILLER_0_103_57 VPWR VGND VPWR VGND sky130_ef_sc_hd__decap_12
XFILLER_0_43_718 VGND VGND VPWR VPWR sky130_fd_sc_hd__decap_8
XFILLER_0_137_293 VPWR VGND VPWR VGND sky130_ef_sc_hd__decap_12
XFILLER_0_12_77 VGND VGND VPWR VPWR sky130_fd_sc_hd__decap_6
XFILLER_0_36_792 VPWR VGND VPWR VGND sky130_ef_sc_hd__decap_12
XPHY_EDGE_ROW_124_Right_124 VGND VGND VPWR VPWR sky130_fd_sc_hd__decap_3
XFILLER_0_88_15 VPWR VGND VPWR VGND sky130_ef_sc_hd__decap_12
Xoutput106 net106 VGND VGND VPWR VPWR RD2[3] sky130_fd_sc_hd__buf_1
XFILLER_0_11_615 VGND VGND VPWR VPWR sky130_fd_sc_hd__fill_1
XFILLER_0_23_453 VGND VGND VPWR VPWR sky130_fd_sc_hd__fill_1
X_5270_ rf.registers\[12\]\[20\] rf.registers\[13\]\[20\] rf.registers\[14\]\[20\]
+ rf.registers\[15\]\[20\] _1922_ _1923_ VGND VGND VPWR VPWR _2013_ sky130_fd_sc_hd__mux4_1
Xoutput128 net128 VGND VGND VPWR VPWR alu_result[23] sky130_fd_sc_hd__buf_1
Xoutput117 net117 VGND VGND VPWR VPWR alu_result[13] sky130_fd_sc_hd__buf_1
Xoutput139 net139 VGND VGND VPWR VPWR alu_result[4] sky130_fd_sc_hd__buf_1
XTAP_TAPCELL_ROW_110_1948 VGND VPWR sky130_fd_sc_hd__tapvpwrvgnd_1
XFILLER_0_128_65 VPWR VGND VPWR VGND sky130_ef_sc_hd__decap_12
X_8960_ clknet_leaf_22_CLK _0048_ VGND VGND VPWR VPWR rf.registers\[19\]\[15\] sky130_fd_sc_hd__dfxtp_1
XTAP_TAPCELL_ROW_52_1077 VGND VPWR sky130_fd_sc_hd__tapvpwrvgnd_1
X_7911_ _3889_ VGND VGND VPWR VPWR _0362_ sky130_fd_sc_hd__clkbuf_1
X_8891_ clknet_leaf_31_CLK _1003_ VGND VGND VPWR VPWR rf.registers\[5\]\[10\] sky130_fd_sc_hd__dfxtp_1
X_7842_ _3852_ VGND VGND VPWR VPWR _0330_ sky130_fd_sc_hd__clkbuf_1
XFILLER_0_77_125 VGND VGND VPWR VPWR sky130_fd_sc_hd__decap_6
X_7773_ rf.registers\[9\]\[9\] _3296_ _3806_ VGND VGND VPWR VPWR _3816_ sky130_fd_sc_hd__mux2_1
XFILLER_0_93_629 VGND VGND VPWR VPWR sky130_fd_sc_hd__fill_2
XFILLER_0_77_169 VPWR VGND VPWR VGND sky130_ef_sc_hd__decap_12
X_4985_ _1733_ _1738_ _1739_ _1740_ _1741_ _1742_ VGND VGND VPWR VPWR _1743_ sky130_fd_sc_hd__mux4_2
XFILLER_0_53_73 VGND VGND VPWR VPWR sky130_fd_sc_hd__decap_4
XFILLER_0_19_748 VGND VGND VPWR VPWR sky130_fd_sc_hd__decap_8
X_6724_ rf.registers\[10\]\[24\] _3037_ _3227_ VGND VGND VPWR VPWR _3232_ sky130_fd_sc_hd__mux2_1
X_9512_ clknet_leaf_2_CLK _0600_ VGND VGND VPWR VPWR rf.registers\[18\]\[23\] sky130_fd_sc_hd__dfxtp_1
XFILLER_0_129_783 VGND VGND VPWR VPWR sky130_fd_sc_hd__fill_1
XFILLER_0_73_353 VGND VGND VPWR VPWR sky130_fd_sc_hd__fill_1
X_9443_ clknet_leaf_4_CLK _0531_ VGND VGND VPWR VPWR rf.registers\[25\]\[18\] sky130_fd_sc_hd__dfxtp_1
XFILLER_0_73_375 VGND VGND VPWR VPWR sky130_fd_sc_hd__decap_3
XFILLER_0_27_781 VGND VGND VPWR VPWR sky130_fd_sc_hd__decap_3
X_6655_ rf.registers\[24\]\[24\] _3037_ _3190_ VGND VGND VPWR VPWR _3195_ sky130_fd_sc_hd__mux2_1
XFILLER_0_116_466 VGND VGND VPWR VPWR sky130_fd_sc_hd__decap_3
X_9374_ clknet_leaf_27_CLK _0462_ VGND VGND VPWR VPWR rf.registers\[26\]\[13\] sky130_fd_sc_hd__dfxtp_1
XFILLER_0_26_280 VGND VGND VPWR VPWR sky130_fd_sc_hd__fill_1
X_6586_ rf.registers\[1\]\[24\] _3037_ _3153_ VGND VGND VPWR VPWR _3158_ sky130_fd_sc_hd__mux2_1
X_5606_ _1872_ _2207_ _1056_ VGND VGND VPWR VPWR _2336_ sky130_fd_sc_hd__o21ai_1
XFILLER_0_42_740 VGND VGND VPWR VPWR sky130_fd_sc_hd__fill_1
X_8325_ rf.registers\[20\]\[12\] net17 _4106_ VGND VGND VPWR VPWR _4109_ sky130_fd_sc_hd__mux2_1
X_5537_ net106 _2238_ _2240_ _2250_ _2267_ VGND VGND VPWR VPWR _2268_ sky130_fd_sc_hd__a221o_1
XFILLER_0_14_475 VGND VGND VPWR VPWR sky130_fd_sc_hd__fill_1
XFILLER_0_42_751 VGND VGND VPWR VPWR sky130_fd_sc_hd__decap_4
X_8256_ _4072_ VGND VGND VPWR VPWR _0524_ sky130_fd_sc_hd__clkbuf_1
X_7207_ _3054_ _3092_ VGND VGND VPWR VPWR _3515_ sky130_fd_sc_hd__nor2_4
X_5468_ net88 net89 VGND VGND VPWR VPWR _2199_ sky130_fd_sc_hd__nor2_1
X_8187_ _3370_ rf.registers\[21\]\[11\] _4034_ VGND VGND VPWR VPWR _4036_ sky130_fd_sc_hd__mux2_1
X_4419_ rf.registers\[16\]\[7\] rf.registers\[17\]\[7\] rf.registers\[18\]\[7\] rf.registers\[19\]\[7\]
+ _1119_ _1122_ VGND VGND VPWR VPWR _1207_ sky130_fd_sc_hd__mux4_1
XFILLER_0_1_391 VGND VGND VPWR VPWR sky130_fd_sc_hd__fill_1
X_5399_ rf.registers\[20\]\[28\] rf.registers\[21\]\[28\] rf.registers\[22\]\[28\]
+ rf.registers\[23\]\[28\] _1951_ _1952_ VGND VGND VPWR VPWR _2134_ sky130_fd_sc_hd__mux4_1
X_7138_ _3478_ VGND VGND VPWR VPWR _0000_ sky130_fd_sc_hd__clkbuf_1
X_7069_ rf.registers\[6\]\[31\] _3342_ _3407_ VGND VGND VPWR VPWR _3442_ sky130_fd_sc_hd__mux2_1
XTAP_TAPCELL_ROW_83_1549 VGND VPWR sky130_fd_sc_hd__tapvpwrvgnd_1
XTAP_TAPCELL_ROW_83_1538 VGND VPWR sky130_fd_sc_hd__tapvpwrvgnd_1
XFILLER_0_127_709 VPWR VGND VPWR VGND sky130_ef_sc_hd__decap_12
XFILLER_0_65_821 VPWR VGND VPWR VGND sky130_ef_sc_hd__decap_12
XTAP_TAPCELL_ROW_25_676 VGND VPWR sky130_fd_sc_hd__tapvpwrvgnd_1
XFILLER_0_135_753 VPWR VGND VPWR VGND sky130_ef_sc_hd__decap_12
XFILLER_0_92_684 VPWR VGND VPWR VGND sky130_ef_sc_hd__decap_12
Xinput19 WD3[14] VGND VGND VPWR VPWR net19 sky130_fd_sc_hd__clkbuf_2
XFILLER_0_80_813 VPWR VGND VPWR VGND sky130_ef_sc_hd__decap_12
XFILLER_0_18_781 VPWR VGND VPWR VGND sky130_ef_sc_hd__decap_12
XFILLER_0_37_578 VPWR VGND VPWR VGND sky130_ef_sc_hd__decap_12
XFILLER_0_135_797 VPWR VGND VPWR VGND sky130_ef_sc_hd__decap_12
XTAP_TAPCELL_ROW_114_2004 VGND VPWR sky130_fd_sc_hd__tapvpwrvgnd_1
XTAP_TAPCELL_ROW_114_2015 VGND VPWR sky130_fd_sc_hd__tapvpwrvgnd_1
XFILLER_0_107_499 VGND VGND VPWR VPWR sky130_fd_sc_hd__decap_4
XTAP_TAPCELL_ROW_98_1770 VGND VPWR sky130_fd_sc_hd__tapvpwrvgnd_1
XFILLER_0_32_250 VGND VGND VPWR VPWR sky130_fd_sc_hd__fill_2
XFILLER_0_110_609 VGND VGND VPWR VPWR sky130_fd_sc_hd__fill_2
XFILLER_0_103_661 VGND VGND VPWR VPWR sky130_fd_sc_hd__decap_8
XFILLER_0_58_29 VPWR VGND VPWR VGND sky130_ef_sc_hd__decap_12
XFILLER_0_0_829 VGND VGND VPWR VPWR sky130_fd_sc_hd__decap_8
XFILLER_0_130_480 VGND VGND VPWR VPWR sky130_fd_sc_hd__fill_2
XTAP_TAPCELL_ROW_125_2177 VGND VPWR sky130_fd_sc_hd__tapvpwrvgnd_1
XFILLER_0_90_27 VGND VGND VPWR VPWR sky130_fd_sc_hd__fill_1
XFILLER_0_87_445 VGND VGND VPWR VPWR sky130_fd_sc_hd__decap_3
XFILLER_0_68_681 VPWR VGND VPWR VGND sky130_ef_sc_hd__decap_12
XFILLER_0_23_54 VGND VGND VPWR VPWR sky130_fd_sc_hd__fill_2
XTAP_TAPCELL_ROW_44_963 VGND VPWR sky130_fd_sc_hd__tapvpwrvgnd_1
XFILLER_0_128_3 VPWR VGND VPWR VGND sky130_ef_sc_hd__decap_12
XFILLER_0_7_417 VPWR VGND VPWR VGND sky130_ef_sc_hd__decap_12
XFILLER_0_16_707 VPWR VGND VPWR VGND sky130_ef_sc_hd__decap_12
XFILLER_0_28_545 VPWR VGND VPWR VGND sky130_ef_sc_hd__decap_12
X_4770_ _1538_ VGND VGND VPWR VPWR net99 sky130_fd_sc_hd__buf_2
XFILLER_0_83_673 VPWR VGND VPWR VGND sky130_ef_sc_hd__decap_12
XFILLER_0_82_161 VPWR VGND VPWR VGND sky130_ef_sc_hd__decap_12
XFILLER_0_70_312 VGND VGND VPWR VPWR sky130_fd_sc_hd__decap_3
XFILLER_0_15_217 VGND VGND VPWR VPWR sky130_fd_sc_hd__decap_6
XFILLER_0_28_589 VGND VGND VPWR VPWR sky130_fd_sc_hd__decap_6
XFILLER_0_82_194 VGND VGND VPWR VPWR sky130_fd_sc_hd__fill_2
XFILLER_0_70_334 VGND VGND VPWR VPWR sky130_fd_sc_hd__decap_3
X_6440_ _3079_ VGND VGND VPWR VPWR _0725_ sky130_fd_sc_hd__clkbuf_1
XFILLER_0_43_559 VGND VGND VPWR VPWR sky130_fd_sc_hd__fill_1
XFILLER_0_130_77 VGND VGND VPWR VPWR sky130_fd_sc_hd__decap_6
XFILLER_0_113_447 VGND VGND VPWR VPWR sky130_fd_sc_hd__fill_1
X_6371_ _3038_ VGND VGND VPWR VPWR _0697_ sky130_fd_sc_hd__clkbuf_1
X_8110_ _3361_ rf.registers\[26\]\[7\] _3987_ VGND VGND VPWR VPWR _3995_ sky130_fd_sc_hd__mux2_1
X_5322_ _1728_ _2053_ _2061_ VGND VGND VPWR VPWR _2062_ sky130_fd_sc_hd__o21ai_4
XFILLER_0_2_133 VGND VGND VPWR VPWR sky130_fd_sc_hd__decap_6
X_9090_ clknet_leaf_10_CLK _0178_ VGND VGND VPWR VPWR rf.registers\[31\]\[17\] sky130_fd_sc_hd__dfxtp_1
XTAP_TAPCELL_ROW_54_1117 VGND VPWR sky130_fd_sc_hd__tapvpwrvgnd_1
XTAP_TAPCELL_ROW_54_1106 VGND VPWR sky130_fd_sc_hd__tapvpwrvgnd_1
XFILLER_0_2_177 VPWR VGND VPWR VGND sky130_ef_sc_hd__decap_12
XFILLER_0_23_294 VGND VGND VPWR VPWR sky130_fd_sc_hd__fill_1
X_5253_ _1991_ _1993_ _1996_ _1744_ _1755_ VGND VGND VPWR VPWR _1997_ sky130_fd_sc_hd__a221o_1
X_8041_ _3958_ VGND VGND VPWR VPWR _0423_ sky130_fd_sc_hd__clkbuf_1
X_5184_ rf.registers\[8\]\[16\] rf.registers\[9\]\[16\] rf.registers\[10\]\[16\] rf.registers\[11\]\[16\]
+ _1929_ _1930_ VGND VGND VPWR VPWR _1931_ sky130_fd_sc_hd__mux4_1
XTAP_TAPCELL_ROW_3_349 VGND VPWR sky130_fd_sc_hd__tapvpwrvgnd_1
XTAP_TAPCELL_ROW_3_338 VGND VPWR sky130_fd_sc_hd__tapvpwrvgnd_1
XFILLER_0_3_53 VGND VGND VPWR VPWR sky130_fd_sc_hd__decap_3
XFILLER_0_64_50 VGND VGND VPWR VPWR sky130_fd_sc_hd__fill_1
X_8943_ clknet_leaf_74_CLK _0031_ VGND VGND VPWR VPWR rf.registers\[4\]\[30\] sky130_fd_sc_hd__dfxtp_1
XFILLER_0_64_94 VGND VGND VPWR VPWR sky130_fd_sc_hd__fill_2
X_8874_ clknet_leaf_68_CLK _0986_ VGND VGND VPWR VPWR rf.registers\[6\]\[25\] sky130_fd_sc_hd__dfxtp_1
X_7825_ _3349_ rf.registers\[28\]\[1\] _3842_ VGND VGND VPWR VPWR _3844_ sky130_fd_sc_hd__mux2_1
XFILLER_0_38_309 VGND VGND VPWR VPWR sky130_fd_sc_hd__decap_4
XTAP_TAPCELL_ROW_65_1279 VGND VPWR sky130_fd_sc_hd__tapvpwrvgnd_1
XTAP_TAPCELL_ROW_65_1268 VGND VPWR sky130_fd_sc_hd__tapvpwrvgnd_1
XFILLER_0_19_501 VGND VGND VPWR VPWR sky130_fd_sc_hd__decap_3
XFILLER_0_47_821 VPWR VGND VPWR VGND sky130_ef_sc_hd__decap_12
X_7756_ _3807_ VGND VGND VPWR VPWR _0289_ sky130_fd_sc_hd__clkbuf_1
X_4968_ _1616_ _1718_ _1722_ _1726_ VGND VGND VPWR VPWR _1727_ sky130_fd_sc_hd__a2bb2o_2
XFILLER_0_80_71 VGND VGND VPWR VPWR sky130_fd_sc_hd__fill_1
XTAP_TAPCELL_ROW_22_624 VGND VPWR sky130_fd_sc_hd__tapvpwrvgnd_1
XTAP_TAPCELL_ROW_22_635 VGND VPWR sky130_fd_sc_hd__tapvpwrvgnd_1
X_7687_ _3344_ rf.registers\[30\]\[0\] _3770_ VGND VGND VPWR VPWR _3771_ sky130_fd_sc_hd__mux2_1
XFILLER_0_117_753 VPWR VGND VPWR VGND sky130_ef_sc_hd__decap_12
X_4899_ rf.registers\[4\]\[1\] rf.registers\[5\]\[1\] rf.registers\[6\]\[1\] rf.registers\[7\]\[1\]
+ _1655_ _1656_ VGND VGND VPWR VPWR _1661_ sky130_fd_sc_hd__mux4_1
X_6707_ rf.registers\[10\]\[16\] _3020_ _3216_ VGND VGND VPWR VPWR _3223_ sky130_fd_sc_hd__mux2_1
XFILLER_0_62_813 VPWR VGND VPWR VGND sky130_ef_sc_hd__decap_12
XFILLER_0_132_701 VPWR VGND VPWR VGND sky130_ef_sc_hd__decap_12
X_9426_ clknet_leaf_42_CLK _0514_ VGND VGND VPWR VPWR rf.registers\[25\]\[1\] sky130_fd_sc_hd__dfxtp_1
X_6638_ rf.registers\[24\]\[16\] _3020_ _3179_ VGND VGND VPWR VPWR _3186_ sky130_fd_sc_hd__mux2_1
XFILLER_0_117_797 VPWR VGND VPWR VGND sky130_ef_sc_hd__decap_12
X_9357_ clknet_leaf_90_CLK _0445_ VGND VGND VPWR VPWR rf.registers\[7\]\[28\] sky130_fd_sc_hd__dfxtp_1
X_8308_ rf.registers\[20\]\[4\] net40 _4095_ VGND VGND VPWR VPWR _4100_ sky130_fd_sc_hd__mux2_1
X_6569_ rf.registers\[1\]\[16\] _3020_ _3142_ VGND VGND VPWR VPWR _3149_ sky130_fd_sc_hd__mux2_1
X_9288_ clknet_leaf_2_CLK _0376_ VGND VGND VPWR VPWR rf.registers\[23\]\[23\] sky130_fd_sc_hd__dfxtp_1
X_8239_ _4063_ VGND VGND VPWR VPWR _0516_ sky130_fd_sc_hd__clkbuf_1
XFILLER_0_97_721 VGND VGND VPWR VPWR sky130_fd_sc_hd__decap_6
XFILLER_0_97_765 VPWR VGND VPWR VGND sky130_ef_sc_hd__decap_12
XFILLER_0_69_467 VGND VGND VPWR VPWR sky130_fd_sc_hd__fill_1
XPHY_EDGE_ROW_69_Right_69 VGND VGND VPWR VPWR sky130_fd_sc_hd__decap_3
XFILLER_0_56_117 VGND VGND VPWR VPWR sky130_fd_sc_hd__decap_6
XFILLER_0_38_810 VGND VGND VPWR VPWR sky130_fd_sc_hd__fill_2
XTAP_TAPCELL_ROW_120_2096 VGND VPWR sky130_fd_sc_hd__tapvpwrvgnd_1
XFILLER_0_84_459 VGND VGND VPWR VPWR sky130_fd_sc_hd__fill_1
XFILLER_0_56_139 VGND VGND VPWR VPWR sky130_fd_sc_hd__fill_1
XTAP_TAPCELL_ROW_41_911 VGND VPWR sky130_fd_sc_hd__tapvpwrvgnd_1
XTAP_TAPCELL_ROW_41_922 VGND VPWR sky130_fd_sc_hd__tapvpwrvgnd_1
XFILLER_0_65_673 VPWR VGND VPWR VGND sky130_ef_sc_hd__decap_12
XFILLER_0_37_375 VGND VGND VPWR VPWR sky130_fd_sc_hd__fill_1
XFILLER_0_135_561 VPWR VGND VPWR VGND sky130_ef_sc_hd__decap_12
XFILLER_0_25_559 VGND VGND VPWR VPWR sky130_fd_sc_hd__fill_1
XFILLER_0_12_209 VPWR VGND VPWR VGND sky130_ef_sc_hd__decap_12
XFILLER_0_122_233 VPWR VGND VPWR VGND sky130_ef_sc_hd__decap_12
XFILLER_0_122_277 VPWR VGND VPWR VGND sky130_ef_sc_hd__decap_12
XPHY_EDGE_ROW_78_Right_78 VGND VGND VPWR VPWR sky130_fd_sc_hd__decap_3
XFILLER_0_21_765 VPWR VGND VPWR VGND sky130_ef_sc_hd__decap_12
XFILLER_0_85_27 VGND VGND VPWR VPWR sky130_fd_sc_hd__decap_3
XTAP_TAPCELL_ROW_127_2206 VGND VPWR sky130_fd_sc_hd__tapvpwrvgnd_1
XFILLER_0_18_65 VPWR VGND VPWR VGND sky130_ef_sc_hd__decap_12
XFILLER_0_19_9 VPWR VGND VPWR VGND sky130_ef_sc_hd__decap_12
X_5940_ _2509_ _2571_ VGND VGND VPWR VPWR _2658_ sky130_fd_sc_hd__nor2_1
XFILLER_0_125_55 VGND VGND VPWR VPWR sky130_fd_sc_hd__fill_1
XPHY_EDGE_ROW_87_Right_87 VGND VGND VPWR VPWR sky130_fd_sc_hd__decap_3
XFILLER_0_87_264 VGND VGND VPWR VPWR sky130_fd_sc_hd__fill_1
XFILLER_0_34_53 VGND VGND VPWR VPWR sky130_fd_sc_hd__decap_3
XTAP_TAPCELL_ROW_105_1869 VGND VPWR sky130_fd_sc_hd__tapvpwrvgnd_1
X_7610_ _2976_ rf.registers\[27\]\[29\] _3719_ VGND VGND VPWR VPWR _3729_ sky130_fd_sc_hd__mux2_1
XFILLER_0_29_821 VPWR VGND VPWR VGND sky130_ef_sc_hd__decap_12
X_5871_ _2577_ _2584_ _2591_ VGND VGND VPWR VPWR _2593_ sky130_fd_sc_hd__o21a_1
X_4822_ rf.registers\[28\]\[30\] rf.registers\[29\]\[30\] rf.registers\[30\]\[30\]
+ rf.registers\[31\]\[30\] _1125_ _1128_ VGND VGND VPWR VPWR _1587_ sky130_fd_sc_hd__mux4_1
X_8590_ clknet_leaf_90_CLK _0702_ VGND VGND VPWR VPWR rf.registers\[12\]\[29\] sky130_fd_sc_hd__dfxtp_1
XFILLER_0_50_41 VGND VGND VPWR VPWR sky130_fd_sc_hd__decap_8
XFILLER_0_7_225 VPWR VGND VPWR VGND sky130_ef_sc_hd__decap_12
X_7541_ _3692_ VGND VGND VPWR VPWR _0189_ sky130_fd_sc_hd__clkbuf_1
X_4753_ _1522_ VGND VGND VPWR VPWR net98 sky130_fd_sc_hd__clkbuf_4
XFILLER_0_44_813 VPWR VGND VPWR VGND sky130_ef_sc_hd__decap_12
XTAP_TAPCELL_ROW_138_2379 VGND VPWR sky130_fd_sc_hd__tapvpwrvgnd_1
XTAP_TAPCELL_ROW_138_2368 VGND VPWR sky130_fd_sc_hd__tapvpwrvgnd_1
XFILLER_0_114_701 VPWR VGND VPWR VGND sky130_ef_sc_hd__decap_12
X_7472_ _2974_ rf.registers\[29\]\[28\] _3647_ VGND VGND VPWR VPWR _3656_ sky130_fd_sc_hd__mux2_1
XFILLER_0_126_583 VGND VGND VPWR VPWR sky130_fd_sc_hd__fill_1
X_9211_ clknet_leaf_33_CLK _0299_ VGND VGND VPWR VPWR rf.registers\[9\]\[10\] sky130_fd_sc_hd__dfxtp_1
X_6423_ _3070_ VGND VGND VPWR VPWR _0717_ sky130_fd_sc_hd__clkbuf_1
X_4684_ rf.registers\[8\]\[21\] rf.registers\[9\]\[21\] rf.registers\[10\]\[21\] rf.registers\[11\]\[21\]
+ _1147_ _1149_ VGND VGND VPWR VPWR _1458_ sky130_fd_sc_hd__mux4_1
XTAP_TAPCELL_ROW_60_1198 VGND VPWR sky130_fd_sc_hd__tapvpwrvgnd_1
XPHY_EDGE_ROW_96_Right_96 VGND VGND VPWR VPWR sky130_fd_sc_hd__decap_3
XFILLER_0_70_186 VGND VGND VPWR VPWR sky130_fd_sc_hd__decap_6
X_6354_ rf.registers\[12\]\[19\] _3026_ _3008_ VGND VGND VPWR VPWR _3027_ sky130_fd_sc_hd__mux2_1
X_9142_ clknet_leaf_65_CLK _0230_ VGND VGND VPWR VPWR rf.registers\[2\]\[5\] sky130_fd_sc_hd__dfxtp_1
XTAP_TAPCELL_ROW_8_419 VGND VPWR sky130_fd_sc_hd__tapvpwrvgnd_1
XFILLER_0_3_497 VGND VGND VPWR VPWR sky130_fd_sc_hd__decap_6
XFILLER_0_12_743 VPWR VGND VPWR VGND sky130_ef_sc_hd__decap_12
X_9073_ clknet_leaf_39_CLK _0161_ VGND VGND VPWR VPWR rf.registers\[31\]\[0\] sky130_fd_sc_hd__dfxtp_1
X_6285_ _2978_ rf.registers\[13\]\[30\] _2968_ VGND VGND VPWR VPWR _2979_ sky130_fd_sc_hd__mux2_1
X_5305_ _1728_ _2037_ _2041_ _2045_ VGND VGND VPWR VPWR _2046_ sky130_fd_sc_hd__a2bb2o_2
X_5236_ _1771_ _1980_ _1755_ VGND VGND VPWR VPWR _1981_ sky130_fd_sc_hd__a21oi_1
X_8024_ _2980_ rf.registers\[22\]\[31\] _3914_ VGND VGND VPWR VPWR _3949_ sky130_fd_sc_hd__mux2_1
XFILLER_0_52_3 VPWR VGND VPWR VGND sky130_ef_sc_hd__decap_12
X_5167_ rf.registers\[12\]\[15\] rf.registers\[13\]\[15\] rf.registers\[14\]\[15\]
+ rf.registers\[15\]\[15\] _1699_ _1700_ VGND VGND VPWR VPWR _1915_ sky130_fd_sc_hd__mux4_1
XFILLER_0_98_529 VGND VGND VPWR VPWR sky130_fd_sc_hd__decap_3
X_5098_ _1848_ _1849_ _1693_ VGND VGND VPWR VPWR _1850_ sky130_fd_sc_hd__mux2_1
XPHY_EDGE_ROW_3_Left_142 VGND VGND VPWR VPWR sky130_fd_sc_hd__decap_3
X_8926_ clknet_leaf_13_CLK _0014_ VGND VGND VPWR VPWR rf.registers\[4\]\[13\] sky130_fd_sc_hd__dfxtp_1
XFILLER_0_79_721 VGND VGND VPWR VPWR sky130_fd_sc_hd__decap_6
XTAP_TAPCELL_ROW_67_1308 VGND VPWR sky130_fd_sc_hd__tapvpwrvgnd_1
XTAP_TAPCELL_ROW_27_705 VGND VPWR sky130_fd_sc_hd__tapvpwrvgnd_1
XFILLER_0_94_713 VPWR VGND VPWR VGND sky130_ef_sc_hd__decap_12
XFILLER_0_79_765 VPWR VGND VPWR VGND sky130_ef_sc_hd__decap_12
XFILLER_0_78_253 VPWR VGND VPWR VGND sky130_ef_sc_hd__decap_12
X_8857_ clknet_leaf_47_CLK _0969_ VGND VGND VPWR VPWR rf.registers\[6\]\[8\] sky130_fd_sc_hd__dfxtp_1
XFILLER_0_66_437 VGND VGND VPWR VPWR sky130_fd_sc_hd__decap_8
XFILLER_0_66_415 VGND VGND VPWR VPWR sky130_fd_sc_hd__fill_2
XFILLER_0_39_629 VPWR VGND VPWR VGND sky130_ef_sc_hd__decap_12
X_8788_ clknet_leaf_40_CLK _0900_ VGND VGND VPWR VPWR rf.registers\[16\]\[3\] sky130_fd_sc_hd__dfxtp_1
XFILLER_0_94_757 VPWR VGND VPWR VGND sky130_ef_sc_hd__decap_12
X_7808_ _3834_ VGND VGND VPWR VPWR _0314_ sky130_fd_sc_hd__clkbuf_1
X_7739_ _2963_ rf.registers\[30\]\[25\] _3792_ VGND VGND VPWR VPWR _3798_ sky130_fd_sc_hd__mux2_1
XFILLER_0_47_673 VGND VGND VPWR VPWR sky130_fd_sc_hd__decap_3
XFILLER_0_19_397 VPWR VGND VPWR VGND sky130_ef_sc_hd__decap_12
X_9409_ clknet_leaf_20_CLK _0497_ VGND VGND VPWR VPWR rf.registers\[21\]\[16\] sky130_fd_sc_hd__dfxtp_1
XFILLER_0_50_805 VGND VGND VPWR VPWR sky130_fd_sc_hd__decap_6
XPHY_EDGE_ROW_49_Left_188 VGND VGND VPWR VPWR sky130_fd_sc_hd__decap_3
XFILLER_0_62_687 VPWR VGND VPWR VGND sky130_ef_sc_hd__decap_12
XFILLER_0_22_529 VGND VGND VPWR VPWR sky130_fd_sc_hd__decap_3
XFILLER_0_120_737 VPWR VGND VPWR VGND sky130_ef_sc_hd__decap_12
XTAP_TAPCELL_ROW_91_1659 VGND VPWR sky130_fd_sc_hd__tapvpwrvgnd_1
XPHY_EDGE_ROW_58_Left_197 VGND VGND VPWR VPWR sky130_fd_sc_hd__decap_3
XFILLER_0_55_19 VPWR VGND VPWR VGND sky130_ef_sc_hd__decap_12
XFILLER_0_89_518 VGND VGND VPWR VPWR sky130_fd_sc_hd__fill_2
XTAP_TAPCELL_ROW_122_2125 VGND VPWR sky130_fd_sc_hd__tapvpwrvgnd_1
XTAP_TAPCELL_ROW_122_2136 VGND VPWR sky130_fd_sc_hd__tapvpwrvgnd_1
XFILLER_0_128_837 VGND VGND VPWR VPWR sky130_fd_sc_hd__fill_2
XFILLER_0_26_813 VPWR VGND VPWR VGND sky130_ef_sc_hd__decap_12
XFILLER_0_5_729 VPWR VGND VPWR VGND sky130_ef_sc_hd__decap_12
XFILLER_0_5_707 VPWR VGND VPWR VGND sky130_ef_sc_hd__decap_12
XTAP_TAPCELL_ROW_100_1799 VGND VPWR sky130_fd_sc_hd__tapvpwrvgnd_1
XFILLER_0_53_654 VGND VGND VPWR VPWR sky130_fd_sc_hd__decap_3
XTAP_TAPCELL_ROW_13_498 VGND VPWR sky130_fd_sc_hd__tapvpwrvgnd_1
XFILLER_0_135_391 VGND VGND VPWR VPWR sky130_fd_sc_hd__fill_1
XFILLER_0_111_57 VPWR VGND VPWR VGND sky130_ef_sc_hd__decap_12
XFILLER_0_13_529 VPWR VGND VPWR VGND sky130_ef_sc_hd__decap_12
XFILLER_0_20_77 VGND VGND VPWR VPWR sky130_fd_sc_hd__decap_6
XFILLER_0_123_575 VGND VGND VPWR VPWR sky130_fd_sc_hd__fill_1
XFILLER_0_96_15 VPWR VGND VPWR VGND sky130_ef_sc_hd__decap_12
XFILLER_0_52_197 VGND VGND VPWR VPWR sky130_fd_sc_hd__decap_8
XFILLER_0_0_412 VGND VGND VPWR VPWR sky130_fd_sc_hd__decap_8
XTAP_TAPCELL_ROW_133_2298 VGND VPWR sky130_fd_sc_hd__tapvpwrvgnd_1
XFILLER_0_110_247 VGND VGND VPWR VPWR sky130_fd_sc_hd__fill_2
XFILLER_0_0_434 VGND VGND VPWR VPWR sky130_fd_sc_hd__fill_2
XFILLER_0_0_489 VGND VGND VPWR VPWR sky130_fd_sc_hd__fill_1
X_6070_ _1115_ _2780_ VGND VGND VPWR VPWR _2781_ sky130_fd_sc_hd__or2_1
X_5021_ _1728_ _1765_ _1770_ _1777_ VGND VGND VPWR VPWR _1778_ sky130_fd_sc_hd__a2bb2o_2
XFILLER_0_136_65 VPWR VGND VPWR VGND sky130_ef_sc_hd__decap_12
XTAP_TAPCELL_ROW_107_1909 VGND VPWR sky130_fd_sc_hd__tapvpwrvgnd_1
XFILLER_0_88_551 VGND VGND VPWR VPWR sky130_fd_sc_hd__fill_1
XTAP_TAPCELL_ROW_49_1038 VGND VPWR sky130_fd_sc_hd__tapvpwrvgnd_1
X_8711_ clknet_leaf_0_CLK _0823_ VGND VGND VPWR VPWR rf.registers\[24\]\[22\] sky130_fd_sc_hd__dfxtp_1
X_6972_ net26 VGND VGND VPWR VPWR _3388_ sky130_fd_sc_hd__clkbuf_2
XFILLER_0_76_713 VPWR VGND VPWR VGND sky130_ef_sc_hd__decap_12
X_5923_ _2269_ _2318_ VGND VGND VPWR VPWR _2642_ sky130_fd_sc_hd__or2_1
XFILLER_0_76_757 VPWR VGND VPWR VGND sky130_ef_sc_hd__decap_12
XFILLER_0_75_223 VGND VGND VPWR VPWR sky130_fd_sc_hd__fill_1
X_8642_ clknet_leaf_11_CLK _0754_ VGND VGND VPWR VPWR rf.registers\[17\]\[17\] sky130_fd_sc_hd__dfxtp_1
XTAP_TAPCELL_ROW_62_1227 VGND VPWR sky130_fd_sc_hd__tapvpwrvgnd_1
X_5854_ _1810_ _2576_ VGND VGND VPWR VPWR _2577_ sky130_fd_sc_hd__nor2_1
XFILLER_0_8_501 VPWR VGND VPWR VGND sky130_ef_sc_hd__decap_12
XFILLER_0_0_65 VPWR VGND VPWR VGND sky130_ef_sc_hd__decap_12
XFILLER_0_29_640 VGND VGND VPWR VPWR sky130_fd_sc_hd__fill_2
X_8573_ clknet_leaf_17_CLK _0685_ VGND VGND VPWR VPWR rf.registers\[12\]\[12\] sky130_fd_sc_hd__dfxtp_1
XFILLER_0_75_267 VGND VGND VPWR VPWR sky130_fd_sc_hd__fill_1
XFILLER_0_8_545 VGND VGND VPWR VPWR sky130_fd_sc_hd__decap_8
X_4805_ rf.registers\[28\]\[29\] rf.registers\[29\]\[29\] rf.registers\[30\]\[29\]
+ rf.registers\[31\]\[29\] _1393_ _1394_ VGND VGND VPWR VPWR _1571_ sky130_fd_sc_hd__mux4_1
XFILLER_0_29_651 VPWR VGND VPWR VGND sky130_ef_sc_hd__decap_12
XFILLER_0_29_673 VPWR VGND VPWR VGND sky130_ef_sc_hd__decap_12
X_7524_ _3388_ rf.registers\[31\]\[20\] _3683_ VGND VGND VPWR VPWR _3684_ sky130_fd_sc_hd__mux2_1
XFILLER_0_8_589 VGND VGND VPWR VPWR sky130_fd_sc_hd__decap_6
XFILLER_0_16_301 VGND VGND VPWR VPWR sky130_fd_sc_hd__decap_6
X_5785_ _2386_ _2509_ _2510_ _2266_ VGND VGND VPWR VPWR _2511_ sky130_fd_sc_hd__a211o_1
XTAP_TAPCELL_ROW_32_774 VGND VPWR sky130_fd_sc_hd__tapvpwrvgnd_1
XTAP_TAPCELL_ROW_32_785 VGND VPWR sky130_fd_sc_hd__tapvpwrvgnd_1
XFILLER_0_133_317 VPWR VGND VPWR VGND sky130_ef_sc_hd__decap_12
XFILLER_0_71_440 VGND VGND VPWR VPWR sky130_fd_sc_hd__decap_8
XFILLER_0_28_194 VGND VGND VPWR VPWR sky130_fd_sc_hd__fill_2
X_4736_ _1291_ _1506_ _1116_ VGND VGND VPWR VPWR _1507_ sky130_fd_sc_hd__o21ai_1
XFILLER_0_114_531 VGND VGND VPWR VPWR sky130_fd_sc_hd__fill_1
X_7455_ _3624_ VGND VGND VPWR VPWR _3647_ sky130_fd_sc_hd__buf_4
X_4667_ rf.registers\[0\]\[20\] rf.registers\[1\]\[20\] rf.registers\[2\]\[20\] rf.registers\[3\]\[20\]
+ _1172_ _1173_ VGND VGND VPWR VPWR _1442_ sky130_fd_sc_hd__mux4_1
XFILLER_0_43_175 VGND VGND VPWR VPWR sky130_fd_sc_hd__fill_1
XFILLER_0_102_737 VPWR VGND VPWR VGND sky130_ef_sc_hd__decap_12
X_6406_ _3061_ VGND VGND VPWR VPWR _0709_ sky130_fd_sc_hd__clkbuf_1
X_7386_ _3587_ VGND VGND VPWR VPWR _3610_ sky130_fd_sc_hd__buf_4
XFILLER_0_3_261 VPWR VGND VPWR VGND sky130_ef_sc_hd__decap_12
X_6337_ _3015_ VGND VGND VPWR VPWR _0686_ sky130_fd_sc_hd__clkbuf_1
X_4598_ rf.registers\[24\]\[17\] rf.registers\[25\]\[17\] rf.registers\[26\]\[17\]
+ rf.registers\[27\]\[17\] _1302_ _1303_ VGND VGND VPWR VPWR _1376_ sky130_fd_sc_hd__mux4_1
XFILLER_0_12_551 VGND VGND VPWR VPWR sky130_fd_sc_hd__fill_1
X_9125_ clknet_leaf_82_CLK _0213_ VGND VGND VPWR VPWR rf.registers\[27\]\[20\] sky130_fd_sc_hd__dfxtp_1
XFILLER_0_110_781 VPWR VGND VPWR VGND sky130_ef_sc_hd__decap_12
X_9056_ clknet_leaf_23_CLK _0144_ VGND VGND VPWR VPWR rf.registers\[29\]\[15\] sky130_fd_sc_hd__dfxtp_1
XTAP_TAPCELL_ROW_73_1389 VGND VPWR sky130_fd_sc_hd__tapvpwrvgnd_1
X_6268_ _2964_ _2966_ VGND VGND VPWR VPWR _2967_ sky130_fd_sc_hd__nand2_4
X_5219_ _1958_ _1963_ _1964_ VGND VGND VPWR VPWR _1965_ sky130_fd_sc_hd__a21oi_1
X_6199_ _2318_ _2901_ VGND VGND VPWR VPWR _2902_ sky130_fd_sc_hd__nor2_1
X_8007_ _3940_ VGND VGND VPWR VPWR _0407_ sky130_fd_sc_hd__clkbuf_1
XFILLER_0_98_337 VGND VGND VPWR VPWR sky130_fd_sc_hd__decap_6
X_8909_ clknet_leaf_89_CLK _1021_ VGND VGND VPWR VPWR rf.registers\[5\]\[28\] sky130_fd_sc_hd__dfxtp_1
XFILLER_0_109_314 VGND VGND VPWR VPWR sky130_fd_sc_hd__fill_1
XFILLER_0_136_133 VGND VGND VPWR VPWR sky130_fd_sc_hd__decap_6
XFILLER_0_82_749 VGND VGND VPWR VPWR sky130_fd_sc_hd__decap_6
XFILLER_0_35_632 VGND VGND VPWR VPWR sky130_fd_sc_hd__fill_2
XFILLER_0_136_177 VPWR VGND VPWR VGND sky130_ef_sc_hd__decap_12
XFILLER_0_35_643 VGND VGND VPWR VPWR sky130_fd_sc_hd__decap_6
XFILLER_0_90_793 VPWR VGND VPWR VGND sky130_ef_sc_hd__decap_12
XFILLER_0_50_613 VGND VGND VPWR VPWR sky130_fd_sc_hd__fill_2
XTAP_TAPCELL_ROW_10_457 VGND VPWR sky130_fd_sc_hd__tapvpwrvgnd_1
XTAP_TAPCELL_ROW_10_446 VGND VPWR sky130_fd_sc_hd__tapvpwrvgnd_1
XFILLER_0_35_687 VPWR VGND VPWR VGND sky130_ef_sc_hd__decap_12
XFILLER_0_34_197 VGND VGND VPWR VPWR sky130_fd_sc_hd__decap_3
XFILLER_0_120_545 VGND VGND VPWR VPWR sky130_fd_sc_hd__fill_2
XFILLER_0_66_29 VGND VGND VPWR VPWR sky130_fd_sc_hd__fill_2
XPHY_EDGE_ROW_66_Left_205 VGND VGND VPWR VPWR sky130_fd_sc_hd__decap_3
XFILLER_0_89_315 VGND VGND VPWR VPWR sky130_fd_sc_hd__fill_1
XFILLER_0_58_713 VPWR VGND VPWR VGND sky130_ef_sc_hd__decap_12
XFILLER_0_15_33 VPWR VGND VPWR VGND sky130_ef_sc_hd__decap_12
XTAP_TAPCELL_ROW_18_568 VGND VPWR sky130_fd_sc_hd__tapvpwrvgnd_1
XTAP_TAPCELL_ROW_102_1828 VGND VPWR sky130_fd_sc_hd__tapvpwrvgnd_1
XFILLER_0_58_757 VPWR VGND VPWR VGND sky130_ef_sc_hd__decap_12
XFILLER_0_57_245 VGND VGND VPWR VPWR sky130_fd_sc_hd__decap_8
XFILLER_0_127_111 VGND VGND VPWR VPWR sky130_fd_sc_hd__fill_1
XPHY_EDGE_ROW_75_Left_214 VGND VGND VPWR VPWR sky130_fd_sc_hd__decap_3
XFILLER_0_128_678 VPWR VGND VPWR VGND sky130_ef_sc_hd__decap_12
XFILLER_0_26_610 VGND VGND VPWR VPWR sky130_fd_sc_hd__decap_8
XFILLER_0_31_43 VPWR VGND VPWR VGND sky130_ef_sc_hd__decap_12
XTAP_TAPCELL_ROW_135_2327 VGND VPWR sky130_fd_sc_hd__tapvpwrvgnd_1
XFILLER_0_110_3 VPWR VGND VPWR VGND sky130_ef_sc_hd__decap_12
XFILLER_0_14_805 VGND VGND VPWR VPWR sky130_fd_sc_hd__decap_6
XFILLER_0_26_654 VGND VGND VPWR VPWR sky130_fd_sc_hd__fill_1
X_5570_ _1998_ _2208_ _2243_ VGND VGND VPWR VPWR _2301_ sky130_fd_sc_hd__o21ai_1
X_4521_ rf.registers\[4\]\[12\] rf.registers\[5\]\[12\] rf.registers\[6\]\[12\] rf.registers\[7\]\[12\]
+ _1302_ _1303_ VGND VGND VPWR VPWR _1304_ sky130_fd_sc_hd__mux4_1
XFILLER_0_5_559 VGND VGND VPWR VPWR sky130_fd_sc_hd__fill_1
XFILLER_0_25_164 VGND VGND VPWR VPWR sky130_fd_sc_hd__decap_4
XFILLER_0_130_309 VPWR VGND VPWR VGND sky130_ef_sc_hd__decap_12
XFILLER_0_123_361 VPWR VGND VPWR VGND sky130_ef_sc_hd__decap_12
X_4452_ _1236_ _1237_ _1031_ VGND VGND VPWR VPWR _1238_ sky130_fd_sc_hd__mux2_1
X_7240_ rf.registers\[19\]\[15\] _3309_ _3527_ VGND VGND VPWR VPWR _3533_ sky130_fd_sc_hd__mux2_1
XFILLER_0_13_337 VPWR VGND VPWR VGND sky130_ef_sc_hd__decap_12
XFILLER_0_25_197 VGND VGND VPWR VPWR sky130_fd_sc_hd__fill_2
XFILLER_0_40_145 VGND VGND VPWR VPWR sky130_fd_sc_hd__fill_1
XFILLER_0_41_657 VPWR VGND VPWR VGND sky130_ef_sc_hd__decap_12
X_7171_ _3496_ VGND VGND VPWR VPWR _0015_ sky130_fd_sc_hd__clkbuf_1
XPHY_EDGE_ROW_84_Left_223 VGND VGND VPWR VPWR sky130_fd_sc_hd__decap_3
X_4383_ _1148_ VGND VGND VPWR VPWR _1173_ sky130_fd_sc_hd__buf_4
XFILLER_0_0_253 VPWR VGND VPWR VGND sky130_ef_sc_hd__decap_12
XFILLER_0_1_765 VPWR VGND VPWR VGND sky130_ef_sc_hd__decap_12
X_6122_ _2326_ _2829_ VGND VGND VPWR VPWR _2830_ sky130_fd_sc_hd__nor2_1
X_6053_ _2696_ _2764_ _2340_ VGND VGND VPWR VPWR _2765_ sky130_fd_sc_hd__mux2_1
X_5004_ rf.registers\[28\]\[6\] rf.registers\[29\]\[6\] rf.registers\[30\]\[6\] rf.registers\[31\]\[6\]
+ _1729_ _1731_ VGND VGND VPWR VPWR _1761_ sky130_fd_sc_hd__mux4_1
X_6955_ _3376_ rf.registers\[15\]\[14\] _3368_ VGND VGND VPWR VPWR _3377_ sky130_fd_sc_hd__mux2_1
XFILLER_0_95_307 VGND VGND VPWR VPWR sky130_fd_sc_hd__decap_3
XTAP_TAPCELL_ROW_37_855 VGND VPWR sky130_fd_sc_hd__tapvpwrvgnd_1
XPHY_EDGE_ROW_138_Right_138 VGND VGND VPWR VPWR sky130_fd_sc_hd__decap_3
XPHY_EDGE_ROW_93_Left_232 VGND VGND VPWR VPWR sky130_fd_sc_hd__decap_3
XFILLER_0_72_83 VGND VGND VPWR VPWR sky130_fd_sc_hd__fill_1
X_5906_ _2334_ _2337_ VGND VGND VPWR VPWR _2626_ sky130_fd_sc_hd__nand2_1
X_8625_ clknet_leaf_39_CLK _0737_ VGND VGND VPWR VPWR rf.registers\[17\]\[0\] sky130_fd_sc_hd__dfxtp_1
XFILLER_0_76_587 VGND VGND VPWR VPWR sky130_fd_sc_hd__fill_1
XFILLER_0_9_821 VPWR VGND VPWR VGND sky130_ef_sc_hd__decap_12
X_6886_ _3329_ VGND VGND VPWR VPWR _0921_ sky130_fd_sc_hd__clkbuf_1
XFILLER_0_118_133 VGND VGND VPWR VPWR sky130_fd_sc_hd__decap_6
XFILLER_0_64_749 VGND VGND VPWR VPWR sky130_fd_sc_hd__decap_6
X_5837_ _2559_ VGND VGND VPWR VPWR _2560_ sky130_fd_sc_hd__clkbuf_4
XFILLER_0_118_177 VPWR VGND VPWR VGND sky130_ef_sc_hd__decap_12
X_8556_ clknet_leaf_86_CLK _0668_ VGND VGND VPWR VPWR rf.registers\[13\]\[27\] sky130_fd_sc_hd__dfxtp_1
X_5768_ _2229_ _2278_ VGND VGND VPWR VPWR _2494_ sky130_fd_sc_hd__nor2_1
XFILLER_0_133_125 VPWR VGND VPWR VGND sky130_ef_sc_hd__decap_12
X_7507_ _3372_ rf.registers\[31\]\[12\] _3672_ VGND VGND VPWR VPWR _3675_ sky130_fd_sc_hd__mux2_1
XFILLER_0_72_793 VPWR VGND VPWR VGND sky130_ef_sc_hd__decap_12
X_4719_ _1301_ _1490_ _1307_ VGND VGND VPWR VPWR _1491_ sky130_fd_sc_hd__a21oi_1
XFILLER_0_16_153 VPWR VGND VPWR VGND sky130_ef_sc_hd__decap_12
X_8487_ _4194_ VGND VGND VPWR VPWR _0633_ sky130_fd_sc_hd__clkbuf_1
XFILLER_0_133_169 VPWR VGND VPWR VGND sky130_ef_sc_hd__decap_12
X_7438_ _3638_ VGND VGND VPWR VPWR _0140_ sky130_fd_sc_hd__clkbuf_1
XFILLER_0_114_361 VGND VGND VPWR VPWR sky130_fd_sc_hd__decap_3
XTAP_TAPCELL_ROW_75_1418 VGND VPWR sky130_fd_sc_hd__tapvpwrvgnd_1
XFILLER_0_71_281 VGND VGND VPWR VPWR sky130_fd_sc_hd__decap_4
XFILLER_0_16_197 VPWR VGND VPWR VGND sky130_ef_sc_hd__decap_12
XFILLER_0_32_657 VGND VGND VPWR VPWR sky130_fd_sc_hd__fill_2
X_5699_ _2426_ _2427_ VGND VGND VPWR VPWR _2428_ sky130_fd_sc_hd__xor2_1
XTAP_TAPCELL_ROW_75_1429 VGND VPWR sky130_fd_sc_hd__tapvpwrvgnd_1
XFILLER_0_4_581 VGND VGND VPWR VPWR sky130_fd_sc_hd__decap_6
X_7369_ _3601_ VGND VGND VPWR VPWR _0108_ sky130_fd_sc_hd__clkbuf_1
X_9108_ clknet_leaf_38_CLK _0196_ VGND VGND VPWR VPWR rf.registers\[27\]\[3\] sky130_fd_sc_hd__dfxtp_1
X_9039_ clknet_leaf_61_CLK _0127_ VGND VGND VPWR VPWR rf.registers\[8\]\[30\] sky130_fd_sc_hd__dfxtp_1
XPHY_EDGE_ROW_105_Right_105 VGND VGND VPWR VPWR sky130_fd_sc_hd__decap_3
XFILLER_0_95_841 VGND VGND VPWR VPWR sky130_fd_sc_hd__fill_1
XFILLER_0_39_223 VGND VGND VPWR VPWR sky130_fd_sc_hd__fill_1
XFILLER_0_109_111 VGND VGND VPWR VPWR sky130_fd_sc_hd__fill_1
XFILLER_0_55_727 VGND VGND VPWR VPWR sky130_fd_sc_hd__fill_1
XTAP_TAPCELL_ROW_15_527 VGND VPWR sky130_fd_sc_hd__tapvpwrvgnd_1
XFILLER_0_27_407 VPWR VGND VPWR VGND sky130_ef_sc_hd__decap_12
XFILLER_0_137_497 VGND VGND VPWR VPWR sky130_fd_sc_hd__decap_6
XFILLER_0_125_615 VGND VGND VPWR VPWR sky130_fd_sc_hd__fill_1
XTAP_TAPCELL_ROW_117_2057 VGND VPWR sky130_fd_sc_hd__tapvpwrvgnd_1
XFILLER_0_121_821 VPWR VGND VPWR VGND sky130_ef_sc_hd__decap_12
XFILLER_0_10_307 VGND VGND VPWR VPWR sky130_fd_sc_hd__fill_1
XTAP_TAPCELL_ROW_130_2257 VGND VPWR sky130_fd_sc_hd__tapvpwrvgnd_1
XTAP_TAPCELL_ROW_130_2246 VGND VPWR sky130_fd_sc_hd__tapvpwrvgnd_1
XFILLER_0_120_342 VPWR VGND VPWR VGND sky130_ef_sc_hd__decap_12
XFILLER_0_77_39 VGND VGND VPWR VPWR sky130_fd_sc_hd__decap_8
XFILLER_0_31_690 VPWR VGND VPWR VGND sky130_ef_sc_hd__decap_12
XFILLER_0_93_27 VPWR VGND VPWR VGND sky130_ef_sc_hd__decap_12
X_6740_ _2985_ _3129_ VGND VGND VPWR VPWR _3240_ sky130_fd_sc_hd__nor2_2
XTAP_TAPCELL_ROW_34_803 VGND VPWR sky130_fd_sc_hd__tapvpwrvgnd_1
XTAP_TAPCELL_ROW_34_814 VGND VPWR sky130_fd_sc_hd__tapvpwrvgnd_1
XFILLER_0_133_55 VGND VGND VPWR VPWR sky130_fd_sc_hd__fill_1
XFILLER_0_73_502 VGND VGND VPWR VPWR sky130_fd_sc_hd__fill_2
X_6671_ net9 net46 net10 VGND VGND VPWR VPWR _3203_ sky130_fd_sc_hd__nand3b_4
XFILLER_0_91_7 VPWR VGND VPWR VGND sky130_ef_sc_hd__decap_12
XFILLER_0_6_813 VPWR VGND VPWR VGND sky130_ef_sc_hd__decap_12
X_9390_ clknet_leaf_93_CLK _0478_ VGND VGND VPWR VPWR rf.registers\[26\]\[29\] sky130_fd_sc_hd__dfxtp_1
X_5622_ _2350_ _2351_ VGND VGND VPWR VPWR _2352_ sky130_fd_sc_hd__nand2_1
X_8410_ rf.registers\[18\]\[20\] net26 _4153_ VGND VGND VPWR VPWR _4154_ sky130_fd_sc_hd__mux2_1
XFILLER_0_115_125 VPWR VGND VPWR VGND sky130_ef_sc_hd__decap_12
XFILLER_0_54_793 VPWR VGND VPWR VGND sky130_ef_sc_hd__decap_12
X_5553_ _1056_ _2283_ VGND VGND VPWR VPWR _2284_ sky130_fd_sc_hd__or2_1
X_8341_ _4094_ VGND VGND VPWR VPWR _4117_ sky130_fd_sc_hd__buf_4
XFILLER_0_115_169 VPWR VGND VPWR VGND sky130_ef_sc_hd__decap_12
X_4504_ _1285_ _1286_ _1145_ VGND VGND VPWR VPWR _1287_ sky130_fd_sc_hd__mux2_1
XFILLER_0_53_281 VGND VGND VPWR VPWR sky130_fd_sc_hd__fill_1
XFILLER_0_130_139 VGND VGND VPWR VPWR sky130_fd_sc_hd__fill_1
XFILLER_0_111_320 VGND VGND VPWR VPWR sky130_fd_sc_hd__fill_1
X_8272_ _4080_ VGND VGND VPWR VPWR _0532_ sky130_fd_sc_hd__clkbuf_1
XFILLER_0_13_167 VGND VGND VPWR VPWR sky130_fd_sc_hd__fill_1
X_5484_ net55 VGND VGND VPWR VPWR _2215_ sky130_fd_sc_hd__inv_2
X_4435_ rf.registers\[20\]\[8\] rf.registers\[21\]\[8\] rf.registers\[22\]\[8\] rf.registers\[23\]\[8\]
+ _1138_ _1121_ VGND VGND VPWR VPWR _1222_ sky130_fd_sc_hd__mux4_1
X_7223_ rf.registers\[19\]\[7\] _3292_ _3516_ VGND VGND VPWR VPWR _3524_ sky130_fd_sc_hd__mux2_1
XTAP_TAPCELL_ROW_57_1159 VGND VPWR sky130_fd_sc_hd__tapvpwrvgnd_1
XTAP_TAPCELL_ROW_57_1148 VGND VPWR sky130_fd_sc_hd__tapvpwrvgnd_1
XFILLER_0_41_498 VGND VGND VPWR VPWR sky130_fd_sc_hd__decap_3
X_4366_ _1142_ _1151_ _1155_ _1156_ _1024_ VGND VGND VPWR VPWR _1157_ sky130_fd_sc_hd__a221o_1
X_7154_ _3487_ VGND VGND VPWR VPWR _0007_ sky130_fd_sc_hd__clkbuf_1
XFILLER_0_6_53 VPWR VGND VPWR VGND sky130_ef_sc_hd__decap_12
XFILLER_0_1_573 VPWR VGND VPWR VGND sky130_ef_sc_hd__decap_12
XTAP_TAPCELL_ROW_70_1348 VGND VPWR sky130_fd_sc_hd__tapvpwrvgnd_1
XFILLER_0_6_97 VPWR VGND VPWR VGND sky130_ef_sc_hd__decap_12
X_6105_ _2016_ _2768_ _2786_ _2032_ VGND VGND VPWR VPWR _2814_ sky130_fd_sc_hd__o22a_1
X_4297_ _1025_ _1089_ VGND VGND VPWR VPWR _1090_ sky130_fd_sc_hd__nand2_1
X_7085_ rf.registers\[5\]\[6\] _3290_ _3444_ VGND VGND VPWR VPWR _3451_ sky130_fd_sc_hd__mux2_1
X_6036_ _2717_ _2748_ _2234_ VGND VGND VPWR VPWR _2749_ sky130_fd_sc_hd__mux2_1
XFILLER_0_68_318 VGND VGND VPWR VPWR sky130_fd_sc_hd__decap_3
X_7987_ _3374_ rf.registers\[22\]\[13\] _3926_ VGND VGND VPWR VPWR _3930_ sky130_fd_sc_hd__mux2_1
XFILLER_0_77_841 VGND VGND VPWR VPWR sky130_fd_sc_hd__fill_1
X_6938_ net45 VGND VGND VPWR VPWR _3365_ sky130_fd_sc_hd__clkbuf_2
XFILLER_0_92_811 VGND VGND VPWR VPWR sky130_fd_sc_hd__fill_1
XTAP_TAPCELL_ROW_85_1580 VGND VPWR sky130_fd_sc_hd__tapvpwrvgnd_1
XFILLER_0_49_554 VGND VGND VPWR VPWR sky130_fd_sc_hd__decap_6
XFILLER_0_119_453 VGND VGND VPWR VPWR sky130_fd_sc_hd__fill_1
X_6869_ rf.registers\[16\]\[19\] _3317_ _3299_ VGND VGND VPWR VPWR _3318_ sky130_fd_sc_hd__mux2_1
XFILLER_0_134_401 VPWR VGND VPWR VGND sky130_ef_sc_hd__decap_12
XFILLER_0_107_615 VGND VGND VPWR VPWR sky130_fd_sc_hd__fill_1
X_8608_ clknet_leaf_22_CLK _0720_ VGND VGND VPWR VPWR rf.registers\[11\]\[15\] sky130_fd_sc_hd__dfxtp_1
XFILLER_0_36_259 VGND VGND VPWR VPWR sky130_fd_sc_hd__decap_4
XFILLER_0_134_445 VGND VGND VPWR VPWR sky130_fd_sc_hd__decap_8
XFILLER_0_91_376 VPWR VGND VPWR VGND sky130_ef_sc_hd__decap_12
X_8539_ _4221_ VGND VGND VPWR VPWR _0658_ sky130_fd_sc_hd__clkbuf_1
XFILLER_0_17_473 VPWR VGND VPWR VGND sky130_ef_sc_hd__decap_12
XFILLER_0_45_771 VPWR VGND VPWR VGND sky130_ef_sc_hd__decap_12
XFILLER_0_103_821 VPWR VGND VPWR VGND sky130_ef_sc_hd__decap_12
XTAP_TAPCELL_ROW_20_596 VGND VPWR sky130_fd_sc_hd__tapvpwrvgnd_1
XFILLER_0_4_3 VPWR VGND VPWR VGND sky130_ef_sc_hd__decap_12
XFILLER_0_129_217 VGND VGND VPWR VPWR sky130_fd_sc_hd__decap_6
XFILLER_0_95_682 VPWR VGND VPWR VGND sky130_ef_sc_hd__decap_12
XFILLER_0_83_833 VGND VGND VPWR VPWR sky130_fd_sc_hd__decap_6
XFILLER_0_137_261 VPWR VGND VPWR VGND sky130_ef_sc_hd__decap_12
XFILLER_0_82_354 VGND VGND VPWR VPWR sky130_fd_sc_hd__decap_6
XFILLER_0_6_109 VPWR VGND VPWR VGND sky130_ef_sc_hd__decap_12
XFILLER_0_103_69 VGND VGND VPWR VPWR sky130_fd_sc_hd__decap_8
XFILLER_0_88_27 VGND VGND VPWR VPWR sky130_fd_sc_hd__fill_1
XFILLER_0_51_741 VPWR VGND VPWR VGND sky130_ef_sc_hd__decap_12
Xoutput107 net107 VGND VGND VPWR VPWR RD2[4] sky130_fd_sc_hd__buf_1
XFILLER_0_112_139 VGND VGND VPWR VPWR sky130_fd_sc_hd__fill_1
XFILLER_0_51_785 VPWR VGND VPWR VGND sky130_ef_sc_hd__decap_12
XFILLER_0_11_627 VGND VGND VPWR VPWR sky130_fd_sc_hd__fill_2
Xoutput129 net129 VGND VGND VPWR VPWR alu_result[24] sky130_fd_sc_hd__buf_1
Xoutput118 net118 VGND VGND VPWR VPWR alu_result[14] sky130_fd_sc_hd__buf_1
XFILLER_0_23_487 VPWR VGND VPWR VGND sky130_ef_sc_hd__decap_12
XFILLER_0_121_673 VPWR VGND VPWR VGND sky130_ef_sc_hd__decap_12
XFILLER_0_50_295 VGND VGND VPWR VPWR sky130_fd_sc_hd__fill_1
XTAP_TAPCELL_ROW_110_1949 VGND VPWR sky130_fd_sc_hd__tapvpwrvgnd_1
XFILLER_0_128_77 VGND VGND VPWR VPWR sky130_fd_sc_hd__decap_6
XTAP_TAPCELL_ROW_52_1078 VGND VPWR sky130_fd_sc_hd__tapvpwrvgnd_1
X_8890_ clknet_leaf_55_CLK _1002_ VGND VGND VPWR VPWR rf.registers\[5\]\[9\] sky130_fd_sc_hd__dfxtp_1
X_7910_ _3365_ rf.registers\[23\]\[9\] _3879_ VGND VGND VPWR VPWR _3889_ sky130_fd_sc_hd__mux2_1
X_7841_ _3365_ rf.registers\[28\]\[9\] _3842_ VGND VGND VPWR VPWR _3852_ sky130_fd_sc_hd__mux2_1
XFILLER_0_59_841 VGND VGND VPWR VPWR sky130_fd_sc_hd__fill_1
XFILLER_0_53_52 VGND VGND VPWR VPWR sky130_fd_sc_hd__fill_1
X_7772_ _3815_ VGND VGND VPWR VPWR _0297_ sky130_fd_sc_hd__clkbuf_1
X_4984_ _1660_ VGND VGND VPWR VPWR _1742_ sky130_fd_sc_hd__clkbuf_8
XFILLER_0_19_716 VGND VGND VPWR VPWR sky130_fd_sc_hd__fill_1
XFILLER_0_74_811 VGND VGND VPWR VPWR sky130_fd_sc_hd__fill_1
X_6723_ _3231_ VGND VGND VPWR VPWR _0856_ sky130_fd_sc_hd__clkbuf_1
XFILLER_0_19_727 VGND VGND VPWR VPWR sky130_fd_sc_hd__fill_1
X_9511_ clknet_leaf_2_CLK _0599_ VGND VGND VPWR VPWR rf.registers\[18\]\[22\] sky130_fd_sc_hd__dfxtp_1
X_9442_ clknet_leaf_11_CLK _0530_ VGND VGND VPWR VPWR rf.registers\[25\]\[17\] sky130_fd_sc_hd__dfxtp_1
X_6654_ _3194_ VGND VGND VPWR VPWR _0824_ sky130_fd_sc_hd__clkbuf_1
XFILLER_0_46_557 VGND VGND VPWR VPWR sky130_fd_sc_hd__fill_1
XFILLER_0_61_505 VPWR VGND VPWR VGND sky130_ef_sc_hd__decap_12
X_5605_ net81 _2230_ _2334_ VGND VGND VPWR VPWR _2335_ sky130_fd_sc_hd__o21ai_1
X_9373_ clknet_leaf_23_CLK _0461_ VGND VGND VPWR VPWR rf.registers\[26\]\[12\] sky130_fd_sc_hd__dfxtp_1
XFILLER_0_82_3 VPWR VGND VPWR VGND sky130_ef_sc_hd__decap_12
X_6585_ _3157_ VGND VGND VPWR VPWR _0792_ sky130_fd_sc_hd__clkbuf_1
XFILLER_0_14_421 VPWR VGND VPWR VGND sky130_ef_sc_hd__decap_12
XFILLER_0_131_437 VGND VGND VPWR VPWR sky130_fd_sc_hd__fill_2
X_8324_ _4108_ VGND VGND VPWR VPWR _0556_ sky130_fd_sc_hd__clkbuf_1
X_5536_ _2252_ _2254_ _2261_ _2266_ VGND VGND VPWR VPWR _2267_ sky130_fd_sc_hd__a31o_1
XFILLER_0_41_251 VGND VGND VPWR VPWR sky130_fd_sc_hd__fill_2
XFILLER_0_42_763 VPWR VGND VPWR VGND sky130_ef_sc_hd__decap_12
X_8255_ _3010_ rf.registers\[25\]\[11\] _4070_ VGND VGND VPWR VPWR _4072_ sky130_fd_sc_hd__mux2_1
X_5467_ _1309_ _1328_ _1344_ _1358_ VGND VGND VPWR VPWR _2198_ sky130_fd_sc_hd__and4_1
XFILLER_0_100_813 VPWR VGND VPWR VGND sky130_ef_sc_hd__decap_12
X_4418_ rf.registers\[20\]\[7\] rf.registers\[21\]\[7\] rf.registers\[22\]\[7\] rf.registers\[23\]\[7\]
+ _1119_ _1122_ VGND VGND VPWR VPWR _1206_ sky130_fd_sc_hd__mux4_1
X_7206_ _3514_ VGND VGND VPWR VPWR _0032_ sky130_fd_sc_hd__clkbuf_1
X_8186_ _4035_ VGND VGND VPWR VPWR _0491_ sky130_fd_sc_hd__clkbuf_1
XFILLER_0_10_671 VGND VGND VPWR VPWR sky130_fd_sc_hd__decap_4
X_5398_ _2133_ VGND VGND VPWR VPWR net68 sky130_fd_sc_hd__clkbuf_2
X_4349_ _1121_ VGND VGND VPWR VPWR _1140_ sky130_fd_sc_hd__clkbuf_8
X_7137_ rf.registers\[5\]\[31\] _3342_ _3443_ VGND VGND VPWR VPWR _3478_ sky130_fd_sc_hd__mux2_1
X_7068_ _3441_ VGND VGND VPWR VPWR _0991_ sky130_fd_sc_hd__clkbuf_1
X_6019_ _1966_ _2732_ VGND VGND VPWR VPWR _2733_ sky130_fd_sc_hd__nand2_1
XTAP_TAPCELL_ROW_83_1539 VGND VPWR sky130_fd_sc_hd__tapvpwrvgnd_1
XFILLER_0_65_833 VGND VGND VPWR VPWR sky130_fd_sc_hd__decap_6
XFILLER_0_135_721 VGND VGND VPWR VPWR sky130_fd_sc_hd__decap_6
XFILLER_0_126_209 VPWR VGND VPWR VGND sky130_ef_sc_hd__decap_12
XFILLER_0_119_261 VPWR VGND VPWR VGND sky130_ef_sc_hd__decap_12
XTAP_TAPCELL_ROW_25_677 VGND VPWR sky130_fd_sc_hd__tapvpwrvgnd_1
XFILLER_0_107_434 VGND VGND VPWR VPWR sky130_fd_sc_hd__fill_2
XFILLER_0_92_696 VGND VGND VPWR VPWR sky130_fd_sc_hd__decap_4
XFILLER_0_80_825 VGND VGND VPWR VPWR sky130_fd_sc_hd__decap_8
XFILLER_0_52_505 VGND VGND VPWR VPWR sky130_fd_sc_hd__fill_1
XPHY_EDGE_ROW_30_Left_169 VGND VGND VPWR VPWR sky130_fd_sc_hd__decap_3
XFILLER_0_135_765 VPWR VGND VPWR VGND sky130_ef_sc_hd__decap_12
XFILLER_0_134_253 VPWR VGND VPWR VGND sky130_ef_sc_hd__decap_12
XTAP_TAPCELL_ROW_114_2005 VGND VPWR sky130_fd_sc_hd__tapvpwrvgnd_1
XFILLER_0_17_281 VPWR VGND VPWR VGND sky130_ef_sc_hd__decap_12
XFILLER_0_18_793 VPWR VGND VPWR VGND sky130_ef_sc_hd__decap_12
XTAP_TAPCELL_ROW_114_2016 VGND VPWR sky130_fd_sc_hd__tapvpwrvgnd_1
XTAP_TAPCELL_ROW_98_1771 VGND VPWR sky130_fd_sc_hd__tapvpwrvgnd_1
XFILLER_0_60_582 VGND VGND VPWR VPWR sky130_fd_sc_hd__decap_6
XFILLER_0_33_785 VPWR VGND VPWR VGND sky130_ef_sc_hd__decap_12
XFILLER_0_103_673 VPWR VGND VPWR VGND sky130_ef_sc_hd__decap_12
XFILLER_0_74_29 VGND VGND VPWR VPWR sky130_fd_sc_hd__decap_6
XTAP_TAPCELL_ROW_5_380 VGND VPWR sky130_fd_sc_hd__tapvpwrvgnd_1
XFILLER_0_87_402 VGND VGND VPWR VPWR sky130_fd_sc_hd__fill_2
XTAP_TAPCELL_ROW_125_2178 VGND VPWR sky130_fd_sc_hd__tapvpwrvgnd_1
XFILLER_0_87_457 VGND VGND VPWR VPWR sky130_fd_sc_hd__fill_1
XFILLER_0_68_693 VGND VGND VPWR VPWR sky130_fd_sc_hd__decap_6
XFILLER_0_56_833 VGND VGND VPWR VPWR sky130_fd_sc_hd__fill_1
XFILLER_0_56_811 VGND VGND VPWR VPWR sky130_fd_sc_hd__fill_1
XFILLER_0_28_513 VGND VGND VPWR VPWR sky130_fd_sc_hd__decap_8
XTAP_TAPCELL_ROW_44_953 VGND VPWR sky130_fd_sc_hd__tapvpwrvgnd_1
XTAP_TAPCELL_ROW_44_964 VGND VPWR sky130_fd_sc_hd__tapvpwrvgnd_1
XFILLER_0_7_429 VPWR VGND VPWR VGND sky130_ef_sc_hd__decap_12
XFILLER_0_28_557 VGND VGND VPWR VPWR sky130_fd_sc_hd__decap_8
XFILLER_0_83_685 VPWR VGND VPWR VGND sky130_ef_sc_hd__decap_12
XFILLER_0_16_719 VPWR VGND VPWR VGND sky130_ef_sc_hd__decap_12
XFILLER_0_82_173 VGND VGND VPWR VPWR sky130_fd_sc_hd__decap_3
XFILLER_0_70_346 VGND VGND VPWR VPWR sky130_fd_sc_hd__fill_2
XFILLER_0_113_437 VGND VGND VPWR VPWR sky130_fd_sc_hd__fill_1
X_6370_ rf.registers\[12\]\[24\] _3037_ _3029_ VGND VGND VPWR VPWR _3038_ sky130_fd_sc_hd__mux2_1
X_5321_ _1744_ _2056_ _2058_ _2060_ _1755_ VGND VGND VPWR VPWR _2061_ sky130_fd_sc_hd__a221o_1
X_8040_ rf.registers\[7\]\[6\] _3290_ _3951_ VGND VGND VPWR VPWR _3958_ sky130_fd_sc_hd__mux2_1
XTAP_TAPCELL_ROW_54_1107 VGND VPWR sky130_fd_sc_hd__tapvpwrvgnd_1
XFILLER_0_2_189 VGND VGND VPWR VPWR sky130_fd_sc_hd__decap_6
X_5252_ _1994_ _1995_ _1741_ VGND VGND VPWR VPWR _1996_ sky130_fd_sc_hd__mux2_1
XFILLER_0_48_41 VGND VGND VPWR VPWR sky130_fd_sc_hd__decap_6
X_5183_ _1731_ VGND VGND VPWR VPWR _1930_ sky130_fd_sc_hd__clkbuf_4
XFILLER_0_47_6 VPWR VGND VPWR VGND sky130_ef_sc_hd__decap_12
XFILLER_0_48_85 VGND VGND VPWR VPWR sky130_fd_sc_hd__fill_1
XFILLER_0_3_21 VPWR VGND VPWR VGND sky130_ef_sc_hd__decap_12
XTAP_TAPCELL_ROW_3_339 VGND VPWR sky130_fd_sc_hd__tapvpwrvgnd_1
X_8942_ clknet_leaf_88_CLK _0030_ VGND VGND VPWR VPWR rf.registers\[4\]\[29\] sky130_fd_sc_hd__dfxtp_1
X_8873_ clknet_leaf_67_CLK _0985_ VGND VGND VPWR VPWR rf.registers\[6\]\[24\] sky130_fd_sc_hd__dfxtp_1
X_7824_ _3843_ VGND VGND VPWR VPWR _0321_ sky130_fd_sc_hd__clkbuf_1
XTAP_TAPCELL_ROW_65_1269 VGND VPWR sky130_fd_sc_hd__tapvpwrvgnd_1
XFILLER_0_47_833 VGND VGND VPWR VPWR sky130_fd_sc_hd__decap_6
X_7755_ rf.registers\[9\]\[0\] _3276_ _3806_ VGND VGND VPWR VPWR _3807_ sky130_fd_sc_hd__mux2_1
X_4967_ _1660_ _1725_ _1709_ VGND VGND VPWR VPWR _1726_ sky130_fd_sc_hd__a21oi_1
XFILLER_0_93_449 VGND VGND VPWR VPWR sky130_fd_sc_hd__decap_6
XFILLER_0_80_83 VGND VGND VPWR VPWR sky130_fd_sc_hd__fill_1
XTAP_TAPCELL_ROW_22_625 VGND VPWR sky130_fd_sc_hd__tapvpwrvgnd_1
XFILLER_0_46_343 VGND VGND VPWR VPWR sky130_fd_sc_hd__decap_4
XFILLER_0_117_721 VGND VGND VPWR VPWR sky130_fd_sc_hd__decap_6
X_4898_ _1641_ VGND VGND VPWR VPWR _1660_ sky130_fd_sc_hd__buf_4
X_6706_ _3222_ VGND VGND VPWR VPWR _0848_ sky130_fd_sc_hd__clkbuf_1
XFILLER_0_74_685 VPWR VGND VPWR VGND sky130_ef_sc_hd__decap_12
X_7686_ _3769_ VGND VGND VPWR VPWR _3770_ sky130_fd_sc_hd__clkbuf_8
XFILLER_0_62_825 VPWR VGND VPWR VGND sky130_ef_sc_hd__decap_12
XFILLER_0_19_579 VGND VGND VPWR VPWR sky130_fd_sc_hd__fill_1
XTAP_TAPCELL_ROW_22_636 VGND VPWR sky130_fd_sc_hd__tapvpwrvgnd_1
XFILLER_0_46_365 VGND VGND VPWR VPWR sky130_fd_sc_hd__fill_2
XFILLER_0_132_713 VPWR VGND VPWR VGND sky130_ef_sc_hd__decap_12
X_9425_ clknet_leaf_39_CLK _0513_ VGND VGND VPWR VPWR rf.registers\[25\]\[0\] sky130_fd_sc_hd__dfxtp_1
XFILLER_0_117_765 VPWR VGND VPWR VGND sky130_ef_sc_hd__decap_12
X_6637_ _3185_ VGND VGND VPWR VPWR _0816_ sky130_fd_sc_hd__clkbuf_1
XFILLER_0_61_335 VGND VGND VPWR VPWR sky130_fd_sc_hd__fill_1
XFILLER_0_61_324 VGND VGND VPWR VPWR sky130_fd_sc_hd__fill_2
XFILLER_0_131_223 VGND VGND VPWR VPWR sky130_fd_sc_hd__fill_1
X_6568_ _3148_ VGND VGND VPWR VPWR _0784_ sky130_fd_sc_hd__clkbuf_1
XFILLER_0_61_346 VPWR VGND VPWR VGND sky130_ef_sc_hd__decap_12
XFILLER_0_15_763 VGND VGND VPWR VPWR sky130_fd_sc_hd__fill_1
X_9356_ clknet_leaf_89_CLK _0444_ VGND VGND VPWR VPWR rf.registers\[7\]\[27\] sky130_fd_sc_hd__dfxtp_1
XFILLER_0_132_757 VPWR VGND VPWR VGND sky130_ef_sc_hd__decap_12
X_8307_ _4099_ VGND VGND VPWR VPWR _0548_ sky130_fd_sc_hd__clkbuf_1
XFILLER_0_14_251 VGND VGND VPWR VPWR sky130_fd_sc_hd__fill_1
XFILLER_0_15_785 VPWR VGND VPWR VGND sky130_ef_sc_hd__decap_12
X_5519_ _2246_ _2249_ _2234_ VGND VGND VPWR VPWR _2250_ sky130_fd_sc_hd__mux2_1
X_6499_ _3111_ VGND VGND VPWR VPWR _0752_ sky130_fd_sc_hd__clkbuf_1
XFILLER_0_30_755 VGND VGND VPWR VPWR sky130_fd_sc_hd__fill_1
XFILLER_0_30_766 VPWR VGND VPWR VGND sky130_ef_sc_hd__decap_12
X_9287_ clknet_leaf_3_CLK _0375_ VGND VGND VPWR VPWR rf.registers\[23\]\[22\] sky130_fd_sc_hd__dfxtp_1
X_8238_ _2993_ rf.registers\[25\]\[3\] _4059_ VGND VGND VPWR VPWR _4063_ sky130_fd_sc_hd__mux2_1
XFILLER_0_100_643 VGND VGND VPWR VPWR sky130_fd_sc_hd__fill_1
X_8169_ _4026_ VGND VGND VPWR VPWR _0483_ sky130_fd_sc_hd__clkbuf_1
XFILLER_0_100_654 VGND VGND VPWR VPWR sky130_fd_sc_hd__fill_1
XTAP_TAPCELL_ROW_93_1690 VGND VPWR sky130_fd_sc_hd__tapvpwrvgnd_1
XFILLER_0_97_777 VGND VGND VPWR VPWR sky130_fd_sc_hd__decap_6
XTAP_TAPCELL_ROW_120_2097 VGND VPWR sky130_fd_sc_hd__tapvpwrvgnd_1
XFILLER_0_65_641 VPWR VGND VPWR VGND sky130_ef_sc_hd__decap_12
XTAP_TAPCELL_ROW_41_912 VGND VPWR sky130_fd_sc_hd__tapvpwrvgnd_1
XFILLER_0_65_685 VPWR VGND VPWR VGND sky130_ef_sc_hd__decap_12
XFILLER_0_25_505 VPWR VGND VPWR VGND sky130_ef_sc_hd__decap_12
XFILLER_0_52_324 VGND VGND VPWR VPWR sky130_fd_sc_hd__fill_1
XFILLER_0_135_573 VPWR VGND VPWR VGND sky130_ef_sc_hd__decap_12
XFILLER_0_122_245 VGND VGND VPWR VPWR sky130_fd_sc_hd__decap_6
XFILLER_0_100_15 VPWR VGND VPWR VGND sky130_ef_sc_hd__decap_12
XFILLER_0_122_289 VPWR VGND VPWR VGND sky130_ef_sc_hd__decap_12
XFILLER_0_21_777 VGND VGND VPWR VPWR sky130_fd_sc_hd__decap_6
XTAP_TAPCELL_ROW_127_2207 VGND VPWR sky130_fd_sc_hd__tapvpwrvgnd_1
XFILLER_0_109_57 VPWR VGND VPWR VGND sky130_ef_sc_hd__decap_12
XFILLER_0_18_77 VGND VGND VPWR VPWR sky130_fd_sc_hd__decap_6
XTAP_TAPCELL_ROW_109_1940 VGND VPWR sky130_fd_sc_hd__tapvpwrvgnd_1
XFILLER_0_88_755 VGND VGND VPWR VPWR sky130_fd_sc_hd__fill_1
X_5870_ _2577_ _2584_ _2591_ VGND VGND VPWR VPWR _2592_ sky130_fd_sc_hd__nor3_1
X_4821_ _1584_ _1585_ _1144_ VGND VGND VPWR VPWR _1586_ sky130_fd_sc_hd__mux2_1
XFILLER_0_29_833 VGND VGND VPWR VPWR sky130_fd_sc_hd__fill_1
XFILLER_0_7_237 VPWR VGND VPWR VGND sky130_ef_sc_hd__decap_12
XFILLER_0_28_365 VGND VGND VPWR VPWR sky130_fd_sc_hd__fill_1
X_7540_ _2974_ rf.registers\[31\]\[28\] _3683_ VGND VGND VPWR VPWR _3692_ sky130_fd_sc_hd__mux2_1
X_4752_ _1203_ _1513_ _1517_ _1521_ VGND VGND VPWR VPWR _1522_ sky130_fd_sc_hd__a22o_1
XFILLER_0_44_825 VPWR VGND VPWR VGND sky130_ef_sc_hd__decap_12
XTAP_TAPCELL_ROW_138_2369 VGND VPWR sky130_fd_sc_hd__tapvpwrvgnd_1
XFILLER_0_70_110 VGND VGND VPWR VPWR sky130_fd_sc_hd__fill_2
X_4683_ _1197_ _1456_ VGND VGND VPWR VPWR _1457_ sky130_fd_sc_hd__nand2_1
X_7471_ _3655_ VGND VGND VPWR VPWR _0156_ sky130_fd_sc_hd__clkbuf_1
XFILLER_0_114_713 VPWR VGND VPWR VGND sky130_ef_sc_hd__decap_12
X_6422_ rf.registers\[11\]\[12\] _3012_ _3067_ VGND VGND VPWR VPWR _3070_ sky130_fd_sc_hd__mux2_1
X_9210_ clknet_leaf_34_CLK _0298_ VGND VGND VPWR VPWR rf.registers\[9\]\[9\] sky130_fd_sc_hd__dfxtp_1
XFILLER_0_70_154 VGND VGND VPWR VPWR sky130_fd_sc_hd__fill_1
XTAP_TAPCELL_ROW_60_1199 VGND VPWR sky130_fd_sc_hd__tapvpwrvgnd_1
XFILLER_0_43_346 VGND VGND VPWR VPWR sky130_fd_sc_hd__fill_1
XFILLER_0_114_757 VPWR VGND VPWR VGND sky130_ef_sc_hd__decap_12
X_9141_ clknet_leaf_48_CLK _0229_ VGND VGND VPWR VPWR rf.registers\[2\]\[4\] sky130_fd_sc_hd__dfxtp_1
XFILLER_0_24_560 VPWR VGND VPWR VGND sky130_ef_sc_hd__decap_12
X_6353_ net24 VGND VGND VPWR VPWR _3026_ sky130_fd_sc_hd__buf_2
XFILLER_0_51_390 VGND VGND VPWR VPWR sky130_fd_sc_hd__fill_2
XFILLER_0_12_755 VGND VGND VPWR VPWR sky130_fd_sc_hd__fill_1
X_9072_ clknet_3_3__leaf_CLK _0160_ VGND VGND VPWR VPWR rf.registers\[29\]\[31\] sky130_fd_sc_hd__dfxtp_1
X_6284_ net37 VGND VGND VPWR VPWR _2978_ sky130_fd_sc_hd__clkbuf_2
X_5304_ _1771_ _2044_ _1755_ VGND VGND VPWR VPWR _2045_ sky130_fd_sc_hd__a21oi_1
X_5235_ _1978_ _1979_ _1768_ VGND VGND VPWR VPWR _1980_ sky130_fd_sc_hd__mux2_1
X_8023_ _3948_ VGND VGND VPWR VPWR _0415_ sky130_fd_sc_hd__clkbuf_1
XFILLER_0_45_3 VPWR VGND VPWR VGND sky130_ef_sc_hd__decap_12
X_5166_ rf.registers\[8\]\[15\] rf.registers\[9\]\[15\] rf.registers\[10\]\[15\] rf.registers\[11\]\[15\]
+ _1699_ _1700_ VGND VGND VPWR VPWR _1914_ sky130_fd_sc_hd__mux4_1
X_5097_ rf.registers\[12\]\[11\] rf.registers\[13\]\[11\] rf.registers\[14\]\[11\]
+ rf.registers\[15\]\[11\] _1734_ _1797_ VGND VGND VPWR VPWR _1849_ sky130_fd_sc_hd__mux4_1
X_8925_ clknet_leaf_18_CLK _0013_ VGND VGND VPWR VPWR rf.registers\[4\]\[12\] sky130_fd_sc_hd__dfxtp_1
XTAP_TAPCELL_ROW_67_1309 VGND VPWR sky130_fd_sc_hd__tapvpwrvgnd_1
XTAP_TAPCELL_ROW_27_706 VGND VPWR sky130_fd_sc_hd__tapvpwrvgnd_1
XFILLER_0_79_777 VGND VGND VPWR VPWR sky130_fd_sc_hd__decap_6
XFILLER_0_94_725 VPWR VGND VPWR VGND sky130_ef_sc_hd__decap_12
X_8856_ clknet_leaf_50_CLK _0968_ VGND VGND VPWR VPWR rf.registers\[6\]\[7\] sky130_fd_sc_hd__dfxtp_1
XFILLER_0_78_265 VGND VGND VPWR VPWR sky130_fd_sc_hd__fill_1
X_8787_ clknet_leaf_44_CLK _0899_ VGND VGND VPWR VPWR rf.registers\[16\]\[2\] sky130_fd_sc_hd__dfxtp_1
XFILLER_0_94_769 VPWR VGND VPWR VGND sky130_ef_sc_hd__decap_12
X_7807_ rf.registers\[9\]\[25\] _3330_ _3828_ VGND VGND VPWR VPWR _3834_ sky130_fd_sc_hd__mux2_1
X_5999_ _2712_ _2708_ VGND VGND VPWR VPWR _2714_ sky130_fd_sc_hd__and2b_1
XFILLER_0_81_419 VGND VGND VPWR VPWR sky130_fd_sc_hd__fill_1
X_7738_ _3797_ VGND VGND VPWR VPWR _0281_ sky130_fd_sc_hd__clkbuf_1
X_9408_ clknet_leaf_22_CLK _0496_ VGND VGND VPWR VPWR rf.registers\[21\]\[15\] sky130_fd_sc_hd__dfxtp_1
X_7669_ _3760_ VGND VGND VPWR VPWR _0249_ sky130_fd_sc_hd__clkbuf_1
XPHY_EDGE_ROW_104_Left_243 VGND VGND VPWR VPWR sky130_fd_sc_hd__decap_3
XTAP_TAPCELL_ROW_95_1730 VGND VPWR sky130_fd_sc_hd__tapvpwrvgnd_1
XFILLER_0_62_699 VGND VGND VPWR VPWR sky130_fd_sc_hd__fill_1
XFILLER_0_104_278 VGND VGND VPWR VPWR sky130_fd_sc_hd__fill_1
X_9339_ clknet_leaf_31_CLK _0427_ VGND VGND VPWR VPWR rf.registers\[7\]\[10\] sky130_fd_sc_hd__dfxtp_1
XFILLER_0_120_749 VGND VGND VPWR VPWR sky130_fd_sc_hd__decap_6
XPHY_EDGE_ROW_113_Left_252 VGND VGND VPWR VPWR sky130_fd_sc_hd__decap_3
XTAP_TAPCELL_ROW_122_2137 VGND VPWR sky130_fd_sc_hd__tapvpwrvgnd_1
XTAP_TAPCELL_ROW_122_2126 VGND VPWR sky130_fd_sc_hd__tapvpwrvgnd_1
XFILLER_0_71_19 VGND VGND VPWR VPWR sky130_fd_sc_hd__decap_8
XFILLER_0_69_254 VGND VGND VPWR VPWR sky130_fd_sc_hd__fill_1
XFILLER_0_128_805 VGND VGND VPWR VPWR sky130_fd_sc_hd__decap_6
XFILLER_0_84_246 VGND VGND VPWR VPWR sky130_fd_sc_hd__decap_6
XFILLER_0_57_449 VGND VGND VPWR VPWR sky130_fd_sc_hd__decap_8
XFILLER_0_127_337 VPWR VGND VPWR VGND sky130_ef_sc_hd__decap_12
XFILLER_0_38_674 VPWR VGND VPWR VGND sky130_ef_sc_hd__decap_12
XPHY_EDGE_ROW_122_Left_261 VGND VGND VPWR VPWR sky130_fd_sc_hd__decap_3
XFILLER_0_5_719 VGND VGND VPWR VPWR sky130_fd_sc_hd__decap_8
XFILLER_0_26_825 VPWR VGND VPWR VGND sky130_ef_sc_hd__decap_12
XFILLER_0_92_290 VGND VGND VPWR VPWR sky130_fd_sc_hd__fill_2
XTAP_TAPCELL_ROW_13_488 VGND VPWR sky130_fd_sc_hd__tapvpwrvgnd_1
XTAP_TAPCELL_ROW_13_499 VGND VPWR sky130_fd_sc_hd__tapvpwrvgnd_1
XFILLER_0_37_195 VGND VGND VPWR VPWR sky130_fd_sc_hd__fill_1
XFILLER_0_111_69 VPWR VGND VPWR VGND sky130_ef_sc_hd__decap_12
XFILLER_0_41_839 VGND VGND VPWR VPWR sky130_fd_sc_hd__fill_1
XFILLER_0_111_727 VGND VGND VPWR VPWR sky130_fd_sc_hd__fill_1
XFILLER_0_21_541 VGND VGND VPWR VPWR sky130_fd_sc_hd__decap_8
XTAP_TAPCELL_ROW_133_2299 VGND VPWR sky130_fd_sc_hd__tapvpwrvgnd_1
XTAP_TAPCELL_ROW_133_2288 VGND VPWR sky130_fd_sc_hd__tapvpwrvgnd_1
XFILLER_0_96_27 VGND VGND VPWR VPWR sky130_fd_sc_hd__fill_1
X_5020_ _1771_ _1776_ _1755_ VGND VGND VPWR VPWR _1777_ sky130_fd_sc_hd__a21oi_1
XPHY_EDGE_ROW_131_Left_270 VGND VGND VPWR VPWR sky130_fd_sc_hd__decap_3
XPHY_EDGE_ROW_119_Right_119 VGND VGND VPWR VPWR sky130_fd_sc_hd__decap_3
XFILLER_0_136_77 VGND VGND VPWR VPWR sky130_fd_sc_hd__decap_6
X_6971_ _3387_ VGND VGND VPWR VPWR _0948_ sky130_fd_sc_hd__clkbuf_1
X_8710_ clknet_leaf_80_CLK _0822_ VGND VGND VPWR VPWR rf.registers\[24\]\[21\] sky130_fd_sc_hd__dfxtp_1
XTAP_TAPCELL_ROW_49_1039 VGND VPWR sky130_fd_sc_hd__tapvpwrvgnd_1
XTAP_TAPCELL_ROW_49_1028 VGND VPWR sky130_fd_sc_hd__tapvpwrvgnd_1
XFILLER_0_76_725 VPWR VGND VPWR VGND sky130_ef_sc_hd__decap_12
X_5922_ _2462_ _2640_ VGND VGND VPWR VPWR _2641_ sky130_fd_sc_hd__nand2_1
XFILLER_0_0_11 VPWR VGND VPWR VGND sky130_ef_sc_hd__decap_12
X_8641_ clknet_leaf_19_CLK _0753_ VGND VGND VPWR VPWR rf.registers\[17\]\[16\] sky130_fd_sc_hd__dfxtp_1
XFILLER_0_76_769 VPWR VGND VPWR VGND sky130_ef_sc_hd__decap_12
XTAP_TAPCELL_ROW_62_1228 VGND VPWR sky130_fd_sc_hd__tapvpwrvgnd_1
X_5853_ net111 _2575_ VGND VGND VPWR VPWR _2576_ sky130_fd_sc_hd__xor2_1
XFILLER_0_8_513 VPWR VGND VPWR VGND sky130_ef_sc_hd__decap_12
XFILLER_0_0_77 VGND VGND VPWR VPWR sky130_fd_sc_hd__decap_6
X_8572_ clknet_leaf_30_CLK _0684_ VGND VGND VPWR VPWR rf.registers\[12\]\[11\] sky130_fd_sc_hd__dfxtp_1
XFILLER_0_75_279 VGND VGND VPWR VPWR sky130_fd_sc_hd__fill_1
XFILLER_0_0_88 VPWR VGND VPWR VGND sky130_ef_sc_hd__decap_12
X_5784_ _2239_ _2339_ _2349_ _2254_ VGND VGND VPWR VPWR _2510_ sky130_fd_sc_hd__a22o_1
X_4804_ rf.registers\[24\]\[29\] rf.registers\[25\]\[29\] rf.registers\[26\]\[29\]
+ rf.registers\[27\]\[29\] _1410_ _1411_ VGND VGND VPWR VPWR _1570_ sky130_fd_sc_hd__mux4_1
XFILLER_0_29_663 VGND VGND VPWR VPWR sky130_fd_sc_hd__decap_8
X_7523_ _3660_ VGND VGND VPWR VPWR _3683_ sky130_fd_sc_hd__buf_4
XFILLER_0_8_568 VPWR VGND VPWR VGND sky130_ef_sc_hd__decap_12
XFILLER_0_29_685 VGND VGND VPWR VPWR sky130_fd_sc_hd__decap_4
XTAP_TAPCELL_ROW_32_775 VGND VPWR sky130_fd_sc_hd__tapvpwrvgnd_1
X_4735_ _1504_ _1505_ _1154_ VGND VGND VPWR VPWR _1506_ sky130_fd_sc_hd__mux2_1
XFILLER_0_133_329 VGND VGND VPWR VPWR sky130_fd_sc_hd__decap_6
XTAP_TAPCELL_ROW_32_786 VGND VPWR sky130_fd_sc_hd__tapvpwrvgnd_1
XFILLER_0_43_143 VGND VGND VPWR VPWR sky130_fd_sc_hd__fill_1
X_7454_ _3646_ VGND VGND VPWR VPWR _0148_ sky130_fd_sc_hd__clkbuf_1
XFILLER_0_44_688 VGND VGND VPWR VPWR sky130_fd_sc_hd__decap_3
X_4666_ rf.registers\[4\]\[20\] rf.registers\[5\]\[20\] rf.registers\[6\]\[20\] rf.registers\[7\]\[20\]
+ _1172_ _1173_ VGND VGND VPWR VPWR _1441_ sky130_fd_sc_hd__mux4_1
XFILLER_0_114_587 VGND VGND VPWR VPWR sky130_fd_sc_hd__fill_1
X_6405_ rf.registers\[11\]\[4\] _2995_ _3056_ VGND VGND VPWR VPWR _3061_ sky130_fd_sc_hd__mux2_1
X_7385_ _3609_ VGND VGND VPWR VPWR _0116_ sky130_fd_sc_hd__clkbuf_1
X_4597_ _1375_ VGND VGND VPWR VPWR net88 sky130_fd_sc_hd__inv_2
XFILLER_0_102_749 VGND VGND VPWR VPWR sky130_fd_sc_hd__decap_6
X_6336_ rf.registers\[12\]\[13\] _3014_ _3008_ VGND VGND VPWR VPWR _3015_ sky130_fd_sc_hd__mux2_1
X_9124_ clknet_leaf_21_CLK _0212_ VGND VGND VPWR VPWR rf.registers\[27\]\[19\] sky130_fd_sc_hd__dfxtp_1
XTAP_TAPCELL_ROW_77_1460 VGND VPWR sky130_fd_sc_hd__tapvpwrvgnd_1
XFILLER_0_3_273 VGND VGND VPWR VPWR sky130_fd_sc_hd__decap_6
X_9055_ clknet_leaf_25_CLK _0143_ VGND VGND VPWR VPWR rf.registers\[29\]\[14\] sky130_fd_sc_hd__dfxtp_1
XFILLER_0_110_793 VPWR VGND VPWR VGND sky130_ef_sc_hd__decap_12
X_6267_ net10 _2965_ VGND VGND VPWR VPWR _2966_ sky130_fd_sc_hd__nor2_4
X_5218_ _1755_ VGND VGND VPWR VPWR _1964_ sky130_fd_sc_hd__buf_6
X_6198_ _2868_ _2900_ _2260_ VGND VGND VPWR VPWR _2901_ sky130_fd_sc_hd__mux2_1
X_8006_ _3393_ rf.registers\[22\]\[22\] _3937_ VGND VGND VPWR VPWR _3940_ sky130_fd_sc_hd__mux2_1
X_5149_ _1707_ _1897_ VGND VGND VPWR VPWR _1898_ sky130_fd_sc_hd__or2_1
XFILLER_0_99_839 VGND VGND VPWR VPWR sky130_fd_sc_hd__fill_1
X_8908_ clknet_leaf_83_CLK _1020_ VGND VGND VPWR VPWR rf.registers\[5\]\[27\] sky130_fd_sc_hd__dfxtp_1
X_8839_ clknet_leaf_4_CLK _0951_ VGND VGND VPWR VPWR rf.registers\[15\]\[22\] sky130_fd_sc_hd__dfxtp_1
XFILLER_0_47_482 VGND VGND VPWR VPWR sky130_fd_sc_hd__decap_6
XFILLER_0_136_189 VGND VGND VPWR VPWR sky130_fd_sc_hd__decap_6
XFILLER_0_124_307 VGND VGND VPWR VPWR sky130_fd_sc_hd__fill_1
XFILLER_0_133_841 VGND VGND VPWR VPWR sky130_fd_sc_hd__fill_1
XFILLER_0_105_532 VGND VGND VPWR VPWR sky130_fd_sc_hd__fill_1
XTAP_TAPCELL_ROW_10_447 VGND VPWR sky130_fd_sc_hd__tapvpwrvgnd_1
XFILLER_0_23_839 VGND VGND VPWR VPWR sky130_fd_sc_hd__fill_1
XFILLER_0_30_360 VGND VGND VPWR VPWR sky130_fd_sc_hd__fill_1
XFILLER_0_85_511 VGND VGND VPWR VPWR sky130_fd_sc_hd__fill_1
XFILLER_0_58_725 VPWR VGND VPWR VGND sky130_ef_sc_hd__decap_12
XFILLER_0_15_45 VGND VGND VPWR VPWR sky130_fd_sc_hd__decap_8
XTAP_TAPCELL_ROW_102_1829 VGND VPWR sky130_fd_sc_hd__tapvpwrvgnd_1
XFILLER_0_97_393 VPWR VGND VPWR VGND sky130_ef_sc_hd__decap_12
XFILLER_0_58_769 VPWR VGND VPWR VGND sky130_ef_sc_hd__decap_12
XTAP_TAPCELL_ROW_18_569 VGND VPWR sky130_fd_sc_hd__tapvpwrvgnd_1
XFILLER_0_73_706 VPWR VGND VPWR VGND sky130_ef_sc_hd__decap_12
XFILLER_0_57_268 VGND VGND VPWR VPWR sky130_fd_sc_hd__decap_3
XFILLER_0_5_505 VPWR VGND VPWR VGND sky130_ef_sc_hd__decap_12
XTAP_TAPCELL_ROW_135_2328 VGND VPWR sky130_fd_sc_hd__tapvpwrvgnd_1
XFILLER_0_127_167 VGND VGND VPWR VPWR sky130_fd_sc_hd__fill_1
XFILLER_0_53_452 VPWR VGND VPWR VGND sky130_ef_sc_hd__decap_12
XFILLER_0_31_55 VGND VGND VPWR VPWR sky130_fd_sc_hd__fill_1
XFILLER_0_81_783 VGND VGND VPWR VPWR sky130_fd_sc_hd__fill_1
XFILLER_0_13_305 VPWR VGND VPWR VGND sky130_ef_sc_hd__decap_12
XFILLER_0_25_154 VGND VGND VPWR VPWR sky130_fd_sc_hd__fill_1
XFILLER_0_26_699 VGND VGND VPWR VPWR sky130_fd_sc_hd__fill_1
X_4520_ _1140_ VGND VGND VPWR VPWR _1303_ sky130_fd_sc_hd__buf_4
XFILLER_0_41_614 VGND VGND VPWR VPWR sky130_fd_sc_hd__fill_2
X_4451_ rf.registers\[16\]\[9\] rf.registers\[17\]\[9\] rf.registers\[18\]\[9\] rf.registers\[19\]\[9\]
+ _1035_ _1036_ VGND VGND VPWR VPWR _1237_ sky130_fd_sc_hd__mux4_1
XFILLER_0_1_711 VPWR VGND VPWR VGND sky130_ef_sc_hd__decap_12
XFILLER_0_13_349 VPWR VGND VPWR VGND sky130_ef_sc_hd__decap_12
XFILLER_0_123_373 VPWR VGND VPWR VGND sky130_ef_sc_hd__decap_12
X_7170_ rf.registers\[4\]\[14\] _3307_ _3491_ VGND VGND VPWR VPWR _3496_ sky130_fd_sc_hd__mux2_1
XFILLER_0_40_157 VGND VGND VPWR VPWR sky130_fd_sc_hd__fill_2
XFILLER_0_41_669 VGND VGND VPWR VPWR sky130_fd_sc_hd__decap_3
X_4382_ _1146_ VGND VGND VPWR VPWR _1172_ sky130_fd_sc_hd__clkbuf_8
XTAP_TAPCELL_ROW_59_1190 VGND VPWR sky130_fd_sc_hd__tapvpwrvgnd_1
XFILLER_0_1_777 VGND VGND VPWR VPWR sky130_fd_sc_hd__decap_6
X_6121_ _2818_ _2819_ _2827_ VGND VGND VPWR VPWR _2829_ sky130_fd_sc_hd__o21a_1
XFILLER_0_0_265 VGND VGND VPWR VPWR sky130_fd_sc_hd__decap_8
XFILLER_0_56_41 VPWR VGND VPWR VGND sky130_ef_sc_hd__decap_12
XPHY_EDGE_ROW_7_Right_7 VGND VGND VPWR VPWR sky130_fd_sc_hd__decap_3
X_6052_ _2726_ _2763_ _2259_ VGND VGND VPWR VPWR _2764_ sky130_fd_sc_hd__mux2_1
X_5003_ _1758_ _1759_ _1747_ VGND VGND VPWR VPWR _1760_ sky130_fd_sc_hd__mux2_1
X_6954_ net19 VGND VGND VPWR VPWR _3376_ sky130_fd_sc_hd__clkbuf_2
XTAP_TAPCELL_ROW_37_856 VGND VPWR sky130_fd_sc_hd__tapvpwrvgnd_1
X_5905_ _2622_ _2623_ VGND VGND VPWR VPWR _2625_ sky130_fd_sc_hd__nor2_1
X_8624_ clknet_leaf_77_CLK _0736_ VGND VGND VPWR VPWR rf.registers\[11\]\[31\] sky130_fd_sc_hd__dfxtp_1
XFILLER_0_9_833 VGND VGND VPWR VPWR sky130_fd_sc_hd__decap_6
XFILLER_0_8_321 VPWR VGND VPWR VGND sky130_ef_sc_hd__decap_12
X_6885_ rf.registers\[16\]\[24\] _3328_ _3320_ VGND VGND VPWR VPWR _3329_ sky130_fd_sc_hd__mux2_1
X_5836_ net107 _2319_ VGND VGND VPWR VPWR _2559_ sky130_fd_sc_hd__or2_2
XFILLER_0_17_600 VPWR VGND VPWR VGND sky130_ef_sc_hd__decap_12
XFILLER_0_118_189 VGND VGND VPWR VPWR sky130_fd_sc_hd__decap_6
XFILLER_0_8_365 VPWR VGND VPWR VGND sky130_ef_sc_hd__decap_12
XFILLER_0_16_121 VPWR VGND VPWR VGND sky130_ef_sc_hd__decap_12
X_8555_ clknet_leaf_69_CLK _0667_ VGND VGND VPWR VPWR rf.registers\[13\]\[26\] sky130_fd_sc_hd__dfxtp_1
X_5767_ _2332_ _2377_ _2492_ VGND VGND VPWR VPWR _2493_ sky130_fd_sc_hd__a21oi_1
XFILLER_0_133_137 VPWR VGND VPWR VGND sky130_ef_sc_hd__decap_12
X_7506_ _3674_ VGND VGND VPWR VPWR _0172_ sky130_fd_sc_hd__clkbuf_1
XFILLER_0_115_841 VGND VGND VPWR VPWR sky130_fd_sc_hd__fill_1
X_4718_ _1488_ _1489_ _1397_ VGND VGND VPWR VPWR _1490_ sky130_fd_sc_hd__mux2_1
XFILLER_0_16_165 VPWR VGND VPWR VGND sky130_ef_sc_hd__decap_12
X_8486_ _3037_ rf.registers\[14\]\[24\] _4189_ VGND VGND VPWR VPWR _4194_ sky130_fd_sc_hd__mux2_1
XFILLER_0_44_452 VGND VGND VPWR VPWR sky130_fd_sc_hd__decap_4
X_5698_ _2321_ _2395_ _2394_ VGND VGND VPWR VPWR _2427_ sky130_fd_sc_hd__a21o_1
XFILLER_0_130_811 VGND VGND VPWR VPWR sky130_fd_sc_hd__fill_1
X_7437_ _3370_ rf.registers\[29\]\[11\] _3636_ VGND VGND VPWR VPWR _3638_ sky130_fd_sc_hd__mux2_1
X_4649_ rf.registers\[4\]\[19\] rf.registers\[5\]\[19\] rf.registers\[6\]\[19\] rf.registers\[7\]\[19\]
+ _1410_ _1411_ VGND VGND VPWR VPWR _1425_ sky130_fd_sc_hd__mux4_1
XFILLER_0_114_395 VGND VGND VPWR VPWR sky130_fd_sc_hd__decap_4
XTAP_TAPCELL_ROW_75_1419 VGND VPWR sky130_fd_sc_hd__tapvpwrvgnd_1
XFILLER_0_20_809 VGND VGND VPWR VPWR sky130_fd_sc_hd__decap_3
X_7368_ rf.registers\[8\]\[11\] _3301_ _3599_ VGND VGND VPWR VPWR _3601_ sky130_fd_sc_hd__mux2_1
X_9107_ clknet_leaf_43_CLK _0195_ VGND VGND VPWR VPWR rf.registers\[27\]\[2\] sky130_fd_sc_hd__dfxtp_1
X_6319_ net44 VGND VGND VPWR VPWR _3003_ sky130_fd_sc_hd__buf_2
X_7299_ _3564_ VGND VGND VPWR VPWR _0075_ sky130_fd_sc_hd__clkbuf_1
X_9038_ clknet_leaf_89_CLK _0126_ VGND VGND VPWR VPWR rf.registers\[8\]\[29\] sky130_fd_sc_hd__dfxtp_1
XFILLER_0_98_157 VGND VGND VPWR VPWR sky130_fd_sc_hd__fill_1
XFILLER_0_87_809 VPWR VGND VPWR VGND sky130_ef_sc_hd__decap_12
XFILLER_0_79_393 VGND VGND VPWR VPWR sky130_fd_sc_hd__decap_6
XFILLER_0_109_101 VGND VGND VPWR VPWR sky130_fd_sc_hd__fill_1
XFILLER_0_94_363 VGND VGND VPWR VPWR sky130_fd_sc_hd__fill_1
XFILLER_0_67_555 VGND VGND VPWR VPWR sky130_fd_sc_hd__decap_4
XTAP_TAPCELL_ROW_15_528 VGND VPWR sky130_fd_sc_hd__tapvpwrvgnd_1
XFILLER_0_82_525 VGND VGND VPWR VPWR sky130_fd_sc_hd__decap_4
XFILLER_0_27_419 VPWR VGND VPWR VGND sky130_ef_sc_hd__decap_12
XFILLER_0_39_279 VGND VGND VPWR VPWR sky130_fd_sc_hd__fill_1
XFILLER_0_63_783 VGND VGND VPWR VPWR sky130_fd_sc_hd__fill_1
XFILLER_0_23_603 VGND VGND VPWR VPWR sky130_fd_sc_hd__decap_8
XFILLER_0_23_625 VPWR VGND VPWR VGND sky130_ef_sc_hd__decap_12
XFILLER_0_133_671 VGND VGND VPWR VPWR sky130_fd_sc_hd__fill_1
XTAP_TAPCELL_ROW_117_2058 VGND VPWR sky130_fd_sc_hd__tapvpwrvgnd_1
XFILLER_0_121_833 VGND VGND VPWR VPWR sky130_fd_sc_hd__decap_6
XFILLER_0_50_477 VGND VGND VPWR VPWR sky130_fd_sc_hd__decap_6
XFILLER_0_11_809 VPWR VGND VPWR VGND sky130_ef_sc_hd__decap_12
XTAP_TAPCELL_ROW_130_2247 VGND VPWR sky130_fd_sc_hd__tapvpwrvgnd_1
XFILLER_0_120_354 VGND VGND VPWR VPWR sky130_fd_sc_hd__decap_8
XFILLER_0_120_365 VGND VGND VPWR VPWR sky130_fd_sc_hd__decap_4
XTAP_TAPCELL_ROW_112_1980 VGND VPWR sky130_fd_sc_hd__tapvpwrvgnd_1
XFILLER_0_93_39 VPWR VGND VPWR VGND sky130_ef_sc_hd__decap_12
XFILLER_0_89_113 VGND VGND VPWR VPWR sky130_fd_sc_hd__decap_8
XFILLER_0_117_57 VPWR VGND VPWR VGND sky130_ef_sc_hd__decap_12
XTAP_TAPCELL_ROW_34_804 VGND VPWR sky130_fd_sc_hd__tapvpwrvgnd_1
XTAP_TAPCELL_ROW_34_815 VGND VPWR sky130_fd_sc_hd__tapvpwrvgnd_1
XFILLER_0_85_385 VGND VGND VPWR VPWR sky130_fd_sc_hd__decap_6
X_6670_ _3202_ VGND VGND VPWR VPWR _0832_ sky130_fd_sc_hd__clkbuf_1
XFILLER_0_61_709 VPWR VGND VPWR VGND sky130_ef_sc_hd__decap_12
XFILLER_0_6_825 VPWR VGND VPWR VGND sky130_ef_sc_hd__decap_12
X_5621_ _1711_ _2219_ _2220_ VGND VGND VPWR VPWR _2351_ sky130_fd_sc_hd__o21ai_1
XFILLER_0_115_137 VPWR VGND VPWR VGND sky130_ef_sc_hd__decap_12
X_8340_ _4116_ VGND VGND VPWR VPWR _0564_ sky130_fd_sc_hd__clkbuf_1
XFILLER_0_5_335 VGND VGND VPWR VPWR sky130_fd_sc_hd__fill_1
XFILLER_0_26_474 VGND VGND VPWR VPWR sky130_fd_sc_hd__fill_2
X_5552_ _2149_ _2218_ VGND VGND VPWR VPWR _2283_ sky130_fd_sc_hd__nor2_1
XFILLER_0_112_811 VGND VGND VPWR VPWR sky130_fd_sc_hd__fill_1
X_4503_ rf.registers\[16\]\[12\] rf.registers\[17\]\[12\] rf.registers\[18\]\[12\]
+ rf.registers\[19\]\[12\] _1283_ _1284_ VGND VGND VPWR VPWR _1286_ sky130_fd_sc_hd__mux4_1
X_8271_ _3026_ rf.registers\[25\]\[19\] _4070_ VGND VGND VPWR VPWR _4080_ sky130_fd_sc_hd__mux2_1
XFILLER_0_13_113 VPWR VGND VPWR VGND sky130_ef_sc_hd__decap_12
XFILLER_0_14_658 VGND VGND VPWR VPWR sky130_fd_sc_hd__fill_1
X_5483_ _2210_ _2213_ VGND VGND VPWR VPWR _2214_ sky130_fd_sc_hd__nand2_1
XFILLER_0_123_181 VPWR VGND VPWR VGND sky130_ef_sc_hd__decap_12
X_7222_ _3523_ VGND VGND VPWR VPWR _0039_ sky130_fd_sc_hd__clkbuf_1
X_4434_ _1221_ VGND VGND VPWR VPWR net110 sky130_fd_sc_hd__inv_2
XTAP_TAPCELL_ROW_57_1149 VGND VPWR sky130_fd_sc_hd__tapvpwrvgnd_1
XFILLER_0_1_541 VPWR VGND VPWR VGND sky130_ef_sc_hd__decap_12
X_7153_ rf.registers\[4\]\[6\] _3290_ _3480_ VGND VGND VPWR VPWR _3487_ sky130_fd_sc_hd__mux2_1
XFILLER_0_6_65 VPWR VGND VPWR VGND sky130_ef_sc_hd__decap_12
XFILLER_0_1_585 VPWR VGND VPWR VGND sky130_ef_sc_hd__decap_12
X_4365_ _1135_ VGND VGND VPWR VPWR _1156_ sky130_fd_sc_hd__buf_6
X_7084_ _3450_ VGND VGND VPWR VPWR _0998_ sky130_fd_sc_hd__clkbuf_1
X_6104_ _2774_ _2812_ VGND VGND VPWR VPWR _2813_ sky130_fd_sc_hd__and2b_1
X_4296_ _1087_ _1088_ _1031_ VGND VGND VPWR VPWR _1089_ sky130_fd_sc_hd__mux2_1
XTAP_TAPCELL_ROW_70_1349 VGND VPWR sky130_fd_sc_hd__tapvpwrvgnd_1
X_6035_ _2297_ _2302_ VGND VGND VPWR VPWR _2748_ sky130_fd_sc_hd__nand2_1
XFILLER_0_83_50 VGND VGND VPWR VPWR sky130_fd_sc_hd__fill_2
XFILLER_0_69_809 VPWR VGND VPWR VGND sky130_ef_sc_hd__decap_12
X_7986_ _3929_ VGND VGND VPWR VPWR _0397_ sky130_fd_sc_hd__clkbuf_1
XFILLER_0_119_410 VGND VGND VPWR VPWR sky130_fd_sc_hd__fill_2
X_6937_ _3364_ VGND VGND VPWR VPWR _0937_ sky130_fd_sc_hd__clkbuf_1
XTAP_TAPCELL_ROW_85_1581 VGND VPWR sky130_fd_sc_hd__tapvpwrvgnd_1
XTAP_TAPCELL_ROW_85_1570 VGND VPWR sky130_fd_sc_hd__tapvpwrvgnd_1
X_6868_ net24 VGND VGND VPWR VPWR _3317_ sky130_fd_sc_hd__buf_2
XFILLER_0_76_374 VGND VGND VPWR VPWR sky130_fd_sc_hd__decap_8
XFILLER_0_9_630 VGND VGND VPWR VPWR sky130_fd_sc_hd__decap_8
XFILLER_0_134_413 VGND VGND VPWR VPWR sky130_fd_sc_hd__decap_6
XFILLER_0_119_476 VGND VGND VPWR VPWR sky130_fd_sc_hd__fill_1
X_8607_ clknet_leaf_17_CLK _0719_ VGND VGND VPWR VPWR rf.registers\[11\]\[14\] sky130_fd_sc_hd__dfxtp_1
X_5819_ net110 _2542_ VGND VGND VPWR VPWR _2543_ sky130_fd_sc_hd__xnor2_1
XFILLER_0_119_498 VGND VGND VPWR VPWR sky130_fd_sc_hd__fill_1
XFILLER_0_91_388 VGND VGND VPWR VPWR sky130_fd_sc_hd__decap_4
X_8538_ _3022_ rf.registers\[13\]\[17\] _4216_ VGND VGND VPWR VPWR _4221_ sky130_fd_sc_hd__mux2_1
XFILLER_0_8_195 VGND VGND VPWR VPWR sky130_fd_sc_hd__fill_1
X_6799_ _3271_ VGND VGND VPWR VPWR _0892_ sky130_fd_sc_hd__clkbuf_1
XFILLER_0_45_783 VGND VGND VPWR VPWR sky130_fd_sc_hd__fill_1
XFILLER_0_17_485 VPWR VGND VPWR VGND sky130_ef_sc_hd__decap_12
XFILLER_0_115_671 VGND VGND VPWR VPWR sky130_fd_sc_hd__fill_1
XFILLER_0_103_833 VGND VGND VPWR VPWR sky130_fd_sc_hd__decap_6
X_8469_ _3020_ rf.registers\[14\]\[16\] _4178_ VGND VGND VPWR VPWR _4185_ sky130_fd_sc_hd__mux2_1
XTAP_TAPCELL_ROW_20_597 VGND VPWR sky130_fd_sc_hd__tapvpwrvgnd_1
XFILLER_0_32_466 VGND VGND VPWR VPWR sky130_fd_sc_hd__fill_1
XFILLER_0_130_641 VGND VGND VPWR VPWR sky130_fd_sc_hd__decap_3
XFILLER_0_102_343 VGND VGND VPWR VPWR sky130_fd_sc_hd__decap_8
XFILLER_0_20_617 VGND VGND VPWR VPWR sky130_fd_sc_hd__fill_1
XFILLER_0_32_477 VGND VGND VPWR VPWR sky130_fd_sc_hd__decap_8
XFILLER_0_102_376 VGND VGND VPWR VPWR sky130_fd_sc_hd__decap_3
XFILLER_0_102_365 VGND VGND VPWR VPWR sky130_fd_sc_hd__fill_2
XFILLER_0_138_741 VPWR VGND VPWR VGND sky130_ef_sc_hd__decap_12
XFILLER_0_95_694 VPWR VGND VPWR VGND sky130_ef_sc_hd__decap_12
XFILLER_0_94_171 VGND VGND VPWR VPWR sky130_fd_sc_hd__decap_3
XFILLER_0_55_503 VGND VGND VPWR VPWR sky130_fd_sc_hd__fill_1
XFILLER_0_138_785 VPWR VGND VPWR VGND sky130_ef_sc_hd__decap_12
XFILLER_0_137_273 VGND VGND VPWR VPWR sky130_fd_sc_hd__decap_6
XFILLER_0_51_753 VPWR VGND VPWR VGND sky130_ef_sc_hd__decap_12
XFILLER_0_3_839 VGND VGND VPWR VPWR sky130_fd_sc_hd__fill_1
Xoutput108 net108 VGND VGND VPWR VPWR RD2[5] sky130_fd_sc_hd__buf_1
XFILLER_0_51_797 VPWR VGND VPWR VGND sky130_ef_sc_hd__decap_12
XFILLER_0_11_617 VGND VGND VPWR VPWR sky130_fd_sc_hd__decap_3
Xoutput119 net119 VGND VGND VPWR VPWR alu_result[15] sky130_fd_sc_hd__buf_1
XFILLER_0_23_499 VGND VGND VPWR VPWR sky130_fd_sc_hd__decap_4
XFILLER_0_121_685 VPWR VGND VPWR VGND sky130_ef_sc_hd__decap_12
XFILLER_0_120_195 VGND VGND VPWR VPWR sky130_fd_sc_hd__fill_1
Xoutput90 net90 VGND VGND VPWR VPWR RD2[18] sky130_fd_sc_hd__buf_1
XTAP_TAPCELL_ROW_52_1079 VGND VPWR sky130_fd_sc_hd__tapvpwrvgnd_1
X_7840_ _3851_ VGND VGND VPWR VPWR _0329_ sky130_fd_sc_hd__clkbuf_1
X_7771_ rf.registers\[9\]\[8\] _3294_ _3806_ VGND VGND VPWR VPWR _3815_ sky130_fd_sc_hd__mux2_1
X_4983_ _1630_ VGND VGND VPWR VPWR _1741_ sky130_fd_sc_hd__clkbuf_8
XFILLER_0_129_741 VPWR VGND VPWR VGND sky130_ef_sc_hd__decap_12
XFILLER_0_86_683 VPWR VGND VPWR VGND sky130_ef_sc_hd__decap_12
X_6722_ rf.registers\[10\]\[23\] _3035_ _3227_ VGND VGND VPWR VPWR _3231_ sky130_fd_sc_hd__mux2_1
XFILLER_0_58_363 VGND VGND VPWR VPWR sky130_fd_sc_hd__fill_1
X_9510_ clknet_leaf_84_CLK _0598_ VGND VGND VPWR VPWR rf.registers\[18\]\[21\] sky130_fd_sc_hd__dfxtp_1
XFILLER_0_129_785 VPWR VGND VPWR VGND sky130_ef_sc_hd__decap_12
XFILLER_0_128_251 VGND VGND VPWR VPWR sky130_fd_sc_hd__fill_1
X_9441_ clknet_leaf_5_CLK _0529_ VGND VGND VPWR VPWR rf.registers\[25\]\[16\] sky130_fd_sc_hd__dfxtp_1
XFILLER_0_73_333 VGND VGND VPWR VPWR sky130_fd_sc_hd__decap_3
X_6653_ rf.registers\[24\]\[23\] _3035_ _3190_ VGND VGND VPWR VPWR _3194_ sky130_fd_sc_hd__mux2_1
XFILLER_0_61_517 VGND VGND VPWR VPWR sky130_fd_sc_hd__decap_8
X_5604_ _2212_ _2224_ VGND VGND VPWR VPWR _2334_ sky130_fd_sc_hd__or2_1
XFILLER_0_131_405 VPWR VGND VPWR VGND sky130_ef_sc_hd__decap_12
X_9372_ clknet_leaf_26_CLK _0460_ VGND VGND VPWR VPWR rf.registers\[26\]\[11\] sky130_fd_sc_hd__dfxtp_1
XFILLER_0_104_608 VGND VGND VPWR VPWR sky130_fd_sc_hd__fill_1
X_6584_ rf.registers\[1\]\[23\] _3035_ _3153_ VGND VGND VPWR VPWR _3157_ sky130_fd_sc_hd__mux2_1
XFILLER_0_6_688 VGND VGND VPWR VPWR sky130_fd_sc_hd__fill_1
XFILLER_0_27_794 VPWR VGND VPWR VGND sky130_ef_sc_hd__decap_12
X_8323_ rf.registers\[20\]\[11\] net16 _4106_ VGND VGND VPWR VPWR _4108_ sky130_fd_sc_hd__mux2_1
X_5535_ _1158_ _2265_ VGND VGND VPWR VPWR _2266_ sky130_fd_sc_hd__nand2_4
XFILLER_0_6_699 VGND VGND VPWR VPWR sky130_fd_sc_hd__fill_1
XFILLER_0_14_433 VPWR VGND VPWR VGND sky130_ef_sc_hd__decap_12
XFILLER_0_42_775 VPWR VGND VPWR VGND sky130_ef_sc_hd__decap_12
X_8254_ _4071_ VGND VGND VPWR VPWR _0523_ sky130_fd_sc_hd__clkbuf_1
X_5466_ _2194_ _2195_ _2196_ VGND VGND VPWR VPWR _2197_ sky130_fd_sc_hd__or3_1
XFILLER_0_14_477 VPWR VGND VPWR VGND sky130_ef_sc_hd__decap_12
XFILLER_0_100_825 VPWR VGND VPWR VGND sky130_ef_sc_hd__decap_12
X_4417_ _1205_ VGND VGND VPWR VPWR net109 sky130_fd_sc_hd__inv_2
X_7205_ rf.registers\[4\]\[31\] _3342_ _3479_ VGND VGND VPWR VPWR _3514_ sky130_fd_sc_hd__mux2_1
X_8185_ _3367_ rf.registers\[21\]\[10\] _4034_ VGND VGND VPWR VPWR _4035_ sky130_fd_sc_hd__mux2_1
XFILLER_0_1_393 VPWR VGND VPWR VGND sky130_ef_sc_hd__decap_12
X_5397_ _1964_ _2124_ _2132_ VGND VGND VPWR VPWR _2133_ sky130_fd_sc_hd__a21o_1
X_4348_ _1138_ VGND VGND VPWR VPWR _1139_ sky130_fd_sc_hd__buf_6
X_7136_ _3477_ VGND VGND VPWR VPWR _1023_ sky130_fd_sc_hd__clkbuf_1
X_4279_ _1061_ _1072_ net8 VGND VGND VPWR VPWR _1073_ sky130_fd_sc_hd__a21oi_1
X_7067_ rf.registers\[6\]\[30\] _3340_ _3407_ VGND VGND VPWR VPWR _3441_ sky130_fd_sc_hd__mux2_1
XTAP_TAPCELL_ROW_87_1610 VGND VPWR sky130_fd_sc_hd__tapvpwrvgnd_1
X_6018_ net89 _2731_ VGND VGND VPWR VPWR _2732_ sky130_fd_sc_hd__xnor2_1
X_7969_ _3920_ VGND VGND VPWR VPWR _0389_ sky130_fd_sc_hd__clkbuf_1
XTAP_TAPCELL_ROW_25_678 VGND VPWR sky130_fd_sc_hd__tapvpwrvgnd_1
XFILLER_0_134_221 VPWR VGND VPWR VGND sky130_ef_sc_hd__decap_12
XFILLER_0_119_273 VGND VGND VPWR VPWR sky130_fd_sc_hd__decap_6
XFILLER_0_64_355 VGND VGND VPWR VPWR sky130_fd_sc_hd__decap_8
XFILLER_0_135_777 VGND VGND VPWR VPWR sky130_fd_sc_hd__decap_6
XFILLER_0_134_265 VPWR VGND VPWR VGND sky130_ef_sc_hd__decap_12
XFILLER_0_80_837 VGND VGND VPWR VPWR sky130_fd_sc_hd__fill_2
XTAP_TAPCELL_ROW_114_2017 VGND VPWR sky130_fd_sc_hd__tapvpwrvgnd_1
XTAP_TAPCELL_ROW_114_2006 VGND VPWR sky130_fd_sc_hd__tapvpwrvgnd_1
XTAP_TAPCELL_ROW_98_1772 VGND VPWR sky130_fd_sc_hd__tapvpwrvgnd_1
XFILLER_0_17_293 VPWR VGND VPWR VGND sky130_ef_sc_hd__decap_12
XFILLER_0_33_753 VGND VGND VPWR VPWR sky130_fd_sc_hd__fill_2
XFILLER_0_33_797 VPWR VGND VPWR VGND sky130_ef_sc_hd__decap_12
XFILLER_0_103_685 VPWR VGND VPWR VGND sky130_ef_sc_hd__decap_12
XFILLER_0_102_162 VGND VGND VPWR VPWR sky130_fd_sc_hd__fill_2
XFILLER_0_130_493 VGND VGND VPWR VPWR sky130_fd_sc_hd__decap_4
XTAP_TAPCELL_ROW_5_381 VGND VPWR sky130_fd_sc_hd__tapvpwrvgnd_1
XTAP_TAPCELL_ROW_5_370 VGND VPWR sky130_fd_sc_hd__tapvpwrvgnd_1
XTAP_TAPCELL_ROW_125_2168 VGND VPWR sky130_fd_sc_hd__tapvpwrvgnd_1
XTAP_TAPCELL_ROW_125_2179 VGND VPWR sky130_fd_sc_hd__tapvpwrvgnd_1
XFILLER_0_90_29 VPWR VGND VPWR VGND sky130_ef_sc_hd__decap_12
XFILLER_0_75_609 VGND VGND VPWR VPWR sky130_fd_sc_hd__decap_4
XTAP_TAPCELL_ROW_44_954 VGND VPWR sky130_fd_sc_hd__tapvpwrvgnd_1
XTAP_TAPCELL_ROW_44_965 VGND VPWR sky130_fd_sc_hd__tapvpwrvgnd_1
XFILLER_0_138_593 VGND VGND VPWR VPWR sky130_fd_sc_hd__fill_1
XFILLER_0_126_755 VGND VGND VPWR VPWR sky130_fd_sc_hd__fill_1
XFILLER_0_83_697 VPWR VGND VPWR VGND sky130_ef_sc_hd__decap_12
XFILLER_0_113_449 VGND VGND VPWR VPWR sky130_fd_sc_hd__fill_1
X_5320_ _1741_ _2059_ _1742_ VGND VGND VPWR VPWR _2060_ sky130_fd_sc_hd__o21a_1
XFILLER_0_51_561 VPWR VGND VPWR VGND sky130_ef_sc_hd__decap_12
X_5251_ rf.registers\[12\]\[19\] rf.registers\[13\]\[19\] rf.registers\[14\]\[19\]
+ rf.registers\[15\]\[19\] _1749_ _1750_ VGND VGND VPWR VPWR _1995_ sky130_fd_sc_hd__mux4_1
XTAP_TAPCELL_ROW_54_1108 VGND VPWR sky130_fd_sc_hd__tapvpwrvgnd_1
XFILLER_0_11_447 VGND VGND VPWR VPWR sky130_fd_sc_hd__fill_1
X_5182_ _1729_ VGND VGND VPWR VPWR _1929_ sky130_fd_sc_hd__buf_4
XFILLER_0_3_33 VPWR VGND VPWR VGND sky130_ef_sc_hd__decap_12
X_8941_ clknet_leaf_89_CLK _0029_ VGND VGND VPWR VPWR rf.registers\[4\]\[28\] sky130_fd_sc_hd__dfxtp_1
XTAP_TAPCELL_ROW_69_1340 VGND VPWR sky130_fd_sc_hd__tapvpwrvgnd_1
X_8872_ clknet_leaf_90_CLK _0984_ VGND VGND VPWR VPWR rf.registers\[6\]\[23\] sky130_fd_sc_hd__dfxtp_1
X_7823_ _3344_ rf.registers\[28\]\[0\] _3842_ VGND VGND VPWR VPWR _3843_ sky130_fd_sc_hd__mux2_1
X_7754_ _3805_ VGND VGND VPWR VPWR _3806_ sky130_fd_sc_hd__clkbuf_8
X_4966_ _1723_ _1724_ _1663_ VGND VGND VPWR VPWR _1725_ sky130_fd_sc_hd__mux2_1
X_6705_ rf.registers\[10\]\[15\] _3018_ _3216_ VGND VGND VPWR VPWR _3222_ sky130_fd_sc_hd__mux2_1
XTAP_TAPCELL_ROW_22_626 VGND VPWR sky130_fd_sc_hd__tapvpwrvgnd_1
XFILLER_0_116_221 VPWR VGND VPWR VGND sky130_ef_sc_hd__decap_12
X_4897_ _1651_ _1658_ VGND VGND VPWR VPWR _1659_ sky130_fd_sc_hd__nand2_1
X_7685_ _3768_ _3623_ VGND VGND VPWR VPWR _3769_ sky130_fd_sc_hd__nand2_4
XTAP_TAPCELL_ROW_22_637 VGND VPWR sky130_fd_sc_hd__tapvpwrvgnd_1
XFILLER_0_117_777 VGND VGND VPWR VPWR sky130_fd_sc_hd__decap_6
X_6636_ rf.registers\[24\]\[15\] _3018_ _3179_ VGND VGND VPWR VPWR _3185_ sky130_fd_sc_hd__mux2_1
XFILLER_0_74_697 VGND VGND VPWR VPWR sky130_fd_sc_hd__decap_3
XFILLER_0_62_837 VGND VGND VPWR VPWR sky130_fd_sc_hd__fill_2
X_9424_ clknet_leaf_62_CLK _0512_ VGND VGND VPWR VPWR rf.registers\[21\]\[31\] sky130_fd_sc_hd__dfxtp_1
XFILLER_0_132_725 VPWR VGND VPWR VGND sky130_ef_sc_hd__decap_12
X_6567_ rf.registers\[1\]\[15\] _3018_ _3142_ VGND VGND VPWR VPWR _3148_ sky130_fd_sc_hd__mux2_1
XFILLER_0_61_358 VGND VGND VPWR VPWR sky130_fd_sc_hd__decap_4
X_9355_ clknet_leaf_67_CLK _0443_ VGND VGND VPWR VPWR rf.registers\[7\]\[26\] sky130_fd_sc_hd__dfxtp_1
XFILLER_0_132_769 VPWR VGND VPWR VGND sky130_ef_sc_hd__decap_12
X_8306_ rf.registers\[20\]\[3\] net39 _4095_ VGND VGND VPWR VPWR _4099_ sky130_fd_sc_hd__mux2_1
XFILLER_0_15_797 VPWR VGND VPWR VGND sky130_ef_sc_hd__decap_12
XFILLER_0_30_701 VPWR VGND VPWR VGND sky130_ef_sc_hd__decap_12
X_5518_ net81 _1727_ _2208_ _2248_ VGND VGND VPWR VPWR _2249_ sky130_fd_sc_hd__o31a_1
XFILLER_0_131_279 VGND VGND VPWR VPWR sky130_fd_sc_hd__fill_1
X_6498_ rf.registers\[17\]\[15\] _3018_ _3105_ VGND VGND VPWR VPWR _3111_ sky130_fd_sc_hd__mux2_1
X_9286_ clknet_leaf_80_CLK _0374_ VGND VGND VPWR VPWR rf.registers\[23\]\[21\] sky130_fd_sc_hd__dfxtp_1
X_8237_ _4062_ VGND VGND VPWR VPWR _0515_ sky130_fd_sc_hd__clkbuf_1
X_5449_ rf.registers\[28\]\[31\] rf.registers\[29\]\[31\] rf.registers\[30\]\[31\]
+ rf.registers\[31\]\[31\] _2109_ _2110_ VGND VGND VPWR VPWR _2181_ sky130_fd_sc_hd__mux4_1
XFILLER_0_30_778 VPWR VGND VPWR VGND sky130_ef_sc_hd__decap_12
X_8168_ _3351_ rf.registers\[21\]\[2\] _4023_ VGND VGND VPWR VPWR _4026_ sky130_fd_sc_hd__mux2_1
XTAP_TAPCELL_ROW_93_1691 VGND VPWR sky130_fd_sc_hd__tapvpwrvgnd_1
Xclkbuf_leaf_20_CLK clknet_3_1__leaf_CLK VGND VGND VPWR VPWR clknet_leaf_20_CLK sky130_fd_sc_hd__clkbuf_8
XFILLER_0_100_699 VGND VGND VPWR VPWR sky130_fd_sc_hd__fill_1
X_7119_ rf.registers\[5\]\[22\] _3324_ _3466_ VGND VGND VPWR VPWR _3469_ sky130_fd_sc_hd__mux2_1
X_8099_ _3989_ VGND VGND VPWR VPWR _0450_ sky130_fd_sc_hd__clkbuf_1
XTAP_TAPCELL_ROW_120_2098 VGND VPWR sky130_fd_sc_hd__tapvpwrvgnd_1
Xclkbuf_leaf_87_CLK clknet_3_0__leaf_CLK VGND VGND VPWR VPWR clknet_leaf_87_CLK sky130_fd_sc_hd__clkbuf_8
XTAP_TAPCELL_ROW_41_913 VGND VPWR sky130_fd_sc_hd__tapvpwrvgnd_1
XFILLER_0_65_653 VPWR VGND VPWR VGND sky130_ef_sc_hd__decap_12
XFILLER_0_25_517 VPWR VGND VPWR VGND sky130_ef_sc_hd__decap_12
XFILLER_0_135_541 VGND VGND VPWR VPWR sky130_fd_sc_hd__decap_8
XFILLER_0_108_755 VGND VGND VPWR VPWR sky130_fd_sc_hd__fill_1
XFILLER_0_65_697 VPWR VGND VPWR VGND sky130_ef_sc_hd__decap_12
XFILLER_0_64_174 VGND VGND VPWR VPWR sky130_fd_sc_hd__fill_2
XFILLER_0_64_163 VGND VGND VPWR VPWR sky130_fd_sc_hd__decap_8
XFILLER_0_135_585 VPWR VGND VPWR VGND sky130_ef_sc_hd__decap_12
XFILLER_0_107_287 VGND VGND VPWR VPWR sky130_fd_sc_hd__fill_2
XFILLER_0_80_656 VPWR VGND VPWR VGND sky130_ef_sc_hd__decap_12
XFILLER_0_107_298 VGND VGND VPWR VPWR sky130_fd_sc_hd__decap_4
XFILLER_0_100_27 VGND VGND VPWR VPWR sky130_fd_sc_hd__fill_1
XFILLER_0_33_561 VGND VGND VPWR VPWR sky130_fd_sc_hd__fill_2
XFILLER_0_0_617 VGND VGND VPWR VPWR sky130_fd_sc_hd__decap_8
XFILLER_0_0_628 VPWR VGND VPWR VGND sky130_ef_sc_hd__decap_12
Xclkbuf_leaf_11_CLK clknet_3_1__leaf_CLK VGND VGND VPWR VPWR clknet_leaf_11_CLK sky130_fd_sc_hd__clkbuf_8
XTAP_TAPCELL_ROW_127_2208 VGND VPWR sky130_fd_sc_hd__tapvpwrvgnd_1
XFILLER_0_109_69 VPWR VGND VPWR VGND sky130_ef_sc_hd__decap_12
XTAP_TAPCELL_ROW_109_1941 VGND VPWR sky130_fd_sc_hd__tapvpwrvgnd_1
XTAP_TAPCELL_ROW_109_1930 VGND VPWR sky130_fd_sc_hd__tapvpwrvgnd_1
XFILLER_0_88_701 VPWR VGND VPWR VGND sky130_ef_sc_hd__decap_12
XFILLER_0_125_57 VPWR VGND VPWR VGND sky130_ef_sc_hd__decap_12
X_4820_ rf.registers\[16\]\[30\] rf.registers\[17\]\[30\] rf.registers\[18\]\[30\]
+ rf.registers\[19\]\[30\] _1125_ _1128_ VGND VGND VPWR VPWR _1585_ sky130_fd_sc_hd__mux4_1
XFILLER_0_133_3 VPWR VGND VPWR VGND sky130_ef_sc_hd__decap_12
XFILLER_0_75_439 VGND VGND VPWR VPWR sky130_fd_sc_hd__decap_3
Xclkbuf_leaf_78_CLK clknet_3_3__leaf_CLK VGND VGND VPWR VPWR clknet_leaf_78_CLK sky130_fd_sc_hd__clkbuf_8
XFILLER_0_7_205 VPWR VGND VPWR VGND sky130_ef_sc_hd__decap_12
XFILLER_0_90_409 VGND VGND VPWR VPWR sky130_fd_sc_hd__decap_8
XFILLER_0_56_653 VPWR VGND VPWR VGND sky130_ef_sc_hd__decap_12
X_4751_ _1168_ _1520_ _1116_ VGND VGND VPWR VPWR _1521_ sky130_fd_sc_hd__o21a_1
XFILLER_0_56_697 VGND VGND VPWR VPWR sky130_fd_sc_hd__decap_3
XFILLER_0_55_163 VGND VGND VPWR VPWR sky130_fd_sc_hd__decap_4
X_4682_ _1454_ _1455_ _1145_ VGND VGND VPWR VPWR _1456_ sky130_fd_sc_hd__mux2_1
XFILLER_0_7_249 VPWR VGND VPWR VGND sky130_ef_sc_hd__decap_12
X_7470_ _2972_ rf.registers\[29\]\[27\] _3647_ VGND VGND VPWR VPWR _3655_ sky130_fd_sc_hd__mux2_1
XFILLER_0_44_837 VGND VGND VPWR VPWR sky130_fd_sc_hd__fill_2
XFILLER_0_114_725 VPWR VGND VPWR VGND sky130_ef_sc_hd__decap_12
X_6421_ _3069_ VGND VGND VPWR VPWR _0716_ sky130_fd_sc_hd__clkbuf_1
XFILLER_0_114_769 VPWR VGND VPWR VGND sky130_ef_sc_hd__decap_12
X_9140_ clknet_leaf_41_CLK _0228_ VGND VGND VPWR VPWR rf.registers\[2\]\[3\] sky130_fd_sc_hd__dfxtp_1
XFILLER_0_24_572 VPWR VGND VPWR VGND sky130_ef_sc_hd__decap_12
XFILLER_0_113_279 VGND VGND VPWR VPWR sky130_fd_sc_hd__fill_1
X_6352_ _3025_ VGND VGND VPWR VPWR _0691_ sky130_fd_sc_hd__clkbuf_1
X_9071_ clknet_leaf_62_CLK _0159_ VGND VGND VPWR VPWR rf.registers\[29\]\[30\] sky130_fd_sc_hd__dfxtp_1
X_5303_ _2042_ _2043_ _1747_ VGND VGND VPWR VPWR _2044_ sky130_fd_sc_hd__mux2_1
X_6283_ _2977_ VGND VGND VPWR VPWR _0670_ sky130_fd_sc_hd__clkbuf_1
X_5234_ rf.registers\[0\]\[18\] rf.registers\[1\]\[18\] rf.registers\[2\]\[18\] rf.registers\[3\]\[18\]
+ _1922_ _1923_ VGND VGND VPWR VPWR _1979_ sky130_fd_sc_hd__mux4_1
X_8022_ _2978_ rf.registers\[22\]\[30\] _3914_ VGND VGND VPWR VPWR _3948_ sky130_fd_sc_hd__mux2_1
X_5165_ _1693_ _1912_ _1660_ VGND VGND VPWR VPWR _1913_ sky130_fd_sc_hd__o21a_1
XFILLER_0_38_3 VPWR VGND VPWR VGND sky130_ef_sc_hd__decap_12
X_5096_ rf.registers\[8\]\[11\] rf.registers\[9\]\[11\] rf.registers\[10\]\[11\] rf.registers\[11\]\[11\]
+ _1734_ _1797_ VGND VGND VPWR VPWR _1848_ sky130_fd_sc_hd__mux4_1
XFILLER_0_75_95 VGND VGND VPWR VPWR sky130_fd_sc_hd__decap_6
X_8924_ clknet_leaf_31_CLK _0012_ VGND VGND VPWR VPWR rf.registers\[4\]\[11\] sky130_fd_sc_hd__dfxtp_1
XTAP_TAPCELL_ROW_27_707 VGND VPWR sky130_fd_sc_hd__tapvpwrvgnd_1
XFILLER_0_78_244 VGND VGND VPWR VPWR sky130_fd_sc_hd__decap_8
X_8855_ clknet_leaf_64_CLK _0967_ VGND VGND VPWR VPWR rf.registers\[6\]\[6\] sky130_fd_sc_hd__dfxtp_1
XFILLER_0_94_737 VPWR VGND VPWR VGND sky130_ef_sc_hd__decap_12
X_7806_ _3833_ VGND VGND VPWR VPWR _0313_ sky130_fd_sc_hd__clkbuf_1
XFILLER_0_137_839 VGND VGND VPWR VPWR sky130_fd_sc_hd__fill_1
X_8786_ clknet_leaf_44_CLK _0898_ VGND VGND VPWR VPWR rf.registers\[16\]\[1\] sky130_fd_sc_hd__dfxtp_1
XFILLER_0_93_225 VGND VGND VPWR VPWR sky130_fd_sc_hd__fill_1
Xclkbuf_leaf_69_CLK clknet_3_2__leaf_CLK VGND VGND VPWR VPWR clknet_leaf_69_CLK sky130_fd_sc_hd__clkbuf_8
X_5998_ _2708_ _2712_ VGND VGND VPWR VPWR _2713_ sky130_fd_sc_hd__and2b_1
X_4949_ net5 VGND VGND VPWR VPWR _1709_ sky130_fd_sc_hd__buf_4
XFILLER_0_19_366 VGND VGND VPWR VPWR sky130_fd_sc_hd__fill_2
X_7737_ _3397_ rf.registers\[30\]\[24\] _3792_ VGND VGND VPWR VPWR _3797_ sky130_fd_sc_hd__mux2_1
XFILLER_0_47_664 VGND VGND VPWR VPWR sky130_fd_sc_hd__decap_8
X_7668_ rf.registers\[2\]\[24\] _3328_ _3755_ VGND VGND VPWR VPWR _3760_ sky130_fd_sc_hd__mux2_1
XFILLER_0_35_837 VGND VGND VPWR VPWR sky130_fd_sc_hd__decap_3
X_9407_ clknet_leaf_25_CLK _0495_ VGND VGND VPWR VPWR rf.registers\[21\]\[14\] sky130_fd_sc_hd__dfxtp_1
X_6619_ rf.registers\[24\]\[7\] _3001_ _3168_ VGND VGND VPWR VPWR _3176_ sky130_fd_sc_hd__mux2_1
XFILLER_0_7_783 VGND VGND VPWR VPWR sky130_fd_sc_hd__fill_1
XTAP_TAPCELL_ROW_95_1731 VGND VPWR sky130_fd_sc_hd__tapvpwrvgnd_1
XTAP_TAPCELL_ROW_95_1720 VGND VPWR sky130_fd_sc_hd__tapvpwrvgnd_1
XFILLER_0_61_155 VGND VGND VPWR VPWR sky130_fd_sc_hd__decap_4
XFILLER_0_15_561 VPWR VGND VPWR VGND sky130_ef_sc_hd__decap_12
X_7599_ _3723_ VGND VGND VPWR VPWR _0216_ sky130_fd_sc_hd__clkbuf_1
X_9338_ clknet_leaf_47_CLK _0426_ VGND VGND VPWR VPWR rf.registers\[7\]\[9\] sky130_fd_sc_hd__dfxtp_1
X_9269_ clknet_leaf_54_CLK _0357_ VGND VGND VPWR VPWR rf.registers\[23\]\[4\] sky130_fd_sc_hd__dfxtp_1
XFILLER_0_30_553 VGND VGND VPWR VPWR sky130_fd_sc_hd__fill_1
XFILLER_0_100_430 VGND VGND VPWR VPWR sky130_fd_sc_hd__decap_4
XTAP_TAPCELL_ROW_7_410 VGND VPWR sky130_fd_sc_hd__tapvpwrvgnd_1
XFILLER_0_97_520 VGND VGND VPWR VPWR sky130_fd_sc_hd__fill_1
XTAP_TAPCELL_ROW_122_2127 VGND VPWR sky130_fd_sc_hd__tapvpwrvgnd_1
XFILLER_0_85_726 VGND VGND VPWR VPWR sky130_fd_sc_hd__fill_2
XFILLER_0_127_305 VPWR VGND VPWR VGND sky130_ef_sc_hd__decap_12
XTAP_TAPCELL_ROW_104_1860 VGND VPWR sky130_fd_sc_hd__tapvpwrvgnd_1
Xclkbuf_leaf_0_CLK clknet_3_0__leaf_CLK VGND VGND VPWR VPWR clknet_leaf_0_CLK sky130_fd_sc_hd__clkbuf_8
XFILLER_0_127_349 VPWR VGND VPWR VGND sky130_ef_sc_hd__decap_12
XFILLER_0_26_837 VGND VGND VPWR VPWR sky130_fd_sc_hd__fill_2
XFILLER_0_38_686 VPWR VGND VPWR VGND sky130_ef_sc_hd__decap_12
XFILLER_0_80_442 VPWR VGND VPWR VGND sky130_ef_sc_hd__decap_12
XTAP_TAPCELL_ROW_13_489 VGND VPWR sky130_fd_sc_hd__tapvpwrvgnd_1
XFILLER_0_135_393 VPWR VGND VPWR VGND sky130_ef_sc_hd__decap_12
XTAP_TAPCELL_ROW_133_2289 VGND VPWR sky130_fd_sc_hd__tapvpwrvgnd_1
XFILLER_0_0_447 VGND VGND VPWR VPWR sky130_fd_sc_hd__fill_1
X_6970_ _3386_ rf.registers\[15\]\[19\] _3368_ VGND VGND VPWR VPWR _3387_ sky130_fd_sc_hd__mux2_1
XFILLER_0_45_43 VGND VGND VPWR VPWR sky130_fd_sc_hd__fill_1
XTAP_TAPCELL_ROW_49_1029 VGND VPWR sky130_fd_sc_hd__tapvpwrvgnd_1
X_5921_ _2633_ _2639_ _2421_ VGND VGND VPWR VPWR _2640_ sky130_fd_sc_hd__mux2_1
XFILLER_0_0_34 VGND VGND VPWR VPWR sky130_fd_sc_hd__fill_2
XFILLER_0_0_23 VGND VGND VPWR VPWR sky130_fd_sc_hd__decap_4
X_8640_ clknet_leaf_22_CLK _0752_ VGND VGND VPWR VPWR rf.registers\[17\]\[15\] sky130_fd_sc_hd__dfxtp_1
XFILLER_0_76_737 VPWR VGND VPWR VGND sky130_ef_sc_hd__decap_12
XFILLER_0_75_225 VGND VGND VPWR VPWR sky130_fd_sc_hd__fill_2
X_5852_ _2201_ _2473_ _2531_ _2392_ VGND VGND VPWR VPWR _2575_ sky130_fd_sc_hd__o31a_1
XFILLER_0_119_839 VGND VGND VPWR VPWR sky130_fd_sc_hd__fill_1
X_8571_ clknet_leaf_33_CLK _0683_ VGND VGND VPWR VPWR rf.registers\[12\]\[10\] sky130_fd_sc_hd__dfxtp_1
XFILLER_0_91_729 VPWR VGND VPWR VGND sky130_ef_sc_hd__decap_12
XTAP_TAPCELL_ROW_62_1229 VGND VPWR sky130_fd_sc_hd__tapvpwrvgnd_1
XFILLER_0_8_525 VGND VGND VPWR VPWR sky130_fd_sc_hd__decap_6
X_5783_ _2507_ _2508_ net103 VGND VGND VPWR VPWR _2509_ sky130_fd_sc_hd__mux2_1
X_4803_ _1569_ VGND VGND VPWR VPWR net101 sky130_fd_sc_hd__inv_2
X_7522_ _3682_ VGND VGND VPWR VPWR _0180_ sky130_fd_sc_hd__clkbuf_1
XFILLER_0_84_781 VPWR VGND VPWR VGND sky130_ef_sc_hd__decap_12
XFILLER_0_17_837 VGND VGND VPWR VPWR sky130_fd_sc_hd__decap_3
XTAP_TAPCELL_ROW_32_776 VGND VPWR sky130_fd_sc_hd__tapvpwrvgnd_1
X_4734_ rf.registers\[0\]\[24\] rf.registers\[1\]\[24\] rf.registers\[2\]\[24\] rf.registers\[3\]\[24\]
+ _1139_ _1140_ VGND VGND VPWR VPWR _1505_ sky130_fd_sc_hd__mux4_1
XTAP_TAPCELL_ROW_32_787 VGND VPWR sky130_fd_sc_hd__tapvpwrvgnd_1
X_7453_ _3386_ rf.registers\[29\]\[19\] _3636_ VGND VGND VPWR VPWR _3646_ sky130_fd_sc_hd__mux2_1
X_4665_ _1190_ _1439_ VGND VGND VPWR VPWR _1440_ sky130_fd_sc_hd__nand2_1
X_6404_ _3060_ VGND VGND VPWR VPWR _0708_ sky130_fd_sc_hd__clkbuf_1
X_7384_ rf.registers\[8\]\[19\] _3317_ _3599_ VGND VGND VPWR VPWR _3609_ sky130_fd_sc_hd__mux2_1
XTAP_TAPCELL_ROW_77_1450 VGND VPWR sky130_fd_sc_hd__tapvpwrvgnd_1
X_4596_ _1307_ _1362_ _1366_ _1370_ _1374_ VGND VGND VPWR VPWR _1375_ sky130_fd_sc_hd__a32o_4
XFILLER_0_12_531 VGND VGND VPWR VPWR sky130_fd_sc_hd__fill_1
X_6335_ net18 VGND VGND VPWR VPWR _3014_ sky130_fd_sc_hd__clkbuf_2
XTAP_TAPCELL_ROW_77_1461 VGND VPWR sky130_fd_sc_hd__tapvpwrvgnd_1
X_9123_ clknet_leaf_4_CLK _0211_ VGND VGND VPWR VPWR rf.registers\[27\]\[18\] sky130_fd_sc_hd__dfxtp_1
X_9054_ clknet_leaf_27_CLK _0142_ VGND VGND VPWR VPWR rf.registers\[29\]\[13\] sky130_fd_sc_hd__dfxtp_1
XFILLER_0_101_249 VGND VGND VPWR VPWR sky130_fd_sc_hd__fill_2
XTAP_TAPCELL_ROW_90_1650 VGND VPWR sky130_fd_sc_hd__tapvpwrvgnd_1
XFILLER_0_86_83 VGND VGND VPWR VPWR sky130_fd_sc_hd__fill_1
X_6266_ net9 net46 VGND VGND VPWR VPWR _2965_ sky130_fd_sc_hd__nand2_1
X_8005_ _3939_ VGND VGND VPWR VPWR _0406_ sky130_fd_sc_hd__clkbuf_1
X_5217_ _1961_ _1962_ _1955_ VGND VGND VPWR VPWR _1963_ sky130_fd_sc_hd__mux2_1
X_6197_ _2272_ _2284_ VGND VGND VPWR VPWR _2900_ sky130_fd_sc_hd__and2b_1
X_5148_ rf.registers\[4\]\[14\] rf.registers\[5\]\[14\] rf.registers\[6\]\[14\] rf.registers\[7\]\[14\]
+ _1703_ _1704_ VGND VGND VPWR VPWR _1897_ sky130_fd_sc_hd__mux4_1
X_5079_ _1830_ _1831_ _1663_ VGND VGND VPWR VPWR _1832_ sky130_fd_sc_hd__mux2_1
X_8907_ clknet_leaf_67_CLK _1019_ VGND VGND VPWR VPWR rf.registers\[5\]\[26\] sky130_fd_sc_hd__dfxtp_1
X_8838_ clknet_leaf_79_CLK _0950_ VGND VGND VPWR VPWR rf.registers\[15\]\[21\] sky130_fd_sc_hd__dfxtp_1
X_8769_ clknet_leaf_13_CLK _0881_ VGND VGND VPWR VPWR rf.registers\[0\]\[16\] sky130_fd_sc_hd__dfxtp_1
XFILLER_0_125_809 VPWR VGND VPWR VGND sky130_ef_sc_hd__decap_12
XFILLER_0_94_589 VGND VGND VPWR VPWR sky130_fd_sc_hd__decap_4
XFILLER_0_105_500 VGND VGND VPWR VPWR sky130_fd_sc_hd__fill_1
XFILLER_0_19_185 VGND VGND VPWR VPWR sky130_fd_sc_hd__fill_1
XTAP_TAPCELL_ROW_10_448 VGND VPWR sky130_fd_sc_hd__tapvpwrvgnd_1
XFILLER_0_132_363 VGND VGND VPWR VPWR sky130_fd_sc_hd__fill_1
XFILLER_0_15_380 VPWR VGND VPWR VGND sky130_ef_sc_hd__decap_12
XFILLER_0_101_783 VGND VGND VPWR VPWR sky130_fd_sc_hd__fill_1
XFILLER_0_106_15 VPWR VGND VPWR VGND sky130_ef_sc_hd__decap_12
XFILLER_0_57_203 VGND VGND VPWR VPWR sky130_fd_sc_hd__fill_2
XFILLER_0_15_57 VPWR VGND VPWR VGND sky130_ef_sc_hd__decap_12
XFILLER_0_97_372 VGND VGND VPWR VPWR sky130_fd_sc_hd__decap_6
XFILLER_0_58_737 VPWR VGND VPWR VGND sky130_ef_sc_hd__decap_12
XFILLER_0_127_113 VPWR VGND VPWR VGND sky130_ef_sc_hd__decap_12
XFILLER_0_73_718 VGND VGND VPWR VPWR sky130_fd_sc_hd__decap_8
XFILLER_0_73_729 VPWR VGND VPWR VGND sky130_ef_sc_hd__decap_12
XFILLER_0_66_781 VPWR VGND VPWR VGND sky130_ef_sc_hd__decap_12
XTAP_TAPCELL_ROW_135_2329 VGND VPWR sky130_fd_sc_hd__tapvpwrvgnd_1
XTAP_TAPCELL_ROW_135_2318 VGND VPWR sky130_fd_sc_hd__tapvpwrvgnd_1
XFILLER_0_115_308 VGND VGND VPWR VPWR sky130_fd_sc_hd__fill_2
XFILLER_0_5_517 VPWR VGND VPWR VGND sky130_ef_sc_hd__decap_12
XFILLER_0_53_464 VGND VGND VPWR VPWR sky130_fd_sc_hd__decap_8
XFILLER_0_13_317 VPWR VGND VPWR VGND sky130_ef_sc_hd__decap_12
XFILLER_0_41_604 VGND VGND VPWR VPWR sky130_fd_sc_hd__decap_4
X_4450_ rf.registers\[20\]\[9\] rf.registers\[21\]\[9\] rf.registers\[22\]\[9\] rf.registers\[23\]\[9\]
+ _1035_ _1036_ VGND VGND VPWR VPWR _1236_ sky130_fd_sc_hd__mux4_1
XFILLER_0_40_114 VGND VGND VPWR VPWR sky130_fd_sc_hd__fill_2
XFILLER_0_123_385 VGND VGND VPWR VPWR sky130_fd_sc_hd__decap_4
X_4381_ _1137_ _1170_ VGND VGND VPWR VPWR _1171_ sky130_fd_sc_hd__or2_1
XFILLER_0_1_723 VGND VGND VPWR VPWR sky130_fd_sc_hd__decap_4
XTAP_TAPCELL_ROW_59_1191 VGND VPWR sky130_fd_sc_hd__tapvpwrvgnd_1
XTAP_TAPCELL_ROW_59_1180 VGND VPWR sky130_fd_sc_hd__tapvpwrvgnd_1
X_6120_ _2818_ _2819_ _2827_ VGND VGND VPWR VPWR _2828_ sky130_fd_sc_hd__or3_1
XFILLER_0_0_277 VGND VGND VPWR VPWR sky130_fd_sc_hd__decap_3
XTAP_TAPCELL_ROW_72_1380 VGND VPWR sky130_fd_sc_hd__tapvpwrvgnd_1
X_6051_ _2361_ _2365_ VGND VGND VPWR VPWR _2763_ sky130_fd_sc_hd__nand2_1
X_5002_ rf.registers\[16\]\[6\] rf.registers\[17\]\[6\] rf.registers\[18\]\[6\] rf.registers\[19\]\[6\]
+ _1729_ _1731_ VGND VGND VPWR VPWR _1759_ sky130_fd_sc_hd__mux4_1
X_6953_ _3375_ VGND VGND VPWR VPWR _0942_ sky130_fd_sc_hd__clkbuf_1
XFILLER_0_72_41 VPWR VGND VPWR VGND sky130_ef_sc_hd__decap_12
XFILLER_0_49_704 VPWR VGND VPWR VGND sky130_ef_sc_hd__decap_12
XTAP_TAPCELL_ROW_37_857 VGND VPWR sky130_fd_sc_hd__tapvpwrvgnd_1
X_6884_ net30 VGND VGND VPWR VPWR _3328_ sky130_fd_sc_hd__buf_2
X_5904_ _2622_ _2623_ VGND VGND VPWR VPWR _2624_ sky130_fd_sc_hd__and2_1
X_8623_ clknet_leaf_61_CLK _0735_ VGND VGND VPWR VPWR rf.registers\[11\]\[30\] sky130_fd_sc_hd__dfxtp_1
X_5835_ _2541_ _2549_ _2558_ VGND VGND VPWR VPWR net142 sky130_fd_sc_hd__o21ai_1
XFILLER_0_119_669 VGND VGND VPWR VPWR sky130_fd_sc_hd__decap_3
XFILLER_0_107_809 VPWR VGND VPWR VGND sky130_ef_sc_hd__decap_12
XFILLER_0_91_526 VGND VGND VPWR VPWR sky130_fd_sc_hd__decap_4
XFILLER_0_76_589 VPWR VGND VPWR VGND sky130_ef_sc_hd__decap_12
XFILLER_0_8_333 VPWR VGND VPWR VGND sky130_ef_sc_hd__decap_12
XFILLER_0_17_612 VGND VGND VPWR VPWR sky130_fd_sc_hd__decap_4
XFILLER_0_133_105 VGND VGND VPWR VPWR sky130_fd_sc_hd__decap_6
XFILLER_0_91_548 VGND VGND VPWR VPWR sky130_fd_sc_hd__fill_1
XFILLER_0_8_377 VPWR VGND VPWR VGND sky130_ef_sc_hd__decap_12
XFILLER_0_16_133 VGND VGND VPWR VPWR sky130_fd_sc_hd__decap_6
X_8554_ clknet_leaf_71_CLK _0666_ VGND VGND VPWR VPWR rf.registers\[13\]\[25\] sky130_fd_sc_hd__dfxtp_1
X_5766_ _2490_ _2491_ _2233_ VGND VGND VPWR VPWR _2492_ sky130_fd_sc_hd__o21a_1
XFILLER_0_133_149 VPWR VGND VPWR VGND sky130_ef_sc_hd__decap_12
X_7505_ _3370_ rf.registers\[31\]\[11\] _3672_ VGND VGND VPWR VPWR _3674_ sky130_fd_sc_hd__mux2_1
X_8485_ _4193_ VGND VGND VPWR VPWR _0632_ sky130_fd_sc_hd__clkbuf_1
X_4717_ rf.registers\[0\]\[23\] rf.registers\[1\]\[23\] rf.registers\[2\]\[23\] rf.registers\[3\]\[23\]
+ _1382_ _1383_ VGND VGND VPWR VPWR _1489_ sky130_fd_sc_hd__mux4_1
X_5697_ net71 _2425_ VGND VGND VPWR VPWR _2426_ sky130_fd_sc_hd__xnor2_1
X_7436_ _3637_ VGND VGND VPWR VPWR _0139_ sky130_fd_sc_hd__clkbuf_1
X_4648_ _1397_ _1423_ _1293_ VGND VGND VPWR VPWR _1424_ sky130_fd_sc_hd__o21a_1
XFILLER_0_16_177 VPWR VGND VPWR VGND sky130_ef_sc_hd__decap_12
XFILLER_0_102_514 VGND VGND VPWR VPWR sky130_fd_sc_hd__decap_6
XFILLER_0_31_169 VGND VGND VPWR VPWR sky130_fd_sc_hd__fill_2
X_9106_ clknet_leaf_42_CLK _0194_ VGND VGND VPWR VPWR rf.registers\[27\]\[1\] sky130_fd_sc_hd__dfxtp_1
X_7367_ _3600_ VGND VGND VPWR VPWR _0107_ sky130_fd_sc_hd__clkbuf_1
X_4579_ _1358_ VGND VGND VPWR VPWR net87 sky130_fd_sc_hd__inv_2
X_7298_ rf.registers\[3\]\[10\] _3298_ _3563_ VGND VGND VPWR VPWR _3564_ sky130_fd_sc_hd__mux2_1
X_6318_ _3002_ VGND VGND VPWR VPWR _0680_ sky130_fd_sc_hd__clkbuf_1
XFILLER_0_40_692 VGND VGND VPWR VPWR sky130_fd_sc_hd__fill_1
X_9037_ clknet_leaf_91_CLK _0125_ VGND VGND VPWR VPWR rf.registers\[8\]\[28\] sky130_fd_sc_hd__dfxtp_1
X_6249_ _2946_ _2949_ VGND VGND VPWR VPWR _2950_ sky130_fd_sc_hd__xnor2_1
XFILLER_0_86_309 VGND VGND VPWR VPWR sky130_fd_sc_hd__fill_2
XFILLER_0_95_821 VPWR VGND VPWR VGND sky130_ef_sc_hd__decap_12
XFILLER_0_67_534 VPWR VGND VPWR VGND sky130_ef_sc_hd__decap_12
XFILLER_0_109_113 VGND VGND VPWR VPWR sky130_fd_sc_hd__fill_1
XFILLER_0_67_567 VPWR VGND VPWR VGND sky130_ef_sc_hd__decap_12
XTAP_TAPCELL_ROW_15_518 VGND VPWR sky130_fd_sc_hd__tapvpwrvgnd_1
XTAP_TAPCELL_ROW_15_529 VGND VPWR sky130_fd_sc_hd__tapvpwrvgnd_1
XFILLER_0_94_375 VGND VGND VPWR VPWR sky130_fd_sc_hd__decap_4
XFILLER_0_82_537 VGND VGND VPWR VPWR sky130_fd_sc_hd__fill_1
XFILLER_0_55_729 VPWR VGND VPWR VGND sky130_ef_sc_hd__decap_12
XFILLER_0_54_206 VGND VGND VPWR VPWR sky130_fd_sc_hd__decap_4
XFILLER_0_48_781 VPWR VGND VPWR VGND sky130_ef_sc_hd__decap_12
XTAP_TAPCELL_ROW_117_2048 VGND VPWR sky130_fd_sc_hd__tapvpwrvgnd_1
XFILLER_0_50_401 VGND VGND VPWR VPWR sky130_fd_sc_hd__decap_3
XTAP_TAPCELL_ROW_117_2059 VGND VPWR sky130_fd_sc_hd__tapvpwrvgnd_1
XFILLER_0_23_637 VGND VGND VPWR VPWR sky130_fd_sc_hd__decap_4
XFILLER_0_50_445 VGND VGND VPWR VPWR sky130_fd_sc_hd__fill_1
XTAP_TAPCELL_ROW_130_2248 VGND VPWR sky130_fd_sc_hd__tapvpwrvgnd_1
XFILLER_0_10_309 VPWR VGND VPWR VGND sky130_ef_sc_hd__decap_12
XTAP_TAPCELL_ROW_112_1981 VGND VPWR sky130_fd_sc_hd__tapvpwrvgnd_1
XFILLER_0_117_69 VPWR VGND VPWR VGND sky130_ef_sc_hd__decap_12
XFILLER_0_26_45 VGND VGND VPWR VPWR sky130_fd_sc_hd__fill_1
XTAP_TAPCELL_ROW_34_805 VGND VPWR sky130_fd_sc_hd__tapvpwrvgnd_1
XTAP_TAPCELL_ROW_34_816 VGND VPWR sky130_fd_sc_hd__tapvpwrvgnd_1
XFILLER_0_133_57 VPWR VGND VPWR VGND sky130_ef_sc_hd__decap_12
XFILLER_0_97_191 VGND VGND VPWR VPWR sky130_fd_sc_hd__fill_1
XFILLER_0_58_589 VGND VGND VPWR VPWR sky130_fd_sc_hd__decap_8
XFILLER_0_39_781 VGND VGND VPWR VPWR sky130_fd_sc_hd__decap_3
XFILLER_0_46_729 VGND VGND VPWR VPWR sky130_fd_sc_hd__decap_3
XFILLER_0_115_105 VGND VGND VPWR VPWR sky130_fd_sc_hd__decap_6
XFILLER_0_73_559 VGND VGND VPWR VPWR sky130_fd_sc_hd__fill_1
XFILLER_0_6_837 VGND VGND VPWR VPWR sky130_fd_sc_hd__fill_2
X_5620_ _1727_ _2219_ _2243_ VGND VGND VPWR VPWR _2350_ sky130_fd_sc_hd__o21ai_1
XFILLER_0_116_639 VGND VGND VPWR VPWR sky130_fd_sc_hd__fill_2
X_5551_ _2234_ _2275_ _2281_ VGND VGND VPWR VPWR _2282_ sky130_fd_sc_hd__o21ai_1
XFILLER_0_115_149 VPWR VGND VPWR VGND sky130_ef_sc_hd__decap_12
X_4502_ rf.registers\[20\]\[12\] rf.registers\[21\]\[12\] rf.registers\[22\]\[12\]
+ rf.registers\[23\]\[12\] _1283_ _1284_ VGND VGND VPWR VPWR _1285_ sky130_fd_sc_hd__mux4_1
XFILLER_0_81_570 VGND VGND VPWR VPWR sky130_fd_sc_hd__fill_2
X_8270_ _4079_ VGND VGND VPWR VPWR _0531_ sky130_fd_sc_hd__clkbuf_1
XFILLER_0_53_272 VGND VGND VPWR VPWR sky130_fd_sc_hd__decap_8
XFILLER_0_13_125 VPWR VGND VPWR VGND sky130_ef_sc_hd__decap_12
XFILLER_0_26_497 VPWR VGND VPWR VGND sky130_ef_sc_hd__decap_12
X_7221_ rf.registers\[19\]\[6\] _3290_ _3516_ VGND VGND VPWR VPWR _3523_ sky130_fd_sc_hd__mux2_1
X_5482_ _1872_ _2207_ _2212_ VGND VGND VPWR VPWR _2213_ sky130_fd_sc_hd__o21ai_1
XFILLER_0_123_193 VPWR VGND VPWR VGND sky130_ef_sc_hd__decap_12
X_4433_ _1117_ _1212_ _1216_ _1220_ VGND VGND VPWR VPWR _1221_ sky130_fd_sc_hd__a2bb2o_1
XFILLER_0_1_553 VGND VGND VPWR VPWR sky130_fd_sc_hd__decap_6
XFILLER_0_13_169 VPWR VGND VPWR VGND sky130_ef_sc_hd__decap_12
X_4364_ _1152_ _1153_ _1154_ VGND VGND VPWR VPWR _1155_ sky130_fd_sc_hd__mux2_1
X_7152_ _3486_ VGND VGND VPWR VPWR _0006_ sky130_fd_sc_hd__clkbuf_1
XFILLER_0_67_30 VGND VGND VPWR VPWR sky130_fd_sc_hd__decap_4
X_4295_ rf.registers\[0\]\[2\] rf.registers\[1\]\[2\] rf.registers\[2\]\[2\] rf.registers\[3\]\[2\]
+ _1026_ _1027_ VGND VGND VPWR VPWR _1088_ sky130_fd_sc_hd__mux4_1
X_7083_ rf.registers\[5\]\[5\] _3288_ _3444_ VGND VGND VPWR VPWR _3450_ sky130_fd_sc_hd__mux2_1
XFILLER_0_6_77 VGND VGND VPWR VPWR sky130_fd_sc_hd__decap_6
XFILLER_0_1_597 VPWR VGND VPWR VGND sky130_ef_sc_hd__decap_12
X_6103_ _2769_ _2787_ VGND VGND VPWR VPWR _2812_ sky130_fd_sc_hd__nor2_1
X_6034_ _2421_ _2605_ VGND VGND VPWR VPWR _2747_ sky130_fd_sc_hd__or2_1
XFILLER_0_20_3 VPWR VGND VPWR VGND sky130_ef_sc_hd__decap_12
X_7985_ _3372_ rf.registers\[22\]\[12\] _3926_ VGND VGND VPWR VPWR _3929_ sky130_fd_sc_hd__mux2_1
X_6936_ _3363_ rf.registers\[15\]\[8\] _3347_ VGND VGND VPWR VPWR _3364_ sky130_fd_sc_hd__mux2_1
XFILLER_0_95_117 VGND VGND VPWR VPWR sky130_fd_sc_hd__decap_3
XFILLER_0_89_670 VGND VGND VPWR VPWR sky130_fd_sc_hd__fill_2
XFILLER_0_77_821 VPWR VGND VPWR VGND sky130_ef_sc_hd__decap_12
XTAP_TAPCELL_ROW_85_1582 VGND VPWR sky130_fd_sc_hd__tapvpwrvgnd_1
XTAP_TAPCELL_ROW_85_1571 VGND VPWR sky130_fd_sc_hd__tapvpwrvgnd_1
XFILLER_0_92_813 VPWR VGND VPWR VGND sky130_ef_sc_hd__decap_12
X_6867_ _3316_ VGND VGND VPWR VPWR _0915_ sky130_fd_sc_hd__clkbuf_1
XFILLER_0_37_729 VGND VGND VPWR VPWR sky130_fd_sc_hd__decap_6
X_8606_ clknet_leaf_29_CLK _0718_ VGND VGND VPWR VPWR rf.registers\[11\]\[13\] sky130_fd_sc_hd__dfxtp_1
X_5818_ net109 _2473_ _2531_ _2392_ VGND VGND VPWR VPWR _2542_ sky130_fd_sc_hd__o31a_1
XFILLER_0_8_141 VPWR VGND VPWR VGND sky130_ef_sc_hd__decap_12
XFILLER_0_17_431 VPWR VGND VPWR VGND sky130_ef_sc_hd__decap_12
X_6798_ rf.registers\[0\]\[27\] _3043_ _3263_ VGND VGND VPWR VPWR _3271_ sky130_fd_sc_hd__mux2_1
XFILLER_0_29_291 VGND VGND VPWR VPWR sky130_fd_sc_hd__fill_1
XFILLER_0_36_228 VGND VGND VPWR VPWR sky130_fd_sc_hd__decap_6
X_8537_ _4220_ VGND VGND VPWR VPWR _0657_ sky130_fd_sc_hd__clkbuf_1
X_5749_ net75 _2475_ VGND VGND VPWR VPWR _2476_ sky130_fd_sc_hd__xnor2_1
XFILLER_0_72_592 VGND VGND VPWR VPWR sky130_fd_sc_hd__decap_6
XFILLER_0_17_497 VGND VGND VPWR VPWR sky130_fd_sc_hd__decap_6
X_8468_ _4184_ VGND VGND VPWR VPWR _0624_ sky130_fd_sc_hd__clkbuf_1
XTAP_TAPCELL_ROW_20_598 VGND VPWR sky130_fd_sc_hd__tapvpwrvgnd_1
X_7419_ _3628_ VGND VGND VPWR VPWR _0131_ sky130_fd_sc_hd__clkbuf_1
X_8399_ rf.registers\[18\]\[15\] net20 _4142_ VGND VGND VPWR VPWR _4148_ sky130_fd_sc_hd__mux2_1
XFILLER_0_59_309 VGND VGND VPWR VPWR sky130_fd_sc_hd__decap_6
XTAP_TAPCELL_ROW_0_290 VGND VPWR sky130_fd_sc_hd__tapvpwrvgnd_1
XFILLER_0_138_753 VGND VGND VPWR VPWR sky130_fd_sc_hd__decap_3
XFILLER_0_138_797 VPWR VGND VPWR VGND sky130_ef_sc_hd__decap_12
XFILLER_0_125_447 VGND VGND VPWR VPWR sky130_fd_sc_hd__fill_1
XFILLER_0_63_581 VPWR VGND VPWR VGND sky130_ef_sc_hd__decap_12
XFILLER_0_35_261 VPWR VGND VPWR VGND sky130_ef_sc_hd__decap_12
XFILLER_0_88_29 VGND VGND VPWR VPWR sky130_fd_sc_hd__decap_6
XFILLER_0_51_765 VPWR VGND VPWR VGND sky130_ef_sc_hd__decap_12
Xoutput109 net109 VGND VGND VPWR VPWR RD2[6] sky130_fd_sc_hd__buf_1
XFILLER_0_120_141 VPWR VGND VPWR VGND sky130_ef_sc_hd__decap_12
XFILLER_0_10_139 VGND VGND VPWR VPWR sky130_fd_sc_hd__fill_1
XFILLER_0_121_697 VPWR VGND VPWR VGND sky130_ef_sc_hd__decap_12
Xoutput91 net91 VGND VGND VPWR VPWR RD2[19] sky130_fd_sc_hd__buf_1
Xoutput80 net80 VGND VGND VPWR VPWR RD1[9] sky130_fd_sc_hd__buf_1
XFILLER_0_37_55 VGND VGND VPWR VPWR sky130_fd_sc_hd__fill_1
XFILLER_0_77_106 VGND VGND VPWR VPWR sky130_fd_sc_hd__decap_6
XFILLER_0_59_821 VPWR VGND VPWR VGND sky130_ef_sc_hd__decap_12
X_7770_ _3814_ VGND VGND VPWR VPWR _0296_ sky130_fd_sc_hd__clkbuf_1
X_4982_ rf.registers\[20\]\[5\] rf.registers\[21\]\[5\] rf.registers\[22\]\[5\] rf.registers\[23\]\[5\]
+ _1730_ _1732_ VGND VGND VPWR VPWR _1740_ sky130_fd_sc_hd__mux4_1
XFILLER_0_129_753 VPWR VGND VPWR VGND sky130_ef_sc_hd__decap_12
XFILLER_0_86_695 VGND VGND VPWR VPWR sky130_fd_sc_hd__decap_4
XFILLER_0_86_662 VGND VGND VPWR VPWR sky130_fd_sc_hd__fill_2
XFILLER_0_74_813 VPWR VGND VPWR VGND sky130_ef_sc_hd__decap_12
X_6721_ _3230_ VGND VGND VPWR VPWR _0855_ sky130_fd_sc_hd__clkbuf_1
X_9440_ clknet_leaf_22_CLK _0528_ VGND VGND VPWR VPWR rf.registers\[25\]\[15\] sky130_fd_sc_hd__dfxtp_1
X_6652_ _3193_ VGND VGND VPWR VPWR _0823_ sky130_fd_sc_hd__clkbuf_1
XFILLER_0_129_797 VPWR VGND VPWR VGND sky130_ef_sc_hd__decap_12
X_9371_ clknet_leaf_26_CLK _0459_ VGND VGND VPWR VPWR rf.registers\[26\]\[10\] sky130_fd_sc_hd__dfxtp_1
XFILLER_0_5_111 VGND VGND VPWR VPWR sky130_fd_sc_hd__fill_1
X_5603_ _2330_ _2331_ _2332_ VGND VGND VPWR VPWR _2333_ sky130_fd_sc_hd__mux2_1
XFILLER_0_27_773 VGND VGND VPWR VPWR sky130_fd_sc_hd__decap_8
X_8322_ _4107_ VGND VGND VPWR VPWR _0555_ sky130_fd_sc_hd__clkbuf_1
X_6583_ _3156_ VGND VGND VPWR VPWR _0791_ sky130_fd_sc_hd__clkbuf_1
XFILLER_0_6_656 VGND VGND VPWR VPWR sky130_fd_sc_hd__decap_6
XFILLER_0_14_401 VPWR VGND VPWR VGND sky130_ef_sc_hd__decap_12
XFILLER_0_26_250 VGND VGND VPWR VPWR sky130_fd_sc_hd__fill_2
XFILLER_0_42_721 VGND VGND VPWR VPWR sky130_fd_sc_hd__decap_8
XFILLER_0_131_417 VPWR VGND VPWR VGND sky130_ef_sc_hd__decap_12
XFILLER_0_14_445 VPWR VGND VPWR VGND sky130_ef_sc_hd__decap_12
X_5534_ _2262_ _2264_ VGND VGND VPWR VPWR _2265_ sky130_fd_sc_hd__nor2_2
XFILLER_0_112_642 VGND VGND VPWR VPWR sky130_fd_sc_hd__fill_2
X_8253_ _3007_ rf.registers\[25\]\[10\] _4070_ VGND VGND VPWR VPWR _4071_ sky130_fd_sc_hd__mux2_1
X_5465_ net93 net94 net104 net105 VGND VGND VPWR VPWR _2196_ sky130_fd_sc_hd__or4_1
XFILLER_0_14_489 VPWR VGND VPWR VGND sky130_ef_sc_hd__decap_12
XFILLER_0_42_787 VPWR VGND VPWR VGND sky130_ef_sc_hd__decap_12
X_4416_ _1117_ _1189_ _1196_ _1204_ VGND VGND VPWR VPWR _1205_ sky130_fd_sc_hd__a2bb2o_2
X_8184_ _4022_ VGND VGND VPWR VPWR _4034_ sky130_fd_sc_hd__clkbuf_8
XFILLER_0_68_3 VPWR VGND VPWR VGND sky130_ef_sc_hd__decap_12
X_7204_ _3513_ VGND VGND VPWR VPWR _0031_ sky130_fd_sc_hd__clkbuf_1
XFILLER_0_1_361 VPWR VGND VPWR VGND sky130_ef_sc_hd__decap_12
XFILLER_0_100_837 VGND VGND VPWR VPWR sky130_fd_sc_hd__fill_2
X_7135_ rf.registers\[5\]\[30\] _3340_ _3443_ VGND VGND VPWR VPWR _3477_ sky130_fd_sc_hd__mux2_1
X_5396_ _2126_ _2128_ _2131_ _1948_ _1728_ VGND VGND VPWR VPWR _2132_ sky130_fd_sc_hd__o221a_1
X_4347_ _1026_ VGND VGND VPWR VPWR _1138_ sky130_fd_sc_hd__buf_4
X_4278_ _1070_ _1071_ net6 VGND VGND VPWR VPWR _1072_ sky130_fd_sc_hd__mux2_1
XFILLER_0_94_61 VGND VGND VPWR VPWR sky130_fd_sc_hd__fill_2
X_7066_ _3440_ VGND VGND VPWR VPWR _0990_ sky130_fd_sc_hd__clkbuf_1
XTAP_TAPCELL_ROW_87_1611 VGND VPWR sky130_fd_sc_hd__tapvpwrvgnd_1
XTAP_TAPCELL_ROW_87_1600 VGND VPWR sky130_fd_sc_hd__tapvpwrvgnd_1
X_6017_ _1375_ _2198_ _2646_ _2709_ VGND VGND VPWR VPWR _2731_ sky130_fd_sc_hd__a31o_1
XFILLER_0_68_106 VGND VGND VPWR VPWR sky130_fd_sc_hd__decap_6
X_7968_ _3355_ rf.registers\[22\]\[4\] _3915_ VGND VGND VPWR VPWR _3920_ sky130_fd_sc_hd__mux2_1
X_7899_ _3883_ VGND VGND VPWR VPWR _0356_ sky130_fd_sc_hd__clkbuf_1
X_6919_ _3352_ VGND VGND VPWR VPWR _0931_ sky130_fd_sc_hd__clkbuf_1
XFILLER_0_77_673 VPWR VGND VPWR VGND sky130_ef_sc_hd__decap_12
XFILLER_0_76_150 VPWR VGND VPWR VGND sky130_ef_sc_hd__decap_12
XFILLER_0_9_461 VPWR VGND VPWR VGND sky130_ef_sc_hd__decap_12
XTAP_TAPCELL_ROW_25_668 VGND VPWR sky130_fd_sc_hd__tapvpwrvgnd_1
XTAP_TAPCELL_ROW_25_679 VGND VPWR sky130_fd_sc_hd__tapvpwrvgnd_1
XFILLER_0_37_548 VGND VGND VPWR VPWR sky130_fd_sc_hd__decap_4
XFILLER_0_80_805 VGND VGND VPWR VPWR sky130_fd_sc_hd__decap_6
XFILLER_0_52_518 VGND VGND VPWR VPWR sky130_fd_sc_hd__decap_4
XFILLER_0_134_233 VPWR VGND VPWR VGND sky130_ef_sc_hd__decap_12
X_9569_ clknet_leaf_16_CLK _0657_ VGND VGND VPWR VPWR rf.registers\[13\]\[16\] sky130_fd_sc_hd__dfxtp_1
XFILLER_0_45_570 VPWR VGND VPWR VGND sky130_ef_sc_hd__decap_12
XFILLER_0_134_277 VPWR VGND VPWR VGND sky130_ef_sc_hd__decap_12
XTAP_TAPCELL_ROW_114_2007 VGND VPWR sky130_fd_sc_hd__tapvpwrvgnd_1
XTAP_TAPCELL_ROW_98_1773 VGND VPWR sky130_fd_sc_hd__tapvpwrvgnd_1
XFILLER_0_20_415 VGND VGND VPWR VPWR sky130_fd_sc_hd__decap_4
XFILLER_0_102_141 VGND VGND VPWR VPWR sky130_fd_sc_hd__fill_1
XFILLER_0_103_697 VPWR VGND VPWR VGND sky130_ef_sc_hd__decap_12
XTAP_TAPCELL_ROW_5_382 VGND VPWR sky130_fd_sc_hd__tapvpwrvgnd_1
XTAP_TAPCELL_ROW_5_371 VGND VPWR sky130_fd_sc_hd__tapvpwrvgnd_1
XTAP_TAPCELL_ROW_125_2169 VGND VPWR sky130_fd_sc_hd__tapvpwrvgnd_1
XFILLER_0_59_117 VGND VGND VPWR VPWR sky130_fd_sc_hd__fill_1
XFILLER_0_114_15 VPWR VGND VPWR VGND sky130_ef_sc_hd__decap_12
XFILLER_0_56_813 VPWR VGND VPWR VGND sky130_ef_sc_hd__decap_12
XTAP_TAPCELL_ROW_44_955 VGND VPWR sky130_fd_sc_hd__tapvpwrvgnd_1
XTAP_TAPCELL_ROW_44_966 VGND VPWR sky130_fd_sc_hd__tapvpwrvgnd_1
XFILLER_0_138_561 VPWR VGND VPWR VGND sky130_ef_sc_hd__decap_12
XFILLER_0_135_7 VPWR VGND VPWR VGND sky130_ef_sc_hd__decap_12
XFILLER_0_126_701 VPWR VGND VPWR VGND sky130_ef_sc_hd__decap_12
XFILLER_0_23_57 VGND VGND VPWR VPWR sky130_fd_sc_hd__decap_4
XFILLER_0_36_570 VPWR VGND VPWR VGND sky130_ef_sc_hd__decap_12
XFILLER_0_3_615 VGND VGND VPWR VPWR sky130_fd_sc_hd__fill_1
XFILLER_0_51_573 VGND VGND VPWR VPWR sky130_fd_sc_hd__fill_2
X_5250_ rf.registers\[8\]\[19\] rf.registers\[9\]\[19\] rf.registers\[10\]\[19\] rf.registers\[11\]\[19\]
+ _1749_ _1750_ VGND VGND VPWR VPWR _1994_ sky130_fd_sc_hd__mux4_1
XTAP_TAPCELL_ROW_54_1109 VGND VPWR sky130_fd_sc_hd__tapvpwrvgnd_1
X_5181_ _1921_ _1924_ _1925_ _1926_ _1927_ _1771_ VGND VGND VPWR VPWR _1928_ sky130_fd_sc_hd__mux4_2
XFILLER_0_3_45 VGND VGND VPWR VPWR sky130_fd_sc_hd__decap_8
X_8940_ clknet_leaf_85_CLK _0028_ VGND VGND VPWR VPWR rf.registers\[4\]\[27\] sky130_fd_sc_hd__dfxtp_1
XTAP_TAPCELL_ROW_69_1330 VGND VPWR sky130_fd_sc_hd__tapvpwrvgnd_1
XTAP_TAPCELL_ROW_69_1341 VGND VPWR sky130_fd_sc_hd__tapvpwrvgnd_1
X_8871_ clknet_leaf_1_CLK _0983_ VGND VGND VPWR VPWR rf.registers\[6\]\[22\] sky130_fd_sc_hd__dfxtp_1
X_7822_ _3841_ VGND VGND VPWR VPWR _3842_ sky130_fd_sc_hd__clkbuf_8
X_4965_ rf.registers\[0\]\[4\] rf.registers\[1\]\[4\] rf.registers\[2\]\[4\] rf.registers\[3\]\[4\]
+ _1655_ _1656_ VGND VGND VPWR VPWR _1724_ sky130_fd_sc_hd__mux4_1
XTAP_TAPCELL_ROW_82_1530 VGND VPWR sky130_fd_sc_hd__tapvpwrvgnd_1
XFILLER_0_80_41 VPWR VGND VPWR VGND sky130_ef_sc_hd__decap_12
X_7753_ _3091_ _3053_ VGND VGND VPWR VPWR _3805_ sky130_fd_sc_hd__nor2_2
XFILLER_0_59_673 VPWR VGND VPWR VGND sky130_ef_sc_hd__decap_12
X_6704_ _3221_ VGND VGND VPWR VPWR _0847_ sky130_fd_sc_hd__clkbuf_1
XFILLER_0_74_643 VGND VGND VPWR VPWR sky130_fd_sc_hd__fill_1
X_4896_ _1654_ _1657_ _1630_ VGND VGND VPWR VPWR _1658_ sky130_fd_sc_hd__mux2_1
XFILLER_0_80_96 VGND VGND VPWR VPWR sky130_fd_sc_hd__decap_8
X_7684_ net9 net46 net10 VGND VGND VPWR VPWR _3768_ sky130_fd_sc_hd__and3b_4
XFILLER_0_62_805 VGND VGND VPWR VPWR sky130_fd_sc_hd__decap_6
XFILLER_0_19_559 VGND VGND VPWR VPWR sky130_fd_sc_hd__fill_1
XTAP_TAPCELL_ROW_22_627 VGND VPWR sky130_fd_sc_hd__tapvpwrvgnd_1
X_9423_ clknet_leaf_67_CLK _0511_ VGND VGND VPWR VPWR rf.registers\[21\]\[30\] sky130_fd_sc_hd__dfxtp_1
XFILLER_0_116_244 VGND VGND VPWR VPWR sky130_fd_sc_hd__decap_8
XFILLER_0_116_233 VGND VGND VPWR VPWR sky130_fd_sc_hd__decap_4
X_6635_ _3184_ VGND VGND VPWR VPWR _0815_ sky130_fd_sc_hd__clkbuf_1
XFILLER_0_132_737 VPWR VGND VPWR VGND sky130_ef_sc_hd__decap_12
X_6566_ _3147_ VGND VGND VPWR VPWR _0783_ sky130_fd_sc_hd__clkbuf_1
XFILLER_0_6_475 VGND VGND VPWR VPWR sky130_fd_sc_hd__fill_1
X_9354_ clknet_leaf_68_CLK _0442_ VGND VGND VPWR VPWR rf.registers\[7\]\[25\] sky130_fd_sc_hd__dfxtp_1
X_8305_ _4098_ VGND VGND VPWR VPWR _0547_ sky130_fd_sc_hd__clkbuf_1
XFILLER_0_131_225 VPWR VGND VPWR VGND sky130_ef_sc_hd__decap_12
XFILLER_0_89_72 VGND VGND VPWR VPWR sky130_fd_sc_hd__decap_4
XFILLER_0_14_253 VPWR VGND VPWR VGND sky130_ef_sc_hd__decap_12
XFILLER_0_30_713 VPWR VGND VPWR VGND sky130_ef_sc_hd__decap_12
X_5517_ _2212_ _2247_ VGND VGND VPWR VPWR _2248_ sky130_fd_sc_hd__or2_1
X_9285_ clknet_leaf_82_CLK _0373_ VGND VGND VPWR VPWR rf.registers\[23\]\[20\] sky130_fd_sc_hd__dfxtp_1
X_8236_ _2991_ rf.registers\[25\]\[2\] _4059_ VGND VGND VPWR VPWR _4062_ sky130_fd_sc_hd__mux2_1
X_6497_ _3110_ VGND VGND VPWR VPWR _0751_ sky130_fd_sc_hd__clkbuf_1
XFILLER_0_112_483 VGND VGND VPWR VPWR sky130_fd_sc_hd__fill_1
X_5448_ rf.registers\[24\]\[31\] rf.registers\[25\]\[31\] rf.registers\[26\]\[31\]
+ rf.registers\[27\]\[31\] _2109_ _2110_ VGND VGND VPWR VPWR _2180_ sky130_fd_sc_hd__mux4_1
XFILLER_0_2_681 VPWR VGND VPWR VGND sky130_ef_sc_hd__decap_12
X_8167_ _4025_ VGND VGND VPWR VPWR _0482_ sky130_fd_sc_hd__clkbuf_1
XFILLER_0_100_645 VGND VGND VPWR VPWR sky130_fd_sc_hd__decap_6
XTAP_TAPCELL_ROW_93_1692 VGND VPWR sky130_fd_sc_hd__tapvpwrvgnd_1
X_5379_ rf.registers\[12\]\[26\] rf.registers\[13\]\[26\] rf.registers\[14\]\[26\]
+ rf.registers\[15\]\[26\] _2070_ _2071_ VGND VGND VPWR VPWR _2116_ sky130_fd_sc_hd__mux4_1
X_8098_ _3349_ rf.registers\[26\]\[1\] _3987_ VGND VGND VPWR VPWR _3989_ sky130_fd_sc_hd__mux2_1
X_7118_ _3468_ VGND VGND VPWR VPWR _1014_ sky130_fd_sc_hd__clkbuf_1
X_7049_ rf.registers\[6\]\[21\] _3322_ _3430_ VGND VGND VPWR VPWR _3432_ sky130_fd_sc_hd__mux2_1
XTAP_TAPCELL_ROW_2_330 VGND VPWR sky130_fd_sc_hd__tapvpwrvgnd_1
XPHY_EDGE_ROW_29_Right_29 VGND VGND VPWR VPWR sky130_fd_sc_hd__decap_3
XFILLER_0_84_429 VPWR VGND VPWR VGND sky130_ef_sc_hd__decap_12
XFILLER_0_38_802 VGND VGND VPWR VPWR sky130_fd_sc_hd__decap_8
XFILLER_0_38_813 VPWR VGND VPWR VGND sky130_ef_sc_hd__decap_12
XFILLER_0_108_701 VPWR VGND VPWR VGND sky130_ef_sc_hd__decap_12
XTAP_TAPCELL_ROW_41_914 VGND VPWR sky130_fd_sc_hd__tapvpwrvgnd_1
XTAP_TAPCELL_ROW_120_2099 VGND VPWR sky130_fd_sc_hd__tapvpwrvgnd_1
XFILLER_0_80_602 VGND VGND VPWR VPWR sky130_fd_sc_hd__fill_1
XFILLER_0_65_665 VGND VGND VPWR VPWR sky130_fd_sc_hd__decap_6
XFILLER_0_25_529 VPWR VGND VPWR VGND sky130_ef_sc_hd__decap_12
XPHY_EDGE_ROW_38_Right_38 VGND VGND VPWR VPWR sky130_fd_sc_hd__decap_3
XFILLER_0_135_597 VPWR VGND VPWR VGND sky130_ef_sc_hd__decap_12
XFILLER_0_80_668 VPWR VGND VPWR VGND sky130_ef_sc_hd__decap_12
XFILLER_0_64_197 VGND VGND VPWR VPWR sky130_fd_sc_hd__fill_1
XTAP_TAPCELL_ROW_127_2209 VGND VPWR sky130_fd_sc_hd__tapvpwrvgnd_1
XFILLER_0_109_15 VPWR VGND VPWR VGND sky130_ef_sc_hd__decap_12
XPHY_EDGE_ROW_47_Right_47 VGND VGND VPWR VPWR sky130_fd_sc_hd__decap_3
XTAP_TAPCELL_ROW_109_1931 VGND VPWR sky130_fd_sc_hd__tapvpwrvgnd_1
XTAP_TAPCELL_ROW_109_1942 VGND VPWR sky130_fd_sc_hd__tapvpwrvgnd_1
XFILLER_0_88_713 VPWR VGND VPWR VGND sky130_ef_sc_hd__decap_12
XFILLER_0_88_757 VPWR VGND VPWR VGND sky130_ef_sc_hd__decap_12
XFILLER_0_125_69 VPWR VGND VPWR VGND sky130_ef_sc_hd__decap_12
XTAP_TAPCELL_ROW_64_1260 VGND VPWR sky130_fd_sc_hd__tapvpwrvgnd_1
XFILLER_0_56_632 VGND VGND VPWR VPWR sky130_fd_sc_hd__fill_1
XFILLER_0_28_323 VGND VGND VPWR VPWR sky130_fd_sc_hd__fill_1
XFILLER_0_126_3 VPWR VGND VPWR VGND sky130_ef_sc_hd__decap_12
XPHY_EDGE_ROW_56_Right_56 VGND VGND VPWR VPWR sky130_fd_sc_hd__decap_3
XFILLER_0_56_665 VPWR VGND VPWR VGND sky130_ef_sc_hd__decap_12
XFILLER_0_7_217 VGND VGND VPWR VPWR sky130_fd_sc_hd__decap_6
X_4750_ _1518_ _1519_ _1154_ VGND VGND VPWR VPWR _1520_ sky130_fd_sc_hd__mux2_1
XFILLER_0_71_613 VGND VGND VPWR VPWR sky130_fd_sc_hd__decap_3
X_4681_ rf.registers\[0\]\[21\] rf.registers\[1\]\[21\] rf.registers\[2\]\[21\] rf.registers\[3\]\[21\]
+ _1198_ _1199_ VGND VGND VPWR VPWR _1455_ sky130_fd_sc_hd__mux4_1
XFILLER_0_50_66 VGND VGND VPWR VPWR sky130_fd_sc_hd__fill_1
XFILLER_0_114_737 VPWR VGND VPWR VGND sky130_ef_sc_hd__decap_12
X_6420_ rf.registers\[11\]\[11\] _3010_ _3067_ VGND VGND VPWR VPWR _3069_ sky130_fd_sc_hd__mux2_1
XFILLER_0_71_668 VGND VGND VPWR VPWR sky130_fd_sc_hd__decap_4
XFILLER_0_55_197 VGND VGND VPWR VPWR sky130_fd_sc_hd__fill_1
XFILLER_0_113_225 VGND VGND VPWR VPWR sky130_fd_sc_hd__fill_1
X_6351_ rf.registers\[12\]\[18\] _3024_ _3008_ VGND VGND VPWR VPWR _3025_ sky130_fd_sc_hd__mux2_1
XFILLER_0_59_31 VPWR VGND VPWR VGND sky130_ef_sc_hd__decap_12
XFILLER_0_11_223 VGND VGND VPWR VPWR sky130_fd_sc_hd__fill_1
XFILLER_0_12_735 VGND VGND VPWR VPWR sky130_fd_sc_hd__fill_1
XFILLER_0_24_584 VGND VGND VPWR VPWR sky130_fd_sc_hd__decap_4
X_5302_ rf.registers\[0\]\[22\] rf.registers\[1\]\[22\] rf.registers\[2\]\[22\] rf.registers\[3\]\[22\]
+ _1772_ _1773_ VGND VGND VPWR VPWR _2043_ sky130_fd_sc_hd__mux4_1
XFILLER_0_122_781 VPWR VGND VPWR VGND sky130_ef_sc_hd__decap_12
XFILLER_0_12_757 VPWR VGND VPWR VGND sky130_ef_sc_hd__decap_12
X_9070_ clknet_leaf_93_CLK _0158_ VGND VGND VPWR VPWR rf.registers\[29\]\[29\] sky130_fd_sc_hd__dfxtp_1
X_6282_ _2976_ rf.registers\[13\]\[29\] _2968_ VGND VGND VPWR VPWR _2977_ sky130_fd_sc_hd__mux2_1
X_5233_ rf.registers\[4\]\[18\] rf.registers\[5\]\[18\] rf.registers\[6\]\[18\] rf.registers\[7\]\[18\]
+ _1922_ _1923_ VGND VGND VPWR VPWR _1978_ sky130_fd_sc_hd__mux4_1
XPHY_EDGE_ROW_65_Right_65 VGND VGND VPWR VPWR sky130_fd_sc_hd__decap_3
X_8021_ _3947_ VGND VGND VPWR VPWR _0414_ sky130_fd_sc_hd__clkbuf_1
X_5164_ rf.registers\[0\]\[15\] rf.registers\[1\]\[15\] rf.registers\[2\]\[15\] rf.registers\[3\]\[15\]
+ _1699_ _1700_ VGND VGND VPWR VPWR _1912_ sky130_fd_sc_hd__mux4_1
XFILLER_0_75_30 VPWR VGND VPWR VGND sky130_ef_sc_hd__decap_12
X_5095_ _1843_ _1844_ _1845_ _1846_ _1693_ _1660_ VGND VGND VPWR VPWR _1847_ sky130_fd_sc_hd__mux4_1
XFILLER_0_75_74 VPWR VGND VPWR VGND sky130_ef_sc_hd__decap_12
X_8923_ clknet_leaf_32_CLK _0011_ VGND VGND VPWR VPWR rf.registers\[4\]\[10\] sky130_fd_sc_hd__dfxtp_1
XFILLER_0_78_212 VGND VGND VPWR VPWR sky130_fd_sc_hd__decap_4
XTAP_TAPCELL_ROW_27_708 VGND VPWR sky130_fd_sc_hd__tapvpwrvgnd_1
XFILLER_0_91_51 VGND VGND VPWR VPWR sky130_fd_sc_hd__fill_2
X_8854_ clknet_leaf_51_CLK _0966_ VGND VGND VPWR VPWR rf.registers\[6\]\[5\] sky130_fd_sc_hd__dfxtp_1
XFILLER_0_66_407 VGND VGND VPWR VPWR sky130_fd_sc_hd__decap_8
X_7805_ rf.registers\[9\]\[24\] _3328_ _3828_ VGND VGND VPWR VPWR _3833_ sky130_fd_sc_hd__mux2_1
X_8785_ clknet_leaf_39_CLK _0897_ VGND VGND VPWR VPWR rf.registers\[16\]\[0\] sky130_fd_sc_hd__dfxtp_1
XFILLER_0_94_749 VGND VGND VPWR VPWR sky130_fd_sc_hd__decap_6
XPHY_EDGE_ROW_74_Right_74 VGND VGND VPWR VPWR sky130_fd_sc_hd__decap_3
X_5997_ net56 _2711_ VGND VGND VPWR VPWR _2712_ sky130_fd_sc_hd__xnor2_1
XFILLER_0_47_610 VGND VGND VPWR VPWR sky130_fd_sc_hd__fill_2
X_4948_ _1705_ _1706_ _1707_ VGND VGND VPWR VPWR _1708_ sky130_fd_sc_hd__mux2_1
X_7736_ _3796_ VGND VGND VPWR VPWR _0280_ sky130_fd_sc_hd__clkbuf_1
XFILLER_0_129_391 VGND VGND VPWR VPWR sky130_fd_sc_hd__fill_1
X_4879_ _1634_ _1637_ _1640_ _1641_ net5 VGND VGND VPWR VPWR _1642_ sky130_fd_sc_hd__a221o_1
XFILLER_0_117_542 VGND VGND VPWR VPWR sky130_fd_sc_hd__decap_3
X_7667_ _3759_ VGND VGND VPWR VPWR _0248_ sky130_fd_sc_hd__clkbuf_1
XFILLER_0_46_153 VGND VGND VPWR VPWR sky130_fd_sc_hd__fill_1
XFILLER_0_46_175 VGND VGND VPWR VPWR sky130_fd_sc_hd__decap_6
X_9406_ clknet_leaf_27_CLK _0494_ VGND VGND VPWR VPWR rf.registers\[21\]\[13\] sky130_fd_sc_hd__dfxtp_1
X_6618_ _3175_ VGND VGND VPWR VPWR _0807_ sky130_fd_sc_hd__clkbuf_1
XFILLER_0_46_197 VGND VGND VPWR VPWR sky130_fd_sc_hd__decap_8
XTAP_TAPCELL_ROW_95_1721 VGND VPWR sky130_fd_sc_hd__tapvpwrvgnd_1
XFILLER_0_15_573 VPWR VGND VPWR VGND sky130_ef_sc_hd__decap_12
X_7598_ _3395_ rf.registers\[27\]\[23\] _3719_ VGND VGND VPWR VPWR _3723_ sky130_fd_sc_hd__mux2_1
X_9337_ clknet_leaf_47_CLK _0425_ VGND VGND VPWR VPWR rf.registers\[7\]\[8\] sky130_fd_sc_hd__dfxtp_1
XTAP_TAPCELL_ROW_95_1732 VGND VPWR sky130_fd_sc_hd__tapvpwrvgnd_1
X_6549_ _3138_ VGND VGND VPWR VPWR _0775_ sky130_fd_sc_hd__clkbuf_1
XFILLER_0_70_690 VGND VGND VPWR VPWR sky130_fd_sc_hd__decap_8
X_9268_ clknet_leaf_38_CLK _0356_ VGND VGND VPWR VPWR rf.registers\[23\]\[3\] sky130_fd_sc_hd__dfxtp_1
XPHY_EDGE_ROW_83_Right_83 VGND VGND VPWR VPWR sky130_fd_sc_hd__decap_3
XPHY_EDGE_ROW_18_Left_157 VGND VGND VPWR VPWR sky130_fd_sc_hd__decap_3
X_9199_ clknet_leaf_74_CLK _0287_ VGND VGND VPWR VPWR rf.registers\[30\]\[30\] sky130_fd_sc_hd__dfxtp_1
XTAP_TAPCELL_ROW_7_411 VGND VPWR sky130_fd_sc_hd__tapvpwrvgnd_1
XTAP_TAPCELL_ROW_7_400 VGND VPWR sky130_fd_sc_hd__tapvpwrvgnd_1
X_8219_ _4052_ VGND VGND VPWR VPWR _0507_ sky130_fd_sc_hd__clkbuf_1
XTAP_TAPCELL_ROW_122_2128 VGND VPWR sky130_fd_sc_hd__tapvpwrvgnd_1
XFILLER_0_69_223 VGND VGND VPWR VPWR sky130_fd_sc_hd__fill_1
XPHY_EDGE_ROW_92_Right_92 VGND VGND VPWR VPWR sky130_fd_sc_hd__decap_3
XPHY_EDGE_ROW_27_Left_166 VGND VGND VPWR VPWR sky130_fd_sc_hd__decap_3
XPHY_EDGE_ROW_133_Right_133 VGND VGND VPWR VPWR sky130_fd_sc_hd__decap_3
XTAP_TAPCELL_ROW_104_1861 VGND VPWR sky130_fd_sc_hd__tapvpwrvgnd_1
XFILLER_0_38_610 VGND VGND VPWR VPWR sky130_fd_sc_hd__decap_6
XFILLER_0_127_317 VPWR VGND VPWR VGND sky130_ef_sc_hd__decap_12
XFILLER_0_26_805 VGND VGND VPWR VPWR sky130_fd_sc_hd__decap_6
XFILLER_0_80_410 VGND VGND VPWR VPWR sky130_fd_sc_hd__decap_8
XFILLER_0_38_698 VGND VGND VPWR VPWR sky130_fd_sc_hd__fill_2
XTAP_TAPCELL_ROW_137_2360 VGND VPWR sky130_fd_sc_hd__tapvpwrvgnd_1
XFILLER_0_135_361 VPWR VGND VPWR VGND sky130_ef_sc_hd__decap_12
XFILLER_0_108_586 VGND VGND VPWR VPWR sky130_fd_sc_hd__fill_2
XFILLER_0_80_421 VGND VGND VPWR VPWR sky130_fd_sc_hd__fill_1
XFILLER_0_53_646 VGND VGND VPWR VPWR sky130_fd_sc_hd__decap_8
XFILLER_0_4_209 VPWR VGND VPWR VGND sky130_ef_sc_hd__decap_12
XFILLER_0_25_337 VGND VGND VPWR VPWR sky130_fd_sc_hd__decap_3
XFILLER_0_80_454 VGND VGND VPWR VPWR sky130_fd_sc_hd__decap_6
XFILLER_0_52_156 VGND VGND VPWR VPWR sky130_fd_sc_hd__fill_2
XFILLER_0_111_729 VPWR VGND VPWR VGND sky130_ef_sc_hd__decap_12
XPHY_EDGE_ROW_36_Left_175 VGND VGND VPWR VPWR sky130_fd_sc_hd__decap_3
XFILLER_0_104_781 VPWR VGND VPWR VGND sky130_ef_sc_hd__decap_12
XFILLER_0_96_29 VPWR VGND VPWR VGND sky130_ef_sc_hd__decap_12
X_5920_ _2563_ _2638_ _2416_ VGND VGND VPWR VPWR _2639_ sky130_fd_sc_hd__mux2_1
XPHY_EDGE_ROW_45_Left_184 VGND VGND VPWR VPWR sky130_fd_sc_hd__decap_3
XFILLER_0_76_749 VGND VGND VPWR VPWR sky130_fd_sc_hd__decap_6
X_5851_ _2238_ _2571_ _2573_ _2295_ VGND VGND VPWR VPWR _2574_ sky130_fd_sc_hd__a2bb2o_1
XFILLER_0_0_57 VGND VGND VPWR VPWR sky130_fd_sc_hd__fill_1
XFILLER_0_118_328 VGND VGND VPWR VPWR sky130_fd_sc_hd__fill_2
X_8570_ clknet_leaf_34_CLK _0682_ VGND VGND VPWR VPWR rf.registers\[12\]\[9\] sky130_fd_sc_hd__dfxtp_1
XPHY_EDGE_ROW_100_Right_100 VGND VGND VPWR VPWR sky130_fd_sc_hd__decap_3
XFILLER_0_61_76 VGND VGND VPWR VPWR sky130_fd_sc_hd__fill_2
X_5782_ _2363_ _2366_ _2304_ VGND VGND VPWR VPWR _2508_ sky130_fd_sc_hd__mux2_1
X_4802_ _1307_ _1560_ _1564_ _1568_ VGND VGND VPWR VPWR _1569_ sky130_fd_sc_hd__o2bb2a_2
X_7521_ _3386_ rf.registers\[31\]\[19\] _3672_ VGND VGND VPWR VPWR _3682_ sky130_fd_sc_hd__mux2_1
XFILLER_0_84_793 VPWR VGND VPWR VGND sky130_ef_sc_hd__decap_12
X_4733_ rf.registers\[4\]\[24\] rf.registers\[5\]\[24\] rf.registers\[6\]\[24\] rf.registers\[7\]\[24\]
+ _1139_ _1140_ VGND VGND VPWR VPWR _1504_ sky130_fd_sc_hd__mux4_1
XFILLER_0_44_602 VGND VGND VPWR VPWR sky130_fd_sc_hd__decap_4
XFILLER_0_83_281 VGND VGND VPWR VPWR sky130_fd_sc_hd__decap_4
X_7452_ _3645_ VGND VGND VPWR VPWR _0147_ sky130_fd_sc_hd__clkbuf_1
XTAP_TAPCELL_ROW_32_777 VGND VPWR sky130_fd_sc_hd__tapvpwrvgnd_1
X_6403_ rf.registers\[11\]\[3\] _2993_ _3056_ VGND VGND VPWR VPWR _3060_ sky130_fd_sc_hd__mux2_1
X_4664_ _1437_ _1438_ _1137_ VGND VGND VPWR VPWR _1439_ sky130_fd_sc_hd__mux2_1
XPHY_EDGE_ROW_54_Left_193 VGND VGND VPWR VPWR sky130_fd_sc_hd__decap_3
XFILLER_0_9_55 VGND VGND VPWR VPWR sky130_fd_sc_hd__fill_1
X_4595_ _1190_ _1373_ _1203_ VGND VGND VPWR VPWR _1374_ sky130_fd_sc_hd__a21oi_1
X_7383_ _3608_ VGND VGND VPWR VPWR _0115_ sky130_fd_sc_hd__clkbuf_1
X_6334_ _3013_ VGND VGND VPWR VPWR _0685_ sky130_fd_sc_hd__clkbuf_1
XTAP_TAPCELL_ROW_77_1462 VGND VPWR sky130_fd_sc_hd__tapvpwrvgnd_1
XTAP_TAPCELL_ROW_77_1451 VGND VPWR sky130_fd_sc_hd__tapvpwrvgnd_1
X_9122_ clknet_leaf_10_CLK _0210_ VGND VGND VPWR VPWR rf.registers\[27\]\[17\] sky130_fd_sc_hd__dfxtp_1
X_9053_ clknet_leaf_25_CLK _0141_ VGND VGND VPWR VPWR rf.registers\[29\]\[12\] sky130_fd_sc_hd__dfxtp_1
X_6265_ net13 net12 net11 VGND VGND VPWR VPWR _2964_ sky130_fd_sc_hd__and3b_2
XTAP_TAPCELL_ROW_90_1651 VGND VPWR sky130_fd_sc_hd__tapvpwrvgnd_1
X_5216_ rf.registers\[0\]\[17\] rf.registers\[1\]\[17\] rf.registers\[2\]\[17\] rf.registers\[3\]\[17\]
+ _1959_ _1960_ VGND VGND VPWR VPWR _1962_ sky130_fd_sc_hd__mux4_1
XFILLER_0_50_3 VPWR VGND VPWR VGND sky130_ef_sc_hd__decap_12
X_8004_ _3391_ rf.registers\[22\]\[21\] _3937_ VGND VGND VPWR VPWR _3939_ sky130_fd_sc_hd__mux2_1
X_6196_ _2293_ _2898_ _2326_ VGND VGND VPWR VPWR _2899_ sky130_fd_sc_hd__o21ai_1
X_5147_ _1894_ _1895_ _1663_ VGND VGND VPWR VPWR _1896_ sky130_fd_sc_hd__mux2_1
X_5078_ rf.registers\[24\]\[10\] rf.registers\[25\]\[10\] rf.registers\[26\]\[10\]
+ rf.registers\[27\]\[10\] _1652_ _1653_ VGND VGND VPWR VPWR _1831_ sky130_fd_sc_hd__mux4_1
XFILLER_0_98_307 VGND VGND VPWR VPWR sky130_fd_sc_hd__fill_1
X_8906_ clknet_leaf_68_CLK _1018_ VGND VGND VPWR VPWR rf.registers\[5\]\[25\] sky130_fd_sc_hd__dfxtp_1
XFILLER_0_67_727 VGND VGND VPWR VPWR sky130_fd_sc_hd__fill_1
X_8837_ clknet_leaf_9_CLK _0949_ VGND VGND VPWR VPWR rf.registers\[15\]\[20\] sky130_fd_sc_hd__dfxtp_1
XFILLER_0_137_615 VGND VGND VPWR VPWR sky130_fd_sc_hd__fill_1
X_8768_ clknet_leaf_16_CLK _0880_ VGND VGND VPWR VPWR rf.registers\[0\]\[15\] sky130_fd_sc_hd__dfxtp_1
X_7719_ _3787_ VGND VGND VPWR VPWR _0272_ sky130_fd_sc_hd__clkbuf_1
XFILLER_0_35_624 VGND VGND VPWR VPWR sky130_fd_sc_hd__decap_8
XFILLER_0_124_309 VPWR VGND VPWR VGND sky130_ef_sc_hd__decap_12
X_8699_ clknet_leaf_37_CLK _0811_ VGND VGND VPWR VPWR rf.registers\[24\]\[10\] sky130_fd_sc_hd__dfxtp_1
XFILLER_0_74_270 VGND VGND VPWR VPWR sky130_fd_sc_hd__fill_2
XFILLER_0_133_821 VPWR VGND VPWR VGND sky130_ef_sc_hd__decap_12
XTAP_TAPCELL_ROW_119_2090 VGND VPWR sky130_fd_sc_hd__tapvpwrvgnd_1
XFILLER_0_62_454 VGND VGND VPWR VPWR sky130_fd_sc_hd__decap_3
XFILLER_0_50_605 VGND VGND VPWR VPWR sky130_fd_sc_hd__decap_8
XTAP_TAPCELL_ROW_10_449 VGND VPWR sky130_fd_sc_hd__tapvpwrvgnd_1
XFILLER_0_105_567 VGND VGND VPWR VPWR sky130_fd_sc_hd__fill_1
XFILLER_0_31_841 VGND VGND VPWR VPWR sky130_fd_sc_hd__fill_1
XFILLER_0_106_27 VGND VGND VPWR VPWR sky130_fd_sc_hd__fill_1
XFILLER_0_58_749 VGND VGND VPWR VPWR sky130_fd_sc_hd__decap_6
XFILLER_0_15_69 VPWR VGND VPWR VGND sky130_ef_sc_hd__decap_12
XFILLER_0_127_125 VPWR VGND VPWR VGND sky130_ef_sc_hd__decap_12
XFILLER_0_122_15 VPWR VGND VPWR VGND sky130_ef_sc_hd__decap_12
XFILLER_0_72_229 VGND VGND VPWR VPWR sky130_fd_sc_hd__fill_1
XFILLER_0_72_218 VGND VGND VPWR VPWR sky130_fd_sc_hd__fill_2
XFILLER_0_72_207 VGND VGND VPWR VPWR sky130_fd_sc_hd__fill_2
XTAP_TAPCELL_ROW_135_2319 VGND VPWR sky130_fd_sc_hd__tapvpwrvgnd_1
XFILLER_0_127_169 VPWR VGND VPWR VGND sky130_ef_sc_hd__decap_12
XFILLER_0_81_741 VPWR VGND VPWR VGND sky130_ef_sc_hd__decap_12
XFILLER_0_66_793 VPWR VGND VPWR VGND sky130_ef_sc_hd__decap_12
XFILLER_0_65_281 VGND VGND VPWR VPWR sky130_fd_sc_hd__decap_6
XFILLER_0_65_270 VGND VGND VPWR VPWR sky130_fd_sc_hd__fill_1
XFILLER_0_5_529 VPWR VGND VPWR VGND sky130_ef_sc_hd__decap_12
XFILLER_0_31_57 VGND VGND VPWR VPWR sky130_fd_sc_hd__fill_1
XFILLER_0_136_681 VPWR VGND VPWR VGND sky130_ef_sc_hd__decap_12
XFILLER_0_81_785 VPWR VGND VPWR VGND sky130_ef_sc_hd__decap_12
XFILLER_0_80_251 VGND VGND VPWR VPWR sky130_fd_sc_hd__fill_1
XFILLER_0_26_668 VGND VGND VPWR VPWR sky130_fd_sc_hd__decap_3
XFILLER_0_13_329 VGND VGND VPWR VPWR sky130_fd_sc_hd__decap_6
XFILLER_0_123_397 VGND VGND VPWR VPWR sky130_fd_sc_hd__fill_2
X_4380_ rf.registers\[8\]\[5\] rf.registers\[9\]\[5\] rf.registers\[10\]\[5\] rf.registers\[11\]\[5\]
+ _1147_ _1149_ VGND VGND VPWR VPWR _1170_ sky130_fd_sc_hd__mux4_1
XTAP_TAPCELL_ROW_59_1192 VGND VPWR sky130_fd_sc_hd__tapvpwrvgnd_1
XTAP_TAPCELL_ROW_59_1181 VGND VPWR sky130_fd_sc_hd__tapvpwrvgnd_1
XFILLER_0_0_245 VGND VGND VPWR VPWR sky130_fd_sc_hd__fill_2
XFILLER_0_0_223 VGND VGND VPWR VPWR sky130_fd_sc_hd__fill_1
X_6050_ _2398_ _2760_ _2761_ VGND VGND VPWR VPWR _2762_ sky130_fd_sc_hd__or3_2
X_5001_ rf.registers\[20\]\[6\] rf.registers\[21\]\[6\] rf.registers\[22\]\[6\] rf.registers\[23\]\[6\]
+ _1729_ _1731_ VGND VGND VPWR VPWR _1758_ sky130_fd_sc_hd__mux4_1
XTAP_TAPCELL_ROW_72_1381 VGND VPWR sky130_fd_sc_hd__tapvpwrvgnd_1
XFILLER_0_89_841 VGND VGND VPWR VPWR sky130_fd_sc_hd__fill_1
X_6952_ _3374_ rf.registers\[15\]\[13\] _3368_ VGND VGND VPWR VPWR _3375_ sky130_fd_sc_hd__mux2_1
XFILLER_0_49_716 VPWR VGND VPWR VGND sky130_ef_sc_hd__decap_12
XTAP_TAPCELL_ROW_37_858 VGND VPWR sky130_fd_sc_hd__tapvpwrvgnd_1
XFILLER_0_72_53 VPWR VGND VPWR VGND sky130_ef_sc_hd__decap_12
X_5903_ _2614_ _2617_ _2612_ VGND VGND VPWR VPWR _2623_ sky130_fd_sc_hd__a21oi_1
X_6883_ _3327_ VGND VGND VPWR VPWR _0920_ sky130_fd_sc_hd__clkbuf_1
XFILLER_0_76_557 VGND VGND VPWR VPWR sky130_fd_sc_hd__decap_4
XFILLER_0_8_301 VGND VGND VPWR VPWR sky130_fd_sc_hd__decap_6
X_5834_ _2269_ _2551_ _2554_ _2463_ _2557_ VGND VGND VPWR VPWR _2558_ sky130_fd_sc_hd__o221a_1
XTAP_TAPCELL_ROW_17_560 VGND VPWR sky130_fd_sc_hd__tapvpwrvgnd_1
X_8622_ clknet_leaf_89_CLK _0734_ VGND VGND VPWR VPWR rf.registers\[11\]\[29\] sky130_fd_sc_hd__dfxtp_1
XFILLER_0_8_345 VPWR VGND VPWR VGND sky130_ef_sc_hd__decap_12
XFILLER_0_134_607 VPWR VGND VPWR VGND sky130_ef_sc_hd__decap_12
XFILLER_0_106_309 VGND VGND VPWR VPWR sky130_fd_sc_hd__fill_1
XPHY_EDGE_ROW_62_Left_201 VGND VGND VPWR VPWR sky130_fd_sc_hd__decap_3
X_5765_ _2243_ _2276_ VGND VGND VPWR VPWR _2491_ sky130_fd_sc_hd__nor2_1
XFILLER_0_44_421 VPWR VGND VPWR VGND sky130_ef_sc_hd__decap_12
X_8553_ _4228_ VGND VGND VPWR VPWR _0665_ sky130_fd_sc_hd__clkbuf_1
X_7504_ _3673_ VGND VGND VPWR VPWR _0171_ sky130_fd_sc_hd__clkbuf_1
XFILLER_0_115_821 VPWR VGND VPWR VGND sky130_ef_sc_hd__decap_12
XFILLER_0_98_3 VPWR VGND VPWR VGND sky130_ef_sc_hd__decap_12
X_8484_ _3035_ rf.registers\[14\]\[23\] _4189_ VGND VGND VPWR VPWR _4193_ sky130_fd_sc_hd__mux2_1
XFILLER_0_8_389 VPWR VGND VPWR VGND sky130_ef_sc_hd__decap_12
X_4716_ rf.registers\[4\]\[23\] rf.registers\[5\]\[23\] rf.registers\[6\]\[23\] rf.registers\[7\]\[23\]
+ _1393_ _1394_ VGND VGND VPWR VPWR _1488_ sky130_fd_sc_hd__mux4_1
X_5696_ _1095_ _2424_ VGND VGND VPWR VPWR _2425_ sky130_fd_sc_hd__xnor2_1
X_7435_ _3367_ rf.registers\[29\]\[10\] _3636_ VGND VGND VPWR VPWR _3637_ sky130_fd_sc_hd__mux2_1
X_4647_ rf.registers\[12\]\[19\] rf.registers\[13\]\[19\] rf.registers\[14\]\[19\]
+ rf.registers\[15\]\[19\] _1403_ _1404_ VGND VGND VPWR VPWR _1423_ sky130_fd_sc_hd__mux4_1
XFILLER_0_16_189 VGND VGND VPWR VPWR sky130_fd_sc_hd__decap_6
XFILLER_0_130_813 VPWR VGND VPWR VGND sky130_ef_sc_hd__decap_12
X_7366_ rf.registers\[8\]\[10\] _3298_ _3599_ VGND VGND VPWR VPWR _3600_ sky130_fd_sc_hd__mux2_1
XFILLER_0_13_841 VGND VGND VPWR VPWR sky130_fd_sc_hd__fill_1
X_9105_ clknet_leaf_39_CLK _0193_ VGND VGND VPWR VPWR rf.registers\[27\]\[0\] sky130_fd_sc_hd__dfxtp_1
X_4578_ _1282_ _1349_ _1353_ _1357_ VGND VGND VPWR VPWR _1358_ sky130_fd_sc_hd__a2bb2o_2
X_6317_ rf.registers\[12\]\[7\] _3001_ _2987_ VGND VGND VPWR VPWR _3002_ sky130_fd_sc_hd__mux2_1
X_7297_ _3551_ VGND VGND VPWR VPWR _3563_ sky130_fd_sc_hd__buf_4
XPHY_EDGE_ROW_71_Left_210 VGND VGND VPWR VPWR sky130_fd_sc_hd__decap_3
XFILLER_0_0_790 VPWR VGND VPWR VGND sky130_ef_sc_hd__decap_12
X_9036_ clknet_leaf_85_CLK _0124_ VGND VGND VPWR VPWR rf.registers\[8\]\[27\] sky130_fd_sc_hd__dfxtp_1
X_6248_ _2916_ _2947_ _2948_ _2931_ VGND VGND VPWR VPWR _2949_ sky130_fd_sc_hd__o211ai_2
X_6179_ _2119_ _2875_ VGND VGND VPWR VPWR _2883_ sky130_fd_sc_hd__nor2_1
XFILLER_0_98_126 VGND VGND VPWR VPWR sky130_fd_sc_hd__fill_2
XFILLER_0_95_833 VGND VGND VPWR VPWR sky130_fd_sc_hd__decap_6
XFILLER_0_79_362 VGND VGND VPWR VPWR sky130_fd_sc_hd__decap_4
XTAP_TAPCELL_ROW_15_519 VGND VPWR sky130_fd_sc_hd__tapvpwrvgnd_1
XTAP_TAPCELL_ROW_101_1820 VGND VPWR sky130_fd_sc_hd__tapvpwrvgnd_1
XFILLER_0_94_365 VGND VGND VPWR VPWR sky130_fd_sc_hd__fill_1
XFILLER_0_67_579 VPWR VGND VPWR VGND sky130_ef_sc_hd__decap_12
XFILLER_0_109_169 VGND VGND VPWR VPWR sky130_fd_sc_hd__decap_4
XFILLER_0_63_741 VPWR VGND VPWR VGND sky130_ef_sc_hd__decap_12
XFILLER_0_48_793 VPWR VGND VPWR VGND sky130_ef_sc_hd__decap_12
XFILLER_0_124_139 VGND VGND VPWR VPWR sky130_fd_sc_hd__fill_1
XFILLER_0_35_443 VGND VGND VPWR VPWR sky130_fd_sc_hd__fill_1
XTAP_TAPCELL_ROW_117_2049 VGND VPWR sky130_fd_sc_hd__tapvpwrvgnd_1
XFILLER_0_63_785 VPWR VGND VPWR VGND sky130_ef_sc_hd__decap_12
XFILLER_0_50_424 VGND VGND VPWR VPWR sky130_fd_sc_hd__decap_4
XFILLER_0_133_673 VPWR VGND VPWR VGND sky130_ef_sc_hd__decap_12
XTAP_TAPCELL_ROW_130_2249 VGND VPWR sky130_fd_sc_hd__tapvpwrvgnd_1
XFILLER_0_31_660 VPWR VGND VPWR VGND sky130_ef_sc_hd__decap_12
XTAP_TAPCELL_ROW_112_1982 VGND VPWR sky130_fd_sc_hd__tapvpwrvgnd_1
XFILLER_0_117_15 VPWR VGND VPWR VGND sky130_ef_sc_hd__decap_12
XFILLER_0_86_811 VGND VGND VPWR VPWR sky130_fd_sc_hd__fill_1
XTAP_TAPCELL_ROW_34_806 VGND VPWR sky130_fd_sc_hd__tapvpwrvgnd_1
XTAP_TAPCELL_ROW_34_817 VGND VPWR sky130_fd_sc_hd__tapvpwrvgnd_1
XFILLER_0_85_332 VGND VGND VPWR VPWR sky130_fd_sc_hd__decap_4
XFILLER_0_133_69 VPWR VGND VPWR VGND sky130_ef_sc_hd__decap_12
XFILLER_0_85_365 VGND VGND VPWR VPWR sky130_fd_sc_hd__fill_1
XFILLER_0_73_505 VGND VGND VPWR VPWR sky130_fd_sc_hd__decap_4
XFILLER_0_39_760 VGND VGND VPWR VPWR sky130_fd_sc_hd__decap_8
XFILLER_0_6_805 VGND VGND VPWR VPWR sky130_fd_sc_hd__decap_6
XFILLER_0_26_421 VGND VGND VPWR VPWR sky130_fd_sc_hd__decap_8
XFILLER_0_5_337 VPWR VGND VPWR VGND sky130_ef_sc_hd__decap_12
X_5550_ _1076_ _2280_ VGND VGND VPWR VPWR _2281_ sky130_fd_sc_hd__or2_1
X_4501_ _1148_ VGND VGND VPWR VPWR _1284_ sky130_fd_sc_hd__buf_4
X_5481_ _2211_ VGND VGND VPWR VPWR _2212_ sky130_fd_sc_hd__buf_2
XFILLER_0_41_402 VGND VGND VPWR VPWR sky130_fd_sc_hd__fill_1
XFILLER_0_130_109 VPWR VGND VPWR VGND sky130_ef_sc_hd__decap_12
XFILLER_0_123_161 VGND VGND VPWR VPWR sky130_fd_sc_hd__decap_6
XFILLER_0_112_813 VPWR VGND VPWR VGND sky130_ef_sc_hd__decap_12
X_4432_ _1156_ _1219_ _1024_ VGND VGND VPWR VPWR _1220_ sky130_fd_sc_hd__a21oi_1
X_7220_ _3522_ VGND VGND VPWR VPWR _0038_ sky130_fd_sc_hd__clkbuf_1
XFILLER_0_13_137 VPWR VGND VPWR VGND sky130_ef_sc_hd__decap_12
XFILLER_0_41_446 VGND VGND VPWR VPWR sky130_fd_sc_hd__fill_2
XTAP_TAPCELL_ROW_74_1410 VGND VPWR sky130_fd_sc_hd__tapvpwrvgnd_1
XFILLER_0_10_811 VGND VGND VPWR VPWR sky130_fd_sc_hd__fill_1
X_7151_ rf.registers\[4\]\[5\] _3288_ _3480_ VGND VGND VPWR VPWR _3486_ sky130_fd_sc_hd__mux2_1
X_4363_ _1144_ VGND VGND VPWR VPWR _1154_ sky130_fd_sc_hd__clkbuf_8
X_4294_ rf.registers\[4\]\[2\] rf.registers\[5\]\[2\] rf.registers\[6\]\[2\] rf.registers\[7\]\[2\]
+ _1026_ _1027_ VGND VGND VPWR VPWR _1087_ sky130_fd_sc_hd__mux4_1
X_7082_ _3449_ VGND VGND VPWR VPWR _0997_ sky130_fd_sc_hd__clkbuf_1
X_6102_ net63 _2810_ VGND VGND VPWR VPWR _2811_ sky130_fd_sc_hd__xnor2_1
X_6033_ _2742_ _2745_ VGND VGND VPWR VPWR _2746_ sky130_fd_sc_hd__xnor2_2
X_7984_ _3928_ VGND VGND VPWR VPWR _0396_ sky130_fd_sc_hd__clkbuf_1
XFILLER_0_13_3 VPWR VGND VPWR VGND sky130_ef_sc_hd__decap_12
X_6935_ net44 VGND VGND VPWR VPWR _3363_ sky130_fd_sc_hd__buf_2
XFILLER_0_77_833 VGND VGND VPWR VPWR sky130_fd_sc_hd__decap_6
XTAP_TAPCELL_ROW_85_1572 VGND VPWR sky130_fd_sc_hd__tapvpwrvgnd_1
XFILLER_0_76_343 VGND VGND VPWR VPWR sky130_fd_sc_hd__fill_1
XFILLER_0_9_610 VGND VGND VPWR VPWR sky130_fd_sc_hd__decap_6
XFILLER_0_119_445 VGND VGND VPWR VPWR sky130_fd_sc_hd__decap_3
XFILLER_0_119_434 VGND VGND VPWR VPWR sky130_fd_sc_hd__fill_2
XFILLER_0_92_825 VPWR VGND VPWR VGND sky130_ef_sc_hd__decap_12
X_6866_ rf.registers\[16\]\[18\] _3315_ _3299_ VGND VGND VPWR VPWR _3316_ sky130_fd_sc_hd__mux2_1
XFILLER_0_64_505 VGND VGND VPWR VPWR sky130_fd_sc_hd__decap_4
XFILLER_0_107_607 VGND VGND VPWR VPWR sky130_fd_sc_hd__decap_8
X_8605_ clknet_leaf_23_CLK _0717_ VGND VGND VPWR VPWR rf.registers\[11\]\[12\] sky130_fd_sc_hd__dfxtp_1
XFILLER_0_91_346 VGND VGND VPWR VPWR sky130_fd_sc_hd__fill_2
XFILLER_0_91_335 VGND VGND VPWR VPWR sky130_fd_sc_hd__fill_1
XFILLER_0_76_398 VGND VGND VPWR VPWR sky130_fd_sc_hd__fill_1
X_5817_ _2398_ VGND VGND VPWR VPWR _2541_ sky130_fd_sc_hd__buf_4
XFILLER_0_9_654 VPWR VGND VPWR VGND sky130_ef_sc_hd__decap_12
XFILLER_0_8_153 VPWR VGND VPWR VGND sky130_ef_sc_hd__decap_12
X_6797_ _3270_ VGND VGND VPWR VPWR _0891_ sky130_fd_sc_hd__clkbuf_1
XFILLER_0_29_281 VGND VGND VPWR VPWR sky130_fd_sc_hd__fill_1
X_8536_ _3020_ rf.registers\[13\]\[16\] _4216_ VGND VGND VPWR VPWR _4220_ sky130_fd_sc_hd__mux2_1
X_5748_ net107 _2474_ VGND VGND VPWR VPWR _2475_ sky130_fd_sc_hd__xnor2_1
XFILLER_0_8_197 VPWR VGND VPWR VGND sky130_ef_sc_hd__decap_12
XFILLER_0_17_443 VGND VGND VPWR VPWR sky130_fd_sc_hd__decap_4
XFILLER_0_45_785 VPWR VGND VPWR VGND sky130_ef_sc_hd__decap_12
X_8467_ _3018_ rf.registers\[14\]\[15\] _4178_ VGND VGND VPWR VPWR _4184_ sky130_fd_sc_hd__mux2_1
XFILLER_0_60_755 VGND VGND VPWR VPWR sky130_fd_sc_hd__fill_1
X_5679_ _2386_ _2407_ VGND VGND VPWR VPWR _2408_ sky130_fd_sc_hd__and2_1
XTAP_TAPCELL_ROW_20_599 VGND VPWR sky130_fd_sc_hd__tapvpwrvgnd_1
X_7418_ _3351_ rf.registers\[29\]\[2\] _3625_ VGND VGND VPWR VPWR _3628_ sky130_fd_sc_hd__mux2_1
X_8398_ _4147_ VGND VGND VPWR VPWR _0591_ sky130_fd_sc_hd__clkbuf_1
X_7349_ rf.registers\[8\]\[2\] _3282_ _3588_ VGND VGND VPWR VPWR _3591_ sky130_fd_sc_hd__mux2_1
X_9019_ clknet_leaf_33_CLK _0107_ VGND VGND VPWR VPWR rf.registers\[8\]\[10\] sky130_fd_sc_hd__dfxtp_1
XFILLER_0_99_446 VGND VGND VPWR VPWR sky130_fd_sc_hd__fill_2
XFILLER_0_86_118 VPWR VGND VPWR VGND sky130_ef_sc_hd__decap_12
XFILLER_0_68_811 VGND VGND VPWR VPWR sky130_fd_sc_hd__fill_1
XFILLER_0_67_321 VGND VGND VPWR VPWR sky130_fd_sc_hd__decap_4
XTAP_TAPCELL_ROW_0_280 VGND VPWR sky130_fd_sc_hd__tapvpwrvgnd_1
XTAP_TAPCELL_ROW_0_291 VGND VPWR sky130_fd_sc_hd__tapvpwrvgnd_1
XFILLER_0_94_195 VGND VGND VPWR VPWR sky130_fd_sc_hd__fill_1
XFILLER_0_12_15 VPWR VGND VPWR VGND sky130_ef_sc_hd__decap_12
XFILLER_0_70_519 VGND VGND VPWR VPWR sky130_fd_sc_hd__decap_6
XFILLER_0_63_593 VGND VGND VPWR VPWR sky130_fd_sc_hd__decap_8
XFILLER_0_35_273 VGND VGND VPWR VPWR sky130_fd_sc_hd__fill_1
XFILLER_0_112_109 VPWR VGND VPWR VGND sky130_ef_sc_hd__decap_12
XFILLER_0_50_221 VGND VGND VPWR VPWR sky130_fd_sc_hd__fill_1
XFILLER_0_2_307 VGND VGND VPWR VPWR sky130_fd_sc_hd__fill_1
XFILLER_0_133_481 VGND VGND VPWR VPWR sky130_fd_sc_hd__fill_1
XFILLER_0_51_777 VGND VGND VPWR VPWR sky130_fd_sc_hd__decap_6
XFILLER_0_120_153 VPWR VGND VPWR VGND sky130_ef_sc_hd__decap_12
XTAP_TAPCELL_ROW_56_1140 VGND VPWR sky130_fd_sc_hd__tapvpwrvgnd_1
XFILLER_0_120_197 VPWR VGND VPWR VGND sky130_ef_sc_hd__decap_12
Xoutput70 net70 VGND VGND VPWR VPWR RD1[29] sky130_fd_sc_hd__buf_1
Xoutput81 net81 VGND VGND VPWR VPWR RD2[0] sky130_fd_sc_hd__buf_1
Xoutput92 net92 VGND VGND VPWR VPWR RD2[1] sky130_fd_sc_hd__buf_1
XFILLER_0_37_78 VGND VGND VPWR VPWR sky130_fd_sc_hd__fill_1
XFILLER_0_59_833 VGND VGND VPWR VPWR sky130_fd_sc_hd__decap_6
X_4981_ rf.registers\[16\]\[5\] rf.registers\[17\]\[5\] rf.registers\[18\]\[5\] rf.registers\[19\]\[5\]
+ _1730_ _1737_ VGND VGND VPWR VPWR _1739_ sky130_fd_sc_hd__mux4_1
XFILLER_0_58_343 VPWR VGND VPWR VGND sky130_ef_sc_hd__decap_12
XFILLER_0_129_721 VGND VGND VPWR VPWR sky130_fd_sc_hd__decap_6
XFILLER_0_74_825 VPWR VGND VPWR VGND sky130_ef_sc_hd__decap_12
X_6720_ rf.registers\[10\]\[22\] _3033_ _3227_ VGND VGND VPWR VPWR _3230_ sky130_fd_sc_hd__mux2_1
XFILLER_0_19_708 VGND VGND VPWR VPWR sky130_fd_sc_hd__decap_8
XFILLER_0_129_765 VPWR VGND VPWR VGND sky130_ef_sc_hd__decap_12
XFILLER_0_18_218 VGND VGND VPWR VPWR sky130_fd_sc_hd__decap_6
X_6651_ rf.registers\[24\]\[22\] _3033_ _3190_ VGND VGND VPWR VPWR _3193_ sky130_fd_sc_hd__mux2_1
XFILLER_0_128_264 VPWR VGND VPWR VGND sky130_ef_sc_hd__decap_12
XFILLER_0_116_426 VGND VGND VPWR VPWR sky130_fd_sc_hd__fill_2
X_9370_ clknet_leaf_56_CLK _0458_ VGND VGND VPWR VPWR rf.registers\[26\]\[9\] sky130_fd_sc_hd__dfxtp_1
X_6582_ rf.registers\[1\]\[22\] _3033_ _3153_ VGND VGND VPWR VPWR _3156_ sky130_fd_sc_hd__mux2_1
XFILLER_0_27_763 VGND VGND VPWR VPWR sky130_fd_sc_hd__fill_1
X_5602_ _1075_ VGND VGND VPWR VPWR _2332_ sky130_fd_sc_hd__clkbuf_4
X_8321_ rf.registers\[20\]\[10\] net15 _4106_ VGND VGND VPWR VPWR _4107_ sky130_fd_sc_hd__mux2_1
X_5533_ _2263_ _1180_ VGND VGND VPWR VPWR _2264_ sky130_fd_sc_hd__nand2_1
XFILLER_0_14_413 VGND VGND VPWR VPWR sky130_fd_sc_hd__decap_6
XFILLER_0_131_429 VGND VGND VPWR VPWR sky130_fd_sc_hd__decap_8
XFILLER_0_81_390 VGND VGND VPWR VPWR sky130_fd_sc_hd__fill_2
XFILLER_0_5_167 VGND VGND VPWR VPWR sky130_fd_sc_hd__fill_1
XFILLER_0_14_457 VPWR VGND VPWR VGND sky130_ef_sc_hd__decap_12
XFILLER_0_42_755 VGND VGND VPWR VPWR sky130_fd_sc_hd__fill_1
X_8252_ _4058_ VGND VGND VPWR VPWR _4070_ sky130_fd_sc_hd__clkbuf_8
X_5464_ net111 net112 net82 net83 VGND VGND VPWR VPWR _2195_ sky130_fd_sc_hd__or4_1
XFILLER_0_2_841 VGND VGND VPWR VPWR sky130_fd_sc_hd__fill_1
XFILLER_0_42_799 VPWR VGND VPWR VGND sky130_ef_sc_hd__decap_12
XFILLER_0_100_805 VGND VGND VPWR VPWR sky130_fd_sc_hd__decap_6
X_8183_ _4033_ VGND VGND VPWR VPWR _0490_ sky130_fd_sc_hd__clkbuf_1
X_4415_ _1197_ _1202_ _1203_ VGND VGND VPWR VPWR _1204_ sky130_fd_sc_hd__a21oi_1
X_7203_ rf.registers\[4\]\[30\] _3340_ _3479_ VGND VGND VPWR VPWR _3513_ sky130_fd_sc_hd__mux2_1
X_5395_ _2129_ _2130_ _1943_ VGND VGND VPWR VPWR _2131_ sky130_fd_sc_hd__mux2_1
XFILLER_0_1_373 VPWR VGND VPWR VGND sky130_ef_sc_hd__decap_12
X_7134_ _3476_ VGND VGND VPWR VPWR _1022_ sky130_fd_sc_hd__clkbuf_1
X_4346_ _1133_ VGND VGND VPWR VPWR _1137_ sky130_fd_sc_hd__clkbuf_8
X_4277_ rf.registers\[12\]\[1\] rf.registers\[13\]\[1\] rf.registers\[14\]\[1\] rf.registers\[15\]\[1\]
+ _1041_ _1043_ VGND VGND VPWR VPWR _1071_ sky130_fd_sc_hd__mux4_1
X_7065_ rf.registers\[6\]\[29\] _3338_ _3430_ VGND VGND VPWR VPWR _3440_ sky130_fd_sc_hd__mux2_1
XTAP_TAPCELL_ROW_87_1612 VGND VPWR sky130_fd_sc_hd__tapvpwrvgnd_1
XTAP_TAPCELL_ROW_87_1601 VGND VPWR sky130_fd_sc_hd__tapvpwrvgnd_1
X_6016_ _2597_ _2716_ _2729_ VGND VGND VPWR VPWR _2730_ sky130_fd_sc_hd__o21ai_1
X_7967_ _3919_ VGND VGND VPWR VPWR _0388_ sky130_fd_sc_hd__clkbuf_1
XFILLER_0_96_449 VGND VGND VPWR VPWR sky130_fd_sc_hd__fill_2
X_7898_ _3353_ rf.registers\[23\]\[3\] _3879_ VGND VGND VPWR VPWR _3883_ sky130_fd_sc_hd__mux2_1
X_6918_ _3351_ rf.registers\[15\]\[2\] _3347_ VGND VGND VPWR VPWR _3352_ sky130_fd_sc_hd__mux2_1
XFILLER_0_77_685 VPWR VGND VPWR VGND sky130_ef_sc_hd__decap_12
X_6849_ _3304_ VGND VGND VPWR VPWR _0909_ sky130_fd_sc_hd__clkbuf_1
XFILLER_0_76_162 VGND VGND VPWR VPWR sky130_fd_sc_hd__decap_6
XFILLER_0_64_324 VPWR VGND VPWR VGND sky130_ef_sc_hd__decap_12
XTAP_TAPCELL_ROW_25_669 VGND VPWR sky130_fd_sc_hd__tapvpwrvgnd_1
XFILLER_0_9_473 VPWR VGND VPWR VGND sky130_ef_sc_hd__decap_12
XFILLER_0_134_245 VGND VGND VPWR VPWR sky130_fd_sc_hd__decap_6
X_9568_ clknet_leaf_23_CLK _0656_ VGND VGND VPWR VPWR rf.registers\[13\]\[15\] sky130_fd_sc_hd__dfxtp_1
XFILLER_0_91_165 VGND VGND VPWR VPWR sky130_fd_sc_hd__decap_3
XFILLER_0_33_722 VGND VGND VPWR VPWR sky130_fd_sc_hd__decap_6
XFILLER_0_45_582 VGND VGND VPWR VPWR sky130_fd_sc_hd__decap_3
XFILLER_0_134_289 VPWR VGND VPWR VGND sky130_ef_sc_hd__decap_12
XTAP_TAPCELL_ROW_114_2008 VGND VPWR sky130_fd_sc_hd__tapvpwrvgnd_1
X_8519_ _3003_ rf.registers\[13\]\[8\] _4205_ VGND VGND VPWR VPWR _4211_ sky130_fd_sc_hd__mux2_1
X_9499_ clknet_leaf_37_CLK _0587_ VGND VGND VPWR VPWR rf.registers\[18\]\[10\] sky130_fd_sc_hd__dfxtp_1
XTAP_TAPCELL_ROW_98_1774 VGND VPWR sky130_fd_sc_hd__tapvpwrvgnd_1
XTAP_TAPCELL_ROW_98_1763 VGND VPWR sky130_fd_sc_hd__tapvpwrvgnd_1
XFILLER_0_102_120 VGND VGND VPWR VPWR sky130_fd_sc_hd__fill_1
XFILLER_0_32_265 VGND VGND VPWR VPWR sky130_fd_sc_hd__fill_1
XFILLER_0_2_3 VPWR VGND VPWR VGND sky130_ef_sc_hd__decap_12
XTAP_TAPCELL_ROW_129_2240 VGND VPWR sky130_fd_sc_hd__tapvpwrvgnd_1
XTAP_TAPCELL_ROW_51_1070 VGND VPWR sky130_fd_sc_hd__tapvpwrvgnd_1
XTAP_TAPCELL_ROW_5_372 VGND VPWR sky130_fd_sc_hd__tapvpwrvgnd_1
XFILLER_0_87_449 VGND VGND VPWR VPWR sky130_fd_sc_hd__decap_8
XFILLER_0_114_27 VGND VGND VPWR VPWR sky130_fd_sc_hd__fill_1
XFILLER_0_56_825 VGND VGND VPWR VPWR sky130_fd_sc_hd__decap_8
XTAP_TAPCELL_ROW_44_956 VGND VPWR sky130_fd_sc_hd__tapvpwrvgnd_1
XTAP_TAPCELL_ROW_44_967 VGND VPWR sky130_fd_sc_hd__tapvpwrvgnd_1
XFILLER_0_28_527 VGND VGND VPWR VPWR sky130_fd_sc_hd__decap_4
XFILLER_0_138_573 VPWR VGND VPWR VGND sky130_ef_sc_hd__decap_12
XFILLER_0_126_713 VPWR VGND VPWR VGND sky130_ef_sc_hd__decap_12
XFILLER_0_55_346 VGND VGND VPWR VPWR sky130_fd_sc_hd__fill_2
XFILLER_0_130_15 VPWR VGND VPWR VGND sky130_ef_sc_hd__decap_12
XFILLER_0_126_757 VPWR VGND VPWR VGND sky130_ef_sc_hd__decap_12
XFILLER_0_125_223 VGND VGND VPWR VPWR sky130_fd_sc_hd__fill_1
XFILLER_0_71_839 VGND VGND VPWR VPWR sky130_fd_sc_hd__fill_1
XFILLER_0_70_305 VGND VGND VPWR VPWR sky130_fd_sc_hd__decap_3
XFILLER_0_36_582 VGND VGND VPWR VPWR sky130_fd_sc_hd__fill_1
XFILLER_0_24_755 VGND VGND VPWR VPWR sky130_fd_sc_hd__fill_1
XFILLER_0_11_405 VPWR VGND VPWR VGND sky130_ef_sc_hd__decap_12
XFILLER_0_11_449 VPWR VGND VPWR VGND sky130_ef_sc_hd__decap_12
X_5180_ _1741_ VGND VGND VPWR VPWR _1927_ sky130_fd_sc_hd__clkbuf_8
XTAP_TAPCELL_ROW_69_1331 VGND VPWR sky130_fd_sc_hd__tapvpwrvgnd_1
XFILLER_0_3_57 VPWR VGND VPWR VGND sky130_ef_sc_hd__decap_12
XFILLER_0_78_416 VGND VGND VPWR VPWR sky130_fd_sc_hd__decap_4
XTAP_TAPCELL_ROW_69_1342 VGND VPWR sky130_fd_sc_hd__tapvpwrvgnd_1
X_8870_ clknet_leaf_80_CLK _0982_ VGND VGND VPWR VPWR rf.registers\[6\]\[21\] sky130_fd_sc_hd__dfxtp_1
X_7821_ _2985_ _3623_ VGND VGND VPWR VPWR _3841_ sky130_fd_sc_hd__nand2b_4
X_4964_ rf.registers\[4\]\[4\] rf.registers\[5\]\[4\] rf.registers\[6\]\[4\] rf.registers\[7\]\[4\]
+ _1655_ _1656_ VGND VGND VPWR VPWR _1723_ sky130_fd_sc_hd__mux4_1
XTAP_TAPCELL_ROW_82_1531 VGND VPWR sky130_fd_sc_hd__tapvpwrvgnd_1
X_7752_ _3804_ VGND VGND VPWR VPWR _0288_ sky130_fd_sc_hd__clkbuf_1
XFILLER_0_19_505 VPWR VGND VPWR VGND sky130_ef_sc_hd__decap_12
X_6703_ rf.registers\[10\]\[14\] _3016_ _3216_ VGND VGND VPWR VPWR _3221_ sky130_fd_sc_hd__mux2_1
XFILLER_0_80_53 VGND VGND VPWR VPWR sky130_fd_sc_hd__decap_3
XFILLER_0_59_685 VPWR VGND VPWR VGND sky130_ef_sc_hd__decap_12
X_4895_ rf.registers\[12\]\[1\] rf.registers\[13\]\[1\] rf.registers\[14\]\[1\] rf.registers\[15\]\[1\]
+ _1655_ _1656_ VGND VGND VPWR VPWR _1657_ sky130_fd_sc_hd__mux4_1
X_7683_ _3767_ VGND VGND VPWR VPWR _0256_ sky130_fd_sc_hd__clkbuf_1
XTAP_TAPCELL_ROW_22_628 VGND VPWR sky130_fd_sc_hd__tapvpwrvgnd_1
X_9422_ clknet_leaf_93_CLK _0510_ VGND VGND VPWR VPWR rf.registers\[21\]\[29\] sky130_fd_sc_hd__dfxtp_1
X_6634_ rf.registers\[24\]\[14\] _3016_ _3179_ VGND VGND VPWR VPWR _3184_ sky130_fd_sc_hd__mux2_1
XFILLER_0_61_316 VGND VGND VPWR VPWR sky130_fd_sc_hd__decap_8
XFILLER_0_6_421 VPWR VGND VPWR VGND sky130_ef_sc_hd__decap_12
XFILLER_0_116_256 VGND VGND VPWR VPWR sky130_fd_sc_hd__decap_3
X_6565_ rf.registers\[1\]\[14\] _3016_ _3142_ VGND VGND VPWR VPWR _3147_ sky130_fd_sc_hd__mux2_1
XFILLER_0_80_3 VPWR VGND VPWR VGND sky130_ef_sc_hd__decap_12
XFILLER_0_73_198 VGND VGND VPWR VPWR sky130_fd_sc_hd__decap_3
XFILLER_0_14_221 VPWR VGND VPWR VGND sky130_ef_sc_hd__decap_12
X_9353_ clknet_leaf_67_CLK _0441_ VGND VGND VPWR VPWR rf.registers\[7\]\[24\] sky130_fd_sc_hd__dfxtp_1
X_8304_ rf.registers\[20\]\[2\] net36 _4095_ VGND VGND VPWR VPWR _4098_ sky130_fd_sc_hd__mux2_1
XFILLER_0_132_749 VGND VGND VPWR VPWR sky130_fd_sc_hd__decap_6
XFILLER_0_131_237 VPWR VGND VPWR VGND sky130_ef_sc_hd__decap_12
X_6496_ rf.registers\[17\]\[14\] _3016_ _3105_ VGND VGND VPWR VPWR _3110_ sky130_fd_sc_hd__mux2_1
X_9284_ clknet_leaf_21_CLK _0372_ VGND VGND VPWR VPWR rf.registers\[23\]\[19\] sky130_fd_sc_hd__dfxtp_1
XFILLER_0_14_265 VPWR VGND VPWR VGND sky130_ef_sc_hd__decap_12
XFILLER_0_42_563 VPWR VGND VPWR VGND sky130_ef_sc_hd__decap_12
X_5516_ _1757_ _2206_ VGND VGND VPWR VPWR _2247_ sky130_fd_sc_hd__or2_1
X_8235_ _4061_ VGND VGND VPWR VPWR _0514_ sky130_fd_sc_hd__clkbuf_1
XFILLER_0_30_725 VPWR VGND VPWR VGND sky130_ef_sc_hd__decap_12
X_5447_ _2179_ VGND VGND VPWR VPWR net72 sky130_fd_sc_hd__inv_2
XFILLER_0_2_693 VGND VGND VPWR VPWR sky130_fd_sc_hd__decap_6
X_8166_ _3349_ rf.registers\[21\]\[1\] _4023_ VGND VGND VPWR VPWR _4025_ sky130_fd_sc_hd__mux2_1
XTAP_TAPCELL_ROW_93_1693 VGND VPWR sky130_fd_sc_hd__tapvpwrvgnd_1
XFILLER_0_1_181 VPWR VGND VPWR VGND sky130_ef_sc_hd__decap_12
X_5378_ rf.registers\[8\]\[26\] rf.registers\[9\]\[26\] rf.registers\[10\]\[26\] rf.registers\[11\]\[26\]
+ _2109_ _2110_ VGND VGND VPWR VPWR _2115_ sky130_fd_sc_hd__mux4_1
X_8097_ _3988_ VGND VGND VPWR VPWR _0449_ sky130_fd_sc_hd__clkbuf_1
X_4329_ _1119_ VGND VGND VPWR VPWR _1120_ sky130_fd_sc_hd__clkbuf_8
X_7117_ rf.registers\[5\]\[21\] _3322_ _3466_ VGND VGND VPWR VPWR _3468_ sky130_fd_sc_hd__mux2_1
X_7048_ _3431_ VGND VGND VPWR VPWR _0981_ sky130_fd_sc_hd__clkbuf_1
XPHY_EDGE_ROW_114_Right_114 VGND VGND VPWR VPWR sky130_fd_sc_hd__decap_3
XTAP_TAPCELL_ROW_2_331 VGND VPWR sky130_fd_sc_hd__tapvpwrvgnd_1
XFILLER_0_69_449 VPWR VGND VPWR VGND sky130_ef_sc_hd__decap_12
X_8999_ clknet_leaf_0_CLK _0087_ VGND VGND VPWR VPWR rf.registers\[3\]\[22\] sky130_fd_sc_hd__dfxtp_1
XFILLER_0_38_825 VPWR VGND VPWR VGND sky130_ef_sc_hd__decap_12
XTAP_TAPCELL_ROW_41_915 VGND VPWR sky130_fd_sc_hd__tapvpwrvgnd_1
XFILLER_0_108_713 VPWR VGND VPWR VGND sky130_ef_sc_hd__decap_12
XFILLER_0_135_554 VGND VGND VPWR VPWR sky130_fd_sc_hd__decap_6
XFILLER_0_108_757 VPWR VGND VPWR VGND sky130_ef_sc_hd__decap_12
XFILLER_0_80_636 VGND VGND VPWR VPWR sky130_fd_sc_hd__fill_1
XFILLER_0_53_839 VGND VGND VPWR VPWR sky130_fd_sc_hd__fill_1
XFILLER_0_9_281 VPWR VGND VPWR VGND sky130_ef_sc_hd__decap_12
XFILLER_0_123_727 VGND VGND VPWR VPWR sky130_fd_sc_hd__fill_1
XFILLER_0_107_278 VGND VGND VPWR VPWR sky130_fd_sc_hd__fill_2
XFILLER_0_45_390 VGND VGND VPWR VPWR sky130_fd_sc_hd__fill_2
XFILLER_0_100_29 VPWR VGND VPWR VGND sky130_ef_sc_hd__decap_12
XFILLER_0_20_224 VGND VGND VPWR VPWR sky130_fd_sc_hd__fill_2
XFILLER_0_109_27 VPWR VGND VPWR VGND sky130_ef_sc_hd__decap_12
XFILLER_0_125_15 VPWR VGND VPWR VGND sky130_ef_sc_hd__decap_12
XTAP_TAPCELL_ROW_109_1932 VGND VPWR sky130_fd_sc_hd__tapvpwrvgnd_1
XFILLER_0_88_725 VPWR VGND VPWR VGND sky130_ef_sc_hd__decap_12
XFILLER_0_88_769 VPWR VGND VPWR VGND sky130_ef_sc_hd__decap_12
XFILLER_0_68_460 VPWR VGND VPWR VGND sky130_ef_sc_hd__decap_12
XTAP_TAPCELL_ROW_64_1261 VGND VPWR sky130_fd_sc_hd__tapvpwrvgnd_1
XFILLER_0_55_132 VGND VGND VPWR VPWR sky130_fd_sc_hd__fill_1
XFILLER_0_44_806 VGND VGND VPWR VPWR sky130_fd_sc_hd__decap_6
XFILLER_0_138_381 VGND VGND VPWR VPWR sky130_fd_sc_hd__decap_8
XFILLER_0_56_677 VPWR VGND VPWR VGND sky130_ef_sc_hd__decap_12
X_4680_ rf.registers\[4\]\[21\] rf.registers\[5\]\[21\] rf.registers\[6\]\[21\] rf.registers\[7\]\[21\]
+ _1198_ _1199_ VGND VGND VPWR VPWR _1454_ sky130_fd_sc_hd__mux4_1
XFILLER_0_24_530 VGND VGND VPWR VPWR sky130_fd_sc_hd__fill_2
XFILLER_0_126_598 VGND VGND VPWR VPWR sky130_fd_sc_hd__fill_2
XFILLER_0_114_749 VGND VGND VPWR VPWR sky130_fd_sc_hd__decap_6
X_6350_ net23 VGND VGND VPWR VPWR _3024_ sky130_fd_sc_hd__clkbuf_2
XFILLER_0_59_43 VPWR VGND VPWR VGND sky130_ef_sc_hd__decap_12
X_5301_ rf.registers\[4\]\[22\] rf.registers\[5\]\[22\] rf.registers\[6\]\[22\] rf.registers\[7\]\[22\]
+ _1772_ _1773_ VGND VGND VPWR VPWR _2042_ sky130_fd_sc_hd__mux4_1
XFILLER_0_122_793 VPWR VGND VPWR VGND sky130_ef_sc_hd__decap_12
XFILLER_0_51_393 VGND VGND VPWR VPWR sky130_fd_sc_hd__fill_1
XFILLER_0_12_769 VGND VGND VPWR VPWR sky130_fd_sc_hd__decap_4
X_6281_ net35 VGND VGND VPWR VPWR _2976_ sky130_fd_sc_hd__clkbuf_2
XFILLER_0_121_281 VPWR VGND VPWR VGND sky130_ef_sc_hd__decap_12
X_5232_ _1948_ _1976_ VGND VGND VPWR VPWR _1977_ sky130_fd_sc_hd__nand2_1
XFILLER_0_59_98 VGND VGND VPWR VPWR sky130_fd_sc_hd__fill_2
XFILLER_0_11_279 VGND VGND VPWR VPWR sky130_fd_sc_hd__fill_1
X_8020_ _2976_ rf.registers\[22\]\[29\] _3937_ VGND VGND VPWR VPWR _3947_ sky130_fd_sc_hd__mux2_1
X_5163_ _1698_ _1910_ VGND VGND VPWR VPWR _1911_ sky130_fd_sc_hd__or2_1
XFILLER_0_75_42 VPWR VGND VPWR VGND sky130_ef_sc_hd__decap_12
X_5094_ rf.registers\[20\]\[11\] rf.registers\[21\]\[11\] rf.registers\[22\]\[11\]
+ rf.registers\[23\]\[11\] _1795_ _1736_ VGND VGND VPWR VPWR _1846_ sky130_fd_sc_hd__mux4_1
XFILLER_0_75_86 VGND VGND VPWR VPWR sky130_fd_sc_hd__decap_6
X_8922_ clknet_leaf_47_CLK _0010_ VGND VGND VPWR VPWR rf.registers\[4\]\[9\] sky130_fd_sc_hd__dfxtp_1
XTAP_TAPCELL_ROW_27_709 VGND VPWR sky130_fd_sc_hd__tapvpwrvgnd_1
X_8853_ clknet_leaf_49_CLK _0965_ VGND VGND VPWR VPWR rf.registers\[6\]\[4\] sky130_fd_sc_hd__dfxtp_1
X_7804_ _3832_ VGND VGND VPWR VPWR _0312_ sky130_fd_sc_hd__clkbuf_1
XFILLER_0_115_81 VPWR VGND VPWR VGND sky130_ef_sc_hd__decap_12
X_5996_ _1375_ _2710_ VGND VGND VPWR VPWR _2711_ sky130_fd_sc_hd__xnor2_2
X_8784_ clknet_leaf_75_CLK _0896_ VGND VGND VPWR VPWR rf.registers\[0\]\[31\] sky130_fd_sc_hd__dfxtp_1
XFILLER_0_136_307 VGND VGND VPWR VPWR sky130_fd_sc_hd__fill_1
X_4947_ _1635_ VGND VGND VPWR VPWR _1707_ sky130_fd_sc_hd__buf_4
XFILLER_0_74_430 VPWR VGND VPWR VGND sky130_ef_sc_hd__decap_12
X_7735_ _3395_ rf.registers\[30\]\[23\] _3792_ VGND VGND VPWR VPWR _3796_ sky130_fd_sc_hd__mux2_1
X_4878_ net4 VGND VGND VPWR VPWR _1641_ sky130_fd_sc_hd__inv_2
XFILLER_0_74_474 VGND VGND VPWR VPWR sky130_fd_sc_hd__fill_2
X_7666_ rf.registers\[2\]\[23\] _3326_ _3755_ VGND VGND VPWR VPWR _3759_ sky130_fd_sc_hd__mux2_1
XFILLER_0_7_741 VPWR VGND VPWR VGND sky130_ef_sc_hd__decap_12
XFILLER_0_34_305 VGND VGND VPWR VPWR sky130_fd_sc_hd__decap_3
X_9405_ clknet_leaf_24_CLK _0493_ VGND VGND VPWR VPWR rf.registers\[21\]\[12\] sky130_fd_sc_hd__dfxtp_1
XFILLER_0_105_727 VGND VGND VPWR VPWR sky130_fd_sc_hd__fill_1
X_6617_ rf.registers\[24\]\[6\] _2999_ _3168_ VGND VGND VPWR VPWR _3175_ sky130_fd_sc_hd__mux2_1
XFILLER_0_61_113 VGND VGND VPWR VPWR sky130_fd_sc_hd__fill_1
XFILLER_0_7_785 VPWR VGND VPWR VGND sky130_ef_sc_hd__decap_12
XFILLER_0_6_251 VGND VGND VPWR VPWR sky130_fd_sc_hd__fill_1
XTAP_TAPCELL_ROW_95_1722 VGND VPWR sky130_fd_sc_hd__tapvpwrvgnd_1
X_9336_ clknet_leaf_50_CLK _0424_ VGND VGND VPWR VPWR rf.registers\[7\]\[7\] sky130_fd_sc_hd__dfxtp_1
XFILLER_0_15_541 VPWR VGND VPWR VGND sky130_ef_sc_hd__decap_12
X_7597_ _3722_ VGND VGND VPWR VPWR _0215_ sky130_fd_sc_hd__clkbuf_1
X_6548_ rf.registers\[1\]\[6\] _2999_ _3131_ VGND VGND VPWR VPWR _3138_ sky130_fd_sc_hd__mux2_1
XFILLER_0_15_585 VGND VGND VPWR VPWR sky130_fd_sc_hd__decap_6
X_9267_ clknet_leaf_43_CLK _0355_ VGND VGND VPWR VPWR rf.registers\[23\]\[2\] sky130_fd_sc_hd__dfxtp_1
X_6479_ rf.registers\[17\]\[6\] _2999_ _3094_ VGND VGND VPWR VPWR _3101_ sky130_fd_sc_hd__mux2_1
XFILLER_0_30_533 VPWR VGND VPWR VGND sky130_ef_sc_hd__decap_12
XFILLER_0_100_421 VGND VGND VPWR VPWR sky130_fd_sc_hd__decap_3
XTAP_TAPCELL_ROW_7_412 VGND VPWR sky130_fd_sc_hd__tapvpwrvgnd_1
XTAP_TAPCELL_ROW_7_401 VGND VPWR sky130_fd_sc_hd__tapvpwrvgnd_1
X_8218_ _3041_ rf.registers\[21\]\[26\] _4045_ VGND VGND VPWR VPWR _4052_ sky130_fd_sc_hd__mux2_1
X_9198_ clknet_leaf_93_CLK _0286_ VGND VGND VPWR VPWR rf.registers\[30\]\[29\] sky130_fd_sc_hd__dfxtp_1
XFILLER_0_30_599 VGND VGND VPWR VPWR sky130_fd_sc_hd__decap_8
X_8149_ _4015_ VGND VGND VPWR VPWR _0474_ sky130_fd_sc_hd__clkbuf_1
XTAP_TAPCELL_ROW_122_2129 VGND VPWR sky130_fd_sc_hd__tapvpwrvgnd_1
XFILLER_0_85_706 VPWR VGND VPWR VGND sky130_ef_sc_hd__decap_12
XTAP_TAPCELL_ROW_104_1862 VGND VPWR sky130_fd_sc_hd__tapvpwrvgnd_1
XFILLER_0_97_599 VGND VGND VPWR VPWR sky130_fd_sc_hd__fill_1
XFILLER_0_84_227 VGND VGND VPWR VPWR sky130_fd_sc_hd__decap_3
XFILLER_0_127_329 VGND VGND VPWR VPWR sky130_fd_sc_hd__decap_6
XFILLER_0_136_841 VGND VGND VPWR VPWR sky130_fd_sc_hd__fill_1
XFILLER_0_93_783 VGND VGND VPWR VPWR sky130_fd_sc_hd__fill_1
XFILLER_0_65_485 VGND VGND VPWR VPWR sky130_fd_sc_hd__fill_1
XFILLER_0_25_316 VGND VGND VPWR VPWR sky130_fd_sc_hd__decap_4
XTAP_TAPCELL_ROW_137_2361 VGND VPWR sky130_fd_sc_hd__tapvpwrvgnd_1
XTAP_TAPCELL_ROW_137_2350 VGND VPWR sky130_fd_sc_hd__tapvpwrvgnd_1
XFILLER_0_20_15 VPWR VGND VPWR VGND sky130_ef_sc_hd__decap_12
XFILLER_0_135_373 VPWR VGND VPWR VGND sky130_ef_sc_hd__decap_12
XFILLER_0_80_477 VGND VGND VPWR VPWR sky130_fd_sc_hd__decap_6
XFILLER_0_41_809 VPWR VGND VPWR VGND sky130_ef_sc_hd__decap_12
XFILLER_0_104_793 VPWR VGND VPWR VGND sky130_ef_sc_hd__decap_12
XFILLER_0_0_405 VGND VGND VPWR VPWR sky130_fd_sc_hd__decap_4
XFILLER_0_0_449 VPWR VGND VPWR VGND sky130_ef_sc_hd__decap_12
XFILLER_0_29_57 VGND VGND VPWR VPWR sky130_fd_sc_hd__fill_2
XFILLER_0_88_544 VGND VGND VPWR VPWR sky130_fd_sc_hd__fill_1
XFILLER_0_88_577 VGND VGND VPWR VPWR sky130_fd_sc_hd__fill_2
X_5850_ _2572_ VGND VGND VPWR VPWR _2573_ sky130_fd_sc_hd__inv_2
XFILLER_0_118_307 VGND VGND VPWR VPWR sky130_fd_sc_hd__fill_1
XFILLER_0_17_806 VPWR VGND VPWR VGND sky130_ef_sc_hd__decap_12
X_5781_ _2330_ _2331_ _2304_ VGND VGND VPWR VPWR _2507_ sky130_fd_sc_hd__mux2_1
X_4801_ _1293_ _1567_ _1282_ VGND VGND VPWR VPWR _1568_ sky130_fd_sc_hd__o21ai_1
XFILLER_0_127_841 VGND VGND VPWR VPWR sky130_fd_sc_hd__fill_1
X_7520_ _3681_ VGND VGND VPWR VPWR _0179_ sky130_fd_sc_hd__clkbuf_1
XFILLER_0_56_474 VGND VGND VPWR VPWR sky130_fd_sc_hd__fill_2
X_4732_ _1156_ _1502_ VGND VGND VPWR VPWR _1503_ sky130_fd_sc_hd__nor2_1
X_7451_ _3384_ rf.registers\[29\]\[18\] _3636_ VGND VGND VPWR VPWR _3645_ sky130_fd_sc_hd__mux2_1
X_4663_ rf.registers\[12\]\[20\] rf.registers\[13\]\[20\] rf.registers\[14\]\[20\]
+ rf.registers\[15\]\[20\] _1198_ _1199_ VGND VGND VPWR VPWR _1438_ sky130_fd_sc_hd__mux4_1
XFILLER_0_28_176 VGND VGND VPWR VPWR sky130_fd_sc_hd__fill_2
XTAP_TAPCELL_ROW_32_778 VGND VPWR sky130_fd_sc_hd__tapvpwrvgnd_1
XFILLER_0_43_102 VGND VGND VPWR VPWR sky130_fd_sc_hd__fill_1
XFILLER_0_43_135 VGND VGND VPWR VPWR sky130_fd_sc_hd__decap_8
X_6402_ _3059_ VGND VGND VPWR VPWR _0707_ sky130_fd_sc_hd__clkbuf_1
XTAP_TAPCELL_ROW_12_480 VGND VPWR sky130_fd_sc_hd__tapvpwrvgnd_1
X_4594_ _1371_ _1372_ _1134_ VGND VGND VPWR VPWR _1373_ sky130_fd_sc_hd__mux2_1
X_7382_ rf.registers\[8\]\[18\] _3315_ _3599_ VGND VGND VPWR VPWR _3608_ sky130_fd_sc_hd__mux2_1
XFILLER_0_4_755 VGND VGND VPWR VPWR sky130_fd_sc_hd__fill_1
XFILLER_0_24_382 VGND VGND VPWR VPWR sky130_fd_sc_hd__fill_2
X_6333_ rf.registers\[12\]\[12\] _3012_ _3008_ VGND VGND VPWR VPWR _3013_ sky130_fd_sc_hd__mux2_1
XTAP_TAPCELL_ROW_77_1452 VGND VPWR sky130_fd_sc_hd__tapvpwrvgnd_1
X_9121_ clknet_leaf_5_CLK _0209_ VGND VGND VPWR VPWR rf.registers\[27\]\[16\] sky130_fd_sc_hd__dfxtp_1
XFILLER_0_12_533 VPWR VGND VPWR VGND sky130_ef_sc_hd__decap_12
X_9052_ clknet_leaf_26_CLK _0140_ VGND VGND VPWR VPWR rf.registers\[29\]\[11\] sky130_fd_sc_hd__dfxtp_1
XFILLER_0_12_566 VPWR VGND VPWR VGND sky130_ef_sc_hd__decap_12
X_6264_ net31 VGND VGND VPWR VPWR _2963_ sky130_fd_sc_hd__clkbuf_2
XTAP_TAPCELL_ROW_90_1652 VGND VPWR sky130_fd_sc_hd__tapvpwrvgnd_1
X_5215_ rf.registers\[4\]\[17\] rf.registers\[5\]\[17\] rf.registers\[6\]\[17\] rf.registers\[7\]\[17\]
+ _1959_ _1960_ VGND VGND VPWR VPWR _1961_ sky130_fd_sc_hd__mux4_1
X_8003_ _3938_ VGND VGND VPWR VPWR _0405_ sky130_fd_sc_hd__clkbuf_1
X_6195_ _2318_ _2266_ VGND VGND VPWR VPWR _2898_ sky130_fd_sc_hd__or2_1
XFILLER_0_99_809 VPWR VGND VPWR VGND sky130_ef_sc_hd__decap_12
X_5146_ rf.registers\[8\]\[14\] rf.registers\[9\]\[14\] rf.registers\[10\]\[14\] rf.registers\[11\]\[14\]
+ _1684_ _1685_ VGND VGND VPWR VPWR _1895_ sky130_fd_sc_hd__mux4_1
X_5077_ rf.registers\[28\]\[10\] rf.registers\[29\]\[10\] rf.registers\[30\]\[10\]
+ rf.registers\[31\]\[10\] _1652_ _1653_ VGND VGND VPWR VPWR _1830_ sky130_fd_sc_hd__mux4_1
X_8905_ clknet_leaf_67_CLK _1017_ VGND VGND VPWR VPWR rf.registers\[5\]\[24\] sky130_fd_sc_hd__dfxtp_1
XFILLER_0_79_555 VGND VGND VPWR VPWR sky130_fd_sc_hd__fill_2
XFILLER_0_94_536 VGND VGND VPWR VPWR sky130_fd_sc_hd__fill_2
X_8836_ clknet_leaf_20_CLK _0948_ VGND VGND VPWR VPWR rf.registers\[15\]\[19\] sky130_fd_sc_hd__dfxtp_1
X_8767_ clknet_leaf_16_CLK _0879_ VGND VGND VPWR VPWR rf.registers\[0\]\[14\] sky130_fd_sc_hd__dfxtp_1
X_5979_ _2241_ _2216_ _2328_ VGND VGND VPWR VPWR _2695_ sky130_fd_sc_hd__a21bo_1
X_7718_ _3378_ rf.registers\[30\]\[15\] _3781_ VGND VGND VPWR VPWR _3787_ sky130_fd_sc_hd__mux2_1
XFILLER_0_81_219 VGND VGND VPWR VPWR sky130_fd_sc_hd__decap_4
XFILLER_0_75_783 VGND VGND VPWR VPWR sky130_fd_sc_hd__fill_1
X_8698_ clknet_leaf_55_CLK _0810_ VGND VGND VPWR VPWR rf.registers\[24\]\[9\] sky130_fd_sc_hd__dfxtp_1
XFILLER_0_133_833 VGND VGND VPWR VPWR sky130_fd_sc_hd__decap_6
XFILLER_0_132_321 VPWR VGND VPWR VGND sky130_ef_sc_hd__decap_12
XTAP_TAPCELL_ROW_119_2080 VGND VPWR sky130_fd_sc_hd__tapvpwrvgnd_1
X_7649_ rf.registers\[2\]\[15\] _3309_ _3744_ VGND VGND VPWR VPWR _3750_ sky130_fd_sc_hd__mux2_1
XFILLER_0_62_477 VGND VGND VPWR VPWR sky130_fd_sc_hd__decap_4
XFILLER_0_23_809 VPWR VGND VPWR VGND sky130_ef_sc_hd__decap_12
XFILLER_0_34_135 VGND VGND VPWR VPWR sky130_fd_sc_hd__fill_2
XTAP_TAPCELL_ROW_119_2091 VGND VPWR sky130_fd_sc_hd__tapvpwrvgnd_1
XFILLER_0_132_365 VPWR VGND VPWR VGND sky130_ef_sc_hd__decap_12
XFILLER_0_15_393 VPWR VGND VPWR VGND sky130_ef_sc_hd__decap_12
X_9319_ clknet_leaf_94_CLK _0407_ VGND VGND VPWR VPWR rf.registers\[22\]\[22\] sky130_fd_sc_hd__dfxtp_1
XTAP_TAPCELL_ROW_132_2280 VGND VPWR sky130_fd_sc_hd__tapvpwrvgnd_1
XFILLER_0_101_741 VPWR VGND VPWR VGND sky130_ef_sc_hd__decap_12
XFILLER_0_101_785 VPWR VGND VPWR VGND sky130_ef_sc_hd__decap_12
XFILLER_0_97_330 VGND VGND VPWR VPWR sky130_fd_sc_hd__decap_6
XFILLER_0_85_503 VGND VGND VPWR VPWR sky130_fd_sc_hd__fill_1
XTAP_TAPCELL_ROW_48_1020 VGND VPWR sky130_fd_sc_hd__tapvpwrvgnd_1
XFILLER_0_128_616 VGND VGND VPWR VPWR sky130_fd_sc_hd__fill_2
XFILLER_0_127_137 VPWR VGND VPWR VGND sky130_ef_sc_hd__decap_12
XFILLER_0_122_27 VGND VGND VPWR VPWR sky130_fd_sc_hd__fill_1
XFILLER_0_109_841 VGND VGND VPWR VPWR sky130_fd_sc_hd__fill_1
XTAP_TAPCELL_ROW_61_1220 VGND VPWR sky130_fd_sc_hd__tapvpwrvgnd_1
XFILLER_0_26_636 VGND VGND VPWR VPWR sky130_fd_sc_hd__decap_8
XFILLER_0_136_693 VGND VGND VPWR VPWR sky130_fd_sc_hd__decap_6
XFILLER_0_124_811 VGND VGND VPWR VPWR sky130_fd_sc_hd__fill_1
XFILLER_0_81_753 VPWR VGND VPWR VGND sky130_ef_sc_hd__decap_12
XFILLER_0_135_181 VPWR VGND VPWR VGND sky130_ef_sc_hd__decap_12
XFILLER_0_81_797 VPWR VGND VPWR VGND sky130_ef_sc_hd__decap_12
XFILLER_0_25_179 VGND VGND VPWR VPWR sky130_fd_sc_hd__fill_2
XFILLER_0_111_527 VGND VGND VPWR VPWR sky130_fd_sc_hd__fill_2
XFILLER_0_40_149 VGND VGND VPWR VPWR sky130_fd_sc_hd__decap_8
XTAP_TAPCELL_ROW_59_1182 VGND VPWR sky130_fd_sc_hd__tapvpwrvgnd_1
X_5000_ _1757_ VGND VGND VPWR VPWR net76 sky130_fd_sc_hd__inv_2
XTAP_TAPCELL_ROW_72_1382 VGND VPWR sky130_fd_sc_hd__tapvpwrvgnd_1
XPHY_EDGE_ROW_0_Left_139 VGND VGND VPWR VPWR sky130_fd_sc_hd__decap_3
X_6951_ net18 VGND VGND VPWR VPWR _3374_ sky130_fd_sc_hd__clkbuf_2
XTAP_TAPCELL_ROW_37_848 VGND VPWR sky130_fd_sc_hd__tapvpwrvgnd_1
XFILLER_0_88_363 VGND VGND VPWR VPWR sky130_fd_sc_hd__fill_1
X_5902_ net51 _2621_ VGND VGND VPWR VPWR _2622_ sky130_fd_sc_hd__xnor2_1
XTAP_TAPCELL_ROW_37_859 VGND VPWR sky130_fd_sc_hd__tapvpwrvgnd_1
X_6882_ rf.registers\[16\]\[23\] _3326_ _3320_ VGND VGND VPWR VPWR _3327_ sky130_fd_sc_hd__mux2_1
XTAP_TAPCELL_ROW_17_550 VGND VPWR sky130_fd_sc_hd__tapvpwrvgnd_1
XTAP_TAPCELL_ROW_17_561 VGND VPWR sky130_fd_sc_hd__tapvpwrvgnd_1
X_5833_ _2386_ _2555_ _2556_ _2358_ VGND VGND VPWR VPWR _2557_ sky130_fd_sc_hd__a211o_1
X_8621_ clknet_leaf_92_CLK _0733_ VGND VGND VPWR VPWR rf.registers\[11\]\[28\] sky130_fd_sc_hd__dfxtp_1
XFILLER_0_57_783 VGND VGND VPWR VPWR sky130_fd_sc_hd__fill_1
X_8552_ _3037_ rf.registers\[13\]\[24\] _2967_ VGND VGND VPWR VPWR _4228_ sky130_fd_sc_hd__mux2_1
XFILLER_0_134_619 VPWR VGND VPWR VGND sky130_ef_sc_hd__decap_12
X_7503_ _3367_ rf.registers\[31\]\[10\] _3672_ VGND VGND VPWR VPWR _3673_ sky130_fd_sc_hd__mux2_1
XFILLER_0_8_357 VGND VGND VPWR VPWR sky130_fd_sc_hd__decap_6
X_5764_ _2229_ _2273_ VGND VGND VPWR VPWR _2490_ sky130_fd_sc_hd__nor2_1
XFILLER_0_44_433 VGND VGND VPWR VPWR sky130_fd_sc_hd__decap_3
XFILLER_0_115_833 VGND VGND VPWR VPWR sky130_fd_sc_hd__decap_6
X_8483_ _4192_ VGND VGND VPWR VPWR _0631_ sky130_fd_sc_hd__clkbuf_1
X_4715_ _1293_ _1486_ VGND VGND VPWR VPWR _1487_ sky130_fd_sc_hd__nand2_1
XFILLER_0_17_658 VGND VGND VPWR VPWR sky130_fd_sc_hd__fill_1
X_5695_ _2211_ _1074_ _2389_ VGND VGND VPWR VPWR _2424_ sky130_fd_sc_hd__a21oi_1
X_4646_ _1381_ _1421_ VGND VGND VPWR VPWR _1422_ sky130_fd_sc_hd__or2_1
X_7434_ _3624_ VGND VGND VPWR VPWR _3636_ sky130_fd_sc_hd__clkbuf_8
XFILLER_0_32_617 VPWR VGND VPWR VGND sky130_ef_sc_hd__decap_12
XFILLER_0_130_825 VPWR VGND VPWR VGND sky130_ef_sc_hd__decap_12
X_4577_ _1301_ _1356_ _1307_ VGND VGND VPWR VPWR _1357_ sky130_fd_sc_hd__a21oi_1
X_7365_ _3587_ VGND VGND VPWR VPWR _3599_ sky130_fd_sc_hd__clkbuf_8
XFILLER_0_97_51 VGND VGND VPWR VPWR sky130_fd_sc_hd__decap_4
X_6316_ net43 VGND VGND VPWR VPWR _3001_ sky130_fd_sc_hd__clkbuf_2
X_9104_ clknet_leaf_62_CLK _0192_ VGND VGND VPWR VPWR rf.registers\[31\]\[31\] sky130_fd_sc_hd__dfxtp_1
Xclkbuf_3_3__f_CLK clknet_0_CLK VGND VGND VPWR VPWR clknet_3_3__leaf_CLK sky130_fd_sc_hd__clkbuf_16
XFILLER_0_12_363 VGND VGND VPWR VPWR sky130_fd_sc_hd__fill_1
XFILLER_0_40_672 VPWR VGND VPWR VGND sky130_ef_sc_hd__decap_12
X_7296_ _3562_ VGND VGND VPWR VPWR _0074_ sky130_fd_sc_hd__clkbuf_1
X_9035_ clknet_leaf_68_CLK _0123_ VGND VGND VPWR VPWR rf.registers\[8\]\[26\] sky130_fd_sc_hd__dfxtp_1
X_6247_ _2907_ _2930_ VGND VGND VPWR VPWR _2948_ sky130_fd_sc_hd__nand2_1
X_6178_ _2867_ _2872_ _2882_ _2391_ VGND VGND VPWR VPWR net131 sky130_fd_sc_hd__a22oi_4
X_5129_ _1875_ _1878_ _1651_ VGND VGND VPWR VPWR _1879_ sky130_fd_sc_hd__mux2_1
XFILLER_0_99_617 VGND VGND VPWR VPWR sky130_fd_sc_hd__fill_2
XFILLER_0_67_503 VGND VGND VPWR VPWR sky130_fd_sc_hd__fill_1
X_8819_ clknet_leaf_44_CLK _0931_ VGND VGND VPWR VPWR rf.registers\[15\]\[2\] sky130_fd_sc_hd__dfxtp_1
XFILLER_0_55_709 VPWR VGND VPWR VGND sky130_ef_sc_hd__decap_12
XTAP_TAPCELL_ROW_101_1821 VGND VPWR sky130_fd_sc_hd__tapvpwrvgnd_1
XTAP_TAPCELL_ROW_101_1810 VGND VPWR sky130_fd_sc_hd__tapvpwrvgnd_1
XFILLER_0_75_580 VGND VGND VPWR VPWR sky130_fd_sc_hd__decap_8
XFILLER_0_106_811 VGND VGND VPWR VPWR sky130_fd_sc_hd__fill_1
XFILLER_0_63_753 VPWR VGND VPWR VGND sky130_ef_sc_hd__decap_12
XFILLER_0_133_641 VPWR VGND VPWR VGND sky130_ef_sc_hd__decap_12
XFILLER_0_117_181 VPWR VGND VPWR VGND sky130_ef_sc_hd__decap_12
XFILLER_0_63_797 VPWR VGND VPWR VGND sky130_ef_sc_hd__decap_12
XFILLER_0_133_685 VPWR VGND VPWR VGND sky130_ef_sc_hd__decap_12
XFILLER_0_132_195 VGND VGND VPWR VPWR sky130_fd_sc_hd__fill_1
XFILLER_0_120_324 VPWR VGND VPWR VGND sky130_ef_sc_hd__decap_12
XTAP_TAPCELL_ROW_112_1983 VGND VPWR sky130_fd_sc_hd__tapvpwrvgnd_1
XFILLER_0_117_27 VPWR VGND VPWR VGND sky130_ef_sc_hd__decap_12
XFILLER_0_133_15 VPWR VGND VPWR VGND sky130_ef_sc_hd__decap_12
XTAP_TAPCELL_ROW_34_807 VGND VPWR sky130_fd_sc_hd__tapvpwrvgnd_1
XFILLER_0_46_709 VPWR VGND VPWR VGND sky130_ef_sc_hd__decap_12
XFILLER_0_42_68 VGND VGND VPWR VPWR sky130_fd_sc_hd__decap_4
XFILLER_0_116_619 VGND VGND VPWR VPWR sky130_fd_sc_hd__fill_1
XFILLER_0_109_682 VPWR VGND VPWR VGND sky130_ef_sc_hd__decap_12
XFILLER_0_109_671 VGND VGND VPWR VPWR sky130_fd_sc_hd__fill_1
XFILLER_0_5_305 VPWR VGND VPWR VGND sky130_ef_sc_hd__decap_12
XFILLER_0_5_349 VPWR VGND VPWR VGND sky130_ef_sc_hd__decap_12
XFILLER_0_13_105 VGND VGND VPWR VPWR sky130_fd_sc_hd__decap_6
XFILLER_0_26_477 VGND VGND VPWR VPWR sky130_fd_sc_hd__decap_4
X_4500_ _1146_ VGND VGND VPWR VPWR _1283_ sky130_fd_sc_hd__clkbuf_8
X_5480_ _1054_ VGND VGND VPWR VPWR _2211_ sky130_fd_sc_hd__clkbuf_2
XFILLER_0_112_825 VPWR VGND VPWR VGND sky130_ef_sc_hd__decap_12
XFILLER_0_111_302 VGND VGND VPWR VPWR sky130_fd_sc_hd__fill_2
XFILLER_0_101_3 VPWR VGND VPWR VGND sky130_ef_sc_hd__decap_12
X_4431_ _1217_ _1218_ _1154_ VGND VGND VPWR VPWR _1219_ sky130_fd_sc_hd__mux2_1
XANTENNA_1 CLK VGND VGND VPWR VPWR sky130_fd_sc_hd__diode_2
XFILLER_0_13_149 VPWR VGND VPWR VGND sky130_ef_sc_hd__decap_12
XTAP_TAPCELL_ROW_74_1411 VGND VPWR sky130_fd_sc_hd__tapvpwrvgnd_1
X_4362_ rf.registers\[0\]\[4\] rf.registers\[1\]\[4\] rf.registers\[2\]\[4\] rf.registers\[3\]\[4\]
+ _1139_ _1140_ VGND VGND VPWR VPWR _1153_ sky130_fd_sc_hd__mux4_1
X_7150_ _3485_ VGND VGND VPWR VPWR _0005_ sky130_fd_sc_hd__clkbuf_1
X_4293_ _1025_ _1085_ VGND VGND VPWR VPWR _1086_ sky130_fd_sc_hd__nand2_1
X_7081_ rf.registers\[5\]\[4\] _3286_ _3444_ VGND VGND VPWR VPWR _3449_ sky130_fd_sc_hd__mux2_1
X_6101_ net95 _2809_ VGND VGND VPWR VPWR _2810_ sky130_fd_sc_hd__xnor2_1
X_6032_ _2708_ _2743_ _2744_ _2734_ VGND VGND VPWR VPWR _2745_ sky130_fd_sc_hd__o22a_1
X_7983_ _3370_ rf.registers\[22\]\[11\] _3926_ VGND VGND VPWR VPWR _3928_ sky130_fd_sc_hd__mux2_1
X_6934_ _3362_ VGND VGND VPWR VPWR _0936_ sky130_fd_sc_hd__clkbuf_1
XFILLER_0_119_402 VGND VGND VPWR VPWR sky130_fd_sc_hd__decap_8
XTAP_TAPCELL_ROW_85_1573 VGND VPWR sky130_fd_sc_hd__tapvpwrvgnd_1
X_8604_ clknet_leaf_30_CLK _0716_ VGND VGND VPWR VPWR rf.registers\[11\]\[11\] sky130_fd_sc_hd__dfxtp_1
X_6865_ net23 VGND VGND VPWR VPWR _3315_ sky130_fd_sc_hd__buf_2
XFILLER_0_9_644 VGND VGND VPWR VPWR sky130_fd_sc_hd__decap_3
XFILLER_0_8_121 VPWR VGND VPWR VGND sky130_ef_sc_hd__decap_12
XFILLER_0_92_837 VGND VGND VPWR VPWR sky130_fd_sc_hd__fill_2
XFILLER_0_9_677 VGND VGND VPWR VPWR sky130_fd_sc_hd__decap_3
XFILLER_0_9_666 VGND VGND VPWR VPWR sky130_fd_sc_hd__decap_6
X_5816_ _2520_ _2530_ _2399_ _2540_ VGND VGND VPWR VPWR net141 sky130_fd_sc_hd__o2bb2a_1
X_6796_ rf.registers\[0\]\[26\] _3041_ _3263_ VGND VGND VPWR VPWR _3270_ sky130_fd_sc_hd__mux2_1
XFILLER_0_123_81 VPWR VGND VPWR VGND sky130_ef_sc_hd__decap_12
X_8535_ _4219_ VGND VGND VPWR VPWR _0656_ sky130_fd_sc_hd__clkbuf_1
XFILLER_0_91_358 VGND VGND VPWR VPWR sky130_fd_sc_hd__fill_2
XFILLER_0_72_550 VGND VGND VPWR VPWR sky130_fd_sc_hd__fill_2
X_5747_ _2392_ _2473_ VGND VGND VPWR VPWR _2474_ sky130_fd_sc_hd__nand2_1
XFILLER_0_9_688 VGND VGND VPWR VPWR sky130_fd_sc_hd__decap_8
XFILLER_0_8_165 VPWR VGND VPWR VGND sky130_ef_sc_hd__decap_12
X_8466_ _4183_ VGND VGND VPWR VPWR _0623_ sky130_fd_sc_hd__clkbuf_1
XFILLER_0_60_701 VPWR VGND VPWR VGND sky130_ef_sc_hd__decap_12
XFILLER_0_45_797 VPWR VGND VPWR VGND sky130_ef_sc_hd__decap_12
X_7417_ _3627_ VGND VGND VPWR VPWR _0130_ sky130_fd_sc_hd__clkbuf_1
X_5678_ _2405_ _2406_ net103 VGND VGND VPWR VPWR _2407_ sky130_fd_sc_hd__mux2_1
XFILLER_0_114_195 VGND VGND VPWR VPWR sky130_fd_sc_hd__fill_1
X_8397_ rf.registers\[18\]\[14\] net19 _4142_ VGND VGND VPWR VPWR _4147_ sky130_fd_sc_hd__mux2_1
X_4629_ rf.registers\[12\]\[18\] rf.registers\[13\]\[18\] rf.registers\[14\]\[18\]
+ rf.registers\[15\]\[18\] _1403_ _1404_ VGND VGND VPWR VPWR _1406_ sky130_fd_sc_hd__mux4_1
XFILLER_0_20_609 VGND VGND VPWR VPWR sky130_fd_sc_hd__decap_8
X_7348_ _3590_ VGND VGND VPWR VPWR _0098_ sky130_fd_sc_hd__clkbuf_1
Xclkbuf_leaf_50_CLK clknet_3_6__leaf_CLK VGND VGND VPWR VPWR clknet_leaf_50_CLK sky130_fd_sc_hd__clkbuf_8
XFILLER_0_130_699 VGND VGND VPWR VPWR sky130_fd_sc_hd__fill_1
X_7279_ rf.registers\[3\]\[1\] _3280_ _3552_ VGND VGND VPWR VPWR _3554_ sky130_fd_sc_hd__mux2_1
X_9018_ clknet_leaf_34_CLK _0106_ VGND VGND VPWR VPWR rf.registers\[8\]\[9\] sky130_fd_sc_hd__dfxtp_1
XFILLER_0_79_193 VGND VGND VPWR VPWR sky130_fd_sc_hd__decap_4
XTAP_TAPCELL_ROW_0_281 VGND VPWR sky130_fd_sc_hd__tapvpwrvgnd_1
XTAP_TAPCELL_ROW_0_292 VGND VPWR sky130_fd_sc_hd__tapvpwrvgnd_1
XFILLER_0_82_325 VGND VGND VPWR VPWR sky130_fd_sc_hd__fill_1
XFILLER_0_48_580 VGND VGND VPWR VPWR sky130_fd_sc_hd__decap_8
XFILLER_0_12_27 VGND VGND VPWR VPWR sky130_fd_sc_hd__fill_1
XFILLER_0_125_405 VGND VGND VPWR VPWR sky130_fd_sc_hd__fill_1
XFILLER_0_35_241 VGND VGND VPWR VPWR sky130_fd_sc_hd__decap_3
XFILLER_0_106_641 VGND VGND VPWR VPWR sky130_fd_sc_hd__decap_3
XFILLER_0_3_809 VPWR VGND VPWR VGND sky130_ef_sc_hd__decap_12
XFILLER_0_23_414 VGND VGND VPWR VPWR sky130_fd_sc_hd__fill_2
XFILLER_0_106_663 VPWR VGND VPWR VGND sky130_ef_sc_hd__decap_12
XFILLER_0_120_121 VPWR VGND VPWR VGND sky130_ef_sc_hd__decap_12
XFILLER_0_105_195 VGND VGND VPWR VPWR sky130_fd_sc_hd__fill_2
XFILLER_0_11_609 VGND VGND VPWR VPWR sky130_fd_sc_hd__decap_6
XPHY_EDGE_ROW_128_Right_128 VGND VGND VPWR VPWR sky130_fd_sc_hd__decap_3
XFILLER_0_121_655 VPWR VGND VPWR VGND sky130_ef_sc_hd__decap_12
Xclkbuf_leaf_41_CLK clknet_3_7__leaf_CLK VGND VGND VPWR VPWR clknet_leaf_41_CLK sky130_fd_sc_hd__clkbuf_8
XTAP_TAPCELL_ROW_56_1141 VGND VPWR sky130_fd_sc_hd__tapvpwrvgnd_1
XFILLER_0_120_165 VPWR VGND VPWR VGND sky130_ef_sc_hd__decap_12
Xoutput60 net60 VGND VGND VPWR VPWR RD1[1] sky130_fd_sc_hd__buf_1
XFILLER_0_128_15 VPWR VGND VPWR VGND sky130_ef_sc_hd__decap_12
Xoutput82 net82 VGND VGND VPWR VPWR RD2[10] sky130_fd_sc_hd__buf_1
Xoutput93 net93 VGND VGND VPWR VPWR RD2[20] sky130_fd_sc_hd__buf_1
Xoutput71 net71 VGND VGND VPWR VPWR RD1[2] sky130_fd_sc_hd__buf_1
XFILLER_0_37_57 VGND VGND VPWR VPWR sky130_fd_sc_hd__decap_4
XPHY_EDGE_ROW_90_Left_229 VGND VGND VPWR VPWR sky130_fd_sc_hd__decap_3
XFILLER_0_58_300 VGND VGND VPWR VPWR sky130_fd_sc_hd__decap_8
X_4980_ rf.registers\[28\]\[5\] rf.registers\[29\]\[5\] rf.registers\[30\]\[5\] rf.registers\[31\]\[5\]
+ _1735_ _1737_ VGND VGND VPWR VPWR _1738_ sky130_fd_sc_hd__mux4_1
XTAP_TAPCELL_ROW_47_998 VGND VPWR sky130_fd_sc_hd__tapvpwrvgnd_1
XFILLER_0_128_221 VPWR VGND VPWR VGND sky130_ef_sc_hd__decap_12
XFILLER_0_58_377 VPWR VGND VPWR VGND sky130_ef_sc_hd__decap_12
XFILLER_0_58_355 VGND VGND VPWR VPWR sky130_fd_sc_hd__decap_8
XFILLER_0_129_777 VGND VGND VPWR VPWR sky130_fd_sc_hd__decap_6
XFILLER_0_74_837 VGND VGND VPWR VPWR sky130_fd_sc_hd__fill_2
X_6650_ _3192_ VGND VGND VPWR VPWR _0822_ sky130_fd_sc_hd__clkbuf_1
XFILLER_0_27_720 VGND VGND VPWR VPWR sky130_fd_sc_hd__decap_8
XFILLER_0_128_276 VPWR VGND VPWR VGND sky130_ef_sc_hd__decap_12
X_6581_ _3155_ VGND VGND VPWR VPWR _0790_ sky130_fd_sc_hd__clkbuf_1
X_5601_ _2298_ _2216_ _2220_ VGND VGND VPWR VPWR _2331_ sky130_fd_sc_hd__mux2_1
XFILLER_0_39_591 VPWR VGND VPWR VGND sky130_ef_sc_hd__decap_12
X_8320_ _4094_ VGND VGND VPWR VPWR _4106_ sky130_fd_sc_hd__clkbuf_8
X_5532_ net48 VGND VGND VPWR VPWR _2263_ sky130_fd_sc_hd__buf_4
XFILLER_0_5_113 VPWR VGND VPWR VGND sky130_ef_sc_hd__decap_12
XFILLER_0_42_701 VGND VGND VPWR VPWR sky130_fd_sc_hd__decap_4
X_8251_ _4069_ VGND VGND VPWR VPWR _0522_ sky130_fd_sc_hd__clkbuf_1
XFILLER_0_75_6 VPWR VGND VPWR VGND sky130_ef_sc_hd__decap_12
X_5463_ net97 net98 net99 net100 VGND VGND VPWR VPWR _2194_ sky130_fd_sc_hd__or4_1
XFILLER_0_14_469 VGND VGND VPWR VPWR sky130_fd_sc_hd__decap_6
Xclkbuf_leaf_32_CLK clknet_3_4__leaf_CLK VGND VGND VPWR VPWR clknet_leaf_32_CLK sky130_fd_sc_hd__clkbuf_8
X_8182_ _3365_ rf.registers\[21\]\[9\] _4023_ VGND VGND VPWR VPWR _4033_ sky130_fd_sc_hd__mux2_1
X_4414_ _1024_ VGND VGND VPWR VPWR _1203_ sky130_fd_sc_hd__buf_4
X_7202_ _3512_ VGND VGND VPWR VPWR _0030_ sky130_fd_sc_hd__clkbuf_1
X_5394_ rf.registers\[0\]\[27\] rf.registers\[1\]\[27\] rf.registers\[2\]\[27\] rf.registers\[3\]\[27\]
+ _2008_ _2009_ VGND VGND VPWR VPWR _2130_ sky130_fd_sc_hd__mux4_1
XFILLER_0_112_699 VGND VGND VPWR VPWR sky130_fd_sc_hd__fill_1
X_4345_ _1124_ _1130_ _1131_ _1132_ _1134_ _1135_ VGND VGND VPWR VPWR _1136_ sky130_fd_sc_hd__mux4_2
XFILLER_0_10_653 VGND VGND VPWR VPWR sky130_fd_sc_hd__fill_1
XFILLER_0_1_385 VGND VGND VPWR VPWR sky130_fd_sc_hd__decap_6
X_7133_ rf.registers\[5\]\[29\] _3338_ _3466_ VGND VGND VPWR VPWR _3476_ sky130_fd_sc_hd__mux2_1
X_4276_ rf.registers\[8\]\[1\] rf.registers\[9\]\[1\] rf.registers\[10\]\[1\] rf.registers\[11\]\[1\]
+ _1041_ _1043_ VGND VGND VPWR VPWR _1070_ sky130_fd_sc_hd__mux4_1
XFILLER_0_94_41 VPWR VGND VPWR VGND sky130_ef_sc_hd__decap_12
X_7064_ _3439_ VGND VGND VPWR VPWR _0989_ sky130_fd_sc_hd__clkbuf_1
XPHY_EDGE_ROW_129_Left_268 VGND VGND VPWR VPWR sky130_fd_sc_hd__decap_3
XFILLER_0_94_85 VGND VGND VPWR VPWR sky130_fd_sc_hd__fill_2
XTAP_TAPCELL_ROW_87_1602 VGND VPWR sky130_fd_sc_hd__tapvpwrvgnd_1
X_6015_ _2325_ _2720_ _2728_ _2463_ _2398_ VGND VGND VPWR VPWR _2729_ sky130_fd_sc_hd__o221a_1
X_7966_ _3353_ rf.registers\[22\]\[3\] _3915_ VGND VGND VPWR VPWR _3919_ sky130_fd_sc_hd__mux2_1
XFILLER_0_77_642 VGND VGND VPWR VPWR sky130_fd_sc_hd__decap_4
X_7897_ _3882_ VGND VGND VPWR VPWR _0355_ sky130_fd_sc_hd__clkbuf_1
X_6917_ net36 VGND VGND VPWR VPWR _3351_ sky130_fd_sc_hd__clkbuf_2
X_6848_ rf.registers\[16\]\[12\] _3303_ _3299_ VGND VGND VPWR VPWR _3304_ sky130_fd_sc_hd__mux2_1
XFILLER_0_77_697 VPWR VGND VPWR VGND sky130_ef_sc_hd__decap_12
XFILLER_0_9_441 VGND VGND VPWR VPWR sky130_fd_sc_hd__decap_6
X_9567_ clknet_leaf_28_CLK _0655_ VGND VGND VPWR VPWR rf.registers\[13\]\[14\] sky130_fd_sc_hd__dfxtp_1
XFILLER_0_64_336 VGND VGND VPWR VPWR sky130_fd_sc_hd__decap_4
XFILLER_0_9_485 VPWR VGND VPWR VGND sky130_ef_sc_hd__decap_12
XPHY_EDGE_ROW_138_Left_277 VGND VGND VPWR VPWR sky130_fd_sc_hd__decap_3
X_8518_ _4210_ VGND VGND VPWR VPWR _0648_ sky130_fd_sc_hd__clkbuf_1
X_6779_ rf.registers\[0\]\[18\] _3024_ _3252_ VGND VGND VPWR VPWR _3261_ sky130_fd_sc_hd__mux2_1
XFILLER_0_17_241 VGND VGND VPWR VPWR sky130_fd_sc_hd__fill_1
XFILLER_0_45_550 VGND VGND VPWR VPWR sky130_fd_sc_hd__fill_1
XTAP_TAPCELL_ROW_114_2009 VGND VPWR sky130_fd_sc_hd__tapvpwrvgnd_1
XTAP_TAPCELL_ROW_98_1764 VGND VPWR sky130_fd_sc_hd__tapvpwrvgnd_1
X_9498_ clknet_leaf_34_CLK _0586_ VGND VGND VPWR VPWR rf.registers\[18\]\[9\] sky130_fd_sc_hd__dfxtp_1
XTAP_TAPCELL_ROW_98_1775 VGND VPWR sky130_fd_sc_hd__tapvpwrvgnd_1
X_8449_ _4174_ VGND VGND VPWR VPWR _0615_ sky130_fd_sc_hd__clkbuf_1
XFILLER_0_33_767 VPWR VGND VPWR VGND sky130_ef_sc_hd__decap_12
Xclkbuf_leaf_23_CLK clknet_3_5__leaf_CLK VGND VGND VPWR VPWR clknet_leaf_23_CLK sky130_fd_sc_hd__clkbuf_8
XTAP_TAPCELL_ROW_129_2241 VGND VPWR sky130_fd_sc_hd__tapvpwrvgnd_1
XTAP_TAPCELL_ROW_129_2230 VGND VPWR sky130_fd_sc_hd__tapvpwrvgnd_1
XTAP_TAPCELL_ROW_51_1071 VGND VPWR sky130_fd_sc_hd__tapvpwrvgnd_1
XTAP_TAPCELL_ROW_51_1060 VGND VPWR sky130_fd_sc_hd__tapvpwrvgnd_1
XTAP_TAPCELL_ROW_5_373 VGND VPWR sky130_fd_sc_hd__tapvpwrvgnd_1
XFILLER_0_87_428 VGND VGND VPWR VPWR sky130_fd_sc_hd__fill_1
XFILLER_0_68_642 VGND VGND VPWR VPWR sky130_fd_sc_hd__fill_2
XFILLER_0_68_631 VGND VGND VPWR VPWR sky130_fd_sc_hd__decap_8
XTAP_TAPCELL_ROW_44_957 VGND VPWR sky130_fd_sc_hd__tapvpwrvgnd_1
XFILLER_0_56_837 VGND VGND VPWR VPWR sky130_fd_sc_hd__fill_2
XFILLER_0_138_585 VGND VGND VPWR VPWR sky130_fd_sc_hd__decap_3
XFILLER_0_126_725 VPWR VGND VPWR VGND sky130_ef_sc_hd__decap_12
XFILLER_0_99_19 VPWR VGND VPWR VGND sky130_ef_sc_hd__decap_12
XFILLER_0_82_144 VGND VGND VPWR VPWR sky130_fd_sc_hd__decap_4
XFILLER_0_43_509 VGND VGND VPWR VPWR sky130_fd_sc_hd__fill_1
XFILLER_0_130_27 VGND VGND VPWR VPWR sky130_fd_sc_hd__fill_1
XFILLER_0_126_769 VPWR VGND VPWR VGND sky130_ef_sc_hd__decap_12
XFILLER_0_24_701 VGND VGND VPWR VPWR sky130_fd_sc_hd__decap_3
XFILLER_0_125_279 VGND VGND VPWR VPWR sky130_fd_sc_hd__fill_1
XFILLER_0_3_617 VPWR VGND VPWR VGND sky130_ef_sc_hd__decap_12
Xclkbuf_leaf_14_CLK clknet_3_1__leaf_CLK VGND VGND VPWR VPWR clknet_leaf_14_CLK sky130_fd_sc_hd__clkbuf_8
XFILLER_0_11_417 VPWR VGND VPWR VGND sky130_ef_sc_hd__decap_12
XFILLER_0_121_474 VGND VGND VPWR VPWR sky130_fd_sc_hd__fill_2
XFILLER_0_64_33 VGND VGND VPWR VPWR sky130_fd_sc_hd__fill_1
XFILLER_0_3_69 VPWR VGND VPWR VGND sky130_ef_sc_hd__decap_12
XTAP_TAPCELL_ROW_69_1332 VGND VPWR sky130_fd_sc_hd__tapvpwrvgnd_1
X_7820_ _3840_ VGND VGND VPWR VPWR _0320_ sky130_fd_sc_hd__clkbuf_1
X_4963_ _1651_ _1721_ VGND VGND VPWR VPWR _1722_ sky130_fd_sc_hd__nand2_1
XTAP_TAPCELL_ROW_82_1532 VGND VPWR sky130_fd_sc_hd__tapvpwrvgnd_1
X_7751_ _2980_ rf.registers\[30\]\[31\] _3769_ VGND VGND VPWR VPWR _3804_ sky130_fd_sc_hd__mux2_1
X_6702_ _3220_ VGND VGND VPWR VPWR _0846_ sky130_fd_sc_hd__clkbuf_1
XFILLER_0_80_65 VGND VGND VPWR VPWR sky130_fd_sc_hd__decap_6
XFILLER_0_59_697 VPWR VGND VPWR VGND sky130_ef_sc_hd__decap_12
X_7682_ rf.registers\[2\]\[31\] _3342_ _3732_ VGND VGND VPWR VPWR _3767_ sky130_fd_sc_hd__mux2_1
XFILLER_0_19_517 VPWR VGND VPWR VGND sky130_ef_sc_hd__decap_12
X_4894_ _1625_ VGND VGND VPWR VPWR _1656_ sky130_fd_sc_hd__clkbuf_4
X_6633_ _3183_ VGND VGND VPWR VPWR _0814_ sky130_fd_sc_hd__clkbuf_1
XTAP_TAPCELL_ROW_22_629 VGND VPWR sky130_fd_sc_hd__tapvpwrvgnd_1
X_9421_ clknet_leaf_0_CLK _0509_ VGND VGND VPWR VPWR rf.registers\[21\]\[28\] sky130_fd_sc_hd__dfxtp_1
XFILLER_0_46_347 VGND VGND VPWR VPWR sky130_fd_sc_hd__fill_1
XFILLER_0_104_83 VGND VGND VPWR VPWR sky130_fd_sc_hd__fill_1
XFILLER_0_73_166 VGND VGND VPWR VPWR sky130_fd_sc_hd__fill_2
XFILLER_0_6_433 VPWR VGND VPWR VGND sky130_ef_sc_hd__decap_12
XFILLER_0_13_81 VPWR VGND VPWR VGND sky130_ef_sc_hd__decap_12
XFILLER_0_27_561 VPWR VGND VPWR VGND sky130_ef_sc_hd__decap_12
XFILLER_0_131_205 VPWR VGND VPWR VGND sky130_ef_sc_hd__decap_12
XFILLER_0_104_419 VGND VGND VPWR VPWR sky130_fd_sc_hd__fill_1
X_6564_ _3146_ VGND VGND VPWR VPWR _0782_ sky130_fd_sc_hd__clkbuf_1
XFILLER_0_54_380 VGND VGND VPWR VPWR sky130_fd_sc_hd__fill_1
XFILLER_0_6_477 VPWR VGND VPWR VGND sky130_ef_sc_hd__decap_12
X_9352_ clknet_leaf_90_CLK _0440_ VGND VGND VPWR VPWR rf.registers\[7\]\[23\] sky130_fd_sc_hd__dfxtp_1
X_8303_ _4097_ VGND VGND VPWR VPWR _0546_ sky130_fd_sc_hd__clkbuf_1
X_6495_ _3109_ VGND VGND VPWR VPWR _0750_ sky130_fd_sc_hd__clkbuf_1
X_9283_ clknet_leaf_5_CLK _0371_ VGND VGND VPWR VPWR rf.registers\[23\]\[18\] sky130_fd_sc_hd__dfxtp_1
XFILLER_0_14_233 VPWR VGND VPWR VGND sky130_ef_sc_hd__decap_12
X_5515_ _2241_ _2242_ _2245_ VGND VGND VPWR VPWR _2246_ sky130_fd_sc_hd__a21bo_1
XFILLER_0_131_249 VPWR VGND VPWR VGND sky130_ef_sc_hd__decap_12
X_8234_ _2989_ rf.registers\[25\]\[1\] _4059_ VGND VGND VPWR VPWR _4061_ sky130_fd_sc_hd__mux2_1
XFILLER_0_73_3 VPWR VGND VPWR VGND sky130_ef_sc_hd__decap_12
XFILLER_0_14_277 VPWR VGND VPWR VGND sky130_ef_sc_hd__decap_12
XFILLER_0_30_737 VGND VGND VPWR VPWR sky130_fd_sc_hd__fill_1
XFILLER_0_42_575 VGND VGND VPWR VPWR sky130_fd_sc_hd__fill_1
X_5446_ _1964_ _2170_ _2178_ VGND VGND VPWR VPWR _2179_ sky130_fd_sc_hd__a21oi_4
XFILLER_0_112_474 VGND VGND VPWR VPWR sky130_fd_sc_hd__fill_2
XFILLER_0_100_603 VGND VGND VPWR VPWR sky130_fd_sc_hd__decap_8
X_8165_ _4024_ VGND VGND VPWR VPWR _0481_ sky130_fd_sc_hd__clkbuf_1
XTAP_TAPCELL_ROW_93_1694 VGND VPWR sky130_fd_sc_hd__tapvpwrvgnd_1
XFILLER_0_1_193 VPWR VGND VPWR VGND sky130_ef_sc_hd__decap_12
X_5377_ _2081_ _2113_ _1950_ VGND VGND VPWR VPWR _2114_ sky130_fd_sc_hd__a21o_1
X_8096_ _3344_ rf.registers\[26\]\[0\] _3987_ VGND VGND VPWR VPWR _3988_ sky130_fd_sc_hd__mux2_1
X_4328_ _1118_ VGND VGND VPWR VPWR _1119_ sky130_fd_sc_hd__clkbuf_8
X_7116_ _3467_ VGND VGND VPWR VPWR _1013_ sky130_fd_sc_hd__clkbuf_1
X_4259_ _1024_ _1033_ _1040_ _1048_ _1053_ VGND VGND VPWR VPWR _1054_ sky130_fd_sc_hd__a32o_2
X_7047_ rf.registers\[6\]\[20\] _3319_ _3430_ VGND VGND VPWR VPWR _3431_ sky130_fd_sc_hd__mux2_1
XTAP_TAPCELL_ROW_2_332 VGND VPWR sky130_fd_sc_hd__tapvpwrvgnd_1
XTAP_TAPCELL_ROW_124_2160 VGND VPWR sky130_fd_sc_hd__tapvpwrvgnd_1
XFILLER_0_96_225 VGND VGND VPWR VPWR sky130_fd_sc_hd__fill_2
X_8998_ clknet_leaf_79_CLK _0086_ VGND VGND VPWR VPWR rf.registers\[3\]\[21\] sky130_fd_sc_hd__dfxtp_1
X_7949_ _3909_ VGND VGND VPWR VPWR _0380_ sky130_fd_sc_hd__clkbuf_1
XFILLER_0_49_185 VGND VGND VPWR VPWR sky130_fd_sc_hd__decap_6
XFILLER_0_38_837 VGND VGND VPWR VPWR sky130_fd_sc_hd__fill_2
XTAP_TAPCELL_ROW_41_916 VGND VPWR sky130_fd_sc_hd__tapvpwrvgnd_1
XFILLER_0_108_725 VPWR VGND VPWR VGND sky130_ef_sc_hd__decap_12
XFILLER_0_108_769 VPWR VGND VPWR VGND sky130_ef_sc_hd__decap_12
XFILLER_0_9_293 VPWR VGND VPWR VGND sky130_ef_sc_hd__decap_12
XFILLER_0_52_328 VGND VGND VPWR VPWR sky130_fd_sc_hd__fill_2
XFILLER_0_131_783 VGND VGND VPWR VPWR sky130_fd_sc_hd__fill_1
XTAP_TAPCELL_ROW_53_1100 VGND VPWR sky130_fd_sc_hd__tapvpwrvgnd_1
XFILLER_0_109_39 VPWR VGND VPWR VGND sky130_ef_sc_hd__decap_12
XFILLER_0_18_15 VPWR VGND VPWR VGND sky130_ef_sc_hd__decap_12
XTAP_TAPCELL_ROW_109_1933 VGND VPWR sky130_fd_sc_hd__tapvpwrvgnd_1
XTAP_TAPCELL_ROW_29_740 VGND VPWR sky130_fd_sc_hd__tapvpwrvgnd_1
XFILLER_0_125_27 VPWR VGND VPWR VGND sky130_ef_sc_hd__decap_12
XFILLER_0_88_737 VPWR VGND VPWR VGND sky130_ef_sc_hd__decap_12
Xclkbuf_leaf_3_CLK clknet_3_1__leaf_CLK VGND VGND VPWR VPWR clknet_leaf_3_CLK sky130_fd_sc_hd__clkbuf_8
XFILLER_0_96_781 VPWR VGND VPWR VGND sky130_ef_sc_hd__decap_12
XFILLER_0_68_472 VGND VGND VPWR VPWR sky130_fd_sc_hd__decap_4
XFILLER_0_8_709 VPWR VGND VPWR VGND sky130_ef_sc_hd__decap_12
XFILLER_0_29_837 VGND VGND VPWR VPWR sky130_fd_sc_hd__decap_3
XTAP_TAPCELL_ROW_64_1262 VGND VPWR sky130_fd_sc_hd__tapvpwrvgnd_1
XFILLER_0_55_122 VGND VGND VPWR VPWR sky130_fd_sc_hd__decap_6
XFILLER_0_138_393 VPWR VGND VPWR VGND sky130_ef_sc_hd__decap_12
XFILLER_0_56_689 VGND VGND VPWR VPWR sky130_fd_sc_hd__decap_8
XFILLER_0_71_659 VGND VGND VPWR VPWR sky130_fd_sc_hd__decap_6
XFILLER_0_71_637 VGND VGND VPWR VPWR sky130_fd_sc_hd__decap_6
XFILLER_0_43_328 VGND VGND VPWR VPWR sky130_fd_sc_hd__fill_2
X_5300_ _1744_ _2040_ VGND VGND VPWR VPWR _2041_ sky130_fd_sc_hd__nand2_1
XFILLER_0_3_447 VGND VGND VPWR VPWR sky130_fd_sc_hd__fill_1
XFILLER_0_59_55 VGND VGND VPWR VPWR sky130_fd_sc_hd__fill_1
XFILLER_0_11_225 VPWR VGND VPWR VGND sky130_ef_sc_hd__decap_12
X_6280_ _2975_ VGND VGND VPWR VPWR _0669_ sky130_fd_sc_hd__clkbuf_1
XFILLER_0_121_293 VGND VGND VPWR VPWR sky130_fd_sc_hd__decap_8
X_5231_ _1974_ _1975_ _1927_ VGND VGND VPWR VPWR _1976_ sky130_fd_sc_hd__mux2_1
X_5162_ rf.registers\[4\]\[15\] rf.registers\[5\]\[15\] rf.registers\[6\]\[15\] rf.registers\[7\]\[15\]
+ _1699_ _1700_ VGND VGND VPWR VPWR _1910_ sky130_fd_sc_hd__mux4_1
X_5093_ rf.registers\[16\]\[11\] rf.registers\[17\]\[11\] rf.registers\[18\]\[11\]
+ rf.registers\[19\]\[11\] _1795_ _1736_ VGND VGND VPWR VPWR _1845_ sky130_fd_sc_hd__mux4_1
XFILLER_0_75_54 VGND VGND VPWR VPWR sky130_fd_sc_hd__fill_2
X_8921_ clknet_leaf_48_CLK _0009_ VGND VGND VPWR VPWR rf.registers\[4\]\[8\] sky130_fd_sc_hd__dfxtp_1
X_8852_ clknet_leaf_35_CLK _0964_ VGND VGND VPWR VPWR rf.registers\[6\]\[3\] sky130_fd_sc_hd__dfxtp_1
XFILLER_0_91_31 VPWR VGND VPWR VGND sky130_ef_sc_hd__decap_12
XFILLER_0_78_236 VGND VGND VPWR VPWR sky130_fd_sc_hd__decap_4
XFILLER_0_78_269 VPWR VGND VPWR VGND sky130_ef_sc_hd__decap_12
X_8783_ clknet_leaf_62_CLK _0895_ VGND VGND VPWR VPWR rf.registers\[0\]\[30\] sky130_fd_sc_hd__dfxtp_1
X_7803_ rf.registers\[9\]\[23\] _3326_ _3828_ VGND VGND VPWR VPWR _3832_ sky130_fd_sc_hd__mux2_1
XFILLER_0_137_809 VPWR VGND VPWR VGND sky130_ef_sc_hd__decap_12
X_5995_ _2198_ _2646_ _2709_ VGND VGND VPWR VPWR _2710_ sky130_fd_sc_hd__a21oi_1
X_7734_ _3795_ VGND VGND VPWR VPWR _0279_ sky130_fd_sc_hd__clkbuf_1
XFILLER_0_47_623 VGND VGND VPWR VPWR sky130_fd_sc_hd__fill_2
XFILLER_0_115_93 VPWR VGND VPWR VGND sky130_ef_sc_hd__decap_12
X_4946_ rf.registers\[0\]\[3\] rf.registers\[1\]\[3\] rf.registers\[2\]\[3\] rf.registers\[3\]\[3\]
+ _1703_ _1704_ VGND VGND VPWR VPWR _1706_ sky130_fd_sc_hd__mux4_1
XFILLER_0_74_442 VPWR VGND VPWR VGND sky130_ef_sc_hd__decap_12
XFILLER_0_129_393 VPWR VGND VPWR VGND sky130_ef_sc_hd__decap_12
X_4877_ _1638_ _1639_ _1635_ VGND VGND VPWR VPWR _1640_ sky130_fd_sc_hd__mux2_1
X_7665_ _3758_ VGND VGND VPWR VPWR _0247_ sky130_fd_sc_hd__clkbuf_1
X_9404_ clknet_leaf_26_CLK _0492_ VGND VGND VPWR VPWR rf.registers\[21\]\[11\] sky130_fd_sc_hd__dfxtp_1
XFILLER_0_74_497 VGND VGND VPWR VPWR sky130_fd_sc_hd__decap_8
X_6616_ _3174_ VGND VGND VPWR VPWR _0806_ sky130_fd_sc_hd__clkbuf_1
XFILLER_0_7_753 VPWR VGND VPWR VGND sky130_ef_sc_hd__decap_12
X_7596_ _3393_ rf.registers\[27\]\[22\] _3719_ VGND VGND VPWR VPWR _3722_ sky130_fd_sc_hd__mux2_1
XFILLER_0_131_81 VPWR VGND VPWR VGND sky130_ef_sc_hd__decap_12
XFILLER_0_104_216 VGND VGND VPWR VPWR sky130_fd_sc_hd__decap_3
X_9335_ clknet_leaf_64_CLK _0423_ VGND VGND VPWR VPWR rf.registers\[7\]\[6\] sky130_fd_sc_hd__dfxtp_1
X_6547_ _3137_ VGND VGND VPWR VPWR _0774_ sky130_fd_sc_hd__clkbuf_1
XFILLER_0_61_169 VGND VGND VPWR VPWR sky130_fd_sc_hd__fill_2
XFILLER_0_7_797 VPWR VGND VPWR VGND sky130_ef_sc_hd__decap_12
XFILLER_0_15_553 VGND VGND VPWR VPWR sky130_fd_sc_hd__decap_6
XTAP_TAPCELL_ROW_95_1723 VGND VPWR sky130_fd_sc_hd__tapvpwrvgnd_1
X_9266_ clknet_leaf_43_CLK _0354_ VGND VGND VPWR VPWR rf.registers\[23\]\[1\] sky130_fd_sc_hd__dfxtp_1
XFILLER_0_113_783 VGND VGND VPWR VPWR sky130_fd_sc_hd__fill_1
X_6478_ _3100_ VGND VGND VPWR VPWR _0742_ sky130_fd_sc_hd__clkbuf_1
XFILLER_0_30_545 VGND VGND VPWR VPWR sky130_fd_sc_hd__decap_8
XTAP_TAPCELL_ROW_7_402 VGND VPWR sky130_fd_sc_hd__tapvpwrvgnd_1
X_8217_ _4051_ VGND VGND VPWR VPWR _0506_ sky130_fd_sc_hd__clkbuf_1
X_5429_ _2161_ _2162_ _2081_ VGND VGND VPWR VPWR _2163_ sky130_fd_sc_hd__mux2_1
X_9197_ clknet_leaf_94_CLK _0285_ VGND VGND VPWR VPWR rf.registers\[30\]\[28\] sky130_fd_sc_hd__dfxtp_1
XFILLER_0_11_781 VGND VGND VPWR VPWR sky130_fd_sc_hd__decap_3
X_8148_ _2963_ rf.registers\[26\]\[25\] _4009_ VGND VGND VPWR VPWR _4015_ sky130_fd_sc_hd__mux2_1
X_8079_ _3978_ VGND VGND VPWR VPWR _0441_ sky130_fd_sc_hd__clkbuf_1
XFILLER_0_69_225 VPWR VGND VPWR VGND sky130_ef_sc_hd__decap_12
XFILLER_0_85_718 VGND VGND VPWR VPWR sky130_fd_sc_hd__decap_8
XFILLER_0_85_729 VPWR VGND VPWR VGND sky130_ef_sc_hd__decap_12
XFILLER_0_78_781 VPWR VGND VPWR VGND sky130_ef_sc_hd__decap_12
XTAP_TAPCELL_ROW_104_1863 VGND VPWR sky130_fd_sc_hd__tapvpwrvgnd_1
XFILLER_0_38_645 VPWR VGND VPWR VGND sky130_ef_sc_hd__decap_12
XFILLER_0_53_615 VGND VGND VPWR VPWR sky130_fd_sc_hd__fill_1
XFILLER_0_37_166 VGND VGND VPWR VPWR sky130_fd_sc_hd__fill_2
XTAP_TAPCELL_ROW_137_2362 VGND VPWR sky130_fd_sc_hd__tapvpwrvgnd_1
XTAP_TAPCELL_ROW_137_2351 VGND VPWR sky130_fd_sc_hd__tapvpwrvgnd_1
XFILLER_0_123_503 VGND VGND VPWR VPWR sky130_fd_sc_hd__fill_1
XFILLER_0_135_385 VGND VGND VPWR VPWR sky130_fd_sc_hd__decap_6
XFILLER_0_52_136 VGND VGND VPWR VPWR sky130_fd_sc_hd__decap_4
XFILLER_0_20_27 VGND VGND VPWR VPWR sky130_fd_sc_hd__fill_1
XFILLER_0_111_709 VPWR VGND VPWR VGND sky130_ef_sc_hd__decap_12
XFILLER_0_61_670 VGND VGND VPWR VPWR sky130_fd_sc_hd__fill_2
XFILLER_0_0_439 VGND VGND VPWR VPWR sky130_fd_sc_hd__decap_8
XFILLER_0_29_47 VGND VGND VPWR VPWR sky130_fd_sc_hd__decap_3
XFILLER_0_136_15 VPWR VGND VPWR VGND sky130_ef_sc_hd__decap_12
XFILLER_0_119_809 VPWR VGND VPWR VGND sky130_ef_sc_hd__decap_12
X_4800_ _1565_ _1566_ _1397_ VGND VGND VPWR VPWR _1567_ sky130_fd_sc_hd__mux2_1
X_5780_ _2269_ _2499_ _2504_ _2505_ VGND VGND VPWR VPWR _2506_ sky130_fd_sc_hd__a2bb2o_1
XFILLER_0_17_818 VPWR VGND VPWR VGND sky130_ef_sc_hd__decap_12
XFILLER_0_29_689 VGND VGND VPWR VPWR sky130_fd_sc_hd__fill_1
X_4731_ _1500_ _1501_ _1137_ VGND VGND VPWR VPWR _1502_ sky130_fd_sc_hd__mux2_1
X_7450_ _3644_ VGND VGND VPWR VPWR _0146_ sky130_fd_sc_hd__clkbuf_1
XFILLER_0_56_486 VGND VGND VPWR VPWR sky130_fd_sc_hd__fill_2
X_4662_ rf.registers\[8\]\[20\] rf.registers\[9\]\[20\] rf.registers\[10\]\[20\] rf.registers\[11\]\[20\]
+ _1283_ _1284_ VGND VGND VPWR VPWR _1437_ sky130_fd_sc_hd__mux4_1
XFILLER_0_4_701 VPWR VGND VPWR VGND sky130_ef_sc_hd__decap_12
XTAP_TAPCELL_ROW_32_779 VGND VPWR sky130_fd_sc_hd__tapvpwrvgnd_1
XFILLER_0_126_363 VGND VGND VPWR VPWR sky130_fd_sc_hd__fill_1
X_6401_ rf.registers\[11\]\[2\] _2991_ _3056_ VGND VGND VPWR VPWR _3059_ sky130_fd_sc_hd__mux2_1
XFILLER_0_114_536 VGND VGND VPWR VPWR sky130_fd_sc_hd__fill_2
XTAP_TAPCELL_ROW_12_481 VGND VPWR sky130_fd_sc_hd__tapvpwrvgnd_1
XFILLER_0_9_57 VPWR VGND VPWR VGND sky130_ef_sc_hd__decap_12
XFILLER_0_44_659 VGND VGND VPWR VPWR sky130_fd_sc_hd__decap_3
X_9120_ clknet_leaf_22_CLK _0208_ VGND VGND VPWR VPWR rf.registers\[27\]\[15\] sky130_fd_sc_hd__dfxtp_1
XFILLER_0_101_51 VGND VGND VPWR VPWR sky130_fd_sc_hd__decap_4
X_4593_ rf.registers\[12\]\[16\] rf.registers\[13\]\[16\] rf.registers\[14\]\[16\]
+ rf.registers\[15\]\[16\] _1283_ _1199_ VGND VGND VPWR VPWR _1372_ sky130_fd_sc_hd__mux4_1
X_7381_ _3607_ VGND VGND VPWR VPWR _0114_ sky130_fd_sc_hd__clkbuf_1
XFILLER_0_12_501 VPWR VGND VPWR VGND sky130_ef_sc_hd__decap_12
XFILLER_0_43_169 VGND VGND VPWR VPWR sky130_fd_sc_hd__decap_6
X_6332_ net17 VGND VGND VPWR VPWR _3012_ sky130_fd_sc_hd__clkbuf_2
XFILLER_0_101_73 VGND VGND VPWR VPWR sky130_fd_sc_hd__fill_1
XTAP_TAPCELL_ROW_77_1453 VGND VPWR sky130_fd_sc_hd__tapvpwrvgnd_1
XFILLER_0_12_545 VGND VGND VPWR VPWR sky130_fd_sc_hd__decap_6
X_9051_ clknet_leaf_26_CLK _0139_ VGND VGND VPWR VPWR rf.registers\[29\]\[10\] sky130_fd_sc_hd__dfxtp_1
XFILLER_0_12_589 VPWR VGND VPWR VGND sky130_ef_sc_hd__decap_12
X_6263_ _2391_ _2956_ _2962_ VGND VGND VPWR VPWR net137 sky130_fd_sc_hd__a21bo_2
X_5214_ _1930_ VGND VGND VPWR VPWR _1960_ sky130_fd_sc_hd__buf_4
X_8002_ _3388_ rf.registers\[22\]\[20\] _3937_ VGND VGND VPWR VPWR _3938_ sky130_fd_sc_hd__mux2_1
XTAP_TAPCELL_ROW_90_1653 VGND VPWR sky130_fd_sc_hd__tapvpwrvgnd_1
X_6194_ _2891_ _2892_ _2897_ VGND VGND VPWR VPWR net132 sky130_fd_sc_hd__a21bo_2
X_5145_ rf.registers\[12\]\[14\] rf.registers\[13\]\[14\] rf.registers\[14\]\[14\]
+ rf.registers\[15\]\[14\] _1684_ _1685_ VGND VGND VPWR VPWR _1894_ sky130_fd_sc_hd__mux4_1
XFILLER_0_36_3 VPWR VGND VPWR VGND sky130_ef_sc_hd__decap_12
X_5076_ _1827_ _1828_ _1663_ VGND VGND VPWR VPWR _1829_ sky130_fd_sc_hd__mux2_1
X_8904_ clknet_leaf_82_CLK _1016_ VGND VGND VPWR VPWR rf.registers\[5\]\[23\] sky130_fd_sc_hd__dfxtp_1
XFILLER_0_94_526 VGND VGND VPWR VPWR sky130_fd_sc_hd__fill_2
XFILLER_0_67_729 VPWR VGND VPWR VGND sky130_ef_sc_hd__decap_12
XFILLER_0_66_228 VGND VGND VPWR VPWR sky130_fd_sc_hd__fill_2
X_8835_ clknet_leaf_6_CLK _0947_ VGND VGND VPWR VPWR rf.registers\[15\]\[18\] sky130_fd_sc_hd__dfxtp_1
XFILLER_0_137_617 VPWR VGND VPWR VGND sky130_ef_sc_hd__decap_12
X_8766_ clknet_leaf_30_CLK _0878_ VGND VGND VPWR VPWR rf.registers\[0\]\[13\] sky130_fd_sc_hd__dfxtp_1
XFILLER_0_19_111 VGND VGND VPWR VPWR sky130_fd_sc_hd__fill_1
X_5978_ _2691_ _2693_ VGND VGND VPWR VPWR _2694_ sky130_fd_sc_hd__xnor2_1
X_4929_ rf.registers\[28\]\[3\] rf.registers\[29\]\[3\] rf.registers\[30\]\[3\] rf.registers\[31\]\[3\]
+ _1684_ _1685_ VGND VGND VPWR VPWR _1689_ sky130_fd_sc_hd__mux4_1
X_7717_ _3786_ VGND VGND VPWR VPWR _0271_ sky130_fd_sc_hd__clkbuf_1
X_8697_ clknet_leaf_36_CLK _0809_ VGND VGND VPWR VPWR rf.registers\[24\]\[8\] sky130_fd_sc_hd__dfxtp_1
X_7648_ _3749_ VGND VGND VPWR VPWR _0239_ sky130_fd_sc_hd__clkbuf_1
XFILLER_0_35_637 VGND VGND VPWR VPWR sky130_fd_sc_hd__fill_1
XTAP_TAPCELL_ROW_119_2081 VGND VPWR sky130_fd_sc_hd__tapvpwrvgnd_1
XFILLER_0_105_514 VPWR VGND VPWR VGND sky130_ef_sc_hd__decap_12
XFILLER_0_7_561 VGND VGND VPWR VPWR sky130_fd_sc_hd__decap_4
XFILLER_0_132_333 VPWR VGND VPWR VGND sky130_ef_sc_hd__decap_12
XTAP_TAPCELL_ROW_119_2092 VGND VPWR sky130_fd_sc_hd__tapvpwrvgnd_1
X_7579_ _3376_ rf.registers\[27\]\[14\] _3708_ VGND VGND VPWR VPWR _3713_ sky130_fd_sc_hd__mux2_1
XFILLER_0_105_558 VGND VGND VPWR VPWR sky130_fd_sc_hd__fill_2
XFILLER_0_15_361 VPWR VGND VPWR VGND sky130_ef_sc_hd__decap_12
XFILLER_0_22_309 VGND VGND VPWR VPWR sky130_fd_sc_hd__decap_3
XFILLER_0_31_821 VPWR VGND VPWR VGND sky130_ef_sc_hd__decap_12
XFILLER_0_43_670 VGND VGND VPWR VPWR sky130_fd_sc_hd__fill_2
XFILLER_0_132_377 VPWR VGND VPWR VGND sky130_ef_sc_hd__decap_12
X_9318_ clknet_leaf_80_CLK _0406_ VGND VGND VPWR VPWR rf.registers\[22\]\[21\] sky130_fd_sc_hd__dfxtp_1
XTAP_TAPCELL_ROW_132_2281 VGND VPWR sky130_fd_sc_hd__tapvpwrvgnd_1
X_9249_ clknet_leaf_15_CLK _0337_ VGND VGND VPWR VPWR rf.registers\[28\]\[16\] sky130_fd_sc_hd__dfxtp_1
XFILLER_0_30_342 VPWR VGND VPWR VGND sky130_ef_sc_hd__decap_12
XFILLER_0_101_753 VPWR VGND VPWR VGND sky130_ef_sc_hd__decap_12
XFILLER_0_101_797 VPWR VGND VPWR VGND sky130_ef_sc_hd__decap_12
XFILLER_0_100_285 VGND VGND VPWR VPWR sky130_fd_sc_hd__fill_1
XFILLER_0_106_29 VPWR VGND VPWR VGND sky130_ef_sc_hd__decap_12
XTAP_TAPCELL_ROW_48_1021 VGND VPWR sky130_fd_sc_hd__tapvpwrvgnd_1
XTAP_TAPCELL_ROW_39_890 VGND VPWR sky130_fd_sc_hd__tapvpwrvgnd_1
XFILLER_0_127_105 VGND VGND VPWR VPWR sky130_fd_sc_hd__decap_6
XTAP_TAPCELL_ROW_61_1221 VGND VPWR sky130_fd_sc_hd__tapvpwrvgnd_1
XTAP_TAPCELL_ROW_61_1210 VGND VPWR sky130_fd_sc_hd__tapvpwrvgnd_1
XFILLER_0_127_149 VPWR VGND VPWR VGND sky130_ef_sc_hd__decap_12
XFILLER_0_93_570 VPWR VGND VPWR VGND sky130_ef_sc_hd__decap_12
XFILLER_0_81_721 VGND VGND VPWR VPWR sky130_fd_sc_hd__decap_6
XFILLER_0_81_765 VPWR VGND VPWR VGND sky130_ef_sc_hd__decap_12
XFILLER_0_135_193 VPWR VGND VPWR VGND sky130_ef_sc_hd__decap_12
XFILLER_0_103_7 VPWR VGND VPWR VGND sky130_ef_sc_hd__decap_12
XFILLER_0_25_169 VGND VGND VPWR VPWR sky130_fd_sc_hd__fill_1
XTAP_TAPCELL_ROW_59_1183 VGND VPWR sky130_fd_sc_hd__tapvpwrvgnd_1
XFILLER_0_0_225 VPWR VGND VPWR VGND sky130_ef_sc_hd__decap_12
XTAP_TAPCELL_ROW_72_1383 VGND VPWR sky130_fd_sc_hd__tapvpwrvgnd_1
XFILLER_0_56_56 VGND VGND VPWR VPWR sky130_fd_sc_hd__decap_6
X_6950_ _3373_ VGND VGND VPWR VPWR _0941_ sky130_fd_sc_hd__clkbuf_1
XFILLER_0_89_821 VPWR VGND VPWR VGND sky130_ef_sc_hd__decap_12
X_5901_ net83 _2620_ VGND VGND VPWR VPWR _2621_ sky130_fd_sc_hd__xnor2_2
XTAP_TAPCELL_ROW_37_849 VGND VPWR sky130_fd_sc_hd__tapvpwrvgnd_1
XFILLER_0_49_729 VPWR VGND VPWR VGND sky130_ef_sc_hd__decap_12
X_6881_ net29 VGND VGND VPWR VPWR _3326_ sky130_fd_sc_hd__buf_2
XFILLER_0_119_617 VGND VGND VPWR VPWR sky130_fd_sc_hd__fill_2
XTAP_TAPCELL_ROW_17_551 VGND VPWR sky130_fd_sc_hd__tapvpwrvgnd_1
XTAP_TAPCELL_ROW_17_562 VGND VPWR sky130_fd_sc_hd__tapvpwrvgnd_1
X_5832_ _2240_ _2445_ _2447_ _2254_ VGND VGND VPWR VPWR _2556_ sky130_fd_sc_hd__a22o_1
X_8620_ clknet_leaf_86_CLK _0732_ VGND VGND VPWR VPWR rf.registers\[11\]\[27\] sky130_fd_sc_hd__dfxtp_1
X_8551_ _4227_ VGND VGND VPWR VPWR _0664_ sky130_fd_sc_hd__clkbuf_1
X_5763_ _2487_ _2488_ VGND VGND VPWR VPWR _2489_ sky130_fd_sc_hd__nor2_1
XFILLER_0_127_661 VGND VGND VPWR VPWR sky130_fd_sc_hd__decap_8
X_7502_ _3660_ VGND VGND VPWR VPWR _3672_ sky130_fd_sc_hd__clkbuf_8
X_4714_ _1484_ _1485_ _1381_ VGND VGND VPWR VPWR _1486_ sky130_fd_sc_hd__mux2_1
XFILLER_0_17_626 VPWR VGND VPWR VGND sky130_ef_sc_hd__decap_12
X_8482_ _3033_ rf.registers\[14\]\[22\] _4189_ VGND VGND VPWR VPWR _4192_ sky130_fd_sc_hd__mux2_1
XFILLER_0_56_294 VGND VGND VPWR VPWR sky130_fd_sc_hd__fill_1
X_5694_ _2269_ _2422_ VGND VGND VPWR VPWR _2423_ sky130_fd_sc_hd__or2_1
XFILLER_0_112_83 VGND VGND VPWR VPWR sky130_fd_sc_hd__fill_1
X_7433_ _3635_ VGND VGND VPWR VPWR _0138_ sky130_fd_sc_hd__clkbuf_1
X_4645_ rf.registers\[8\]\[19\] rf.registers\[9\]\[19\] rf.registers\[10\]\[19\] rf.registers\[11\]\[19\]
+ _1403_ _1404_ VGND VGND VPWR VPWR _1421_ sky130_fd_sc_hd__mux4_1
XFILLER_0_4_531 VGND VGND VPWR VPWR sky130_fd_sc_hd__fill_1
XFILLER_0_13_821 VPWR VGND VPWR VGND sky130_ef_sc_hd__decap_12
XFILLER_0_21_81 VGND VGND VPWR VPWR sky130_fd_sc_hd__decap_8
XFILLER_0_32_629 VGND VGND VPWR VPWR sky130_fd_sc_hd__decap_3
X_7364_ _3598_ VGND VGND VPWR VPWR _0106_ sky130_fd_sc_hd__clkbuf_1
X_4576_ _1354_ _1355_ _1312_ VGND VGND VPWR VPWR _1356_ sky130_fd_sc_hd__mux2_1
XFILLER_0_130_837 VGND VGND VPWR VPWR sky130_fd_sc_hd__fill_2
X_6315_ _3000_ VGND VGND VPWR VPWR _0679_ sky130_fd_sc_hd__clkbuf_1
X_9103_ clknet_leaf_74_CLK _0191_ VGND VGND VPWR VPWR rf.registers\[31\]\[30\] sky130_fd_sc_hd__dfxtp_1
X_7295_ rf.registers\[3\]\[9\] _3296_ _3552_ VGND VGND VPWR VPWR _3562_ sky130_fd_sc_hd__mux2_1
X_9034_ clknet_leaf_68_CLK _0122_ VGND VGND VPWR VPWR rf.registers\[8\]\[25\] sky130_fd_sc_hd__dfxtp_1
XFILLER_0_40_684 VGND VGND VPWR VPWR sky130_fd_sc_hd__decap_8
X_6246_ _2909_ _2932_ VGND VGND VPWR VPWR _2947_ sky130_fd_sc_hd__nand2_1
XPHY_EDGE_ROW_110_Left_249 VGND VGND VPWR VPWR sky130_fd_sc_hd__decap_3
X_6177_ _2880_ _2881_ VGND VGND VPWR VPWR _2882_ sky130_fd_sc_hd__or2b_1
X_5128_ _1876_ _1877_ _1663_ VGND VGND VPWR VPWR _1878_ sky130_fd_sc_hd__mux2_1
X_5059_ rf.registers\[16\]\[9\] rf.registers\[17\]\[9\] rf.registers\[18\]\[9\] rf.registers\[19\]\[9\]
+ _1729_ _1731_ VGND VGND VPWR VPWR _1813_ sky130_fd_sc_hd__mux4_1
X_8818_ clknet_leaf_46_CLK _0930_ VGND VGND VPWR VPWR rf.registers\[15\]\[1\] sky130_fd_sc_hd__dfxtp_1
XFILLER_0_67_559 VGND VGND VPWR VPWR sky130_fd_sc_hd__fill_1
XFILLER_0_137_447 VGND VGND VPWR VPWR sky130_fd_sc_hd__fill_1
XTAP_TAPCELL_ROW_101_1822 VGND VPWR sky130_fd_sc_hd__tapvpwrvgnd_1
XTAP_TAPCELL_ROW_101_1811 VGND VPWR sky130_fd_sc_hd__tapvpwrvgnd_1
XFILLER_0_48_751 VGND VGND VPWR VPWR sky130_fd_sc_hd__decap_4
XFILLER_0_63_721 VGND VGND VPWR VPWR sky130_fd_sc_hd__decap_6
X_8749_ clknet_leaf_91_CLK _0861_ VGND VGND VPWR VPWR rf.registers\[10\]\[28\] sky130_fd_sc_hd__dfxtp_1
XFILLER_0_35_412 VGND VGND VPWR VPWR sky130_fd_sc_hd__decap_6
XTAP_TAPCELL_ROW_134_2310 VGND VPWR sky130_fd_sc_hd__tapvpwrvgnd_1
XFILLER_0_118_672 VPWR VGND VPWR VGND sky130_ef_sc_hd__decap_12
XPHY_EDGE_ROW_109_Right_109 VGND VGND VPWR VPWR sky130_fd_sc_hd__decap_3
XFILLER_0_63_765 VPWR VGND VPWR VGND sky130_ef_sc_hd__decap_12
XFILLER_0_133_653 VPWR VGND VPWR VGND sky130_ef_sc_hd__decap_12
XFILLER_0_117_193 VPWR VGND VPWR VGND sky130_ef_sc_hd__decap_12
XFILLER_0_7_391 VGND VGND VPWR VPWR sky130_fd_sc_hd__fill_1
XFILLER_0_132_141 VPWR VGND VPWR VGND sky130_ef_sc_hd__decap_12
XFILLER_0_50_437 VGND VGND VPWR VPWR sky130_fd_sc_hd__decap_8
XFILLER_0_16_681 VGND VGND VPWR VPWR sky130_fd_sc_hd__fill_1
XFILLER_0_133_697 VPWR VGND VPWR VGND sky130_ef_sc_hd__decap_12
XFILLER_0_120_336 VGND VGND VPWR VPWR sky130_fd_sc_hd__decap_3
XFILLER_0_31_673 VGND VGND VPWR VPWR sky130_fd_sc_hd__fill_1
XFILLER_0_120_369 VGND VGND VPWR VPWR sky130_fd_sc_hd__fill_1
XTAP_TAPCELL_ROW_112_1984 VGND VPWR sky130_fd_sc_hd__tapvpwrvgnd_1
XTAP_TAPCELL_ROW_112_1973 VGND VPWR sky130_fd_sc_hd__tapvpwrvgnd_1
XFILLER_0_26_15 VPWR VGND VPWR VGND sky130_ef_sc_hd__decap_12
XFILLER_0_117_39 VPWR VGND VPWR VGND sky130_ef_sc_hd__decap_12
XFILLER_0_89_106 VGND VGND VPWR VPWR sky130_fd_sc_hd__decap_6
XFILLER_0_86_813 VPWR VGND VPWR VGND sky130_ef_sc_hd__decap_12
XTAP_TAPCELL_ROW_34_808 VGND VPWR sky130_fd_sc_hd__tapvpwrvgnd_1
XFILLER_0_133_27 VPWR VGND VPWR VGND sky130_ef_sc_hd__decap_12
XFILLER_0_128_403 VPWR VGND VPWR VGND sky130_ef_sc_hd__decap_12
XTAP_TAPCELL_ROW_14_510 VGND VPWR sky130_fd_sc_hd__tapvpwrvgnd_1
XFILLER_0_39_751 VGND VGND VPWR VPWR sky130_fd_sc_hd__decap_6
XFILLER_0_39_773 VGND VGND VPWR VPWR sky130_fd_sc_hd__decap_8
XFILLER_0_5_317 VPWR VGND VPWR VGND sky130_ef_sc_hd__decap_12
XFILLER_0_109_694 VPWR VGND VPWR VGND sky130_ef_sc_hd__decap_12
X_4430_ rf.registers\[0\]\[7\] rf.registers\[1\]\[7\] rf.registers\[2\]\[7\] rf.registers\[3\]\[7\]
+ _1147_ _1149_ VGND VGND VPWR VPWR _1218_ sky130_fd_sc_hd__mux4_1
XANTENNA_2 _1156_ VGND VGND VPWR VPWR sky130_fd_sc_hd__diode_2
XFILLER_0_112_837 VGND VGND VPWR VPWR sky130_fd_sc_hd__fill_2
XTAP_TAPCELL_ROW_74_1412 VGND VPWR sky130_fd_sc_hd__tapvpwrvgnd_1
XFILLER_0_22_662 VPWR VGND VPWR VGND sky130_ef_sc_hd__decap_12
X_4361_ rf.registers\[4\]\[4\] rf.registers\[5\]\[4\] rf.registers\[6\]\[4\] rf.registers\[7\]\[4\]
+ _1139_ _1140_ VGND VGND VPWR VPWR _1152_ sky130_fd_sc_hd__mux4_1
X_6100_ _1445_ _1462_ _2200_ _2646_ _2709_ VGND VGND VPWR VPWR _2809_ sky130_fd_sc_hd__a41o_1
XFILLER_0_10_813 VPWR VGND VPWR VGND sky130_ef_sc_hd__decap_12
X_4292_ _1083_ _1084_ _1030_ VGND VGND VPWR VPWR _1085_ sky130_fd_sc_hd__mux2_1
X_7080_ _3448_ VGND VGND VPWR VPWR _0996_ sky130_fd_sc_hd__clkbuf_1
X_6031_ _2737_ _2735_ VGND VGND VPWR VPWR _2744_ sky130_fd_sc_hd__nor2_1
X_7982_ _3927_ VGND VGND VPWR VPWR _0395_ sky130_fd_sc_hd__clkbuf_1
XFILLER_0_89_673 VPWR VGND VPWR VGND sky130_ef_sc_hd__decap_12
X_6933_ _3361_ rf.registers\[15\]\[7\] _3347_ VGND VGND VPWR VPWR _3362_ sky130_fd_sc_hd__mux2_1
XTAP_TAPCELL_ROW_85_1574 VGND VPWR sky130_fd_sc_hd__tapvpwrvgnd_1
X_6864_ _3314_ VGND VGND VPWR VPWR _0914_ sky130_fd_sc_hd__clkbuf_1
XFILLER_0_49_526 VGND VGND VPWR VPWR sky130_fd_sc_hd__decap_8
X_8603_ clknet_leaf_33_CLK _0715_ VGND VGND VPWR VPWR rf.registers\[11\]\[10\] sky130_fd_sc_hd__dfxtp_1
XFILLER_0_92_805 VGND VGND VPWR VPWR sky130_fd_sc_hd__decap_6
X_5815_ _2537_ _2539_ VGND VGND VPWR VPWR _2540_ sky130_fd_sc_hd__xnor2_1
XFILLER_0_8_133 VGND VGND VPWR VPWR sky130_fd_sc_hd__decap_6
X_6795_ _3269_ VGND VGND VPWR VPWR _0890_ sky130_fd_sc_hd__clkbuf_1
XFILLER_0_45_710 VGND VGND VPWR VPWR sky130_fd_sc_hd__fill_2
XFILLER_0_123_93 VPWR VGND VPWR VGND sky130_ef_sc_hd__decap_12
X_8534_ _3018_ rf.registers\[13\]\[15\] _4216_ VGND VGND VPWR VPWR _4219_ sky130_fd_sc_hd__mux2_1
XFILLER_0_57_592 VGND VGND VPWR VPWR sky130_fd_sc_hd__decap_4
X_5746_ _2472_ VGND VGND VPWR VPWR _2473_ sky130_fd_sc_hd__clkbuf_2
XFILLER_0_8_177 VPWR VGND VPWR VGND sky130_ef_sc_hd__decap_12
X_8465_ _3016_ rf.registers\[14\]\[14\] _4178_ VGND VGND VPWR VPWR _4183_ sky130_fd_sc_hd__mux2_1
XFILLER_0_60_713 VPWR VGND VPWR VGND sky130_ef_sc_hd__decap_12
X_5677_ _2300_ _2222_ _2383_ VGND VGND VPWR VPWR _2406_ sky130_fd_sc_hd__mux2_1
X_7416_ _3349_ rf.registers\[29\]\[1\] _3625_ VGND VGND VPWR VPWR _3627_ sky130_fd_sc_hd__mux2_1
XTAP_TAPCELL_ROW_116_2040 VGND VPWR sky130_fd_sc_hd__tapvpwrvgnd_1
XFILLER_0_114_141 VPWR VGND VPWR VGND sky130_ef_sc_hd__decap_12
X_4628_ rf.registers\[8\]\[18\] rf.registers\[9\]\[18\] rf.registers\[10\]\[18\] rf.registers\[11\]\[18\]
+ _1403_ _1404_ VGND VGND VPWR VPWR _1405_ sky130_fd_sc_hd__mux4_1
XFILLER_0_60_757 VPWR VGND VPWR VGND sky130_ef_sc_hd__decap_12
XFILLER_0_130_645 VPWR VGND VPWR VGND sky130_ef_sc_hd__decap_12
X_8396_ _4146_ VGND VGND VPWR VPWR _0590_ sky130_fd_sc_hd__clkbuf_1
X_7347_ rf.registers\[8\]\[1\] _3280_ _3588_ VGND VGND VPWR VPWR _3590_ sky130_fd_sc_hd__mux2_1
XFILLER_0_102_358 VGND VGND VPWR VPWR sky130_fd_sc_hd__fill_2
X_4559_ rf.registers\[4\]\[14\] rf.registers\[5\]\[14\] rf.registers\[6\]\[14\] rf.registers\[7\]\[14\]
+ _1320_ _1321_ VGND VGND VPWR VPWR _1340_ sky130_fd_sc_hd__mux4_1
XFILLER_0_13_673 VGND VGND VPWR VPWR sky130_fd_sc_hd__decap_6
X_7278_ _3553_ VGND VGND VPWR VPWR _0065_ sky130_fd_sc_hd__clkbuf_1
X_9017_ clknet_leaf_49_CLK _0105_ VGND VGND VPWR VPWR rf.registers\[8\]\[8\] sky130_fd_sc_hd__dfxtp_1
X_6229_ _2165_ _2929_ VGND VGND VPWR VPWR _2931_ sky130_fd_sc_hd__or2_1
XFILLER_0_68_813 VPWR VGND VPWR VGND sky130_ef_sc_hd__decap_12
XFILLER_0_138_701 VGND VGND VPWR VPWR sky130_fd_sc_hd__decap_6
XFILLER_0_94_153 VGND VGND VPWR VPWR sky130_fd_sc_hd__fill_1
XTAP_TAPCELL_ROW_0_282 VGND VPWR sky130_fd_sc_hd__tapvpwrvgnd_1
XTAP_TAPCELL_ROW_0_293 VGND VPWR sky130_fd_sc_hd__tapvpwrvgnd_1
XFILLER_0_103_19 VPWR VGND VPWR VGND sky130_ef_sc_hd__decap_12
XFILLER_0_94_197 VGND VGND VPWR VPWR sky130_fd_sc_hd__fill_2
XFILLER_0_51_702 VPWR VGND VPWR VGND sky130_ef_sc_hd__decap_12
XFILLER_0_106_675 VPWR VGND VPWR VGND sky130_ef_sc_hd__decap_12
XFILLER_0_2_309 VPWR VGND VPWR VGND sky130_ef_sc_hd__decap_12
XFILLER_0_23_437 VGND VGND VPWR VPWR sky130_fd_sc_hd__decap_4
XFILLER_0_121_667 VGND VGND VPWR VPWR sky130_fd_sc_hd__decap_4
XFILLER_0_120_133 VGND VGND VPWR VPWR sky130_fd_sc_hd__decap_6
XFILLER_0_10_109 VPWR VGND VPWR VGND sky130_ef_sc_hd__decap_12
XFILLER_0_120_177 VPWR VGND VPWR VGND sky130_ef_sc_hd__decap_12
XTAP_TAPCELL_ROW_56_1142 VGND VPWR sky130_fd_sc_hd__tapvpwrvgnd_1
Xoutput50 net50 VGND VGND VPWR VPWR RD1[10] sky130_fd_sc_hd__buf_1
Xoutput61 net61 VGND VGND VPWR VPWR RD1[20] sky130_fd_sc_hd__buf_1
XFILLER_0_128_27 VGND VGND VPWR VPWR sky130_fd_sc_hd__fill_1
Xoutput83 net83 VGND VGND VPWR VPWR RD2[11] sky130_fd_sc_hd__buf_1
Xoutput94 net94 VGND VGND VPWR VPWR RD2[21] sky130_fd_sc_hd__buf_1
Xoutput72 net72 VGND VGND VPWR VPWR RD1[30] sky130_fd_sc_hd__buf_1
XFILLER_0_86_621 VGND VGND VPWR VPWR sky130_fd_sc_hd__decap_4
XTAP_TAPCELL_ROW_47_999 VGND VPWR sky130_fd_sc_hd__tapvpwrvgnd_1
XFILLER_0_74_805 VGND VGND VPWR VPWR sky130_fd_sc_hd__decap_6
XFILLER_0_128_233 VPWR VGND VPWR VGND sky130_ef_sc_hd__decap_12
XFILLER_0_73_315 VGND VGND VPWR VPWR sky130_fd_sc_hd__decap_3
XFILLER_0_58_389 VGND VGND VPWR VPWR sky130_fd_sc_hd__fill_2
XFILLER_0_128_288 VPWR VGND VPWR VGND sky130_ef_sc_hd__decap_12
XFILLER_0_73_337 VPWR VGND VPWR VGND sky130_ef_sc_hd__decap_12
X_6580_ rf.registers\[1\]\[21\] _3031_ _3153_ VGND VGND VPWR VPWR _3155_ sky130_fd_sc_hd__mux2_1
X_5600_ _2328_ _2329_ VGND VGND VPWR VPWR _2330_ sky130_fd_sc_hd__nand2_1
XTAP_TAPCELL_ROW_80_1493 VGND VPWR sky130_fd_sc_hd__tapvpwrvgnd_1
XFILLER_0_5_125 VPWR VGND VPWR VGND sky130_ef_sc_hd__decap_12
X_5531_ net47 VGND VGND VPWR VPWR _2262_ sky130_fd_sc_hd__inv_2
X_8250_ _3005_ rf.registers\[25\]\[9\] _4059_ VGND VGND VPWR VPWR _4069_ sky130_fd_sc_hd__mux2_1
XFILLER_0_5_169 VPWR VGND VPWR VGND sky130_ef_sc_hd__decap_12
XFILLER_0_42_757 VGND VGND VPWR VPWR sky130_fd_sc_hd__fill_2
XFILLER_0_124_483 VGND VGND VPWR VPWR sky130_fd_sc_hd__fill_2
XFILLER_0_111_111 VGND VGND VPWR VPWR sky130_fd_sc_hd__fill_1
X_5462_ _2193_ VGND VGND VPWR VPWR net73 sky130_fd_sc_hd__inv_2
X_7201_ rf.registers\[4\]\[29\] _3338_ _3502_ VGND VGND VPWR VPWR _3512_ sky130_fd_sc_hd__mux2_1
X_8181_ _4032_ VGND VGND VPWR VPWR _0489_ sky130_fd_sc_hd__clkbuf_1
X_4413_ _1200_ _1201_ _1145_ VGND VGND VPWR VPWR _1202_ sky130_fd_sc_hd__mux2_1
XFILLER_0_10_621 VGND VGND VPWR VPWR sky130_fd_sc_hd__decap_8
X_5393_ rf.registers\[4\]\[27\] rf.registers\[5\]\[27\] rf.registers\[6\]\[27\] rf.registers\[7\]\[27\]
+ _2008_ _2009_ VGND VGND VPWR VPWR _2129_ sky130_fd_sc_hd__mux4_1
X_4344_ _1025_ VGND VGND VPWR VPWR _1135_ sky130_fd_sc_hd__buf_4
XFILLER_0_10_643 VGND VGND VPWR VPWR sky130_fd_sc_hd__fill_1
X_7132_ _3475_ VGND VGND VPWR VPWR _1021_ sky130_fd_sc_hd__clkbuf_1
X_7063_ rf.registers\[6\]\[28\] _3336_ _3430_ VGND VGND VPWR VPWR _3439_ sky130_fd_sc_hd__mux2_1
X_4275_ _1025_ _1068_ VGND VGND VPWR VPWR _1069_ sky130_fd_sc_hd__nand2_1
XFILLER_0_94_53 VGND VGND VPWR VPWR sky130_fd_sc_hd__decap_8
XFILLER_0_10_698 VGND VGND VPWR VPWR sky130_fd_sc_hd__fill_2
X_6014_ _2725_ _2727_ _2237_ VGND VGND VPWR VPWR _2728_ sky130_fd_sc_hd__mux2_1
XTAP_TAPCELL_ROW_87_1603 VGND VPWR sky130_fd_sc_hd__tapvpwrvgnd_1
XFILLER_0_96_407 VGND VGND VPWR VPWR sky130_fd_sc_hd__decap_4
X_7965_ _3918_ VGND VGND VPWR VPWR _0387_ sky130_fd_sc_hd__clkbuf_1
XFILLER_0_49_334 VGND VGND VPWR VPWR sky130_fd_sc_hd__fill_2
X_7896_ _3351_ rf.registers\[23\]\[2\] _3879_ VGND VGND VPWR VPWR _3882_ sky130_fd_sc_hd__mux2_1
X_6916_ _3350_ VGND VGND VPWR VPWR _0930_ sky130_fd_sc_hd__clkbuf_1
X_6847_ net17 VGND VGND VPWR VPWR _3303_ sky130_fd_sc_hd__clkbuf_2
XFILLER_0_119_288 VGND VGND VPWR VPWR sky130_fd_sc_hd__fill_1
X_9566_ clknet_leaf_29_CLK _0654_ VGND VGND VPWR VPWR rf.registers\[13\]\[13\] sky130_fd_sc_hd__dfxtp_1
X_6778_ _3260_ VGND VGND VPWR VPWR _0882_ sky130_fd_sc_hd__clkbuf_1
X_8517_ _3001_ rf.registers\[13\]\[7\] _4205_ VGND VGND VPWR VPWR _4210_ sky130_fd_sc_hd__mux2_1
XFILLER_0_9_497 VGND VGND VPWR VPWR sky130_fd_sc_hd__decap_6
X_5729_ _2391_ _2436_ _2456_ VGND VGND VPWR VPWR net138 sky130_fd_sc_hd__a21oi_1
X_9497_ clknet_leaf_36_CLK _0585_ VGND VGND VPWR VPWR rf.registers\[18\]\[8\] sky130_fd_sc_hd__dfxtp_1
XTAP_TAPCELL_ROW_98_1765 VGND VPWR sky130_fd_sc_hd__tapvpwrvgnd_1
XTAP_TAPCELL_ROW_98_1776 VGND VPWR sky130_fd_sc_hd__tapvpwrvgnd_1
X_8448_ _2999_ rf.registers\[14\]\[6\] _4167_ VGND VGND VPWR VPWR _4174_ sky130_fd_sc_hd__mux2_1
XFILLER_0_60_565 VGND VGND VPWR VPWR sky130_fd_sc_hd__fill_1
XFILLER_0_33_779 VGND VGND VPWR VPWR sky130_fd_sc_hd__decap_4
X_8379_ _4137_ VGND VGND VPWR VPWR _0582_ sky130_fd_sc_hd__clkbuf_1
XFILLER_0_20_429 VGND VGND VPWR VPWR sky130_fd_sc_hd__decap_3
XTAP_TAPCELL_ROW_129_2242 VGND VPWR sky130_fd_sc_hd__tapvpwrvgnd_1
XTAP_TAPCELL_ROW_129_2231 VGND VPWR sky130_fd_sc_hd__tapvpwrvgnd_1
XTAP_TAPCELL_ROW_51_1061 VGND VPWR sky130_fd_sc_hd__tapvpwrvgnd_1
XFILLER_0_99_234 VGND VGND VPWR VPWR sky130_fd_sc_hd__fill_1
XFILLER_0_99_223 VGND VGND VPWR VPWR sky130_fd_sc_hd__fill_1
XTAP_TAPCELL_ROW_51_1072 VGND VPWR sky130_fd_sc_hd__tapvpwrvgnd_1
XTAP_TAPCELL_ROW_5_374 VGND VPWR sky130_fd_sc_hd__tapvpwrvgnd_1
XFILLER_0_114_29 VPWR VGND VPWR VGND sky130_ef_sc_hd__decap_12
XFILLER_0_56_805 VGND VGND VPWR VPWR sky130_fd_sc_hd__decap_6
XTAP_TAPCELL_ROW_44_958 VGND VPWR sky130_fd_sc_hd__tapvpwrvgnd_1
XFILLER_0_83_613 VGND VGND VPWR VPWR sky130_fd_sc_hd__decap_3
XFILLER_0_83_668 VGND VGND VPWR VPWR sky130_fd_sc_hd__decap_4
XTAP_TAPCELL_ROW_24_660 VGND VPWR sky130_fd_sc_hd__tapvpwrvgnd_1
XFILLER_0_126_737 VPWR VGND VPWR VGND sky130_ef_sc_hd__decap_12
XFILLER_0_125_225 VPWR VGND VPWR VGND sky130_ef_sc_hd__decap_12
XFILLER_0_134_781 VPWR VGND VPWR VGND sky130_ef_sc_hd__decap_12
XFILLER_0_3_629 VPWR VGND VPWR VGND sky130_ef_sc_hd__decap_12
XFILLER_0_24_757 VGND VGND VPWR VPWR sky130_fd_sc_hd__decap_4
XFILLER_0_106_494 VGND VGND VPWR VPWR sky130_fd_sc_hd__fill_1
XFILLER_0_11_429 VPWR VGND VPWR VGND sky130_ef_sc_hd__decap_12
XFILLER_0_2_139 VGND VGND VPWR VPWR sky130_fd_sc_hd__fill_1
XTAP_TAPCELL_ROW_69_1333 VGND VPWR sky130_fd_sc_hd__tapvpwrvgnd_1
XFILLER_0_59_621 VGND VGND VPWR VPWR sky130_fd_sc_hd__decap_8
X_4962_ _1719_ _1720_ _1630_ VGND VGND VPWR VPWR _1721_ sky130_fd_sc_hd__mux2_1
XTAP_TAPCELL_ROW_82_1533 VGND VPWR sky130_fd_sc_hd__tapvpwrvgnd_1
X_7750_ _3803_ VGND VGND VPWR VPWR _0287_ sky130_fd_sc_hd__clkbuf_1
XFILLER_0_129_542 VGND VGND VPWR VPWR sky130_fd_sc_hd__fill_2
X_4893_ _1624_ VGND VGND VPWR VPWR _1655_ sky130_fd_sc_hd__buf_4
X_6701_ rf.registers\[10\]\[13\] _3014_ _3216_ VGND VGND VPWR VPWR _3220_ sky130_fd_sc_hd__mux2_1
X_7681_ _3766_ VGND VGND VPWR VPWR _0255_ sky130_fd_sc_hd__clkbuf_1
XFILLER_0_19_529 VPWR VGND VPWR VGND sky130_ef_sc_hd__decap_12
X_6632_ rf.registers\[24\]\[13\] _3014_ _3179_ VGND VGND VPWR VPWR _3183_ sky130_fd_sc_hd__mux2_1
XFILLER_0_73_134 VGND VGND VPWR VPWR sky130_fd_sc_hd__fill_1
XFILLER_0_6_401 VPWR VGND VPWR VGND sky130_ef_sc_hd__decap_12
X_9420_ clknet_leaf_88_CLK _0508_ VGND VGND VPWR VPWR rf.registers\[21\]\[27\] sky130_fd_sc_hd__dfxtp_1
XFILLER_0_6_445 VPWR VGND VPWR VGND sky130_ef_sc_hd__decap_12
XFILLER_0_13_93 VPWR VGND VPWR VGND sky130_ef_sc_hd__decap_12
XFILLER_0_27_573 VPWR VGND VPWR VGND sky130_ef_sc_hd__decap_12
X_6563_ rf.registers\[1\]\[13\] _3014_ _3142_ VGND VGND VPWR VPWR _3146_ sky130_fd_sc_hd__mux2_1
XFILLER_0_61_329 VGND VGND VPWR VPWR sky130_fd_sc_hd__decap_6
X_9351_ clknet_leaf_8_CLK _0439_ VGND VGND VPWR VPWR rf.registers\[7\]\[22\] sky130_fd_sc_hd__dfxtp_1
XFILLER_0_15_724 VGND VGND VPWR VPWR sky130_fd_sc_hd__decap_4
XFILLER_0_131_217 VGND VGND VPWR VPWR sky130_fd_sc_hd__decap_6
X_8302_ rf.registers\[20\]\[1\] net25 _4095_ VGND VGND VPWR VPWR _4097_ sky130_fd_sc_hd__mux2_1
X_6494_ rf.registers\[17\]\[13\] _3014_ _3105_ VGND VGND VPWR VPWR _3109_ sky130_fd_sc_hd__mux2_1
X_9282_ clknet_leaf_10_CLK _0370_ VGND VGND VPWR VPWR rf.registers\[23\]\[17\] sky130_fd_sc_hd__dfxtp_1
XFILLER_0_6_489 VPWR VGND VPWR VGND sky130_ef_sc_hd__decap_12
XFILLER_0_14_245 VGND VGND VPWR VPWR sky130_fd_sc_hd__decap_6
XFILLER_0_15_757 VGND VGND VPWR VPWR sky130_fd_sc_hd__decap_6
X_5514_ _2243_ _2244_ VGND VGND VPWR VPWR _2245_ sky130_fd_sc_hd__nand2_1
X_8233_ _4060_ VGND VGND VPWR VPWR _0513_ sky130_fd_sc_hd__clkbuf_1
XFILLER_0_120_83 VGND VGND VPWR VPWR sky130_fd_sc_hd__fill_1
XFILLER_0_112_442 VGND VGND VPWR VPWR sky130_fd_sc_hd__fill_2
X_5445_ _2172_ _2174_ _2177_ _1958_ _1940_ VGND VGND VPWR VPWR _2178_ sky130_fd_sc_hd__o221a_1
XFILLER_0_14_289 VPWR VGND VPWR VGND sky130_ef_sc_hd__decap_12
XFILLER_0_42_587 VGND VGND VPWR VPWR sky130_fd_sc_hd__fill_1
XFILLER_0_42_598 VPWR VGND VPWR VGND sky130_ef_sc_hd__decap_12
X_8164_ _3344_ rf.registers\[21\]\[0\] _4023_ VGND VGND VPWR VPWR _4024_ sky130_fd_sc_hd__mux2_1
XFILLER_0_100_615 VGND VGND VPWR VPWR sky130_fd_sc_hd__decap_4
XFILLER_0_66_3 VPWR VGND VPWR VGND sky130_ef_sc_hd__decap_12
XFILLER_0_1_161 VGND VGND VPWR VPWR sky130_fd_sc_hd__decap_6
XTAP_TAPCELL_ROW_93_1695 VGND VPWR sky130_fd_sc_hd__tapvpwrvgnd_1
X_5376_ rf.registers\[0\]\[26\] rf.registers\[1\]\[26\] rf.registers\[2\]\[26\] rf.registers\[3\]\[26\]
+ _2109_ _2110_ VGND VGND VPWR VPWR _2113_ sky130_fd_sc_hd__mux4_1
X_7115_ rf.registers\[5\]\[20\] _3319_ _3466_ VGND VGND VPWR VPWR _3467_ sky130_fd_sc_hd__mux2_1
X_4327_ _1041_ VGND VGND VPWR VPWR _1118_ sky130_fd_sc_hd__buf_4
X_8095_ _3986_ VGND VGND VPWR VPWR _3987_ sky130_fd_sc_hd__buf_4
XFILLER_0_129_81 VPWR VGND VPWR VGND sky130_ef_sc_hd__decap_12
X_4258_ _1025_ _1051_ _1052_ VGND VGND VPWR VPWR _1053_ sky130_fd_sc_hd__a21oi_1
X_7046_ _3407_ VGND VGND VPWR VPWR _3430_ sky130_fd_sc_hd__buf_4
XFILLER_0_97_727 VGND VGND VPWR VPWR sky130_fd_sc_hd__fill_1
XTAP_TAPCELL_ROW_2_333 VGND VPWR sky130_fd_sc_hd__tapvpwrvgnd_1
XTAP_TAPCELL_ROW_124_2161 VGND VPWR sky130_fd_sc_hd__tapvpwrvgnd_1
X_8997_ clknet_leaf_72_CLK _0085_ VGND VGND VPWR VPWR rf.registers\[3\]\[20\] sky130_fd_sc_hd__dfxtp_1
X_7948_ _2972_ rf.registers\[23\]\[27\] _3901_ VGND VGND VPWR VPWR _3909_ sky130_fd_sc_hd__mux2_1
XFILLER_0_65_602 VGND VGND VPWR VPWR sky130_fd_sc_hd__fill_1
XFILLER_0_92_432 VGND VGND VPWR VPWR sky130_fd_sc_hd__fill_1
XFILLER_0_92_421 VGND VGND VPWR VPWR sky130_fd_sc_hd__fill_2
XFILLER_0_9_261 VPWR VGND VPWR VGND sky130_ef_sc_hd__decap_12
X_7879_ _2972_ rf.registers\[28\]\[27\] _3864_ VGND VGND VPWR VPWR _3872_ sky130_fd_sc_hd__mux2_1
XTAP_TAPCELL_ROW_41_917 VGND VPWR sky130_fd_sc_hd__tapvpwrvgnd_1
XFILLER_0_108_737 VPWR VGND VPWR VGND sky130_ef_sc_hd__decap_12
XFILLER_0_92_454 VGND VGND VPWR VPWR sky130_fd_sc_hd__fill_1
XFILLER_0_64_156 VGND VGND VPWR VPWR sky130_fd_sc_hd__fill_1
X_9549_ clknet_leaf_92_CLK _0637_ VGND VGND VPWR VPWR rf.registers\[14\]\[28\] sky130_fd_sc_hd__dfxtp_1
XFILLER_0_123_729 VPWR VGND VPWR VGND sky130_ef_sc_hd__decap_12
XFILLER_0_116_781 VPWR VGND VPWR VGND sky130_ef_sc_hd__decap_12
XFILLER_0_61_841 VGND VGND VPWR VPWR sky130_fd_sc_hd__fill_1
XFILLER_0_103_431 VGND VGND VPWR VPWR sky130_fd_sc_hd__fill_1
XFILLER_0_60_351 VPWR VGND VPWR VGND sky130_ef_sc_hd__decap_12
XFILLER_0_21_716 VGND VGND VPWR VPWR sky130_fd_sc_hd__decap_3
XTAP_TAPCELL_ROW_53_1101 VGND VPWR sky130_fd_sc_hd__tapvpwrvgnd_1
XFILLER_0_18_27 VGND VGND VPWR VPWR sky130_fd_sc_hd__fill_1
XTAP_TAPCELL_ROW_109_1934 VGND VPWR sky130_fd_sc_hd__tapvpwrvgnd_1
XTAP_TAPCELL_ROW_29_730 VGND VPWR sky130_fd_sc_hd__tapvpwrvgnd_1
XFILLER_0_125_39 VPWR VGND VPWR VGND sky130_ef_sc_hd__decap_12
XFILLER_0_88_749 VGND VGND VPWR VPWR sky130_fd_sc_hd__decap_6
XPHY_EDGE_ROW_16_Right_16 VGND VGND VPWR VPWR sky130_fd_sc_hd__decap_3
XTAP_TAPCELL_ROW_29_741 VGND VPWR sky130_fd_sc_hd__tapvpwrvgnd_1
XFILLER_0_34_15 VPWR VGND VPWR VGND sky130_ef_sc_hd__decap_12
XFILLER_0_96_793 VPWR VGND VPWR VGND sky130_ef_sc_hd__decap_12
XFILLER_0_56_624 VGND VGND VPWR VPWR sky130_fd_sc_hd__decap_3
XFILLER_0_56_602 VPWR VGND VPWR VGND sky130_ef_sc_hd__decap_12
XFILLER_0_138_361 VGND VGND VPWR VPWR sky130_fd_sc_hd__decap_3
XFILLER_0_68_495 VGND VGND VPWR VPWR sky130_fd_sc_hd__fill_2
XTAP_TAPCELL_ROW_64_1263 VGND VPWR sky130_fd_sc_hd__tapvpwrvgnd_1
XFILLER_0_83_476 VGND VGND VPWR VPWR sky130_fd_sc_hd__decap_3
XFILLER_0_55_167 VGND VGND VPWR VPWR sky130_fd_sc_hd__fill_1
XFILLER_0_43_307 VPWR VGND VPWR VGND sky130_ef_sc_hd__decap_12
XFILLER_0_24_510 VPWR VGND VPWR VGND sky130_ef_sc_hd__decap_12
XPHY_EDGE_ROW_25_Right_25 VGND VGND VPWR VPWR sky130_fd_sc_hd__decap_3
XFILLER_0_121_261 VPWR VGND VPWR VGND sky130_ef_sc_hd__decap_12
X_5230_ rf.registers\[12\]\[18\] rf.registers\[13\]\[18\] rf.registers\[14\]\[18\]
+ rf.registers\[15\]\[18\] _1919_ _1920_ VGND VGND VPWR VPWR _1975_ sky130_fd_sc_hd__mux4_1
XFILLER_0_11_237 VPWR VGND VPWR VGND sky130_ef_sc_hd__decap_12
X_5161_ _1905_ _1908_ _1764_ VGND VGND VPWR VPWR _1909_ sky130_fd_sc_hd__mux2_1
X_5092_ rf.registers\[28\]\[11\] rf.registers\[29\]\[11\] rf.registers\[30\]\[11\]
+ rf.registers\[31\]\[11\] _1795_ _1736_ VGND VGND VPWR VPWR _1844_ sky130_fd_sc_hd__mux4_1
X_8920_ clknet_leaf_50_CLK _0008_ VGND VGND VPWR VPWR rf.registers\[4\]\[7\] sky130_fd_sc_hd__dfxtp_1
XPHY_EDGE_ROW_34_Right_34 VGND VGND VPWR VPWR sky130_fd_sc_hd__decap_3
X_8851_ clknet_leaf_41_CLK _0963_ VGND VGND VPWR VPWR rf.registers\[6\]\[2\] sky130_fd_sc_hd__dfxtp_1
XFILLER_0_79_727 VGND VGND VPWR VPWR sky130_fd_sc_hd__fill_1
XFILLER_0_91_43 VGND VGND VPWR VPWR sky130_fd_sc_hd__decap_8
X_7802_ _3831_ VGND VGND VPWR VPWR _0311_ sky130_fd_sc_hd__clkbuf_1
X_5994_ _2389_ VGND VGND VPWR VPWR _2709_ sky130_fd_sc_hd__buf_2
X_8782_ clknet_leaf_88_CLK _0894_ VGND VGND VPWR VPWR rf.registers\[0\]\[29\] sky130_fd_sc_hd__dfxtp_1
X_4945_ rf.registers\[4\]\[3\] rf.registers\[5\]\[3\] rf.registers\[6\]\[3\] rf.registers\[7\]\[3\]
+ _1703_ _1704_ VGND VGND VPWR VPWR _1705_ sky130_fd_sc_hd__mux4_1
X_7733_ _3393_ rf.registers\[30\]\[22\] _3792_ VGND VGND VPWR VPWR _3795_ sky130_fd_sc_hd__mux2_1
XFILLER_0_136_309 VPWR VGND VPWR VGND sky130_ef_sc_hd__decap_12
XFILLER_0_129_361 VPWR VGND VPWR VGND sky130_ef_sc_hd__decap_12
XFILLER_0_19_337 VGND VGND VPWR VPWR sky130_fd_sc_hd__decap_8
X_4876_ rf.registers\[0\]\[0\] rf.registers\[1\]\[0\] rf.registers\[2\]\[0\] rf.registers\[3\]\[0\]
+ _1617_ _1618_ VGND VGND VPWR VPWR _1639_ sky130_fd_sc_hd__mux4_1
XFILLER_0_74_454 VPWR VGND VPWR VGND sky130_ef_sc_hd__decap_12
X_7664_ rf.registers\[2\]\[22\] _3324_ _3755_ VGND VGND VPWR VPWR _3758_ sky130_fd_sc_hd__mux2_1
X_9403_ clknet_leaf_26_CLK _0491_ VGND VGND VPWR VPWR rf.registers\[21\]\[10\] sky130_fd_sc_hd__dfxtp_1
X_6615_ rf.registers\[24\]\[5\] _2997_ _3168_ VGND VGND VPWR VPWR _3174_ sky130_fd_sc_hd__mux2_1
X_7595_ _3721_ VGND VGND VPWR VPWR _0214_ sky130_fd_sc_hd__clkbuf_1
XFILLER_0_7_765 VPWR VGND VPWR VGND sky130_ef_sc_hd__decap_12
XFILLER_0_6_253 VPWR VGND VPWR VGND sky130_ef_sc_hd__decap_12
XPHY_EDGE_ROW_43_Right_43 VGND VGND VPWR VPWR sky130_fd_sc_hd__decap_3
XFILLER_0_131_93 VPWR VGND VPWR VGND sky130_ef_sc_hd__decap_12
XFILLER_0_105_729 VPWR VGND VPWR VGND sky130_ef_sc_hd__decap_12
X_9334_ clknet_leaf_65_CLK _0422_ VGND VGND VPWR VPWR rf.registers\[7\]\[5\] sky130_fd_sc_hd__dfxtp_1
X_6546_ rf.registers\[1\]\[5\] _2997_ _3131_ VGND VGND VPWR VPWR _3137_ sky130_fd_sc_hd__mux2_1
XFILLER_0_43_841 VGND VGND VPWR VPWR sky130_fd_sc_hd__fill_1
XTAP_TAPCELL_ROW_95_1724 VGND VPWR sky130_fd_sc_hd__tapvpwrvgnd_1
XFILLER_0_42_362 VGND VGND VPWR VPWR sky130_fd_sc_hd__fill_2
X_9265_ clknet_leaf_39_CLK _0353_ VGND VGND VPWR VPWR rf.registers\[23\]\[0\] sky130_fd_sc_hd__dfxtp_1
X_6477_ rf.registers\[17\]\[5\] _2997_ _3094_ VGND VGND VPWR VPWR _3100_ sky130_fd_sc_hd__mux2_1
XTAP_TAPCELL_ROW_7_403 VGND VPWR sky130_fd_sc_hd__tapvpwrvgnd_1
X_8216_ _3039_ rf.registers\[21\]\[25\] _4045_ VGND VGND VPWR VPWR _4051_ sky130_fd_sc_hd__mux2_1
X_9196_ clknet_leaf_87_CLK _0284_ VGND VGND VPWR VPWR rf.registers\[30\]\[27\] sky130_fd_sc_hd__dfxtp_1
X_5428_ rf.registers\[0\]\[29\] rf.registers\[1\]\[29\] rf.registers\[2\]\[29\] rf.registers\[3\]\[29\]
+ _2086_ _2087_ VGND VGND VPWR VPWR _2162_ sky130_fd_sc_hd__mux4_1
X_5359_ rf.registers\[0\]\[25\] rf.registers\[1\]\[25\] rf.registers\[2\]\[25\] rf.registers\[3\]\[25\]
+ _2008_ _2009_ VGND VGND VPWR VPWR _2097_ sky130_fd_sc_hd__mux4_1
X_8147_ _4014_ VGND VGND VPWR VPWR _0473_ sky130_fd_sc_hd__clkbuf_1
X_8078_ rf.registers\[7\]\[24\] _3328_ _3973_ VGND VGND VPWR VPWR _3978_ sky130_fd_sc_hd__mux2_1
X_7029_ _3421_ VGND VGND VPWR VPWR _0972_ sky130_fd_sc_hd__clkbuf_1
XPHY_EDGE_ROW_52_Right_52 VGND VGND VPWR VPWR sky130_fd_sc_hd__decap_3
XFILLER_0_69_237 VGND VGND VPWR VPWR sky130_fd_sc_hd__decap_4
XTAP_TAPCELL_ROW_104_1864 VGND VPWR sky130_fd_sc_hd__tapvpwrvgnd_1
XTAP_TAPCELL_ROW_104_1853 VGND VPWR sky130_fd_sc_hd__tapvpwrvgnd_1
XFILLER_0_93_741 VPWR VGND VPWR VGND sky130_ef_sc_hd__decap_12
XFILLER_0_78_793 VPWR VGND VPWR VGND sky130_ef_sc_hd__decap_12
XFILLER_0_38_657 VPWR VGND VPWR VGND sky130_ef_sc_hd__decap_12
XFILLER_0_93_785 VPWR VGND VPWR VGND sky130_ef_sc_hd__decap_12
XPHY_EDGE_ROW_61_Right_61 VGND VGND VPWR VPWR sky130_fd_sc_hd__decap_3
XTAP_TAPCELL_ROW_137_2352 VGND VPWR sky130_fd_sc_hd__tapvpwrvgnd_1
XFILLER_0_37_178 VGND VGND VPWR VPWR sky130_fd_sc_hd__fill_1
XFILLER_0_108_589 VGND VGND VPWR VPWR sky130_fd_sc_hd__decap_4
XFILLER_0_46_690 VGND VGND VPWR VPWR sky130_fd_sc_hd__fill_1
XFILLER_0_123_559 VGND VGND VPWR VPWR sky130_fd_sc_hd__fill_1
XFILLER_0_0_429 VGND VGND VPWR VPWR sky130_fd_sc_hd__decap_3
XFILLER_0_21_579 VPWR VGND VPWR VGND sky130_ef_sc_hd__decap_12
XFILLER_0_29_15 VPWR VGND VPWR VGND sky130_ef_sc_hd__decap_12
XPHY_EDGE_ROW_70_Right_70 VGND VGND VPWR VPWR sky130_fd_sc_hd__decap_3
XFILLER_0_136_27 VGND VGND VPWR VPWR sky130_fd_sc_hd__fill_1
XFILLER_0_0_38 VPWR VGND VPWR VGND sky130_ef_sc_hd__decap_12
XFILLER_0_0_27 VGND VGND VPWR VPWR sky130_fd_sc_hd__fill_1
XFILLER_0_29_602 VGND VGND VPWR VPWR sky130_fd_sc_hd__decap_4
XPHY_EDGE_ROW_14_Left_153 VGND VGND VPWR VPWR sky130_fd_sc_hd__decap_3
XFILLER_0_127_821 VPWR VGND VPWR VGND sky130_ef_sc_hd__decap_12
XFILLER_0_16_307 VGND VGND VPWR VPWR sky130_fd_sc_hd__fill_1
X_4730_ rf.registers\[12\]\[24\] rf.registers\[13\]\[24\] rf.registers\[14\]\[24\]
+ rf.registers\[15\]\[24\] _1172_ _1173_ VGND VGND VPWR VPWR _1501_ sky130_fd_sc_hd__mux4_1
XFILLER_0_124_3 VPWR VGND VPWR VGND sky130_ef_sc_hd__decap_12
X_4661_ _1432_ _1435_ _1168_ VGND VGND VPWR VPWR _1436_ sky130_fd_sc_hd__mux2_1
X_6400_ _3058_ VGND VGND VPWR VPWR _0706_ sky130_fd_sc_hd__clkbuf_1
X_7380_ rf.registers\[8\]\[17\] _3313_ _3599_ VGND VGND VPWR VPWR _3607_ sky130_fd_sc_hd__mux2_1
XFILLER_0_9_69 VPWR VGND VPWR VGND sky130_ef_sc_hd__decap_12
XFILLER_0_4_713 VPWR VGND VPWR VGND sky130_ef_sc_hd__decap_12
XFILLER_0_25_830 VGND VGND VPWR VPWR sky130_fd_sc_hd__decap_8
XFILLER_0_25_841 VGND VGND VPWR VPWR sky130_fd_sc_hd__fill_1
X_6331_ _3011_ VGND VGND VPWR VPWR _0684_ sky130_fd_sc_hd__clkbuf_1
X_4592_ rf.registers\[8\]\[16\] rf.registers\[9\]\[16\] rf.registers\[10\]\[16\] rf.registers\[11\]\[16\]
+ _1283_ _1284_ VGND VGND VPWR VPWR _1371_ sky130_fd_sc_hd__mux4_1
XTAP_TAPCELL_ROW_12_482 VGND VPWR sky130_fd_sc_hd__tapvpwrvgnd_1
XFILLER_0_12_513 VPWR VGND VPWR VGND sky130_ef_sc_hd__decap_12
XFILLER_0_4_757 VPWR VGND VPWR VGND sky130_ef_sc_hd__decap_12
XFILLER_0_3_223 VGND VGND VPWR VPWR sky130_fd_sc_hd__fill_1
XFILLER_0_40_811 VGND VGND VPWR VPWR sky130_fd_sc_hd__fill_1
XTAP_TAPCELL_ROW_77_1454 VGND VPWR sky130_fd_sc_hd__tapvpwrvgnd_1
XFILLER_0_51_181 VGND VGND VPWR VPWR sky130_fd_sc_hd__decap_3
X_9050_ clknet_leaf_34_CLK _0138_ VGND VGND VPWR VPWR rf.registers\[29\]\[9\] sky130_fd_sc_hd__dfxtp_1
XFILLER_0_10_83 VGND VGND VPWR VPWR sky130_fd_sc_hd__fill_1
X_6262_ _2698_ _2780_ _2898_ _2440_ _2961_ VGND VGND VPWR VPWR _2962_ sky130_fd_sc_hd__o221a_1
XPHY_EDGE_ROW_23_Left_162 VGND VGND VPWR VPWR sky130_fd_sc_hd__decap_3
XTAP_TAPCELL_ROW_90_1643 VGND VPWR sky130_fd_sc_hd__tapvpwrvgnd_1
X_5213_ _1929_ VGND VGND VPWR VPWR _1959_ sky130_fd_sc_hd__clkbuf_8
X_6193_ _2442_ _2571_ _2629_ _2780_ _2896_ VGND VGND VPWR VPWR _2897_ sky130_fd_sc_hd__o221a_1
X_8001_ _3914_ VGND VGND VPWR VPWR _3937_ sky130_fd_sc_hd__clkbuf_8
X_5144_ _1889_ _1890_ _1891_ _1892_ _1698_ _1628_ VGND VGND VPWR VPWR _1893_ sky130_fd_sc_hd__mux4_2
XTAP_TAPCELL_ROW_90_1654 VGND VPWR sky130_fd_sc_hd__tapvpwrvgnd_1
XFILLER_0_19_81 VPWR VGND VPWR VGND sky130_ef_sc_hd__decap_12
X_5075_ rf.registers\[16\]\[10\] rf.registers\[17\]\[10\] rf.registers\[18\]\[10\]
+ rf.registers\[19\]\[10\] _1652_ _1653_ VGND VGND VPWR VPWR _1828_ sky130_fd_sc_hd__mux4_1
XFILLER_0_29_3 VPWR VGND VPWR VGND sky130_ef_sc_hd__decap_12
X_8903_ clknet_leaf_82_CLK _1015_ VGND VGND VPWR VPWR rf.registers\[5\]\[22\] sky130_fd_sc_hd__dfxtp_1
XTAP_TAPCELL_ROW_121_2120 VGND VPWR sky130_fd_sc_hd__tapvpwrvgnd_1
X_8834_ clknet_leaf_10_CLK _0946_ VGND VGND VPWR VPWR rf.registers\[15\]\[17\] sky130_fd_sc_hd__dfxtp_1
XPHY_EDGE_ROW_32_Left_171 VGND VGND VPWR VPWR sky130_fd_sc_hd__decap_3
XFILLER_0_137_629 VPWR VGND VPWR VGND sky130_ef_sc_hd__decap_12
X_8765_ clknet_leaf_17_CLK _0877_ VGND VGND VPWR VPWR rf.registers\[0\]\[12\] sky130_fd_sc_hd__dfxtp_1
XFILLER_0_75_741 VPWR VGND VPWR VGND sky130_ef_sc_hd__decap_12
XFILLER_0_59_281 VGND VGND VPWR VPWR sky130_fd_sc_hd__decap_8
X_5977_ _2676_ _2679_ _2692_ VGND VGND VPWR VPWR _2693_ sky130_fd_sc_hd__a21o_1
XFILLER_0_136_139 VGND VGND VPWR VPWR sky130_fd_sc_hd__fill_1
X_4928_ _1686_ _1687_ _1663_ VGND VGND VPWR VPWR _1688_ sky130_fd_sc_hd__mux2_1
X_7716_ _3376_ rf.registers\[30\]\[14\] _3781_ VGND VGND VPWR VPWR _3786_ sky130_fd_sc_hd__mux2_1
X_8696_ clknet_leaf_54_CLK _0808_ VGND VGND VPWR VPWR rf.registers\[24\]\[7\] sky130_fd_sc_hd__dfxtp_1
XFILLER_0_74_251 VGND VGND VPWR VPWR sky130_fd_sc_hd__fill_1
XFILLER_0_47_465 VGND VGND VPWR VPWR sky130_fd_sc_hd__fill_1
X_7647_ rf.registers\[2\]\[14\] _3307_ _3744_ VGND VGND VPWR VPWR _3749_ sky130_fd_sc_hd__mux2_1
XFILLER_0_75_785 VPWR VGND VPWR VGND sky130_ef_sc_hd__decap_12
XFILLER_0_19_167 VGND VGND VPWR VPWR sky130_fd_sc_hd__fill_1
XFILLER_0_35_649 VGND VGND VPWR VPWR sky130_fd_sc_hd__fill_1
XFILLER_0_132_301 VGND VGND VPWR VPWR sky130_fd_sc_hd__decap_6
X_4859_ _1619_ _1620_ _1621_ VGND VGND VPWR VPWR _1622_ sky130_fd_sc_hd__mux2_1
XFILLER_0_105_526 VGND VGND VPWR VPWR sky130_fd_sc_hd__decap_6
XFILLER_0_90_755 VGND VGND VPWR VPWR sky130_fd_sc_hd__fill_1
XFILLER_0_132_345 VPWR VGND VPWR VGND sky130_ef_sc_hd__decap_12
XTAP_TAPCELL_ROW_119_2082 VGND VPWR sky130_fd_sc_hd__tapvpwrvgnd_1
X_7578_ _3712_ VGND VGND VPWR VPWR _0206_ sky130_fd_sc_hd__clkbuf_1
XFILLER_0_15_373 VGND VGND VPWR VPWR sky130_fd_sc_hd__decap_4
XFILLER_0_31_833 VGND VGND VPWR VPWR sky130_fd_sc_hd__decap_6
XPHY_EDGE_ROW_41_Left_180 VGND VGND VPWR VPWR sky130_fd_sc_hd__decap_3
X_9317_ clknet_leaf_82_CLK _0405_ VGND VGND VPWR VPWR rf.registers\[22\]\[20\] sky130_fd_sc_hd__dfxtp_1
X_6529_ rf.registers\[17\]\[30\] _3049_ _3093_ VGND VGND VPWR VPWR _3127_ sky130_fd_sc_hd__mux2_1
XTAP_TAPCELL_ROW_132_2282 VGND VPWR sky130_fd_sc_hd__tapvpwrvgnd_1
XFILLER_0_132_389 VPWR VGND VPWR VGND sky130_ef_sc_hd__decap_12
X_9248_ clknet_leaf_23_CLK _0336_ VGND VGND VPWR VPWR rf.registers\[28\]\[15\] sky130_fd_sc_hd__dfxtp_1
XFILLER_0_101_721 VGND VGND VPWR VPWR sky130_fd_sc_hd__decap_6
XFILLER_0_30_354 VGND VGND VPWR VPWR sky130_fd_sc_hd__decap_6
XFILLER_0_30_365 VGND VGND VPWR VPWR sky130_fd_sc_hd__fill_1
XFILLER_0_101_765 VPWR VGND VPWR VGND sky130_ef_sc_hd__decap_12
XFILLER_0_30_398 VGND VGND VPWR VPWR sky130_fd_sc_hd__fill_1
X_9179_ clknet_leaf_37_CLK _0267_ VGND VGND VPWR VPWR rf.registers\[30\]\[10\] sky130_fd_sc_hd__dfxtp_1
XFILLER_0_98_811 VGND VGND VPWR VPWR sky130_fd_sc_hd__fill_1
XTAP_TAPCELL_ROW_48_1022 VGND VPWR sky130_fd_sc_hd__tapvpwrvgnd_1
XTAP_TAPCELL_ROW_39_880 VGND VPWR sky130_fd_sc_hd__tapvpwrvgnd_1
XFILLER_0_85_505 VGND VGND VPWR VPWR sky130_fd_sc_hd__decap_6
XTAP_TAPCELL_ROW_39_891 VGND VPWR sky130_fd_sc_hd__tapvpwrvgnd_1
XFILLER_0_38_421 VGND VGND VPWR VPWR sky130_fd_sc_hd__fill_2
XFILLER_0_122_29 VPWR VGND VPWR VGND sky130_ef_sc_hd__decap_12
XFILLER_0_109_821 VPWR VGND VPWR VGND sky130_ef_sc_hd__decap_12
XTAP_TAPCELL_ROW_61_1222 VGND VPWR sky130_fd_sc_hd__tapvpwrvgnd_1
XTAP_TAPCELL_ROW_61_1211 VGND VPWR sky130_fd_sc_hd__tapvpwrvgnd_1
XFILLER_0_93_582 VGND VGND VPWR VPWR sky130_fd_sc_hd__fill_2
XFILLER_0_135_161 VGND VGND VPWR VPWR sky130_fd_sc_hd__decap_6
XFILLER_0_124_813 VPWR VGND VPWR VGND sky130_ef_sc_hd__decap_12
XFILLER_0_65_295 VGND VGND VPWR VPWR sky130_fd_sc_hd__decap_6
XFILLER_0_53_446 VGND VGND VPWR VPWR sky130_fd_sc_hd__fill_2
XFILLER_0_25_137 VGND VGND VPWR VPWR sky130_fd_sc_hd__decap_8
XFILLER_0_81_777 VGND VGND VPWR VPWR sky130_fd_sc_hd__decap_6
XFILLER_0_53_479 VPWR VGND VPWR VGND sky130_ef_sc_hd__decap_12
XFILLER_0_22_811 VGND VGND VPWR VPWR sky130_fd_sc_hd__fill_1
XFILLER_0_1_727 VGND VGND VPWR VPWR sky130_fd_sc_hd__fill_1
XTAP_TAPCELL_ROW_59_1184 VGND VPWR sky130_fd_sc_hd__tapvpwrvgnd_1
XFILLER_0_0_237 VGND VGND VPWR VPWR sky130_fd_sc_hd__decap_8
XTAP_TAPCELL_ROW_72_1384 VGND VPWR sky130_fd_sc_hd__tapvpwrvgnd_1
XTAP_TAPCELL_ROW_72_1373 VGND VPWR sky130_fd_sc_hd__tapvpwrvgnd_1
XFILLER_0_89_833 VGND VGND VPWR VPWR sky130_fd_sc_hd__decap_6
X_5900_ net82 _2479_ _2610_ VGND VGND VPWR VPWR _2620_ sky130_fd_sc_hd__a21oi_1
XFILLER_0_15_9 VPWR VGND VPWR VGND sky130_ef_sc_hd__decap_12
XFILLER_0_76_527 VGND VGND VPWR VPWR sky130_fd_sc_hd__decap_4
X_6880_ _3325_ VGND VGND VPWR VPWR _0919_ sky130_fd_sc_hd__clkbuf_1
XFILLER_0_48_218 VGND VGND VPWR VPWR sky130_fd_sc_hd__fill_2
XTAP_TAPCELL_ROW_17_552 VGND VPWR sky130_fd_sc_hd__tapvpwrvgnd_1
X_5831_ _2444_ _2437_ net103 VGND VGND VPWR VPWR _2555_ sky130_fd_sc_hd__mux2_1
X_8550_ _3035_ rf.registers\[13\]\[23\] _2967_ VGND VGND VPWR VPWR _4227_ sky130_fd_sc_hd__mux2_1
XFILLER_0_57_741 VPWR VGND VPWR VGND sky130_ef_sc_hd__decap_12
X_5762_ _2482_ _2484_ _2486_ _2263_ VGND VGND VPWR VPWR _2488_ sky130_fd_sc_hd__a31o_1
XFILLER_0_29_443 VGND VGND VPWR VPWR sky130_fd_sc_hd__decap_4
XFILLER_0_118_139 VGND VGND VPWR VPWR sky130_fd_sc_hd__fill_1
X_7501_ _3671_ VGND VGND VPWR VPWR _0170_ sky130_fd_sc_hd__clkbuf_1
XFILLER_0_57_785 VPWR VGND VPWR VGND sky130_ef_sc_hd__decap_12
X_4713_ rf.registers\[12\]\[23\] rf.registers\[13\]\[23\] rf.registers\[14\]\[23\]
+ rf.registers\[15\]\[23\] _1393_ _1394_ VGND VGND VPWR VPWR _1485_ sky130_fd_sc_hd__mux4_1
XFILLER_0_17_638 VPWR VGND VPWR VGND sky130_ef_sc_hd__decap_12
XFILLER_0_127_673 VPWR VGND VPWR VGND sky130_ef_sc_hd__decap_12
XFILLER_0_72_755 VGND VGND VPWR VPWR sky130_fd_sc_hd__fill_1
X_8481_ _4191_ VGND VGND VPWR VPWR _0630_ sky130_fd_sc_hd__clkbuf_1
X_5693_ _2417_ _2420_ _2421_ VGND VGND VPWR VPWR _2422_ sky130_fd_sc_hd__mux2_1
X_7432_ _3365_ rf.registers\[29\]\[9\] _3625_ VGND VGND VPWR VPWR _3635_ sky130_fd_sc_hd__mux2_1
X_4644_ _1416_ _1417_ _1418_ _1419_ _1397_ _1293_ VGND VGND VPWR VPWR _1420_ sky130_fd_sc_hd__mux4_2
XFILLER_0_130_805 VGND VGND VPWR VPWR sky130_fd_sc_hd__decap_6
X_7363_ rf.registers\[8\]\[9\] _3296_ _3588_ VGND VGND VPWR VPWR _3598_ sky130_fd_sc_hd__mux2_1
X_4575_ rf.registers\[0\]\[15\] rf.registers\[1\]\[15\] rf.registers\[2\]\[15\] rf.registers\[3\]\[15\]
+ _1320_ _1321_ VGND VGND VPWR VPWR _1355_ sky130_fd_sc_hd__mux4_1
XFILLER_0_12_321 VPWR VGND VPWR VGND sky130_ef_sc_hd__decap_12
XFILLER_0_13_833 VGND VGND VPWR VPWR sky130_fd_sc_hd__fill_1
XFILLER_0_24_170 VGND VGND VPWR VPWR sky130_fd_sc_hd__fill_1
X_7294_ _3561_ VGND VGND VPWR VPWR _0073_ sky130_fd_sc_hd__clkbuf_1
X_6314_ rf.registers\[12\]\[6\] _2999_ _2987_ VGND VGND VPWR VPWR _3000_ sky130_fd_sc_hd__mux2_1
XFILLER_0_4_587 VGND VGND VPWR VPWR sky130_fd_sc_hd__fill_1
X_9102_ clknet_leaf_93_CLK _0190_ VGND VGND VPWR VPWR rf.registers\[31\]\[29\] sky130_fd_sc_hd__dfxtp_1
XFILLER_0_97_86 VGND VGND VPWR VPWR sky130_fd_sc_hd__decap_3
XFILLER_0_12_365 VPWR VGND VPWR VGND sky130_ef_sc_hd__decap_12
X_6245_ _2944_ _2945_ VGND VGND VPWR VPWR _2946_ sky130_fd_sc_hd__or2_1
X_9033_ clknet_leaf_73_CLK _0121_ VGND VGND VPWR VPWR rf.registers\[8\]\[24\] sky130_fd_sc_hd__dfxtp_1
X_6176_ _2876_ _2879_ VGND VGND VPWR VPWR _2881_ sky130_fd_sc_hd__nand2_1
X_5127_ rf.registers\[24\]\[13\] rf.registers\[25\]\[13\] rf.registers\[26\]\[13\]
+ rf.registers\[27\]\[13\] _1684_ _1685_ VGND VGND VPWR VPWR _1877_ sky130_fd_sc_hd__mux4_1
XFILLER_0_137_81 VPWR VGND VPWR VGND sky130_ef_sc_hd__decap_12
X_5058_ rf.registers\[28\]\[9\] rf.registers\[29\]\[9\] rf.registers\[30\]\[9\] rf.registers\[31\]\[9\]
+ _1729_ _1731_ VGND VGND VPWR VPWR _1812_ sky130_fd_sc_hd__mux4_1
XPHY_EDGE_ROW_2_Right_2 VGND VGND VPWR VPWR sky130_fd_sc_hd__decap_3
XFILLER_0_67_505 VPWR VGND VPWR VGND sky130_ef_sc_hd__decap_12
X_8817_ clknet_leaf_40_CLK _0929_ VGND VGND VPWR VPWR rf.registers\[15\]\[0\] sky130_fd_sc_hd__dfxtp_1
XFILLER_0_1_81 VPWR VGND VPWR VGND sky130_ef_sc_hd__decap_12
XTAP_TAPCELL_ROW_101_1812 VGND VPWR sky130_fd_sc_hd__tapvpwrvgnd_1
XFILLER_0_94_379 VGND VGND VPWR VPWR sky130_fd_sc_hd__fill_1
X_8748_ clknet_leaf_87_CLK _0860_ VGND VGND VPWR VPWR rf.registers\[10\]\[27\] sky130_fd_sc_hd__dfxtp_1
XFILLER_0_118_651 VGND VGND VPWR VPWR sky130_fd_sc_hd__fill_1
XFILLER_0_118_640 VGND VGND VPWR VPWR sky130_fd_sc_hd__decap_4
XFILLER_0_124_109 VPWR VGND VPWR VGND sky130_ef_sc_hd__decap_12
XFILLER_0_118_684 VPWR VGND VPWR VGND sky130_ef_sc_hd__decap_12
XFILLER_0_117_161 VGND VGND VPWR VPWR sky130_fd_sc_hd__decap_6
XFILLER_0_106_813 VPWR VGND VPWR VGND sky130_ef_sc_hd__decap_12
X_8679_ clknet_leaf_1_CLK _0791_ VGND VGND VPWR VPWR rf.registers\[1\]\[22\] sky130_fd_sc_hd__dfxtp_1
XTAP_TAPCELL_ROW_134_2311 VGND VPWR sky130_fd_sc_hd__tapvpwrvgnd_1
XFILLER_0_105_334 VGND VGND VPWR VPWR sky130_fd_sc_hd__fill_2
XFILLER_0_63_777 VGND VGND VPWR VPWR sky130_fd_sc_hd__decap_6
XFILLER_0_133_665 VGND VGND VPWR VPWR sky130_fd_sc_hd__decap_6
XFILLER_0_132_153 VPWR VGND VPWR VGND sky130_ef_sc_hd__decap_12
XFILLER_0_15_181 VPWR VGND VPWR VGND sky130_ef_sc_hd__decap_12
XFILLER_0_132_197 VPWR VGND VPWR VGND sky130_ef_sc_hd__decap_12
XFILLER_0_101_573 VGND VGND VPWR VPWR sky130_fd_sc_hd__fill_2
XTAP_TAPCELL_ROW_112_1985 VGND VPWR sky130_fd_sc_hd__tapvpwrvgnd_1
XTAP_TAPCELL_ROW_112_1974 VGND VPWR sky130_fd_sc_hd__tapvpwrvgnd_1
XFILLER_0_26_27 VGND VGND VPWR VPWR sky130_fd_sc_hd__fill_1
XFILLER_0_98_641 VGND VGND VPWR VPWR sky130_fd_sc_hd__decap_3
XFILLER_0_98_674 VPWR VGND VPWR VGND sky130_ef_sc_hd__decap_12
XFILLER_0_86_825 VPWR VGND VPWR VGND sky130_ef_sc_hd__decap_12
XFILLER_0_133_39 VPWR VGND VPWR VGND sky130_ef_sc_hd__decap_12
XTAP_TAPCELL_ROW_34_809 VGND VPWR sky130_fd_sc_hd__tapvpwrvgnd_1
XFILLER_0_42_15 VPWR VGND VPWR VGND sky130_ef_sc_hd__decap_12
XFILLER_0_128_415 VGND VGND VPWR VPWR sky130_fd_sc_hd__decap_4
XFILLER_0_85_357 VGND VGND VPWR VPWR sky130_fd_sc_hd__decap_8
XFILLER_0_85_346 VGND VGND VPWR VPWR sky130_fd_sc_hd__fill_2
XTAP_TAPCELL_ROW_14_511 VGND VPWR sky130_fd_sc_hd__tapvpwrvgnd_1
XFILLER_0_39_785 VPWR VGND VPWR VGND sky130_ef_sc_hd__decap_12
XFILLER_0_93_390 VGND VGND VPWR VPWR sky130_fd_sc_hd__fill_2
XFILLER_0_54_755 VGND VGND VPWR VPWR sky130_fd_sc_hd__fill_1
XFILLER_0_5_329 VGND VGND VPWR VPWR sky130_fd_sc_hd__decap_6
XFILLER_0_124_643 VGND VGND VPWR VPWR sky130_fd_sc_hd__fill_1
XFILLER_0_124_654 VPWR VGND VPWR VGND sky130_ef_sc_hd__decap_12
XFILLER_0_112_805 VGND VGND VPWR VPWR sky130_fd_sc_hd__decap_6
XANTENNA_3 _1747_ VGND VGND VPWR VPWR sky130_fd_sc_hd__diode_2
XFILLER_0_124_698 VGND VGND VPWR VPWR sky130_fd_sc_hd__fill_2
X_4360_ _1145_ _1150_ _1034_ VGND VGND VPWR VPWR _1151_ sky130_fd_sc_hd__o21a_1
XTAP_TAPCELL_ROW_74_1413 VGND VPWR sky130_fd_sc_hd__tapvpwrvgnd_1
XFILLER_0_6_15 VPWR VGND VPWR VGND sky130_ef_sc_hd__decap_12
XFILLER_0_111_337 VGND VGND VPWR VPWR sky130_fd_sc_hd__decap_4
XFILLER_0_10_825 VPWR VGND VPWR VGND sky130_ef_sc_hd__decap_12
XFILLER_0_21_162 VGND VGND VPWR VPWR sky130_fd_sc_hd__decap_6
XFILLER_0_22_674 VGND VGND VPWR VPWR sky130_fd_sc_hd__decap_3
X_4291_ rf.registers\[16\]\[2\] rf.registers\[17\]\[2\] rf.registers\[18\]\[2\] rf.registers\[19\]\[2\]
+ _1077_ _1078_ VGND VGND VPWR VPWR _1084_ sky130_fd_sc_hd__mux4_1
X_6030_ _2735_ _2712_ _2733_ VGND VGND VPWR VPWR _2743_ sky130_fd_sc_hd__nand3b_1
X_7981_ _3367_ rf.registers\[22\]\[10\] _3926_ VGND VGND VPWR VPWR _3927_ sky130_fd_sc_hd__mux2_1
XFILLER_0_89_685 VPWR VGND VPWR VGND sky130_ef_sc_hd__decap_12
XFILLER_0_89_663 VGND VGND VPWR VPWR sky130_fd_sc_hd__decap_4
X_6932_ net43 VGND VGND VPWR VPWR _3361_ sky130_fd_sc_hd__clkbuf_2
XTAP_TAPCELL_ROW_85_1575 VGND VPWR sky130_fd_sc_hd__tapvpwrvgnd_1
XFILLER_0_76_302 VGND VGND VPWR VPWR sky130_fd_sc_hd__decap_3
X_6863_ rf.registers\[16\]\[17\] _3313_ _3299_ VGND VGND VPWR VPWR _3314_ sky130_fd_sc_hd__mux2_1
XFILLER_0_9_602 VGND VGND VPWR VPWR sky130_fd_sc_hd__fill_1
XFILLER_0_119_426 VGND VGND VPWR VPWR sky130_fd_sc_hd__decap_8
XFILLER_0_119_415 VGND VGND VPWR VPWR sky130_fd_sc_hd__fill_2
X_8602_ clknet_leaf_34_CLK _0714_ VGND VGND VPWR VPWR rf.registers\[11\]\[9\] sky130_fd_sc_hd__dfxtp_1
X_5814_ _2485_ _2482_ _2538_ _2477_ _2483_ VGND VGND VPWR VPWR _2539_ sky130_fd_sc_hd__a221oi_2
XFILLER_0_17_413 VGND VGND VPWR VPWR sky130_fd_sc_hd__fill_2
X_6794_ rf.registers\[0\]\[25\] _3039_ _3263_ VGND VGND VPWR VPWR _3269_ sky130_fd_sc_hd__mux2_1
X_8533_ _4218_ VGND VGND VPWR VPWR _0655_ sky130_fd_sc_hd__clkbuf_1
X_5745_ _1055_ _1075_ _1096_ _1114_ VGND VGND VPWR VPWR _2472_ sky130_fd_sc_hd__or4_1
XFILLER_0_115_632 VGND VGND VPWR VPWR sky130_fd_sc_hd__fill_2
X_8464_ _4182_ VGND VGND VPWR VPWR _0622_ sky130_fd_sc_hd__clkbuf_1
XFILLER_0_96_3 VPWR VGND VPWR VGND sky130_ef_sc_hd__decap_12
XFILLER_0_8_189 VGND VGND VPWR VPWR sky130_fd_sc_hd__decap_6
XFILLER_0_5_841 VGND VGND VPWR VPWR sky130_fd_sc_hd__fill_1
X_5676_ _2214_ _2227_ _2383_ VGND VGND VPWR VPWR _2405_ sky130_fd_sc_hd__mux2_1
X_7415_ _3626_ VGND VGND VPWR VPWR _0129_ sky130_fd_sc_hd__clkbuf_1
XTAP_TAPCELL_ROW_116_2041 VGND VPWR sky130_fd_sc_hd__tapvpwrvgnd_1
XFILLER_0_114_153 VPWR VGND VPWR VGND sky130_ef_sc_hd__decap_12
X_4627_ _1330_ VGND VGND VPWR VPWR _1404_ sky130_fd_sc_hd__clkbuf_4
XFILLER_0_60_725 VPWR VGND VPWR VGND sky130_ef_sc_hd__decap_12
XFILLER_0_32_427 VPWR VGND VPWR VGND sky130_ef_sc_hd__decap_12
X_8395_ rf.registers\[18\]\[13\] net18 _4142_ VGND VGND VPWR VPWR _4146_ sky130_fd_sc_hd__mux2_1
XFILLER_0_60_769 VPWR VGND VPWR VGND sky130_ef_sc_hd__decap_12
XFILLER_0_130_657 VPWR VGND VPWR VGND sky130_ef_sc_hd__decap_12
X_7346_ _3589_ VGND VGND VPWR VPWR _0097_ sky130_fd_sc_hd__clkbuf_1
XFILLER_0_114_197 VGND VGND VPWR VPWR sky130_fd_sc_hd__fill_2
X_4558_ _1190_ _1338_ VGND VGND VPWR VPWR _1339_ sky130_fd_sc_hd__nand2_1
X_7277_ rf.registers\[3\]\[0\] _3276_ _3552_ VGND VGND VPWR VPWR _3553_ sky130_fd_sc_hd__mux2_1
X_4489_ rf.registers\[12\]\[11\] rf.registers\[13\]\[11\] rf.registers\[14\]\[11\]
+ rf.registers\[15\]\[11\] _1146_ _1148_ VGND VGND VPWR VPWR _1273_ sky130_fd_sc_hd__mux4_1
XFILLER_0_12_195 VGND VGND VPWR VPWR sky130_fd_sc_hd__fill_1
X_9016_ clknet_leaf_51_CLK _0104_ VGND VGND VPWR VPWR rf.registers\[8\]\[7\] sky130_fd_sc_hd__dfxtp_1
X_6228_ _2165_ _2929_ VGND VGND VPWR VPWR _2930_ sky130_fd_sc_hd__nand2_1
X_6159_ _2386_ _2728_ _2864_ _2560_ VGND VGND VPWR VPWR _2865_ sky130_fd_sc_hd__a211o_1
XFILLER_0_68_825 VPWR VGND VPWR VGND sky130_ef_sc_hd__decap_12
XTAP_TAPCELL_ROW_0_283 VGND VPWR sky130_fd_sc_hd__tapvpwrvgnd_1
XTAP_TAPCELL_ROW_0_294 VGND VPWR sky130_fd_sc_hd__tapvpwrvgnd_1
XFILLER_0_138_757 VGND VGND VPWR VPWR sky130_fd_sc_hd__decap_8
XFILLER_0_137_223 VGND VGND VPWR VPWR sky130_fd_sc_hd__fill_1
XFILLER_0_83_839 VGND VGND VPWR VPWR sky130_fd_sc_hd__fill_1
XFILLER_0_12_29 VPWR VGND VPWR VGND sky130_ef_sc_hd__decap_12
XFILLER_0_36_744 VGND VGND VPWR VPWR sky130_fd_sc_hd__decap_6
XFILLER_0_51_714 VPWR VGND VPWR VGND sky130_ef_sc_hd__decap_12
XFILLER_0_106_687 VPWR VGND VPWR VGND sky130_ef_sc_hd__decap_12
XFILLER_0_23_449 VGND VGND VPWR VPWR sky130_fd_sc_hd__decap_4
XTAP_TAPCELL_ROW_56_1143 VGND VPWR sky130_fd_sc_hd__tapvpwrvgnd_1
Xoutput51 net51 VGND VGND VPWR VPWR RD1[11] sky130_fd_sc_hd__buf_1
XFILLER_0_120_189 VGND VGND VPWR VPWR sky130_fd_sc_hd__decap_6
Xoutput84 net84 VGND VGND VPWR VPWR RD2[12] sky130_fd_sc_hd__buf_1
Xoutput73 net73 VGND VGND VPWR VPWR RD1[31] sky130_fd_sc_hd__buf_1
Xoutput62 net62 VGND VGND VPWR VPWR RD1[21] sky130_fd_sc_hd__buf_1
XFILLER_0_37_15 VPWR VGND VPWR VGND sky130_ef_sc_hd__decap_12
Xoutput95 net95 VGND VGND VPWR VPWR RD2[22] sky130_fd_sc_hd__buf_1
XFILLER_0_128_245 VGND VGND VPWR VPWR sky130_fd_sc_hd__decap_6
XFILLER_0_86_699 VGND VGND VPWR VPWR sky130_fd_sc_hd__fill_1
XFILLER_0_73_349 VGND VGND VPWR VPWR sky130_fd_sc_hd__decap_4
XFILLER_0_27_744 VGND VGND VPWR VPWR sky130_fd_sc_hd__decap_4
XTAP_TAPCELL_ROW_80_1494 VGND VPWR sky130_fd_sc_hd__tapvpwrvgnd_1
XFILLER_0_5_137 VPWR VGND VPWR VGND sky130_ef_sc_hd__decap_12
X_5530_ _2257_ _2258_ _2260_ VGND VGND VPWR VPWR _2261_ sky130_fd_sc_hd__mux2_1
XFILLER_0_81_393 VGND VGND VPWR VPWR sky130_fd_sc_hd__decap_4
XFILLER_0_81_360 VGND VGND VPWR VPWR sky130_fd_sc_hd__decap_8
X_5461_ _1964_ _2184_ _2192_ VGND VGND VPWR VPWR _2193_ sky130_fd_sc_hd__a21oi_4
X_4412_ rf.registers\[0\]\[6\] rf.registers\[1\]\[6\] rf.registers\[2\]\[6\] rf.registers\[3\]\[6\]
+ _1198_ _1199_ VGND VGND VPWR VPWR _1201_ sky130_fd_sc_hd__mux4_1
XFILLER_0_2_811 VGND VGND VPWR VPWR sky130_fd_sc_hd__fill_1
X_7200_ _3511_ VGND VGND VPWR VPWR _0029_ sky130_fd_sc_hd__clkbuf_1
X_8180_ _3363_ rf.registers\[21\]\[8\] _4023_ VGND VGND VPWR VPWR _4032_ sky130_fd_sc_hd__mux2_1
XFILLER_0_22_471 VGND VGND VPWR VPWR sky130_fd_sc_hd__fill_2
X_5392_ _1927_ _2127_ _1771_ VGND VGND VPWR VPWR _2128_ sky130_fd_sc_hd__a21o_1
XFILLER_0_112_679 VPWR VGND VPWR VGND sky130_ef_sc_hd__decap_12
XFILLER_0_111_167 VGND VGND VPWR VPWR sky130_fd_sc_hd__fill_1
XPHY_EDGE_ROW_99_Right_99 VGND VGND VPWR VPWR sky130_fd_sc_hd__decap_3
X_4343_ _1133_ VGND VGND VPWR VPWR _1134_ sky130_fd_sc_hd__buf_6
XFILLER_0_22_493 VPWR VGND VPWR VGND sky130_ef_sc_hd__decap_12
X_7131_ rf.registers\[5\]\[28\] _3336_ _3466_ VGND VGND VPWR VPWR _3475_ sky130_fd_sc_hd__mux2_1
X_4274_ _1066_ _1067_ _1030_ VGND VGND VPWR VPWR _1068_ sky130_fd_sc_hd__mux2_1
XFILLER_0_10_666 VGND VGND VPWR VPWR sky130_fd_sc_hd__fill_1
X_7062_ _3438_ VGND VGND VPWR VPWR _0988_ sky130_fd_sc_hd__clkbuf_1
X_6013_ _2695_ _2726_ _2348_ VGND VGND VPWR VPWR _2727_ sky130_fd_sc_hd__mux2_1
XFILLER_0_118_83 VGND VGND VPWR VPWR sky130_fd_sc_hd__fill_1
XTAP_TAPCELL_ROW_87_1604 VGND VPWR sky130_fd_sc_hd__tapvpwrvgnd_1
X_7964_ _3351_ rf.registers\[22\]\[2\] _3915_ VGND VGND VPWR VPWR _3918_ sky130_fd_sc_hd__mux2_1
XPHY_EDGE_ROW_6_Left_145 VGND VGND VPWR VPWR sky130_fd_sc_hd__decap_3
X_6915_ _3349_ rf.registers\[15\]\[1\] _3347_ VGND VGND VPWR VPWR _3350_ sky130_fd_sc_hd__mux2_1
X_7895_ _3881_ VGND VGND VPWR VPWR _0354_ sky130_fd_sc_hd__clkbuf_1
XFILLER_0_119_223 VGND VGND VPWR VPWR sky130_fd_sc_hd__fill_1
X_6846_ _3302_ VGND VGND VPWR VPWR _0908_ sky130_fd_sc_hd__clkbuf_1
XFILLER_0_65_839 VGND VGND VPWR VPWR sky130_fd_sc_hd__fill_1
XFILLER_0_135_727 VGND VGND VPWR VPWR sky130_fd_sc_hd__fill_1
X_9565_ clknet_leaf_28_CLK _0653_ VGND VGND VPWR VPWR rf.registers\[13\]\[12\] sky130_fd_sc_hd__dfxtp_1
XFILLER_0_91_113 VGND VGND VPWR VPWR sky130_fd_sc_hd__fill_2
X_6777_ rf.registers\[0\]\[17\] _3022_ _3252_ VGND VGND VPWR VPWR _3260_ sky130_fd_sc_hd__mux2_1
XFILLER_0_18_755 VGND VGND VPWR VPWR sky130_fd_sc_hd__fill_1
XFILLER_0_107_429 VGND VGND VPWR VPWR sky130_fd_sc_hd__fill_1
X_8516_ _4209_ VGND VGND VPWR VPWR _0647_ sky130_fd_sc_hd__clkbuf_1
X_5728_ _2269_ _2443_ _2451_ _2455_ VGND VGND VPWR VPWR _2456_ sky130_fd_sc_hd__o211a_1
XFILLER_0_33_703 VGND VGND VPWR VPWR sky130_fd_sc_hd__decap_3
X_9496_ clknet_leaf_54_CLK _0584_ VGND VGND VPWR VPWR rf.registers\[18\]\[7\] sky130_fd_sc_hd__dfxtp_1
XFILLER_0_45_596 VPWR VGND VPWR VGND sky130_ef_sc_hd__decap_12
XTAP_TAPCELL_ROW_98_1777 VGND VPWR sky130_fd_sc_hd__tapvpwrvgnd_1
XTAP_TAPCELL_ROW_98_1766 VGND VPWR sky130_fd_sc_hd__tapvpwrvgnd_1
X_8447_ _4173_ VGND VGND VPWR VPWR _0614_ sky130_fd_sc_hd__clkbuf_1
XFILLER_0_5_671 VGND VGND VPWR VPWR sky130_fd_sc_hd__fill_1
X_5659_ _2262_ _2263_ VGND VGND VPWR VPWR _2389_ sky130_fd_sc_hd__nor2_2
XFILLER_0_130_421 VGND VGND VPWR VPWR sky130_fd_sc_hd__decap_8
X_8378_ rf.registers\[18\]\[5\] net41 _4131_ VGND VGND VPWR VPWR _4137_ sky130_fd_sc_hd__mux2_1
XFILLER_0_20_419 VGND VGND VPWR VPWR sky130_fd_sc_hd__fill_1
X_7329_ rf.registers\[3\]\[25\] _3330_ _3574_ VGND VGND VPWR VPWR _3580_ sky130_fd_sc_hd__mux2_1
XTAP_TAPCELL_ROW_129_2232 VGND VPWR sky130_fd_sc_hd__tapvpwrvgnd_1
XTAP_TAPCELL_ROW_51_1062 VGND VPWR sky130_fd_sc_hd__tapvpwrvgnd_1
XTAP_TAPCELL_ROW_5_375 VGND VPWR sky130_fd_sc_hd__tapvpwrvgnd_1
XFILLER_0_68_699 VGND VGND VPWR VPWR sky130_fd_sc_hd__fill_1
XTAP_TAPCELL_ROW_44_959 VGND VPWR sky130_fd_sc_hd__tapvpwrvgnd_1
XFILLER_0_71_809 VPWR VGND VPWR VGND sky130_ef_sc_hd__decap_12
XTAP_TAPCELL_ROW_24_661 VGND VPWR sky130_fd_sc_hd__tapvpwrvgnd_1
XFILLER_0_138_598 VPWR VGND VPWR VGND sky130_ef_sc_hd__decap_12
XFILLER_0_126_749 VGND VGND VPWR VPWR sky130_fd_sc_hd__decap_6
XFILLER_0_125_237 VPWR VGND VPWR VGND sky130_ef_sc_hd__decap_12
XFILLER_0_130_29 VPWR VGND VPWR VGND sky130_ef_sc_hd__decap_12
XFILLER_0_134_793 VPWR VGND VPWR VGND sky130_ef_sc_hd__decap_12
XFILLER_0_90_190 VGND VGND VPWR VPWR sky130_fd_sc_hd__fill_2
XFILLER_0_133_281 VPWR VGND VPWR VGND sky130_ef_sc_hd__decap_12
XFILLER_0_121_443 VGND VGND VPWR VPWR sky130_fd_sc_hd__fill_1
XFILLER_0_31_290 VGND VGND VPWR VPWR sky130_fd_sc_hd__fill_1
XFILLER_0_48_47 VGND VGND VPWR VPWR sky130_fd_sc_hd__fill_1
XTAP_TAPCELL_ROW_69_1334 VGND VPWR sky130_fd_sc_hd__tapvpwrvgnd_1
X_4961_ rf.registers\[12\]\[4\] rf.registers\[13\]\[4\] rf.registers\[14\]\[4\] rf.registers\[15\]\[4\]
+ _1652_ _1653_ VGND VGND VPWR VPWR _1720_ sky130_fd_sc_hd__mux4_1
XTAP_TAPCELL_ROW_82_1523 VGND VPWR sky130_fd_sc_hd__tapvpwrvgnd_1
X_4892_ rf.registers\[8\]\[1\] rf.registers\[9\]\[1\] rf.registers\[10\]\[1\] rf.registers\[11\]\[1\]
+ _1652_ _1653_ VGND VGND VPWR VPWR _1654_ sky130_fd_sc_hd__mux4_1
X_6700_ _3219_ VGND VGND VPWR VPWR _0845_ sky130_fd_sc_hd__clkbuf_1
XFILLER_0_86_474 VGND VGND VPWR VPWR sky130_fd_sc_hd__fill_2
XTAP_TAPCELL_ROW_82_1534 VGND VPWR sky130_fd_sc_hd__tapvpwrvgnd_1
X_7680_ rf.registers\[2\]\[30\] _3340_ _3732_ VGND VGND VPWR VPWR _3766_ sky130_fd_sc_hd__mux2_1
XFILLER_0_47_839 VGND VGND VPWR VPWR sky130_fd_sc_hd__fill_1
XFILLER_0_117_727 VGND VGND VPWR VPWR sky130_fd_sc_hd__fill_1
X_6631_ _3182_ VGND VGND VPWR VPWR _0813_ sky130_fd_sc_hd__clkbuf_1
XFILLER_0_104_41 VPWR VGND VPWR VGND sky130_ef_sc_hd__decap_12
XFILLER_0_116_237 VGND VGND VPWR VPWR sky130_fd_sc_hd__fill_1
XFILLER_0_104_85 VGND VGND VPWR VPWR sky130_fd_sc_hd__decap_3
X_9350_ clknet_leaf_76_CLK _0438_ VGND VGND VPWR VPWR rf.registers\[7\]\[21\] sky130_fd_sc_hd__dfxtp_1
XFILLER_0_6_413 VGND VGND VPWR VPWR sky130_fd_sc_hd__decap_6
X_8301_ _4096_ VGND VGND VPWR VPWR _0545_ sky130_fd_sc_hd__clkbuf_1
X_6562_ _3145_ VGND VGND VPWR VPWR _0781_ sky130_fd_sc_hd__clkbuf_1
XFILLER_0_6_457 VPWR VGND VPWR VGND sky130_ef_sc_hd__decap_12
XFILLER_0_27_585 VPWR VGND VPWR VGND sky130_ef_sc_hd__decap_12
XTAP_TAPCELL_ROW_113_2000 VGND VPWR sky130_fd_sc_hd__tapvpwrvgnd_1
X_6493_ _3108_ VGND VGND VPWR VPWR _0749_ sky130_fd_sc_hd__clkbuf_1
X_9281_ clknet_leaf_20_CLK _0369_ VGND VGND VPWR VPWR rf.registers\[23\]\[16\] sky130_fd_sc_hd__dfxtp_1
XFILLER_0_54_393 VGND VGND VPWR VPWR sky130_fd_sc_hd__fill_1
XFILLER_0_15_747 VGND VGND VPWR VPWR sky130_fd_sc_hd__fill_1
X_5513_ _1794_ _2218_ VGND VGND VPWR VPWR _2244_ sky130_fd_sc_hd__or2_1
XFILLER_0_42_555 VGND VGND VPWR VPWR sky130_fd_sc_hd__fill_1
X_8232_ _2982_ rf.registers\[25\]\[0\] _4059_ VGND VGND VPWR VPWR _4060_ sky130_fd_sc_hd__mux2_1
X_5444_ _2175_ _2176_ _1927_ VGND VGND VPWR VPWR _2177_ sky130_fd_sc_hd__mux2_1
X_8163_ _4022_ VGND VGND VPWR VPWR _4023_ sky130_fd_sc_hd__clkbuf_8
X_7114_ _3443_ VGND VGND VPWR VPWR _3466_ sky130_fd_sc_hd__buf_4
X_5375_ _2074_ _2111_ VGND VGND VPWR VPWR _2112_ sky130_fd_sc_hd__and2_1
XTAP_TAPCELL_ROW_93_1696 VGND VPWR sky130_fd_sc_hd__tapvpwrvgnd_1
X_4326_ _1116_ VGND VGND VPWR VPWR _1117_ sky130_fd_sc_hd__clkbuf_8
X_8094_ _3166_ _3768_ VGND VGND VPWR VPWR _3986_ sky130_fd_sc_hd__nand2_4
XFILLER_0_129_93 VPWR VGND VPWR VGND sky130_ef_sc_hd__decap_12
X_4257_ net8 VGND VGND VPWR VPWR _1052_ sky130_fd_sc_hd__buf_4
X_7045_ _3429_ VGND VGND VPWR VPWR _0980_ sky130_fd_sc_hd__clkbuf_1
XTAP_TAPCELL_ROW_2_323 VGND VPWR sky130_fd_sc_hd__tapvpwrvgnd_1
XFILLER_0_69_408 VPWR VGND VPWR VGND sky130_ef_sc_hd__decap_12
XTAP_TAPCELL_ROW_2_334 VGND VPWR sky130_fd_sc_hd__tapvpwrvgnd_1
XTAP_TAPCELL_ROW_124_2162 VGND VPWR sky130_fd_sc_hd__tapvpwrvgnd_1
X_8996_ clknet_leaf_18_CLK _0084_ VGND VGND VPWR VPWR rf.registers\[3\]\[19\] sky130_fd_sc_hd__dfxtp_1
XFILLER_0_49_110 VGND VGND VPWR VPWR sky130_fd_sc_hd__fill_2
X_7947_ _3908_ VGND VGND VPWR VPWR _0379_ sky130_fd_sc_hd__clkbuf_1
X_7878_ _3871_ VGND VGND VPWR VPWR _0347_ sky130_fd_sc_hd__clkbuf_1
X_6829_ rf.registers\[16\]\[6\] _3290_ _3278_ VGND VGND VPWR VPWR _3291_ sky130_fd_sc_hd__mux2_1
XFILLER_0_77_485 VGND VGND VPWR VPWR sky130_fd_sc_hd__fill_1
XTAP_TAPCELL_ROW_41_918 VGND VPWR sky130_fd_sc_hd__tapvpwrvgnd_1
XFILLER_0_108_749 VGND VGND VPWR VPWR sky130_fd_sc_hd__decap_6
XFILLER_0_107_204 VGND VGND VPWR VPWR sky130_fd_sc_hd__fill_2
XFILLER_0_92_477 VGND VGND VPWR VPWR sky130_fd_sc_hd__decap_3
XFILLER_0_80_606 VPWR VGND VPWR VGND sky130_ef_sc_hd__decap_12
XFILLER_0_53_809 VPWR VGND VPWR VGND sky130_ef_sc_hd__decap_12
XFILLER_0_9_273 VGND VGND VPWR VPWR sky130_fd_sc_hd__decap_6
XTAP_TAPCELL_ROW_21_620 VGND VPWR sky130_fd_sc_hd__tapvpwrvgnd_1
XFILLER_0_107_248 VGND VGND VPWR VPWR sky130_fd_sc_hd__fill_2
X_9548_ clknet_leaf_86_CLK _0636_ VGND VGND VPWR VPWR rf.registers\[14\]\[27\] sky130_fd_sc_hd__dfxtp_1
XFILLER_0_33_511 VGND VGND VPWR VPWR sky130_fd_sc_hd__fill_2
X_9479_ clknet_leaf_94_CLK _0567_ VGND VGND VPWR VPWR rf.registers\[20\]\[22\] sky130_fd_sc_hd__dfxtp_1
XFILLER_0_45_393 VGND VGND VPWR VPWR sky130_fd_sc_hd__decap_8
XFILLER_0_131_741 VPWR VGND VPWR VGND sky130_ef_sc_hd__decap_12
XFILLER_0_116_793 VPWR VGND VPWR VGND sky130_ef_sc_hd__decap_12
XFILLER_0_115_281 VGND VGND VPWR VPWR sky130_fd_sc_hd__fill_2
XFILLER_0_60_363 VGND VGND VPWR VPWR sky130_fd_sc_hd__fill_1
XFILLER_0_131_785 VPWR VGND VPWR VGND sky130_ef_sc_hd__decap_12
XFILLER_0_130_251 VGND VGND VPWR VPWR sky130_fd_sc_hd__fill_1
XFILLER_0_103_465 VGND VGND VPWR VPWR sky130_fd_sc_hd__decap_6
XFILLER_0_103_487 VGND VGND VPWR VPWR sky130_fd_sc_hd__fill_1
XTAP_TAPCELL_ROW_53_1102 VGND VPWR sky130_fd_sc_hd__tapvpwrvgnd_1
XFILLER_0_0_3 VGND VGND VPWR VPWR sky130_fd_sc_hd__fill_1
XPHY_EDGE_ROW_69_Left_208 VGND VGND VPWR VPWR sky130_fd_sc_hd__decap_3
XTAP_TAPCELL_ROW_109_1935 VGND VPWR sky130_fd_sc_hd__tapvpwrvgnd_1
XTAP_TAPCELL_ROW_29_731 VGND VPWR sky130_fd_sc_hd__tapvpwrvgnd_1
XTAP_TAPCELL_ROW_29_742 VGND VPWR sky130_fd_sc_hd__tapvpwrvgnd_1
XFILLER_0_34_27 VGND VGND VPWR VPWR sky130_fd_sc_hd__fill_1
XFILLER_0_56_614 VGND VGND VPWR VPWR sky130_fd_sc_hd__decap_4
XFILLER_0_83_422 VGND VGND VPWR VPWR sky130_fd_sc_hd__fill_1
XTAP_TAPCELL_ROW_64_1264 VGND VPWR sky130_fd_sc_hd__tapvpwrvgnd_1
XTAP_TAPCELL_ROW_64_1253 VGND VPWR sky130_fd_sc_hd__tapvpwrvgnd_1
XFILLER_0_55_102 VGND VGND VPWR VPWR sky130_fd_sc_hd__fill_1
XFILLER_0_50_15 VPWR VGND VPWR VGND sky130_ef_sc_hd__decap_12
XFILLER_0_83_466 VGND VGND VPWR VPWR sky130_fd_sc_hd__decap_6
XPHY_EDGE_ROW_78_Left_217 VGND VGND VPWR VPWR sky130_fd_sc_hd__decap_3
XFILLER_0_71_617 VGND VGND VPWR VPWR sky130_fd_sc_hd__fill_1
XFILLER_0_24_522 VGND VGND VPWR VPWR sky130_fd_sc_hd__decap_8
XFILLER_0_3_405 VPWR VGND VPWR VGND sky130_ef_sc_hd__decap_12
XFILLER_0_24_533 VPWR VGND VPWR VGND sky130_ef_sc_hd__decap_12
XFILLER_0_106_270 VGND VGND VPWR VPWR sky130_fd_sc_hd__fill_2
XFILLER_0_11_205 VPWR VGND VPWR VGND sky130_ef_sc_hd__decap_12
XFILLER_0_3_449 VPWR VGND VPWR VGND sky130_ef_sc_hd__decap_12
XFILLER_0_59_57 VPWR VGND VPWR VGND sky130_ef_sc_hd__decap_12
XFILLER_0_121_273 VGND VGND VPWR VPWR sky130_fd_sc_hd__decap_6
XFILLER_0_11_249 VPWR VGND VPWR VGND sky130_ef_sc_hd__decap_12
X_5160_ _1906_ _1907_ _1707_ VGND VGND VPWR VPWR _1908_ sky130_fd_sc_hd__mux2_1
XPHY_EDGE_ROW_87_Left_226 VGND VGND VPWR VPWR sky130_fd_sc_hd__decap_3
X_5091_ rf.registers\[24\]\[11\] rf.registers\[25\]\[11\] rf.registers\[26\]\[11\]
+ rf.registers\[27\]\[11\] _1795_ _1736_ VGND VGND VPWR VPWR _1843_ sky130_fd_sc_hd__mux4_1
X_8850_ clknet_leaf_45_CLK _0962_ VGND VGND VPWR VPWR rf.registers\[6\]\[1\] sky130_fd_sc_hd__dfxtp_1
XFILLER_0_78_216 VGND VGND VPWR VPWR sky130_fd_sc_hd__fill_1
X_7801_ rf.registers\[9\]\[22\] _3324_ _3828_ VGND VGND VPWR VPWR _3831_ sky130_fd_sc_hd__mux2_1
X_8781_ clknet_leaf_90_CLK _0893_ VGND VGND VPWR VPWR rf.registers\[0\]\[28\] sky130_fd_sc_hd__dfxtp_1
X_5993_ _2702_ _2703_ _2707_ VGND VGND VPWR VPWR _2708_ sky130_fd_sc_hd__and3_1
X_4944_ _1632_ VGND VGND VPWR VPWR _1704_ sky130_fd_sc_hd__buf_4
XFILLER_0_87_783 VGND VGND VPWR VPWR sky130_fd_sc_hd__fill_1
X_7732_ _3794_ VGND VGND VPWR VPWR _0278_ sky130_fd_sc_hd__clkbuf_1
XPHY_EDGE_ROW_96_Left_235 VGND VGND VPWR VPWR sky130_fd_sc_hd__decap_3
XFILLER_0_47_647 VPWR VGND VPWR VGND sky130_ef_sc_hd__decap_12
XFILLER_0_129_373 VPWR VGND VPWR VGND sky130_ef_sc_hd__decap_12
X_4875_ rf.registers\[4\]\[0\] rf.registers\[5\]\[0\] rf.registers\[6\]\[0\] rf.registers\[7\]\[0\]
+ _1617_ _1618_ VGND VGND VPWR VPWR _1638_ sky130_fd_sc_hd__mux4_1
X_9402_ clknet_leaf_56_CLK _0490_ VGND VGND VPWR VPWR rf.registers\[21\]\[9\] sky130_fd_sc_hd__dfxtp_1
XFILLER_0_74_466 VGND VGND VPWR VPWR sky130_fd_sc_hd__decap_8
X_7663_ _3757_ VGND VGND VPWR VPWR _0246_ sky130_fd_sc_hd__clkbuf_1
XFILLER_0_35_809 VPWR VGND VPWR VGND sky130_ef_sc_hd__decap_12
X_6614_ _3173_ VGND VGND VPWR VPWR _0805_ sky130_fd_sc_hd__clkbuf_1
X_7594_ _3391_ rf.registers\[27\]\[21\] _3719_ VGND VGND VPWR VPWR _3721_ sky130_fd_sc_hd__mux2_1
XFILLER_0_7_777 VGND VGND VPWR VPWR sky130_fd_sc_hd__decap_6
XFILLER_0_6_221 VPWR VGND VPWR VGND sky130_ef_sc_hd__decap_12
X_6545_ _3136_ VGND VGND VPWR VPWR _0773_ sky130_fd_sc_hd__clkbuf_1
X_9333_ clknet_leaf_49_CLK _0421_ VGND VGND VPWR VPWR rf.registers\[7\]\[4\] sky130_fd_sc_hd__dfxtp_1
XFILLER_0_6_265 VPWR VGND VPWR VGND sky130_ef_sc_hd__decap_12
XFILLER_0_27_382 VGND VGND VPWR VPWR sky130_fd_sc_hd__fill_1
XFILLER_0_113_741 VPWR VGND VPWR VGND sky130_ef_sc_hd__decap_12
XTAP_TAPCELL_ROW_95_1725 VGND VPWR sky130_fd_sc_hd__tapvpwrvgnd_1
X_9264_ clknet_leaf_66_CLK _0352_ VGND VGND VPWR VPWR rf.registers\[28\]\[31\] sky130_fd_sc_hd__dfxtp_1
X_6476_ _3099_ VGND VGND VPWR VPWR _0741_ sky130_fd_sc_hd__clkbuf_1
X_8215_ _4050_ VGND VGND VPWR VPWR _0505_ sky130_fd_sc_hd__clkbuf_1
XFILLER_0_113_785 VPWR VGND VPWR VGND sky130_ef_sc_hd__decap_12
XTAP_TAPCELL_ROW_7_404 VGND VPWR sky130_fd_sc_hd__tapvpwrvgnd_1
X_9195_ clknet_leaf_85_CLK _0283_ VGND VGND VPWR VPWR rf.registers\[30\]\[26\] sky130_fd_sc_hd__dfxtp_1
X_5427_ rf.registers\[4\]\[29\] rf.registers\[5\]\[29\] rf.registers\[6\]\[29\] rf.registers\[7\]\[29\]
+ _2077_ _2078_ VGND VGND VPWR VPWR _2161_ sky130_fd_sc_hd__mux4_1
X_5358_ rf.registers\[4\]\[25\] rf.registers\[5\]\[25\] rf.registers\[6\]\[25\] rf.registers\[7\]\[25\]
+ _2008_ _2009_ VGND VGND VPWR VPWR _2096_ sky130_fd_sc_hd__mux4_1
X_8146_ _3397_ rf.registers\[26\]\[24\] _4009_ VGND VGND VPWR VPWR _4014_ sky130_fd_sc_hd__mux2_1
X_4309_ rf.registers\[28\]\[3\] rf.registers\[29\]\[3\] rf.registers\[30\]\[3\] rf.registers\[31\]\[3\]
+ _1026_ _1027_ VGND VGND VPWR VPWR _1101_ sky130_fd_sc_hd__mux4_1
X_8077_ _3977_ VGND VGND VPWR VPWR _0440_ sky130_fd_sc_hd__clkbuf_1
X_7028_ rf.registers\[6\]\[11\] _3301_ _3419_ VGND VGND VPWR VPWR _3421_ sky130_fd_sc_hd__mux2_1
X_5289_ _1958_ _2030_ _1964_ VGND VGND VPWR VPWR _2031_ sky130_fd_sc_hd__a21oi_1
XFILLER_0_97_503 VGND VGND VPWR VPWR sky130_fd_sc_hd__fill_1
X_8979_ clknet_leaf_41_CLK _0067_ VGND VGND VPWR VPWR rf.registers\[3\]\[2\] sky130_fd_sc_hd__dfxtp_1
XFILLER_0_97_558 VGND VGND VPWR VPWR sky130_fd_sc_hd__fill_2
XTAP_TAPCELL_ROW_104_1865 VGND VPWR sky130_fd_sc_hd__tapvpwrvgnd_1
XTAP_TAPCELL_ROW_104_1854 VGND VPWR sky130_fd_sc_hd__tapvpwrvgnd_1
XFILLER_0_136_811 VGND VGND VPWR VPWR sky130_fd_sc_hd__fill_1
XFILLER_0_93_753 VPWR VGND VPWR VGND sky130_ef_sc_hd__decap_12
XTAP_TAPCELL_ROW_137_2353 VGND VPWR sky130_fd_sc_hd__tapvpwrvgnd_1
XFILLER_0_93_797 VPWR VGND VPWR VGND sky130_ef_sc_hd__decap_12
XFILLER_0_53_639 VGND VGND VPWR VPWR sky130_fd_sc_hd__decap_3
XFILLER_0_18_360 VGND VGND VPWR VPWR sky130_fd_sc_hd__decap_4
XFILLER_0_20_29 VPWR VGND VPWR VGND sky130_ef_sc_hd__decap_12
XFILLER_0_103_284 VGND VGND VPWR VPWR sky130_fd_sc_hd__fill_1
XFILLER_0_103_262 VGND VGND VPWR VPWR sky130_fd_sc_hd__fill_2
XFILLER_0_21_569 VGND VGND VPWR VPWR sky130_fd_sc_hd__fill_2
XFILLER_0_29_27 VPWR VGND VPWR VGND sky130_ef_sc_hd__decap_12
XFILLER_0_45_15 VPWR VGND VPWR VGND sky130_ef_sc_hd__decap_12
XFILLER_0_88_536 VGND VGND VPWR VPWR sky130_fd_sc_hd__decap_8
XFILLER_0_29_614 VGND VGND VPWR VPWR sky130_fd_sc_hd__fill_2
XFILLER_0_69_783 VGND VGND VPWR VPWR sky130_fd_sc_hd__fill_1
XFILLER_0_127_833 VGND VGND VPWR VPWR sky130_fd_sc_hd__decap_6
XFILLER_0_44_606 VGND VGND VPWR VPWR sky130_fd_sc_hd__fill_1
XFILLER_0_138_181 VPWR VGND VPWR VGND sky130_ef_sc_hd__decap_12
XFILLER_0_126_321 VPWR VGND VPWR VGND sky130_ef_sc_hd__decap_12
XFILLER_0_83_285 VGND VGND VPWR VPWR sky130_fd_sc_hd__fill_1
XFILLER_0_9_15 VPWR VGND VPWR VGND sky130_ef_sc_hd__decap_12
XFILLER_0_37_680 VGND VGND VPWR VPWR sky130_fd_sc_hd__fill_1
X_4660_ _1433_ _1434_ _1163_ VGND VGND VPWR VPWR _1435_ sky130_fd_sc_hd__mux2_1
XFILLER_0_126_365 VPWR VGND VPWR VGND sky130_ef_sc_hd__decap_12
XFILLER_0_117_3 VPWR VGND VPWR VGND sky130_ef_sc_hd__decap_12
XFILLER_0_4_725 VPWR VGND VPWR VGND sky130_ef_sc_hd__decap_12
X_6330_ rf.registers\[12\]\[11\] _3010_ _3008_ VGND VGND VPWR VPWR _3011_ sky130_fd_sc_hd__mux2_1
X_4591_ _1197_ _1369_ VGND VGND VPWR VPWR _1370_ sky130_fd_sc_hd__nand2_1
XTAP_TAPCELL_ROW_12_483 VGND VPWR sky130_fd_sc_hd__tapvpwrvgnd_1
XTAP_TAPCELL_ROW_77_1455 VGND VPWR sky130_fd_sc_hd__tapvpwrvgnd_1
XFILLER_0_12_525 VGND VGND VPWR VPWR sky130_fd_sc_hd__decap_6
XFILLER_0_4_769 VPWR VGND VPWR VGND sky130_ef_sc_hd__decap_12
XFILLER_0_51_193 VGND VGND VPWR VPWR sky130_fd_sc_hd__fill_1
XFILLER_0_3_279 VGND VGND VPWR VPWR sky130_fd_sc_hd__fill_1
X_6261_ _2296_ _2834_ _2959_ _2960_ _2559_ VGND VGND VPWR VPWR _2961_ sky130_fd_sc_hd__a2111o_1
XFILLER_0_110_755 VGND VGND VPWR VPWR sky130_fd_sc_hd__fill_1
X_8000_ _3936_ VGND VGND VPWR VPWR _0404_ sky130_fd_sc_hd__clkbuf_1
X_6192_ _2386_ _2765_ _2895_ _2559_ VGND VGND VPWR VPWR _2896_ sky130_fd_sc_hd__a211o_1
X_5212_ _1771_ VGND VGND VPWR VPWR _1958_ sky130_fd_sc_hd__buf_4
X_5143_ rf.registers\[24\]\[14\] rf.registers\[25\]\[14\] rf.registers\[26\]\[14\]
+ rf.registers\[27\]\[14\] _1795_ _1736_ VGND VGND VPWR VPWR _1892_ sky130_fd_sc_hd__mux4_1
XTAP_TAPCELL_ROW_90_1655 VGND VPWR sky130_fd_sc_hd__tapvpwrvgnd_1
XTAP_TAPCELL_ROW_90_1644 VGND VPWR sky130_fd_sc_hd__tapvpwrvgnd_1
X_5074_ rf.registers\[20\]\[10\] rf.registers\[21\]\[10\] rf.registers\[22\]\[10\]
+ rf.registers\[23\]\[10\] _1684_ _1685_ VGND VGND VPWR VPWR _1827_ sky130_fd_sc_hd__mux4_1
XFILLER_0_19_93 VPWR VGND VPWR VGND sky130_ef_sc_hd__decap_12
XFILLER_0_79_525 VGND VGND VPWR VPWR sky130_fd_sc_hd__fill_2
XFILLER_0_79_503 VGND VGND VPWR VPWR sky130_fd_sc_hd__fill_1
X_8902_ clknet_leaf_76_CLK _1014_ VGND VGND VPWR VPWR rf.registers\[5\]\[21\] sky130_fd_sc_hd__dfxtp_1
XFILLER_0_126_83 VGND VGND VPWR VPWR sky130_fd_sc_hd__fill_1
XTAP_TAPCELL_ROW_121_2110 VGND VPWR sky130_fd_sc_hd__tapvpwrvgnd_1
X_8833_ clknet_leaf_15_CLK _0945_ VGND VGND VPWR VPWR rf.registers\[15\]\[16\] sky130_fd_sc_hd__dfxtp_1
XFILLER_0_67_709 VPWR VGND VPWR VGND sky130_ef_sc_hd__decap_12
XTAP_TAPCELL_ROW_121_2121 VGND VPWR sky130_fd_sc_hd__tapvpwrvgnd_1
XFILLER_0_35_81 VGND VGND VPWR VPWR sky130_fd_sc_hd__fill_1
X_8764_ clknet_leaf_31_CLK _0876_ VGND VGND VPWR VPWR rf.registers\[0\]\[11\] sky130_fd_sc_hd__dfxtp_1
XFILLER_0_19_113 VPWR VGND VPWR VGND sky130_ef_sc_hd__decap_12
X_5976_ _1902_ _2675_ VGND VGND VPWR VPWR _2692_ sky130_fd_sc_hd__nor2_1
XFILLER_0_47_422 VGND VGND VPWR VPWR sky130_fd_sc_hd__decap_3
X_4927_ rf.registers\[16\]\[3\] rf.registers\[17\]\[3\] rf.registers\[18\]\[3\] rf.registers\[19\]\[3\]
+ _1684_ _1685_ VGND VGND VPWR VPWR _1687_ sky130_fd_sc_hd__mux4_1
XFILLER_0_118_811 VGND VGND VPWR VPWR sky130_fd_sc_hd__fill_1
X_7715_ _3785_ VGND VGND VPWR VPWR _0270_ sky130_fd_sc_hd__clkbuf_1
X_8695_ clknet_leaf_57_CLK _0807_ VGND VGND VPWR VPWR rf.registers\[24\]\[6\] sky130_fd_sc_hd__dfxtp_1
XFILLER_0_75_753 VPWR VGND VPWR VGND sky130_ef_sc_hd__decap_12
XFILLER_0_74_230 VPWR VGND VPWR VGND sky130_ef_sc_hd__decap_12
XFILLER_0_129_181 VPWR VGND VPWR VGND sky130_ef_sc_hd__decap_12
X_4858_ net3 VGND VGND VPWR VPWR _1621_ sky130_fd_sc_hd__inv_2
XFILLER_0_117_332 VGND VGND VPWR VPWR sky130_fd_sc_hd__fill_1
XFILLER_0_90_701 VPWR VGND VPWR VGND sky130_ef_sc_hd__decap_12
X_7646_ _3748_ VGND VGND VPWR VPWR _0238_ sky130_fd_sc_hd__clkbuf_1
XFILLER_0_75_797 VPWR VGND VPWR VGND sky130_ef_sc_hd__decap_12
XFILLER_0_7_541 VPWR VGND VPWR VGND sky130_ef_sc_hd__decap_12
XFILLER_0_7_574 VGND VGND VPWR VPWR sky130_fd_sc_hd__fill_1
XFILLER_0_28_691 VGND VGND VPWR VPWR sky130_fd_sc_hd__decap_8
XTAP_TAPCELL_ROW_31_770 VGND VPWR sky130_fd_sc_hd__tapvpwrvgnd_1
XTAP_TAPCELL_ROW_119_2083 VGND VPWR sky130_fd_sc_hd__tapvpwrvgnd_1
X_7577_ _3374_ rf.registers\[27\]\[13\] _3708_ VGND VGND VPWR VPWR _3712_ sky130_fd_sc_hd__mux2_1
X_9316_ clknet_leaf_21_CLK _0404_ VGND VGND VPWR VPWR rf.registers\[22\]\[19\] sky130_fd_sc_hd__dfxtp_1
X_4789_ _1554_ _1555_ _1298_ VGND VGND VPWR VPWR _1556_ sky130_fd_sc_hd__mux2_1
XFILLER_0_132_357 VGND VGND VPWR VPWR sky130_fd_sc_hd__decap_6
Xclkbuf_leaf_80_CLK clknet_3_3__leaf_CLK VGND VGND VPWR VPWR clknet_leaf_80_CLK sky130_fd_sc_hd__clkbuf_8
X_6528_ _3126_ VGND VGND VPWR VPWR _0766_ sky130_fd_sc_hd__clkbuf_1
XTAP_TAPCELL_ROW_132_2283 VGND VPWR sky130_fd_sc_hd__tapvpwrvgnd_1
X_9247_ clknet_leaf_27_CLK _0335_ VGND VGND VPWR VPWR rf.registers\[28\]\[14\] sky130_fd_sc_hd__dfxtp_1
X_6459_ rf.registers\[11\]\[30\] _3049_ _3055_ VGND VGND VPWR VPWR _3089_ sky130_fd_sc_hd__mux2_1
X_9178_ clknet_leaf_32_CLK _0266_ VGND VGND VPWR VPWR rf.registers\[30\]\[9\] sky130_fd_sc_hd__dfxtp_1
XFILLER_0_30_377 VGND VGND VPWR VPWR sky130_fd_sc_hd__fill_2
XFILLER_0_101_777 VGND VGND VPWR VPWR sky130_fd_sc_hd__decap_6
X_8129_ _3380_ rf.registers\[26\]\[16\] _3998_ VGND VGND VPWR VPWR _4005_ sky130_fd_sc_hd__mux2_1
XTAP_TAPCELL_ROW_39_881 VGND VPWR sky130_fd_sc_hd__tapvpwrvgnd_1
XFILLER_0_97_355 VGND VGND VPWR VPWR sky130_fd_sc_hd__fill_1
XTAP_TAPCELL_ROW_48_1023 VGND VPWR sky130_fd_sc_hd__tapvpwrvgnd_1
XTAP_TAPCELL_ROW_39_892 VGND VPWR sky130_fd_sc_hd__tapvpwrvgnd_1
XFILLER_0_109_833 VGND VGND VPWR VPWR sky130_fd_sc_hd__decap_6
XTAP_TAPCELL_ROW_61_1212 VGND VPWR sky130_fd_sc_hd__tapvpwrvgnd_1
XFILLER_0_108_321 VGND VGND VPWR VPWR sky130_fd_sc_hd__decap_3
XFILLER_0_38_477 VGND VGND VPWR VPWR sky130_fd_sc_hd__fill_2
XFILLER_0_124_825 VPWR VGND VPWR VGND sky130_ef_sc_hd__decap_12
XFILLER_0_108_354 VGND VGND VPWR VPWR sky130_fd_sc_hd__fill_1
XFILLER_0_123_335 VGND VGND VPWR VPWR sky130_fd_sc_hd__fill_1
XFILLER_0_108_387 VGND VGND VPWR VPWR sky130_fd_sc_hd__decap_3
XFILLER_0_21_311 VGND VGND VPWR VPWR sky130_fd_sc_hd__fill_2
XFILLER_0_21_322 VGND VGND VPWR VPWR sky130_fd_sc_hd__fill_2
Xclkbuf_leaf_71_CLK clknet_3_2__leaf_CLK VGND VGND VPWR VPWR clknet_leaf_71_CLK sky130_fd_sc_hd__clkbuf_8
XFILLER_0_34_683 VGND VGND VPWR VPWR sky130_fd_sc_hd__fill_2
XTAP_TAPCELL_ROW_59_1185 VGND VPWR sky130_fd_sc_hd__tapvpwrvgnd_1
XFILLER_0_21_377 VGND VGND VPWR VPWR sky130_fd_sc_hd__decap_6
XTAP_TAPCELL_ROW_72_1385 VGND VPWR sky130_fd_sc_hd__tapvpwrvgnd_1
XTAP_TAPCELL_ROW_72_1374 VGND VPWR sky130_fd_sc_hd__tapvpwrvgnd_1
XFILLER_0_72_79 VGND VGND VPWR VPWR sky130_fd_sc_hd__decap_4
XTAP_TAPCELL_ROW_17_553 VGND VPWR sky130_fd_sc_hd__tapvpwrvgnd_1
X_5830_ _2454_ _2553_ _2416_ VGND VGND VPWR VPWR _2554_ sky130_fd_sc_hd__mux2_1
XFILLER_0_57_753 VPWR VGND VPWR VGND sky130_ef_sc_hd__decap_12
X_5761_ _2482_ _2484_ _2486_ VGND VGND VPWR VPWR _2487_ sky130_fd_sc_hd__a21oi_1
XFILLER_0_9_839 VGND VGND VPWR VPWR sky130_fd_sc_hd__fill_1
XFILLER_0_29_433 VGND VGND VPWR VPWR sky130_fd_sc_hd__fill_1
X_7500_ _3365_ rf.registers\[31\]\[9\] _3661_ VGND VGND VPWR VPWR _3671_ sky130_fd_sc_hd__mux2_1
XFILLER_0_72_701 VPWR VGND VPWR VGND sky130_ef_sc_hd__decap_12
X_8480_ _3031_ rf.registers\[14\]\[21\] _4189_ VGND VGND VPWR VPWR _4191_ sky130_fd_sc_hd__mux2_1
XFILLER_0_57_797 VPWR VGND VPWR VGND sky130_ef_sc_hd__decap_12
X_4712_ rf.registers\[8\]\[23\] rf.registers\[9\]\[23\] rf.registers\[10\]\[23\] rf.registers\[11\]\[23\]
+ _1393_ _1394_ VGND VGND VPWR VPWR _1484_ sky130_fd_sc_hd__mux4_1
XFILLER_0_127_685 VPWR VGND VPWR VGND sky130_ef_sc_hd__decap_12
X_7431_ _3634_ VGND VGND VPWR VPWR _0137_ sky130_fd_sc_hd__clkbuf_1
XFILLER_0_112_41 VPWR VGND VPWR VGND sky130_ef_sc_hd__decap_12
X_5692_ _1113_ VGND VGND VPWR VPWR _2421_ sky130_fd_sc_hd__clkbuf_4
XFILLER_0_29_499 VGND VGND VPWR VPWR sky130_fd_sc_hd__fill_1
XFILLER_0_126_195 VGND VGND VPWR VPWR sky130_fd_sc_hd__fill_1
XFILLER_0_112_85 VPWR VGND VPWR VGND sky130_ef_sc_hd__decap_12
X_4643_ rf.registers\[24\]\[19\] rf.registers\[25\]\[19\] rf.registers\[26\]\[19\]
+ rf.registers\[27\]\[19\] _1403_ _1404_ VGND VGND VPWR VPWR _1419_ sky130_fd_sc_hd__mux4_1
XFILLER_0_4_533 VPWR VGND VPWR VGND sky130_ef_sc_hd__decap_12
XFILLER_0_25_661 VGND VGND VPWR VPWR sky130_fd_sc_hd__decap_8
X_7362_ _3597_ VGND VGND VPWR VPWR _0105_ sky130_fd_sc_hd__clkbuf_1
X_4574_ rf.registers\[4\]\[15\] rf.registers\[5\]\[15\] rf.registers\[6\]\[15\] rf.registers\[7\]\[15\]
+ _1320_ _1321_ VGND VGND VPWR VPWR _1354_ sky130_fd_sc_hd__mux4_1
Xclkbuf_leaf_62_CLK clknet_3_3__leaf_CLK VGND VGND VPWR VPWR clknet_leaf_62_CLK sky130_fd_sc_hd__clkbuf_8
X_7293_ rf.registers\[3\]\[8\] _3294_ _3552_ VGND VGND VPWR VPWR _3561_ sky130_fd_sc_hd__mux2_1
X_6313_ net42 VGND VGND VPWR VPWR _2999_ sky130_fd_sc_hd__buf_2
XFILLER_0_12_333 VPWR VGND VPWR VGND sky130_ef_sc_hd__decap_12
X_9101_ clknet_leaf_94_CLK _0189_ VGND VGND VPWR VPWR rf.registers\[31\]\[28\] sky130_fd_sc_hd__dfxtp_1
XPHY_EDGE_ROW_123_Right_123 VGND VGND VPWR VPWR sky130_fd_sc_hd__decap_3
X_9032_ clknet_leaf_9_CLK _0120_ VGND VGND VPWR VPWR rf.registers\[8\]\[23\] sky130_fd_sc_hd__dfxtp_1
XFILLER_0_12_377 VPWR VGND VPWR VGND sky130_ef_sc_hd__decap_12
X_6244_ _2179_ _2943_ VGND VGND VPWR VPWR _2945_ sky130_fd_sc_hd__nor2_1
XFILLER_0_0_783 VGND VGND VPWR VPWR sky130_fd_sc_hd__fill_1
X_6175_ _2876_ _2879_ VGND VGND VPWR VPWR _2880_ sky130_fd_sc_hd__nor2_1
XFILLER_0_41_3 VPWR VGND VPWR VGND sky130_ef_sc_hd__decap_12
X_5126_ rf.registers\[28\]\[13\] rf.registers\[29\]\[13\] rf.registers\[30\]\[13\]
+ rf.registers\[31\]\[13\] _1684_ _1685_ VGND VGND VPWR VPWR _1876_ sky130_fd_sc_hd__mux4_1
X_5057_ rf.registers\[24\]\[9\] rf.registers\[25\]\[9\] rf.registers\[26\]\[9\] rf.registers\[27\]\[9\]
+ _1749_ _1750_ VGND VGND VPWR VPWR _1811_ sky130_fd_sc_hd__mux4_1
XFILLER_0_137_93 VPWR VGND VPWR VGND sky130_ef_sc_hd__decap_12
XFILLER_0_79_366 VGND VGND VPWR VPWR sky130_fd_sc_hd__fill_1
XFILLER_0_67_517 VGND VGND VPWR VPWR sky130_fd_sc_hd__decap_8
XFILLER_0_94_325 VGND VGND VPWR VPWR sky130_fd_sc_hd__fill_1
XFILLER_0_79_399 VGND VGND VPWR VPWR sky130_fd_sc_hd__fill_1
X_8816_ clknet_leaf_62_CLK _0928_ VGND VGND VPWR VPWR rf.registers\[16\]\[31\] sky130_fd_sc_hd__dfxtp_1
XTAP_TAPCELL_ROW_36_840 VGND VPWR sky130_fd_sc_hd__tapvpwrvgnd_1
XFILLER_0_137_405 VPWR VGND VPWR VGND sky130_ef_sc_hd__decap_12
XTAP_TAPCELL_ROW_101_1813 VGND VPWR sky130_fd_sc_hd__tapvpwrvgnd_1
XFILLER_0_94_347 VPWR VGND VPWR VGND sky130_ef_sc_hd__decap_12
XFILLER_0_1_93 VPWR VGND VPWR VGND sky130_ef_sc_hd__decap_12
X_8747_ clknet_leaf_69_CLK _0859_ VGND VGND VPWR VPWR rf.registers\[10\]\[26\] sky130_fd_sc_hd__dfxtp_1
X_5959_ net54 _2675_ VGND VGND VPWR VPWR _2676_ sky130_fd_sc_hd__xnor2_2
XFILLER_0_137_449 VPWR VGND VPWR VGND sky130_ef_sc_hd__decap_12
XFILLER_0_106_825 VPWR VGND VPWR VGND sky130_ef_sc_hd__decap_12
X_8678_ clknet_leaf_79_CLK _0790_ VGND VGND VPWR VPWR rf.registers\[1\]\[21\] sky130_fd_sc_hd__dfxtp_1
XFILLER_0_35_447 VGND VGND VPWR VPWR sky130_fd_sc_hd__fill_1
XTAP_TAPCELL_ROW_134_2312 VGND VPWR sky130_fd_sc_hd__tapvpwrvgnd_1
XFILLER_0_133_611 VGND VGND VPWR VPWR sky130_fd_sc_hd__decap_4
XFILLER_0_118_696 VGND VGND VPWR VPWR sky130_fd_sc_hd__decap_4
XFILLER_0_105_302 VGND VGND VPWR VPWR sky130_fd_sc_hd__fill_2
X_7629_ _3739_ VGND VGND VPWR VPWR _0230_ sky130_fd_sc_hd__clkbuf_1
XFILLER_0_7_393 VPWR VGND VPWR VGND sky130_ef_sc_hd__decap_12
XFILLER_0_132_121 VPWR VGND VPWR VGND sky130_ef_sc_hd__decap_12
Xclkbuf_leaf_53_CLK clknet_3_6__leaf_CLK VGND VGND VPWR VPWR clknet_leaf_53_CLK sky130_fd_sc_hd__clkbuf_8
XFILLER_0_132_165 VPWR VGND VPWR VGND sky130_ef_sc_hd__decap_12
XFILLER_0_121_839 VGND VGND VPWR VPWR sky130_fd_sc_hd__fill_1
XFILLER_0_15_193 VPWR VGND VPWR VGND sky130_ef_sc_hd__decap_12
XFILLER_0_30_141 VGND VGND VPWR VPWR sky130_fd_sc_hd__decap_4
XTAP_TAPCELL_ROW_112_1986 VGND VPWR sky130_fd_sc_hd__tapvpwrvgnd_1
XTAP_TAPCELL_ROW_112_1975 VGND VPWR sky130_fd_sc_hd__tapvpwrvgnd_1
XFILLER_0_98_686 VPWR VGND VPWR VGND sky130_ef_sc_hd__decap_12
XFILLER_0_86_837 VGND VGND VPWR VPWR sky130_fd_sc_hd__fill_2
XTAP_TAPCELL_ROW_14_512 VGND VPWR sky130_fd_sc_hd__tapvpwrvgnd_1
XFILLER_0_42_27 VGND VGND VPWR VPWR sky130_fd_sc_hd__fill_1
XFILLER_0_42_49 VGND VGND VPWR VPWR sky130_fd_sc_hd__decap_3
XFILLER_0_128_449 VGND VGND VPWR VPWR sky130_fd_sc_hd__fill_2
XFILLER_0_54_701 VPWR VGND VPWR VGND sky130_ef_sc_hd__decap_12
XFILLER_0_39_797 VPWR VGND VPWR VGND sky130_ef_sc_hd__decap_12
XFILLER_0_38_285 VGND VGND VPWR VPWR sky130_fd_sc_hd__fill_2
XFILLER_0_108_162 VGND VGND VPWR VPWR sky130_fd_sc_hd__decap_3
XFILLER_0_53_255 VGND VGND VPWR VPWR sky130_fd_sc_hd__fill_1
Xclkbuf_leaf_44_CLK clknet_3_7__leaf_CLK VGND VGND VPWR VPWR clknet_leaf_44_CLK sky130_fd_sc_hd__clkbuf_8
XFILLER_0_124_666 VPWR VGND VPWR VGND sky130_ef_sc_hd__decap_12
XFILLER_0_108_195 VGND VGND VPWR VPWR sky130_fd_sc_hd__fill_1
XANTENNA_4 _1755_ VGND VGND VPWR VPWR sky130_fd_sc_hd__diode_2
XTAP_TAPCELL_ROW_74_1403 VGND VPWR sky130_fd_sc_hd__tapvpwrvgnd_1
XFILLER_0_1_503 VGND VGND VPWR VPWR sky130_fd_sc_hd__fill_1
XFILLER_0_22_653 VGND VGND VPWR VPWR sky130_fd_sc_hd__fill_2
XTAP_TAPCELL_ROW_74_1414 VGND VPWR sky130_fd_sc_hd__tapvpwrvgnd_1
XFILLER_0_10_837 VGND VGND VPWR VPWR sky130_fd_sc_hd__fill_2
XFILLER_0_6_27 VGND VGND VPWR VPWR sky130_fd_sc_hd__fill_1
XFILLER_0_22_686 VPWR VGND VPWR VGND sky130_ef_sc_hd__decap_12
X_4290_ rf.registers\[20\]\[2\] rf.registers\[21\]\[2\] rf.registers\[22\]\[2\] rf.registers\[23\]\[2\]
+ _1077_ _1078_ VGND VGND VPWR VPWR _1083_ sky130_fd_sc_hd__mux4_1
XPHY_EDGE_ROW_60_Left_199 VGND VGND VPWR VPWR sky130_fd_sc_hd__decap_3
X_7980_ _3914_ VGND VGND VPWR VPWR _3926_ sky130_fd_sc_hd__clkbuf_8
X_6931_ _3360_ VGND VGND VPWR VPWR _0935_ sky130_fd_sc_hd__clkbuf_1
XFILLER_0_89_697 VPWR VGND VPWR VGND sky130_ef_sc_hd__decap_12
XTAP_TAPCELL_ROW_85_1576 VGND VPWR sky130_fd_sc_hd__tapvpwrvgnd_1
X_6862_ net22 VGND VGND VPWR VPWR _3313_ sky130_fd_sc_hd__clkbuf_2
XFILLER_0_16_83 VGND VGND VPWR VPWR sky130_fd_sc_hd__fill_1
X_8601_ clknet_leaf_49_CLK _0713_ VGND VGND VPWR VPWR rf.registers\[11\]\[8\] sky130_fd_sc_hd__dfxtp_1
XFILLER_0_64_509 VGND VGND VPWR VPWR sky130_fd_sc_hd__fill_1
X_5813_ _2483_ _2476_ _2482_ VGND VGND VPWR VPWR _2538_ sky130_fd_sc_hd__and3b_1
XFILLER_0_119_449 VGND VGND VPWR VPWR sky130_fd_sc_hd__decap_4
X_8532_ _3016_ rf.registers\[13\]\[14\] _4216_ VGND VGND VPWR VPWR _4218_ sky130_fd_sc_hd__mux2_1
XFILLER_0_57_561 VPWR VGND VPWR VGND sky130_ef_sc_hd__decap_12
XFILLER_0_29_241 VGND VGND VPWR VPWR sky130_fd_sc_hd__fill_2
X_6793_ _3268_ VGND VGND VPWR VPWR _0889_ sky130_fd_sc_hd__clkbuf_1
XFILLER_0_134_419 VGND VGND VPWR VPWR sky130_fd_sc_hd__fill_1
XFILLER_0_72_531 VGND VGND VPWR VPWR sky130_fd_sc_hd__fill_1
X_5744_ _2463_ _2467_ _2326_ _2470_ VGND VGND VPWR VPWR _2471_ sky130_fd_sc_hd__o211a_1
XFILLER_0_17_447 VGND VGND VPWR VPWR sky130_fd_sc_hd__fill_1
X_8463_ _3014_ rf.registers\[14\]\[13\] _4178_ VGND VGND VPWR VPWR _4182_ sky130_fd_sc_hd__mux2_1
X_5675_ _2348_ _2401_ _2403_ VGND VGND VPWR VPWR _2404_ sky130_fd_sc_hd__o21a_1
X_7414_ _3344_ rf.registers\[29\]\[0\] _3625_ VGND VGND VPWR VPWR _3626_ sky130_fd_sc_hd__mux2_1
XTAP_TAPCELL_ROW_116_2042 VGND VPWR sky130_fd_sc_hd__tapvpwrvgnd_1
XFILLER_0_114_121 VPWR VGND VPWR VGND sky130_ef_sc_hd__decap_12
Xclkbuf_leaf_35_CLK clknet_3_7__leaf_CLK VGND VGND VPWR VPWR clknet_leaf_35_CLK sky130_fd_sc_hd__clkbuf_8
X_8394_ _4145_ VGND VGND VPWR VPWR _0589_ sky130_fd_sc_hd__clkbuf_1
XFILLER_0_89_3 VPWR VGND VPWR VGND sky130_ef_sc_hd__decap_12
X_4626_ _1329_ VGND VGND VPWR VPWR _1403_ sky130_fd_sc_hd__buf_4
XFILLER_0_60_737 VPWR VGND VPWR VGND sky130_ef_sc_hd__decap_12
X_7345_ rf.registers\[8\]\[0\] _3276_ _3588_ VGND VGND VPWR VPWR _3589_ sky130_fd_sc_hd__mux2_1
XFILLER_0_114_165 VPWR VGND VPWR VGND sky130_ef_sc_hd__decap_12
XFILLER_0_103_839 VGND VGND VPWR VPWR sky130_fd_sc_hd__fill_1
XFILLER_0_4_363 VGND VGND VPWR VPWR sky130_fd_sc_hd__fill_1
XFILLER_0_130_669 VPWR VGND VPWR VGND sky130_ef_sc_hd__decap_12
X_4557_ _1336_ _1337_ _1134_ VGND VGND VPWR VPWR _1338_ sky130_fd_sc_hd__mux2_1
XFILLER_0_12_141 VPWR VGND VPWR VGND sky130_ef_sc_hd__decap_12
X_4488_ _1268_ _1269_ _1270_ _1271_ _1143_ _1061_ VGND VGND VPWR VPWR _1272_ sky130_fd_sc_hd__mux4_1
X_7276_ _3551_ VGND VGND VPWR VPWR _3552_ sky130_fd_sc_hd__buf_4
X_9015_ clknet_leaf_61_CLK _0103_ VGND VGND VPWR VPWR rf.registers\[8\]\[6\] sky130_fd_sc_hd__dfxtp_1
X_6227_ net102 _2928_ VGND VGND VPWR VPWR _2929_ sky130_fd_sc_hd__xnor2_1
X_6158_ _2318_ _2863_ _2793_ _2240_ VGND VGND VPWR VPWR _2864_ sky130_fd_sc_hd__a2bb2o_1
X_5109_ rf.registers\[28\]\[12\] rf.registers\[29\]\[12\] rf.registers\[30\]\[12\]
+ rf.registers\[31\]\[12\] _1694_ _1695_ VGND VGND VPWR VPWR _1860_ sky130_fd_sc_hd__mux4_1
X_6089_ _2524_ _2781_ _2326_ VGND VGND VPWR VPWR _2798_ sky130_fd_sc_hd__o21ai_1
XFILLER_0_95_623 VGND VGND VPWR VPWR sky130_fd_sc_hd__fill_2
XFILLER_0_68_837 VGND VGND VPWR VPWR sky130_fd_sc_hd__fill_2
XFILLER_0_138_714 VPWR VGND VPWR VGND sky130_ef_sc_hd__decap_12
XTAP_TAPCELL_ROW_0_284 VGND VPWR sky130_fd_sc_hd__tapvpwrvgnd_1
XTAP_TAPCELL_ROW_0_295 VGND VPWR sky130_fd_sc_hd__tapvpwrvgnd_1
XFILLER_0_36_701 VGND VGND VPWR VPWR sky130_fd_sc_hd__decap_8
XFILLER_0_137_279 VGND VGND VPWR VPWR sky130_fd_sc_hd__fill_1
XFILLER_0_63_520 VGND VGND VPWR VPWR sky130_fd_sc_hd__decap_8
XFILLER_0_133_441 VGND VGND VPWR VPWR sky130_fd_sc_hd__decap_6
Xclkbuf_leaf_26_CLK clknet_3_5__leaf_CLK VGND VGND VPWR VPWR clknet_leaf_26_CLK sky130_fd_sc_hd__clkbuf_8
XFILLER_0_90_361 VGND VGND VPWR VPWR sky130_fd_sc_hd__decap_3
XFILLER_0_51_726 VGND VGND VPWR VPWR sky130_fd_sc_hd__fill_2
XFILLER_0_121_614 VGND VGND VPWR VPWR sky130_fd_sc_hd__fill_2
XFILLER_0_106_699 VGND VGND VPWR VPWR sky130_fd_sc_hd__fill_1
XFILLER_0_50_269 VGND VGND VPWR VPWR sky130_fd_sc_hd__fill_1
XTAP_TAPCELL_ROW_56_1144 VGND VPWR sky130_fd_sc_hd__tapvpwrvgnd_1
XTAP_TAPCELL_ROW_56_1133 VGND VPWR sky130_fd_sc_hd__tapvpwrvgnd_1
Xoutput52 net52 VGND VGND VPWR VPWR RD1[12] sky130_fd_sc_hd__buf_1
Xoutput85 net85 VGND VGND VPWR VPWR RD2[13] sky130_fd_sc_hd__buf_1
Xoutput74 net74 VGND VGND VPWR VPWR RD1[3] sky130_fd_sc_hd__buf_1
Xoutput63 net63 VGND VGND VPWR VPWR RD1[22] sky130_fd_sc_hd__buf_1
XFILLER_0_128_29 VPWR VGND VPWR VGND sky130_ef_sc_hd__decap_12
Xoutput96 net96 VGND VGND VPWR VPWR RD2[23] sky130_fd_sc_hd__buf_1
XFILLER_0_37_27 VPWR VGND VPWR VGND sky130_ef_sc_hd__decap_12
XFILLER_0_53_15 VPWR VGND VPWR VGND sky130_ef_sc_hd__decap_12
XFILLER_0_85_111 VGND VGND VPWR VPWR sky130_fd_sc_hd__fill_1
XFILLER_0_39_561 VGND VGND VPWR VPWR sky130_fd_sc_hd__decap_3
XFILLER_0_54_531 VGND VGND VPWR VPWR sky130_fd_sc_hd__fill_1
XTAP_TAPCELL_ROW_80_1495 VGND VPWR sky130_fd_sc_hd__tapvpwrvgnd_1
XFILLER_0_6_628 VPWR VGND VPWR VGND sky130_ef_sc_hd__decap_12
XFILLER_0_5_105 VGND VGND VPWR VPWR sky130_fd_sc_hd__decap_6
Xclkbuf_leaf_17_CLK clknet_3_4__leaf_CLK VGND VGND VPWR VPWR clknet_leaf_17_CLK sky130_fd_sc_hd__clkbuf_8
X_5460_ _2186_ _2188_ _2191_ _1958_ _1940_ VGND VGND VPWR VPWR _2192_ sky130_fd_sc_hd__o221a_1
XFILLER_0_54_586 VGND VGND VPWR VPWR sky130_fd_sc_hd__fill_2
XFILLER_0_5_149 VPWR VGND VPWR VGND sky130_ef_sc_hd__decap_12
XFILLER_0_124_474 VGND VGND VPWR VPWR sky130_fd_sc_hd__fill_2
XFILLER_0_112_603 VGND VGND VPWR VPWR sky130_fd_sc_hd__fill_1
XFILLER_0_78_23 VGND VGND VPWR VPWR sky130_fd_sc_hd__fill_2
X_4411_ rf.registers\[4\]\[6\] rf.registers\[5\]\[6\] rf.registers\[6\]\[6\] rf.registers\[7\]\[6\]
+ _1198_ _1199_ VGND VGND VPWR VPWR _1200_ sky130_fd_sc_hd__mux4_1
XFILLER_0_41_225 VGND VGND VPWR VPWR sky130_fd_sc_hd__fill_1
XFILLER_0_111_113 VGND VGND VPWR VPWR sky130_fd_sc_hd__decap_3
X_5391_ rf.registers\[12\]\[27\] rf.registers\[13\]\[27\] rf.registers\[14\]\[27\]
+ rf.registers\[15\]\[27\] _2008_ _2009_ VGND VGND VPWR VPWR _2127_ sky130_fd_sc_hd__mux4_1
X_4342_ net6 VGND VGND VPWR VPWR _1133_ sky130_fd_sc_hd__buf_4
XFILLER_0_50_781 VPWR VGND VPWR VGND sky130_ef_sc_hd__decap_12
XFILLER_0_10_645 VGND VGND VPWR VPWR sky130_fd_sc_hd__decap_8
X_7130_ _3474_ VGND VGND VPWR VPWR _1020_ sky130_fd_sc_hd__clkbuf_1
X_4273_ rf.registers\[0\]\[1\] rf.registers\[1\]\[1\] rf.registers\[2\]\[1\] rf.registers\[3\]\[1\]
+ _1041_ _1043_ VGND VGND VPWR VPWR _1067_ sky130_fd_sc_hd__mux4_1
XFILLER_0_10_678 VPWR VGND VPWR VGND sky130_ef_sc_hd__decap_12
X_7061_ rf.registers\[6\]\[27\] _3334_ _3430_ VGND VGND VPWR VPWR _3438_ sky130_fd_sc_hd__mux2_1
X_6012_ net81 _2298_ _2362_ VGND VGND VPWR VPWR _2726_ sky130_fd_sc_hd__a21bo_1
.ends
